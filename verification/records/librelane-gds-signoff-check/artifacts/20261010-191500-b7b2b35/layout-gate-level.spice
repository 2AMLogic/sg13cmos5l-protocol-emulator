* extracted by klt extract --deck sg13cmos5l

* cell tt_um_2amlogic_protocol_emulator
* pin VGND
* pin VPWR
* pin clk
* pin rst_n
* pin ui_in[0]
* pin ui_in[1]
* pin ui_in[2]
* pin ui_in[3]
* pin ui_in[4]
* pin ui_in[5]
* pin ui_in[6]
* pin ui_in[7]
* pin uio_in[0]
* pin uio_in[1]
* pin uio_in[2]
* pin uio_in[3]
* pin uio_in[4]
* pin uio_in[5]
* pin uio_in[6]
* pin uio_in[7]
* pin uio_oe[0]
* pin uio_oe[1]
* pin uio_oe[2]
* pin uio_oe[3]
* pin uio_oe[4]
* pin uio_oe[5]
* pin uio_oe[6]
* pin uio_oe[7]
* pin uio_out[0]
* pin uio_out[1]
* pin uio_out[2]
* pin uio_out[3]
* pin uio_out[4]
* pin uio_out[5]
* pin uio_out[6]
* pin uio_out[7]
* pin uo_out[0]
* pin uo_out[1]
* pin uo_out[2]
* pin uo_out[3]
* pin uo_out[4]
* pin uo_out[5]
* pin uo_out[6]
* pin uo_out[7]
* pin ena
.SUBCKT tt_um_2amlogic_protocol_emulator VGND VPWR clk rst_n ui_in[0] ui_in[1]
+ ui_in[2] ui_in[3] ui_in[4] ui_in[5] ui_in[6] ui_in[7] uio_in[0] uio_in[1]
+ uio_in[2] uio_in[3] uio_in[4] uio_in[5] uio_in[6] uio_in[7] uio_oe[0]
+ uio_oe[1] uio_oe[2] uio_oe[3] uio_oe[4] uio_oe[5] uio_oe[6] uio_oe[7]
+ uio_out[0] uio_out[1] uio_out[2] uio_out[3] uio_out[4] uio_out[5] uio_out[6]
+ uio_out[7] uo_out[0] uo_out[1] uo_out[2] uo_out[3] uo_out[4] uo_out[5]
+ uo_out[6] uo_out[7] ena
* cell instance RM_IHPSG13_1P_256x16_c2_bm_bist_0 r0 *1 0,0
XRM_IHPSG13_1P_256x16_c2_bm_bist_0 \$4638 \$4308 \$4914 \$4912 \$4650 \$4920
+ \$4630 \$4901 \$4641 \$4214 \$4558 \$4910 \$4925 \$4559 \$4554 \$4555 \$4611
+ \$4966 \$4982 \$5002 \$5013 \$5026 \$5045 \$4814 \$4826 \$4842 \$4854 \$4866
+ \$4878 \$4892 \$4936 \$4948 \$4202 \$5311 \$4972 \$4986 \$5000 \$5017 \$5030
+ \$5285 \$4808 \$4822 \$4836 \$4850 \$4862 \$4874 \$4886 \$4940 \$4956 \$5631
+ \$4556 \$4210 \$4557 \$4615 \$4963 \$4979 \$4992 \$5010 \$5023 \$5041 \$4819
+ \$4831 \$4847 \$4859 \$4871 \$4883 \$4896 \$4933 \$4945 \$4627 \$5212 \$4961
+ \$4977 \$5001 \$5020 \$5284 \$5313 \$5344 \$5208 \$5213 \$4796 \$4805 \$4801
+ \$4813 \$4426 \$4649 \$4924 \$3057 \$1738 \$1917 \$1896 \$1899 \$1886 \$1808
+ \$3201 \$3470 \$3206 \$2130 \$2030 \$2179 \$2028 \$1904 \$1893 \$4635 \$4410
+ \$4626 VPWR VPWR VGND RM_IHPSG13_1P_256x16_c2_bm_bist
* cell instance sg13cmos5l_a21o_1_0 r0 *1 0,0
Xsg13cmos5l_a21o_1_0 \$4406 \$6067 \$5907 VPWR VGND \$5636 sg13cmos5l_a21o_1
* cell instance sg13cmos5l_a21o_1_1 r0 *1 0,0
Xsg13cmos5l_a21o_1_1 \$4406 \$6238 \$5865 VPWR VGND \$6426 sg13cmos5l_a21o_1
* cell instance sg13cmos5l_a21o_1_2 r0 *1 0,0
Xsg13cmos5l_a21o_1_2 \$7703 \$7251 \$7198 VPWR VGND \$7533 sg13cmos5l_a21o_1
* cell instance sg13cmos5l_a21o_1_3 r0 *1 0,0
Xsg13cmos5l_a21o_1_3 \$2598 \$3423 \$3317 VPWR VGND \$3177 sg13cmos5l_a21o_1
* cell instance sg13cmos5l_a21o_1_4 r0 *1 0,0
Xsg13cmos5l_a21o_1_4 \$2604 \$2294 \$2735 VPWR VGND \$2595 sg13cmos5l_a21o_1
* cell instance sg13cmos5l_a21o_1_5 r0 *1 0,0
Xsg13cmos5l_a21o_1_5 \$2155 \$2156 \$2153 VPWR VGND \$2019 sg13cmos5l_a21o_1
* cell instance sg13cmos5l_a21o_1_6 r0 *1 0,0
Xsg13cmos5l_a21o_1_6 \$1287 \$1645 \$937 VPWR VGND \$1841 sg13cmos5l_a21o_1
* cell instance sg13cmos5l_a21o_1_7 r0 *1 0,0
Xsg13cmos5l_a21o_1_7 \$2614 \$2616 \$2613 VPWR VGND \$901 sg13cmos5l_a21o_1
* cell instance sg13cmos5l_a21o_1_8 r0 *1 0,0
Xsg13cmos5l_a21o_1_8 \$1303 \$1301 \$1304 VPWR VGND \$1454 sg13cmos5l_a21o_1
* cell instance sg13cmos5l_a21o_1_9 r0 *1 0,0
Xsg13cmos5l_a21o_1_9 \$1303 \$2312 \$2310 VPWR VGND \$2166 sg13cmos5l_a21o_1
* cell instance sg13cmos5l_a21o_1_10 r0 *1 0,0
Xsg13cmos5l_a21o_1_10 \$1303 \$1624 \$1455 VPWR VGND \$1311 sg13cmos5l_a21o_1
* cell instance sg13cmos5l_a21o_1_11 r0 *1 0,0
Xsg13cmos5l_a21o_1_11 \$2849 \$2752 \$1461 VPWR VGND \$2895 sg13cmos5l_a21o_1
* cell instance sg13cmos5l_a21o_1_12 r0 *1 0,0
Xsg13cmos5l_a21o_1_12 \$1193 \$1991 \$1643 VPWR VGND \$2035 sg13cmos5l_a21o_1
* cell instance sg13cmos5l_a21o_1_13 r0 *1 0,0
Xsg13cmos5l_a21o_1_13 \$1661 \$1662 \$1461 VPWR VGND \$1321 sg13cmos5l_a21o_1
* cell instance sg13cmos5l_a21o_1_14 r0 *1 0,0
Xsg13cmos5l_a21o_1_14 \$1667 \$1668 \$1461 VPWR VGND \$1320 sg13cmos5l_a21o_1
* cell instance sg13cmos5l_a21o_1_15 r0 *1 0,0
Xsg13cmos5l_a21o_1_15 \$2462 \$2908 \$2906 VPWR VGND \$2021 sg13cmos5l_a21o_1
* cell instance sg13cmos5l_a21o_1_16 r0 *1 0,0
Xsg13cmos5l_a21o_1_16 \$3299 \$4356 \$3211 VPWR VGND \$3598 sg13cmos5l_a21o_1
* cell instance sg13cmos5l_a21o_1_17 r0 *1 0,0
Xsg13cmos5l_a21o_1_17 \$2123 \$1970 \$1201 VPWR VGND \$1684 sg13cmos5l_a21o_1
* cell instance sg13cmos5l_a21o_1_18 r0 *1 0,0
Xsg13cmos5l_a21o_1_18 \$679 \$680 \$785 VPWR VGND \$747 sg13cmos5l_a21o_1
* cell instance sg13cmos5l_a21o_1_19 r0 *1 0,0
Xsg13cmos5l_a21o_1_19 \$65 \$976 \$855 VPWR VGND \$978 sg13cmos5l_a21o_1
* cell instance sg13cmos5l_a21o_1_20 r0 *1 0,0
Xsg13cmos5l_a21o_1_20 \$86 \$154 \$308 VPWR VGND \$272 sg13cmos5l_a21o_1
* cell instance sg13cmos5l_a21o_1_21 r0 *1 0,0
Xsg13cmos5l_a21o_1_21 \$281 \$212 \$78 VPWR VGND \$274 sg13cmos5l_a21o_1
* cell instance sg13cmos5l_a21o_1_22 r0 *1 0,0
Xsg13cmos5l_a21o_1_22 \$866 \$989 \$697 VPWR VGND \$991 sg13cmos5l_a21o_1
* cell instance sg13cmos5l_a21o_1_23 r0 *1 0,0
Xsg13cmos5l_a21o_1_23 \$696 \$694 \$589 VPWR VGND \$810 sg13cmos5l_a21o_1
* cell instance sg13cmos5l_a21o_1_24 r0 *1 0,0
Xsg13cmos5l_a21o_1_24 \$814 \$1336 \$384 VPWR VGND \$1342 sg13cmos5l_a21o_1
* cell instance sg13cmos5l_a21o_1_25 r0 *1 0,0
Xsg13cmos5l_a21o_1_25 \$806 \$1208 \$1002 VPWR VGND \$1210 sg13cmos5l_a21o_1
* cell instance sg13cmos5l_a21o_1_26 r0 *1 0,0
Xsg13cmos5l_a21o_1_26 \$2071 \$1899 \$2563 VPWR VGND \$1357 sg13cmos5l_a21o_1
* cell instance sg13cmos5l_a21o_1_27 r0 *1 0,0
Xsg13cmos5l_a21o_1_27 \$1701 \$2329 \$2090 VPWR VGND \$2209 sg13cmos5l_a21o_1
* cell instance sg13cmos5l_a21o_1_28 r0 *1 0,0
Xsg13cmos5l_a21o_1_28 \$409 \$399 \$236 VPWR VGND \$436 sg13cmos5l_a21o_1
* cell instance sg13cmos5l_a21o_1_29 r0 *1 0,0
Xsg13cmos5l_a21o_1_29 \$4059 \$4521 \$4281 VPWR VGND \$4529 sg13cmos5l_a21o_1
* cell instance sg13cmos5l_a21oi_1_0 r0 *1 0,0
Xsg13cmos5l_a21oi_1_0 \$7009 \$7011 \$6701 VPWR VGND \$7198 sg13cmos5l_a21oi_1
* cell instance sg13cmos5l_a21oi_1_1 r0 *1 0,0
Xsg13cmos5l_a21oi_1_1 \$1817 \$1815 \$1818 VPWR VGND \$1997 sg13cmos5l_a21oi_1
* cell instance sg13cmos5l_a21oi_1_2 r0 *1 0,0
Xsg13cmos5l_a21oi_1_2 \$1817 \$3170 \$3172 VPWR VGND \$3171 sg13cmos5l_a21oi_1
* cell instance sg13cmos5l_a21oi_1_3 r0 *1 0,0
Xsg13cmos5l_a21oi_1_3 \$2446 \$8320 \$9275 VPWR VGND \$9350 sg13cmos5l_a21oi_1
* cell instance sg13cmos5l_a21oi_1_4 r0 *1 0,0
Xsg13cmos5l_a21oi_1_4 \$2446 \$9804 \$12872 VPWR VGND \$12941 sg13cmos5l_a21oi_1
* cell instance sg13cmos5l_a21oi_1_5 r0 *1 0,0
Xsg13cmos5l_a21oi_1_5 \$3521 \$9804 \$10704 VPWR VGND \$11311 sg13cmos5l_a21oi_1
* cell instance sg13cmos5l_a21oi_1_6 r0 *1 0,0
Xsg13cmos5l_a21oi_1_6 \$3521 \$8320 \$8175 VPWR VGND \$8754 sg13cmos5l_a21oi_1
* cell instance sg13cmos5l_a21oi_1_7 r0 *1 0,0
Xsg13cmos5l_a21oi_1_7 \$1638 \$1822 \$1824 VPWR VGND \$1823 sg13cmos5l_a21oi_1
* cell instance sg13cmos5l_a21oi_1_8 r0 *1 0,0
Xsg13cmos5l_a21oi_1_8 \$10873 uio_out[6] \$11162 VPWR VGND uio_oe[6]
+ sg13cmos5l_a21oi_1
* cell instance sg13cmos5l_a21oi_1_9 r0 *1 0,0
Xsg13cmos5l_a21oi_1_9 uio_out[7] \$7584 \$12640 VPWR VGND uio_oe[7]
+ sg13cmos5l_a21oi_1
* cell instance sg13cmos5l_a21oi_1_10 r0 *1 0,0
Xsg13cmos5l_a21oi_1_10 \$4224 \$9804 \$9785 VPWR VGND \$9786 sg13cmos5l_a21oi_1
* cell instance sg13cmos5l_a21oi_1_11 r0 *1 0,0
Xsg13cmos5l_a21oi_1_11 \$4224 \$8320 \$8322 VPWR VGND \$8283 sg13cmos5l_a21oi_1
* cell instance sg13cmos5l_a21oi_1_12 r0 *1 0,0
Xsg13cmos5l_a21oi_1_12 \$1817 \$3180 \$3183 VPWR VGND \$3182 sg13cmos5l_a21oi_1
* cell instance sg13cmos5l_a21oi_1_13 r0 *1 0,0
Xsg13cmos5l_a21oi_1_13 \$1833 \$2294 \$2260 VPWR VGND \$2296 sg13cmos5l_a21oi_1
* cell instance sg13cmos5l_a21oi_1_14 r0 *1 0,0
Xsg13cmos5l_a21oi_1_14 uio_out[4] \$9363 \$9364 VPWR VGND uio_oe[4]
+ sg13cmos5l_a21oi_1
* cell instance sg13cmos5l_a21oi_1_15 r0 *1 0,0
Xsg13cmos5l_a21oi_1_15 \$7586 uio_out[5] \$16329 VPWR VGND uio_oe[5]
+ sg13cmos5l_a21oi_1
* cell instance sg13cmos5l_a21oi_1_16 r0 *1 0,0
Xsg13cmos5l_a21oi_1_16 \$899 \$8922 \$8777 VPWR VGND \$8760 sg13cmos5l_a21oi_1
* cell instance sg13cmos5l_a21oi_1_17 r0 *1 0,0
Xsg13cmos5l_a21oi_1_17 \$7332 uio_out[2] \$14695 VPWR VGND uio_oe[2]
+ sg13cmos5l_a21oi_1
* cell instance sg13cmos5l_a21oi_1_18 r0 *1 0,0
Xsg13cmos5l_a21oi_1_18 \$2021 \$2301 \$2153 VPWR VGND \$2300 sg13cmos5l_a21oi_1
* cell instance sg13cmos5l_a21oi_1_19 r0 *1 0,0
Xsg13cmos5l_a21oi_1_19 \$11314 uio_out[3] \$11171 VPWR VGND uio_oe[3]
+ sg13cmos5l_a21oi_1
* cell instance sg13cmos5l_a21oi_1_20 r0 *1 0,0
Xsg13cmos5l_a21oi_1_20 \$3579 \$3440 \$3438 VPWR VGND \$3434 sg13cmos5l_a21oi_1
* cell instance sg13cmos5l_a21oi_1_21 r0 *1 0,0
Xsg13cmos5l_a21oi_1_21 \$1642 \$1991 \$1643 VPWR VGND \$1804 sg13cmos5l_a21oi_1
* cell instance sg13cmos5l_a21oi_1_22 r0 *1 0,0
Xsg13cmos5l_a21oi_1_22 \$899 \$11895 \$11749 VPWR VGND \$11750
+ sg13cmos5l_a21oi_1
* cell instance sg13cmos5l_a21oi_1_23 r0 *1 0,0
Xsg13cmos5l_a21oi_1_23 \$2445 \$2448 \$1447 VPWR VGND \$2608 sg13cmos5l_a21oi_1
* cell instance sg13cmos5l_a21oi_1_24 r0 *1 0,0
Xsg13cmos5l_a21oi_1_24 \$3579 \$3447 \$3437 VPWR VGND \$3573 sg13cmos5l_a21oi_1
* cell instance sg13cmos5l_a21oi_1_25 r0 *1 0,0
Xsg13cmos5l_a21oi_1_25 \$2176 \$11895 \$13361 VPWR VGND \$13090
+ sg13cmos5l_a21oi_1
* cell instance sg13cmos5l_a21oi_1_26 r0 *1 0,0
Xsg13cmos5l_a21oi_1_26 \$1658 \$11895 \$12651 VPWR VGND \$12652
+ sg13cmos5l_a21oi_1
* cell instance sg13cmos5l_a21oi_1_27 r0 *1 0,0
Xsg13cmos5l_a21oi_1_27 \$3419 uio_out[0] \$16598 VPWR VGND uio_oe[0]
+ sg13cmos5l_a21oi_1
* cell instance sg13cmos5l_a21oi_1_28 r0 *1 0,0
Xsg13cmos5l_a21oi_1_28 \$2026 \$3339 \$3909 VPWR VGND \$3907 sg13cmos5l_a21oi_1
* cell instance sg13cmos5l_a21oi_1_29 r0 *1 0,0
Xsg13cmos5l_a21oi_1_29 \$1658 \$8922 \$8324 VPWR VGND \$8179 sg13cmos5l_a21oi_1
* cell instance sg13cmos5l_a21oi_1_30 r0 *1 0,0
Xsg13cmos5l_a21oi_1_30 \$2750 \$2331 \$3039 VPWR VGND \$2741 sg13cmos5l_a21oi_1
* cell instance sg13cmos5l_a21oi_1_31 r0 *1 0,0
Xsg13cmos5l_a21oi_1_31 \$665 \$191 \$442 VPWR VGND \$441 sg13cmos5l_a21oi_1
* cell instance sg13cmos5l_a21oi_1_32 r0 *1 0,0
Xsg13cmos5l_a21oi_1_32 \$2176 \$8922 \$9370 VPWR VGND \$9504 sg13cmos5l_a21oi_1
* cell instance sg13cmos5l_a21oi_1_33 r0 *1 0,0
Xsg13cmos5l_a21oi_1_33 \$1447 \$1449 \$1451 VPWR VGND \$835 sg13cmos5l_a21oi_1
* cell instance sg13cmos5l_a21oi_1_34 r0 *1 0,0
Xsg13cmos5l_a21oi_1_34 \$1303 \$1301 \$1304 VPWR VGND \$832 sg13cmos5l_a21oi_1
* cell instance sg13cmos5l_a21oi_1_35 r0 *1 0,0
Xsg13cmos5l_a21oi_1_35 \$6408 uio_out[1] \$13092 VPWR VGND uio_oe[1]
+ sg13cmos5l_a21oi_1
* cell instance sg13cmos5l_a21oi_1_36 r0 *1 0,0
Xsg13cmos5l_a21oi_1_36 \$262 \$349 \$128 VPWR VGND \$347 sg13cmos5l_a21oi_1
* cell instance sg13cmos5l_a21oi_1_37 r0 *1 0,0
Xsg13cmos5l_a21oi_1_37 \$450 \$451 \$936 VPWR VGND \$447 sg13cmos5l_a21oi_1
* cell instance sg13cmos5l_a21oi_1_38 r0 *1 0,0
Xsg13cmos5l_a21oi_1_38 \$1447 \$1850 \$1451 VPWR VGND \$2164 sg13cmos5l_a21oi_1
* cell instance sg13cmos5l_a21oi_1_39 r0 *1 0,0
Xsg13cmos5l_a21oi_1_39 \$2000 \$2330 \$2021 VPWR VGND \$2452 sg13cmos5l_a21oi_1
* cell instance sg13cmos5l_a21oi_1_40 r0 *1 0,0
Xsg13cmos5l_a21oi_1_40 \$186 \$457 \$130 VPWR VGND \$619 sg13cmos5l_a21oi_1
* cell instance sg13cmos5l_a21oi_1_41 r0 *1 0,0
Xsg13cmos5l_a21oi_1_41 \$3739 \$3913 \$3339 VPWR VGND \$3737 sg13cmos5l_a21oi_1
* cell instance sg13cmos5l_a21oi_1_42 r0 *1 0,0
Xsg13cmos5l_a21oi_1_42 \$3579 \$3578 \$3582 VPWR VGND \$3581 sg13cmos5l_a21oi_1
* cell instance sg13cmos5l_a21oi_1_43 r0 *1 0,0
Xsg13cmos5l_a21oi_1_43 \$512 \$840 \$790 VPWR VGND \$829 sg13cmos5l_a21oi_1
* cell instance sg13cmos5l_a21oi_1_44 r0 *1 0,0
Xsg13cmos5l_a21oi_1_44 \$148 \$267 \$152 VPWR VGND \$730 sg13cmos5l_a21oi_1
* cell instance sg13cmos5l_a21oi_1_45 r0 *1 0,0
Xsg13cmos5l_a21oi_1_45 \$1461 \$1655 \$1451 VPWR VGND \$1310 sg13cmos5l_a21oi_1
* cell instance sg13cmos5l_a21oi_1_46 r0 *1 0,0
Xsg13cmos5l_a21oi_1_46 \$310 \$148 \$49 VPWR VGND \$308 sg13cmos5l_a21oi_1
* cell instance sg13cmos5l_a21oi_1_47 r0 *1 0,0
Xsg13cmos5l_a21oi_1_47 \$1461 \$1653 \$1451 VPWR VGND \$1312 sg13cmos5l_a21oi_1
* cell instance sg13cmos5l_a21oi_1_48 r0 *1 0,0
Xsg13cmos5l_a21oi_1_48 \$2462 \$2463 \$1657 VPWR VGND \$2318 sg13cmos5l_a21oi_1
* cell instance sg13cmos5l_a21oi_1_49 r0 *1 0,0
Xsg13cmos5l_a21oi_1_49 \$1657 \$1837 \$2035 VPWR VGND \$2036 sg13cmos5l_a21oi_1
* cell instance sg13cmos5l_a21oi_1_50 r0 *1 0,0
Xsg13cmos5l_a21oi_1_50 \$2750 \$2331 \$2752 VPWR VGND \$2463 sg13cmos5l_a21oi_1
* cell instance sg13cmos5l_a21oi_1_51 r0 *1 0,0
Xsg13cmos5l_a21oi_1_51 \$310 \$246 \$49 VPWR VGND \$343 sg13cmos5l_a21oi_1
* cell instance sg13cmos5l_a21oi_1_52 r0 *1 0,0
Xsg13cmos5l_a21oi_1_52 \$3605 \$3931 \$3752 VPWR VGND \$4155 sg13cmos5l_a21oi_1
* cell instance sg13cmos5l_a21oi_1_53 r0 *1 0,0
Xsg13cmos5l_a21oi_1_53 \$1461 \$1657 \$1451 VPWR VGND \$1463 sg13cmos5l_a21oi_1
* cell instance sg13cmos5l_a21oi_1_54 r0 *1 0,0
Xsg13cmos5l_a21oi_1_54 \$250 \$284 \$145 VPWR VGND \$251 sg13cmos5l_a21oi_1
* cell instance sg13cmos5l_a21oi_1_55 r0 *1 0,0
Xsg13cmos5l_a21oi_1_55 \$47 \$57 \$153 VPWR VGND \$96 sg13cmos5l_a21oi_1
* cell instance sg13cmos5l_a21oi_1_56 r0 *1 0,0
Xsg13cmos5l_a21oi_1_56 \$1855 \$3339 \$4154 VPWR VGND \$3935 sg13cmos5l_a21oi_1
* cell instance sg13cmos5l_a21oi_1_57 r0 *1 0,0
Xsg13cmos5l_a21oi_1_57 \$848 \$849 \$32 VPWR VGND \$795 sg13cmos5l_a21oi_1
* cell instance sg13cmos5l_a21oi_1_58 r0 *1 0,0
Xsg13cmos5l_a21oi_1_58 \$3471 \$3935 \$3754 VPWR VGND \$3937 sg13cmos5l_a21oi_1
* cell instance sg13cmos5l_a21oi_1_59 r0 *1 0,0
Xsg13cmos5l_a21oi_1_59 \$30 \$284 \$32 VPWR VGND \$15 sg13cmos5l_a21oi_1
* cell instance sg13cmos5l_a21oi_1_60 r0 *1 0,0
Xsg13cmos5l_a21oi_1_60 \$612 \$849 \$405 VPWR VGND \$851 sg13cmos5l_a21oi_1
* cell instance sg13cmos5l_a21oi_1_61 r0 *1 0,0
Xsg13cmos5l_a21oi_1_61 \$571 \$412 \$610 VPWR VGND \$572 sg13cmos5l_a21oi_1
* cell instance sg13cmos5l_a21oi_1_62 r0 *1 0,0
Xsg13cmos5l_a21oi_1_62 \$806 \$742 \$32 VPWR VGND \$629 sg13cmos5l_a21oi_1
* cell instance sg13cmos5l_a21oi_1_63 r0 *1 0,0
Xsg13cmos5l_a21oi_1_63 \$3211 \$3212 \$3215 VPWR VGND \$3352 sg13cmos5l_a21oi_1
* cell instance sg13cmos5l_a21oi_1_64 r0 *1 0,0
Xsg13cmos5l_a21oi_1_64 \$310 \$621 \$745 VPWR VGND \$632 sg13cmos5l_a21oi_1
* cell instance sg13cmos5l_a21oi_1_65 r0 *1 0,0
Xsg13cmos5l_a21oi_1_65 \$250 \$313 \$306 VPWR VGND \$60 sg13cmos5l_a21oi_1
* cell instance sg13cmos5l_a21oi_1_66 r0 *1 0,0
Xsg13cmos5l_a21oi_1_66 \$588 \$676 \$144 VPWR VGND \$741 sg13cmos5l_a21oi_1
* cell instance sg13cmos5l_a21oi_1_67 r0 *1 0,0
Xsg13cmos5l_a21oi_1_67 \$2351 \$3491 \$4161 VPWR VGND \$3761 sg13cmos5l_a21oi_1
* cell instance sg13cmos5l_a21oi_1_68 r0 *1 0,0
Xsg13cmos5l_a21oi_1_68 \$3579 \$3761 \$3758 VPWR VGND \$3949 sg13cmos5l_a21oi_1
* cell instance sg13cmos5l_a21oi_1_69 r0 *1 0,0
Xsg13cmos5l_a21oi_1_69 \$3579 \$3478 \$3476 VPWR VGND \$3475 sg13cmos5l_a21oi_1
* cell instance sg13cmos5l_a21oi_1_70 r0 *1 0,0
Xsg13cmos5l_a21oi_1_70 \$17261 \$17244 \$2058 VPWR VGND \$3633
+ sg13cmos5l_a21oi_1
* cell instance sg13cmos5l_a21oi_1_71 r0 *1 0,0
Xsg13cmos5l_a21oi_1_71 \$197 \$187 \$306 VPWR VGND \$361 sg13cmos5l_a21oi_1
* cell instance sg13cmos5l_a21oi_1_72 r0 *1 0,0
Xsg13cmos5l_a21oi_1_72 \$67 \$1326 \$1086 VPWR VGND \$1475 sg13cmos5l_a21oi_1
* cell instance sg13cmos5l_a21oi_1_73 r0 *1 0,0
Xsg13cmos5l_a21oi_1_73 \$69 \$70 \$59 VPWR VGND \$66 sg13cmos5l_a21oi_1
* cell instance sg13cmos5l_a21oi_1_74 r0 *1 0,0
Xsg13cmos5l_a21oi_1_74 \$47 \$57 \$405 VPWR VGND \$973 sg13cmos5l_a21oi_1
* cell instance sg13cmos5l_a21oi_1_75 r0 *1 0,0
Xsg13cmos5l_a21oi_1_75 \$3084 \$3216 \$3220 VPWR VGND \$3474 sg13cmos5l_a21oi_1
* cell instance sg13cmos5l_a21oi_1_76 r0 *1 0,0
Xsg13cmos5l_a21oi_1_76 \$747 \$633 \$748 VPWR VGND \$749 sg13cmos5l_a21oi_1
* cell instance sg13cmos5l_a21oi_1_77 r0 *1 0,0
Xsg13cmos5l_a21oi_1_77 \$4394 \$4566 \$3299 VPWR VGND \$2926 sg13cmos5l_a21oi_1
* cell instance sg13cmos5l_a21oi_1_78 r0 *1 0,0
Xsg13cmos5l_a21oi_1_78 \$4620 \$4622 \$3299 VPWR VGND \$3361 sg13cmos5l_a21oi_1
* cell instance sg13cmos5l_a21oi_1_79 r0 *1 0,0
Xsg13cmos5l_a21oi_1_79 \$2464 \$2500 \$2495 VPWR VGND \$2759 sg13cmos5l_a21oi_1
* cell instance sg13cmos5l_a21oi_1_80 r0 *1 0,0
Xsg13cmos5l_a21oi_1_80 \$2502 \$3491 \$3490 VPWR VGND \$3478 sg13cmos5l_a21oi_1
* cell instance sg13cmos5l_a21oi_1_81 r0 *1 0,0
Xsg13cmos5l_a21oi_1_81 \$50 \$267 \$264 VPWR VGND \$265 sg13cmos5l_a21oi_1
* cell instance sg13cmos5l_a21oi_1_82 r0 *1 0,0
Xsg13cmos5l_a21oi_1_82 \$2176 \$3772 \$3773 VPWR VGND \$3774 sg13cmos5l_a21oi_1
* cell instance sg13cmos5l_a21oi_1_83 r0 *1 0,0
Xsg13cmos5l_a21oi_1_83 \$1658 \$3772 \$3960 VPWR VGND \$3958 sg13cmos5l_a21oi_1
* cell instance sg13cmos5l_a21oi_1_84 r0 *1 0,0
Xsg13cmos5l_a21oi_1_84 \$274 \$365 \$369 VPWR VGND \$371 sg13cmos5l_a21oi_1
* cell instance sg13cmos5l_a21oi_1_85 r0 *1 0,0
Xsg13cmos5l_a21oi_1_85 \$1327 \$1332 \$669 VPWR VGND \$1330 sg13cmos5l_a21oi_1
* cell instance sg13cmos5l_a21oi_1_86 r0 *1 0,0
Xsg13cmos5l_a21oi_1_86 \$186 \$457 \$171 VPWR VGND \$1093 sg13cmos5l_a21oi_1
* cell instance sg13cmos5l_a21oi_1_87 r0 *1 0,0
Xsg13cmos5l_a21oi_1_87 \$210 \$539 \$290 VPWR VGND \$1332 sg13cmos5l_a21oi_1
* cell instance sg13cmos5l_a21oi_1_88 r0 *1 0,0
Xsg13cmos5l_a21oi_1_88 \$631 \$308 \$636 VPWR VGND \$419 sg13cmos5l_a21oi_1
* cell instance sg13cmos5l_a21oi_1_89 r0 *1 0,0
Xsg13cmos5l_a21oi_1_89 \$73 \$269 \$172 VPWR VGND \$83 sg13cmos5l_a21oi_1
* cell instance sg13cmos5l_a21oi_1_90 r0 *1 0,0
Xsg13cmos5l_a21oi_1_90 \$418 \$640 \$484 VPWR VGND \$638 sg13cmos5l_a21oi_1
* cell instance sg13cmos5l_a21oi_1_91 r0 *1 0,0
Xsg13cmos5l_a21oi_1_91 \$3089 \$3159 \$3087 VPWR VGND \$2334 sg13cmos5l_a21oi_1
* cell instance sg13cmos5l_a21oi_1_92 r0 *1 0,0
Xsg13cmos5l_a21oi_1_92 \$107 \$425 \$171 VPWR VGND \$278 sg13cmos5l_a21oi_1
* cell instance sg13cmos5l_a21oi_1_93 r0 *1 0,0
Xsg13cmos5l_a21oi_1_93 \$4405 \$4305 \$3299 VPWR VGND \$2198 sg13cmos5l_a21oi_1
* cell instance sg13cmos5l_a21oi_1_94 r0 *1 0,0
Xsg13cmos5l_a21oi_1_94 \$644 \$683 \$542 VPWR VGND \$667 sg13cmos5l_a21oi_1
* cell instance sg13cmos5l_a21oi_1_95 r0 *1 0,0
Xsg13cmos5l_a21oi_1_95 \$166 \$316 \$279 VPWR VGND \$281 sg13cmos5l_a21oi_1
* cell instance sg13cmos5l_a21oi_1_96 r0 *1 0,0
Xsg13cmos5l_a21oi_1_96 \$267 \$425 \$688 VPWR VGND \$917 sg13cmos5l_a21oi_1
* cell instance sg13cmos5l_a21oi_1_97 r0 *1 0,0
Xsg13cmos5l_a21oi_1_97 \$57 \$457 \$1102 VPWR VGND \$676 sg13cmos5l_a21oi_1
* cell instance sg13cmos5l_a21oi_1_98 r0 *1 0,0
Xsg13cmos5l_a21oi_1_98 \$248 \$923 \$290 VPWR VGND \$420 sg13cmos5l_a21oi_1
* cell instance sg13cmos5l_a21oi_1_99 r0 *1 0,0
Xsg13cmos5l_a21oi_1_99 \$474 \$635 \$542 VPWR VGND \$686 sg13cmos5l_a21oi_1
* cell instance sg13cmos5l_a21oi_1_100 r0 *1 0,0
Xsg13cmos5l_a21oi_1_100 \$689 \$583 \$176 VPWR VGND \$690 sg13cmos5l_a21oi_1
* cell instance sg13cmos5l_a21oi_1_101 r0 *1 0,0
Xsg13cmos5l_a21oi_1_101 \$595 \$869 \$870 VPWR VGND \$807 sg13cmos5l_a21oi_1
* cell instance sg13cmos5l_a21oi_1_102 r0 *1 0,0
Xsg13cmos5l_a21oi_1_102 \$320 \$178 \$321 VPWR VGND \$315 sg13cmos5l_a21oi_1
* cell instance sg13cmos5l_a21oi_1_103 r0 *1 0,0
Xsg13cmos5l_a21oi_1_103 \$1206 \$860 \$331 VPWR VGND \$1337 sg13cmos5l_a21oi_1
* cell instance sg13cmos5l_a21oi_1_104 r0 *1 0,0
Xsg13cmos5l_a21oi_1_104 \$993 \$991 \$589 VPWR VGND \$870 sg13cmos5l_a21oi_1
* cell instance sg13cmos5l_a21oi_1_105 r0 *1 0,0
Xsg13cmos5l_a21oi_1_105 \$3792 \$3790 \$3797 VPWR VGND \$3788 sg13cmos5l_a21oi_1
* cell instance sg13cmos5l_a21oi_1_106 r0 *1 0,0
Xsg13cmos5l_a21oi_1_106 \$2202 \$3098 \$2500 VPWR VGND \$3160 sg13cmos5l_a21oi_1
* cell instance sg13cmos5l_a21oi_1_107 r0 *1 0,0
Xsg13cmos5l_a21oi_1_107 \$539 \$929 \$873 VPWR VGND \$840 sg13cmos5l_a21oi_1
* cell instance sg13cmos5l_a21oi_1_108 r0 *1 0,0
Xsg13cmos5l_a21oi_1_108 \$39 \$576 \$873 VPWR VGND \$993 sg13cmos5l_a21oi_1
* cell instance sg13cmos5l_a21oi_1_109 r0 *1 0,0
Xsg13cmos5l_a21oi_1_109 \$103 \$96 \$171 VPWR VGND \$104 sg13cmos5l_a21oi_1
* cell instance sg13cmos5l_a21oi_1_110 r0 *1 0,0
Xsg13cmos5l_a21oi_1_110 \$17245 \$17281 \$2058 VPWR VGND \$3620
+ sg13cmos5l_a21oi_1
* cell instance sg13cmos5l_a21oi_1_111 r0 *1 0,0
Xsg13cmos5l_a21oi_1_111 \$2067 \$2191 \$2060 VPWR VGND \$2065 sg13cmos5l_a21oi_1
* cell instance sg13cmos5l_a21oi_1_112 r0 *1 0,0
Xsg13cmos5l_a21oi_1_112 \$3502 \$3795 \$3505 VPWR VGND \$3618 sg13cmos5l_a21oi_1
* cell instance sg13cmos5l_a21oi_1_113 r0 *1 0,0
Xsg13cmos5l_a21oi_1_113 \$644 \$222 \$589 VPWR VGND \$620 sg13cmos5l_a21oi_1
* cell instance sg13cmos5l_a21oi_1_114 r0 *1 0,0
Xsg13cmos5l_a21oi_1_114 \$752 \$688 \$996 VPWR VGND \$1091 sg13cmos5l_a21oi_1
* cell instance sg13cmos5l_a21oi_1_115 r0 *1 0,0
Xsg13cmos5l_a21oi_1_115 \$27 \$37 \$874 VPWR VGND \$929 sg13cmos5l_a21oi_1
* cell instance sg13cmos5l_a21oi_1_116 r0 *1 0,0
Xsg13cmos5l_a21oi_1_116 \$3085 \$3504 \$3620 VPWR VGND \$3004 sg13cmos5l_a21oi_1
* cell instance sg13cmos5l_a21oi_1_117 r0 *1 0,0
Xsg13cmos5l_a21oi_1_117 \$287 \$168 \$290 VPWR VGND \$289 sg13cmos5l_a21oi_1
* cell instance sg13cmos5l_a21oi_1_118 r0 *1 0,0
Xsg13cmos5l_a21oi_1_118 \$804 \$25 \$107 VPWR VGND \$99 sg13cmos5l_a21oi_1
* cell instance sg13cmos5l_a21oi_1_119 r0 *1 0,0
Xsg13cmos5l_a21oi_1_119 \$489 \$134 \$487 VPWR VGND \$388 sg13cmos5l_a21oi_1
* cell instance sg13cmos5l_a21oi_1_120 r0 *1 0,0
Xsg13cmos5l_a21oi_1_120 \$2781 \$2779 \$2782 VPWR VGND \$2498 sg13cmos5l_a21oi_1
* cell instance sg13cmos5l_a21oi_1_121 r0 *1 0,0
Xsg13cmos5l_a21oi_1_121 \$93 \$650 \$565 VPWR VGND \$648 sg13cmos5l_a21oi_1
* cell instance sg13cmos5l_a21oi_1_122 r0 *1 0,0
Xsg13cmos5l_a21oi_1_122 \$877 \$878 \$489 VPWR VGND \$844 sg13cmos5l_a21oi_1
* cell instance sg13cmos5l_a21oi_1_123 r0 *1 0,0
Xsg13cmos5l_a21oi_1_123 \$2569 \$2493 \$2500 VPWR VGND \$2652 sg13cmos5l_a21oi_1
* cell instance sg13cmos5l_a21oi_1_124 r0 *1 0,0
Xsg13cmos5l_a21oi_1_124 \$765 \$817 \$811 VPWR VGND \$815 sg13cmos5l_a21oi_1
* cell instance sg13cmos5l_a21oi_1_125 r0 *1 0,0
Xsg13cmos5l_a21oi_1_125 \$248 \$330 \$39 VPWR VGND \$545 sg13cmos5l_a21oi_1
* cell instance sg13cmos5l_a21oi_1_126 r0 *1 0,0
Xsg13cmos5l_a21oi_1_126 \$39 \$765 \$589 VPWR VGND \$878 sg13cmos5l_a21oi_1
* cell instance sg13cmos5l_a21oi_1_127 r0 *1 0,0
Xsg13cmos5l_a21oi_1_127 \$700 \$284 \$290 VPWR VGND \$702 sg13cmos5l_a21oi_1
* cell instance sg13cmos5l_a21oi_1_128 r0 *1 0,0
Xsg13cmos5l_a21oi_1_128 \$2717 \$2501 \$2500 VPWR VGND \$2937 sg13cmos5l_a21oi_1
* cell instance sg13cmos5l_a21oi_1_129 r0 *1 0,0
Xsg13cmos5l_a21oi_1_129 \$320 \$332 \$811 VPWR VGND \$334 sg13cmos5l_a21oi_1
* cell instance sg13cmos5l_a21oi_1_130 r0 *1 0,0
Xsg13cmos5l_a21oi_1_130 \$3234 \$3499 \$3235 VPWR VGND \$3624 sg13cmos5l_a21oi_1
* cell instance sg13cmos5l_a21oi_1_131 r0 *1 0,0
Xsg13cmos5l_a21oi_1_131 \$768 \$702 \$387 VPWR VGND \$769 sg13cmos5l_a21oi_1
* cell instance sg13cmos5l_a21oi_1_132 r0 *1 0,0
Xsg13cmos5l_a21oi_1_132 \$3802 \$3509 \$3627 VPWR VGND \$3790 sg13cmos5l_a21oi_1
* cell instance sg13cmos5l_a21oi_1_133 r0 *1 0,0
Xsg13cmos5l_a21oi_1_133 \$1205 \$820 \$768 VPWR VGND \$393 sg13cmos5l_a21oi_1
* cell instance sg13cmos5l_a21oi_1_134 r0 *1 0,0
Xsg13cmos5l_a21oi_1_134 \$1205 \$126 \$504 VPWR VGND \$1008 sg13cmos5l_a21oi_1
* cell instance sg13cmos5l_a21oi_1_135 r0 *1 0,0
Xsg13cmos5l_a21oi_1_135 \$126 \$707 \$703 VPWR VGND \$705 sg13cmos5l_a21oi_1
* cell instance sg13cmos5l_a21oi_1_136 r0 *1 0,0
Xsg13cmos5l_a21oi_1_136 \$3360 \$3512 \$3510 VPWR VGND \$3509 sg13cmos5l_a21oi_1
* cell instance sg13cmos5l_a21oi_1_137 r0 *1 0,0
Xsg13cmos5l_a21oi_1_137 \$223 \$265 \$290 VPWR VGND \$295 sg13cmos5l_a21oi_1
* cell instance sg13cmos5l_a21oi_1_138 r0 *1 0,0
Xsg13cmos5l_a21oi_1_138 \$2657 \$2493 \$2500 VPWR VGND \$2564 sg13cmos5l_a21oi_1
* cell instance sg13cmos5l_a21oi_1_139 r0 *1 0,0
Xsg13cmos5l_a21oi_1_139 \$2202 \$2357 \$2500 VPWR VGND \$2505 sg13cmos5l_a21oi_1
* cell instance sg13cmos5l_a21oi_1_140 r0 *1 0,0
Xsg13cmos5l_a21oi_1_140 \$2795 \$2493 \$2500 VPWR VGND \$2941 sg13cmos5l_a21oi_1
* cell instance sg13cmos5l_a21oi_1_141 r0 *1 0,0
Xsg13cmos5l_a21oi_1_141 \$899 \$3772 \$3631 VPWR VGND \$3995 sg13cmos5l_a21oi_1
* cell instance sg13cmos5l_a21oi_1_142 r0 *1 0,0
Xsg13cmos5l_a21oi_1_142 \$1538 \$1724 \$1534 VPWR VGND \$1535 sg13cmos5l_a21oi_1
* cell instance sg13cmos5l_a21oi_1_143 r0 *1 0,0
Xsg13cmos5l_a21oi_1_143 \$1748 \$1724 \$2081 VPWR VGND \$1913 sg13cmos5l_a21oi_1
* cell instance sg13cmos5l_a21oi_1_144 r0 *1 0,0
Xsg13cmos5l_a21oi_1_144 \$122 \$124 \$78 VPWR VGND \$108 sg13cmos5l_a21oi_1
* cell instance sg13cmos5l_a21oi_1_145 r0 *1 0,0
Xsg13cmos5l_a21oi_1_145 \$925 \$1116 \$504 VPWR VGND \$1208 sg13cmos5l_a21oi_1
* cell instance sg13cmos5l_a21oi_1_146 r0 *1 0,0
Xsg13cmos5l_a21oi_1_146 \$97 \$73 \$213 VPWR VGND \$297 sg13cmos5l_a21oi_1
* cell instance sg13cmos5l_a21oi_1_147 r0 *1 0,0
Xsg13cmos5l_a21oi_1_147 \$90 \$248 \$932 VPWR VGND \$880 sg13cmos5l_a21oi_1
* cell instance sg13cmos5l_a21oi_1_148 r0 *1 0,0
Xsg13cmos5l_a21oi_1_148 \$159 \$34 \$182 VPWR VGND \$183 sg13cmos5l_a21oi_1
* cell instance sg13cmos5l_a21oi_1_149 r0 *1 0,0
Xsg13cmos5l_a21oi_1_149 \$42 \$25 \$115 VPWR VGND \$396 sg13cmos5l_a21oi_1
* cell instance sg13cmos5l_a21oi_1_150 r0 *1 0,0
Xsg13cmos5l_a21oi_1_150 \$27 \$99 \$504 VPWR VGND \$124 sg13cmos5l_a21oi_1
* cell instance sg13cmos5l_a21oi_1_151 r0 *1 0,0
Xsg13cmos5l_a21oi_1_151 \$502 \$433 \$811 VPWR VGND \$431 sg13cmos5l_a21oi_1
* cell instance sg13cmos5l_a21oi_1_152 r0 *1 0,0
Xsg13cmos5l_a21oi_1_152 \$230 \$603 \$504 VPWR VGND \$600 sg13cmos5l_a21oi_1
* cell instance sg13cmos5l_a21oi_1_153 r0 *1 0,0
Xsg13cmos5l_a21oi_1_153 \$518 \$711 \$655 VPWR VGND \$817 sg13cmos5l_a21oi_1
* cell instance sg13cmos5l_a21oi_1_154 r0 *1 0,0
Xsg13cmos5l_a21oi_1_154 \$97 \$159 \$504 VPWR VGND \$772 sg13cmos5l_a21oi_1
* cell instance sg13cmos5l_a21oi_1_155 r0 *1 0,0
Xsg13cmos5l_a21oi_1_155 \$112 \$551 \$936 VPWR VGND \$553 sg13cmos5l_a21oi_1
* cell instance sg13cmos5l_a21oi_1_156 r0 *1 0,0
Xsg13cmos5l_a21oi_1_156 \$580 \$126 \$142 VPWR VGND \$710 sg13cmos5l_a21oi_1
* cell instance sg13cmos5l_a21oi_1_157 r0 *1 0,0
Xsg13cmos5l_a21oi_1_157 \$3085 \$3518 \$2346 VPWR VGND \$3516 sg13cmos5l_a21oi_1
* cell instance sg13cmos5l_a21oi_1_158 r0 *1 0,0
Xsg13cmos5l_a21oi_1_158 \$2781 \$2951 \$3239 VPWR VGND \$2793 sg13cmos5l_a21oi_1
* cell instance sg13cmos5l_a21oi_1_159 r0 *1 0,0
Xsg13cmos5l_a21oi_1_159 \$772 \$710 \$489 VPWR VGND \$773 sg13cmos5l_a21oi_1
* cell instance sg13cmos5l_a21oi_1_160 r0 *1 0,0
Xsg13cmos5l_a21oi_1_160 \$2781 \$2947 \$3374 VPWR VGND \$2945 sg13cmos5l_a21oi_1
* cell instance sg13cmos5l_a21oi_1_161 r0 *1 0,0
Xsg13cmos5l_a21oi_1_161 \$12 \$41 \$185 VPWR VGND \$292 sg13cmos5l_a21oi_1
* cell instance sg13cmos5l_a21oi_1_162 r0 *1 0,0
Xsg13cmos5l_a21oi_1_162 \$42 \$25 \$185 VPWR VGND \$399 sg13cmos5l_a21oi_1
* cell instance sg13cmos5l_a21oi_1_163 r0 *1 0,0
Xsg13cmos5l_a21oi_1_163 \$508 \$440 \$304 VPWR VGND \$433 sg13cmos5l_a21oi_1
* cell instance sg13cmos5l_a21oi_1_164 r0 *1 0,0
Xsg13cmos5l_a21oi_1_164 \$4224 \$3638 \$4247 VPWR VGND \$4246 sg13cmos5l_a21oi_1
* cell instance sg13cmos5l_a21oi_1_165 r0 *1 0,0
Xsg13cmos5l_a21oi_1_165 \$3006 \$2661 \$2797 VPWR VGND \$3112 sg13cmos5l_a21oi_1
* cell instance sg13cmos5l_a21oi_1_166 r0 *1 0,0
Xsg13cmos5l_a21oi_1_166 \$185 \$188 \$182 VPWR VGND \$508 sg13cmos5l_a21oi_1
* cell instance sg13cmos5l_a21oi_1_167 r0 *1 0,0
Xsg13cmos5l_a21oi_1_167 \$591 \$999 \$182 VPWR VGND \$935 sg13cmos5l_a21oi_1
* cell instance sg13cmos5l_a21oi_1_168 r0 *1 0,0
Xsg13cmos5l_a21oi_1_168 \$595 \$817 \$883 VPWR VGND \$828 sg13cmos5l_a21oi_1
* cell instance sg13cmos5l_a21oi_1_169 r0 *1 0,0
Xsg13cmos5l_a21oi_1_169 \$4006 \$3832 \$4007 VPWR VGND \$3830 sg13cmos5l_a21oi_1
* cell instance sg13cmos5l_a21oi_1_170 r0 *1 0,0
Xsg13cmos5l_a21oi_1_170 \$2220 \$1926 \$2365 VPWR VGND \$2221 sg13cmos5l_a21oi_1
* cell instance sg13cmos5l_a21oi_1_171 r0 *1 0,0
Xsg13cmos5l_a21oi_1_171 \$2953 \$2664 \$2799 VPWR VGND \$3116 sg13cmos5l_a21oi_1
* cell instance sg13cmos5l_a21oi_1_172 r0 *1 0,0
Xsg13cmos5l_a21oi_1_172 \$2673 \$1566 \$2568 VPWR VGND \$2671 sg13cmos5l_a21oi_1
* cell instance sg13cmos5l_a21oi_1_173 r0 *1 0,0
Xsg13cmos5l_a21oi_1_173 \$2961 \$2068 \$3119 VPWR VGND \$3120 sg13cmos5l_a21oi_1
* cell instance sg13cmos5l_a21oi_1_174 r0 *1 0,0
Xsg13cmos5l_a21oi_1_174 \$3839 \$3535 \$3533 VPWR VGND \$3532 sg13cmos5l_a21oi_1
* cell instance sg13cmos5l_a21oi_1_175 r0 *1 0,0
Xsg13cmos5l_a21oi_1_175 \$2971 \$2106 \$2099 VPWR VGND \$2966 sg13cmos5l_a21oi_1
* cell instance sg13cmos5l_a21oi_1_176 r0 *1 0,0
Xsg13cmos5l_a21oi_1_176 \$1774 \$1745 \$1635 VPWR VGND \$1584 sg13cmos5l_a21oi_1
* cell instance sg13cmos5l_a21oi_1_177 r0 *1 0,0
Xsg13cmos5l_a21oi_1_177 \$3246 \$2677 \$3262 VPWR VGND \$3261 sg13cmos5l_a21oi_1
* cell instance sg13cmos5l_a21oi_1_178 r0 *1 0,0
Xsg13cmos5l_a21oi_1_178 \$4109 \$4279 \$4197 VPWR VGND \$4142 sg13cmos5l_a21oi_1
* cell instance sg13cmos5l_a21oi_1_179 r0 *1 0,0
Xsg13cmos5l_a21oi_1_179 \$3521 \$3638 \$5541 VPWR VGND \$5468 sg13cmos5l_a21oi_1
* cell instance sg13cmos5l_a21oi_1_180 r0 *1 0,0
Xsg13cmos5l_a21oi_1_180 \$3854 \$3638 \$6038 VPWR VGND \$5895 sg13cmos5l_a21oi_1
* cell instance sg13cmos5l_a221oi_1_0 r0 *1 0,0
Xsg13cmos5l_a221oi_1_0 \$1837 \$2443 \$2158 \$2300 \$2440 VPWR VGND \$2555
+ sg13cmos5l_a221oi_1
* cell instance sg13cmos5l_a221oi_1_1 r0 *1 0,0
Xsg13cmos5l_a221oi_1_1 \$937 \$2023 \$1838 \$2021 \$2019 VPWR VGND \$2018
+ sg13cmos5l_a221oi_1
* cell instance sg13cmos5l_a221oi_1_2 r0 *1 0,0
Xsg13cmos5l_a221oi_1_2 \$2026 \$1969 \$1849 \$1838 \$1447 VPWR VGND \$1839
+ sg13cmos5l_a221oi_1
* cell instance sg13cmos5l_a221oi_1_3 r0 *1 0,0
Xsg13cmos5l_a221oi_1_3 \$1154 \$2023 \$2156 \$2000 \$3039 VPWR VGND \$2307
+ sg13cmos5l_a221oi_1
* cell instance sg13cmos5l_a221oi_1_4 r0 *1 0,0
Xsg13cmos5l_a221oi_1_4 \$240 \$448 \$447 \$445 \$665 VPWR VGND \$442
+ sg13cmos5l_a221oi_1
* cell instance sg13cmos5l_a221oi_1_5 r0 *1 0,0
Xsg13cmos5l_a221oi_1_5 \$1287 \$2023 \$1646 \$2021 \$2163 VPWR VGND \$1844
+ sg13cmos5l_a221oi_1
* cell instance sg13cmos5l_a221oi_1_6 r0 *1 0,0
Xsg13cmos5l_a221oi_1_6 \$2619 \$1969 \$1849 \$2615 \$1447 VPWR VGND \$2616
+ sg13cmos5l_a221oi_1
* cell instance sg13cmos5l_a221oi_1_7 r0 *1 0,0
Xsg13cmos5l_a221oi_1_7 \$4146 \$3435 \$3454 \$1283 \$3735 VPWR VGND \$4143
+ sg13cmos5l_a221oi_1
* cell instance sg13cmos5l_a221oi_1_8 r0 *1 0,0
Xsg13cmos5l_a221oi_1_8 \$4787 \$3435 \$3448 \$5602 \$4786 VPWR VGND \$4597
+ sg13cmos5l_a221oi_1
* cell instance sg13cmos5l_a221oi_1_9 r0 *1 0,0
Xsg13cmos5l_a221oi_1_9 \$522 \$615 \$562 \$619 \$936 VPWR VGND \$616
+ sg13cmos5l_a221oi_1
* cell instance sg13cmos5l_a221oi_1_10 r0 *1 0,0
Xsg13cmos5l_a221oi_1_10 \$1454 \$835 \$363 \$905 \$936 VPWR VGND \$722
+ sg13cmos5l_a221oi_1
* cell instance sg13cmos5l_a221oi_1_11 r0 *1 0,0
Xsg13cmos5l_a221oi_1_11 \$50 \$1 \$614 \$30 \$130 VPWR VGND \$622
+ sg13cmos5l_a221oi_1
* cell instance sg13cmos5l_a221oi_1_12 r0 *1 0,0
Xsg13cmos5l_a221oi_1_12 \$1855 \$1969 \$1849 \$1853 \$1447 VPWR VGND \$1456
+ sg13cmos5l_a221oi_1
* cell instance sg13cmos5l_a221oi_1_13 r0 *1 0,0
Xsg13cmos5l_a221oi_1_13 \$729 \$730 \$671 \$724 \$790 VPWR VGND \$723
+ sg13cmos5l_a221oi_1
* cell instance sg13cmos5l_a221oi_1_14 r0 *1 0,0
Xsg13cmos5l_a221oi_1_14 \$621 \$30 \$1 \$24 \$130 VPWR VGND \$724
+ sg13cmos5l_a221oi_1
* cell instance sg13cmos5l_a221oi_1_15 r0 *1 0,0
Xsg13cmos5l_a221oi_1_15 \$1320 \$1310 \$1459 \$1456 \$1305 VPWR VGND \$793
+ sg13cmos5l_a221oi_1
* cell instance sg13cmos5l_a221oi_1_16 r0 *1 0,0
Xsg13cmos5l_a221oi_1_16 \$1166 \$2023 \$2168 \$2021 \$2315 VPWR VGND \$2313
+ sg13cmos5l_a221oi_1
* cell instance sg13cmos5l_a221oi_1_17 r0 *1 0,0
Xsg13cmos5l_a221oi_1_17 \$1307 \$2023 \$1853 \$2021 \$2033 VPWR VGND \$1651
+ sg13cmos5l_a221oi_1
* cell instance sg13cmos5l_a221oi_1_18 r0 *1 0,0
Xsg13cmos5l_a221oi_1_18 \$621 \$267 \$305 \$820 \$32 VPWR VGND \$565
+ sg13cmos5l_a221oi_1
* cell instance sg13cmos5l_a221oi_1_19 r0 *1 0,0
Xsg13cmos5l_a221oi_1_19 \$30 \$439 \$729 \$308 \$405 VPWR VGND \$721
+ sg13cmos5l_a221oi_1
* cell instance sg13cmos5l_a221oi_1_20 r0 *1 0,0
Xsg13cmos5l_a221oi_1_20 \$1657 \$2021 \$2156 \$2319 \$2318 VPWR VGND \$2317
+ sg13cmos5l_a221oi_1
* cell instance sg13cmos5l_a221oi_1_21 r0 *1 0,0
Xsg13cmos5l_a221oi_1_21 \$1316 \$1317 \$1311 \$1312 \$1313 VPWR VGND \$909
+ sg13cmos5l_a221oi_1
* cell instance sg13cmos5l_a221oi_1_22 r0 *1 0,0
Xsg13cmos5l_a221oi_1_22 \$1316 \$1317 \$1320 \$1310 \$1313 VPWR VGND \$8
+ sg13cmos5l_a221oi_1
* cell instance sg13cmos5l_a221oi_1_23 r0 *1 0,0
Xsg13cmos5l_a221oi_1_23 \$30 \$46 \$518 \$305 \$145 VPWR VGND \$567
+ sg13cmos5l_a221oi_1
* cell instance sg13cmos5l_a221oi_1_24 r0 *1 0,0
Xsg13cmos5l_a221oi_1_24 \$1062 \$1991 \$2039 \$1837 \$1643 VPWR VGND \$2037
+ sg13cmos5l_a221oi_1
* cell instance sg13cmos5l_a221oi_1_25 r0 *1 0,0
Xsg13cmos5l_a221oi_1_25 \$1062 \$2023 \$2039 \$2021 \$2173 VPWR VGND \$2042
+ sg13cmos5l_a221oi_1
* cell instance sg13cmos5l_a221oi_1_26 r0 *1 0,0
Xsg13cmos5l_a221oi_1_26 \$3211 \$3212 \$2889 \$3210 \$3215 VPWR VGND \$2462
+ sg13cmos5l_a221oi_1
* cell instance sg13cmos5l_a221oi_1_27 r0 *1 0,0
Xsg13cmos5l_a221oi_1_27 \$1321 \$1463 \$1669 \$1299 \$1322 VPWR VGND \$301
+ sg13cmos5l_a221oi_1
* cell instance sg13cmos5l_a221oi_1_28 r0 *1 0,0
Xsg13cmos5l_a221oi_1_28 \$254 \$251 \$205 \$249 \$256 VPWR VGND \$204
+ sg13cmos5l_a221oi_1
* cell instance sg13cmos5l_a221oi_1_29 r0 *1 0,0
Xsg13cmos5l_a221oi_1_29 \$740 \$741 \$734 \$155 \$256 VPWR VGND \$673
+ sg13cmos5l_a221oi_1
* cell instance sg13cmos5l_a221oi_1_30 r0 *1 0,0
Xsg13cmos5l_a221oi_1_30 \$159 \$96 \$313 \$524 \$405 VPWR VGND \$525
+ sg13cmos5l_a221oi_1
* cell instance sg13cmos5l_a221oi_1_31 r0 *1 0,0
Xsg13cmos5l_a221oi_1_31 \$304 \$64 \$60 \$33 \$61 VPWR VGND \$43
+ sg13cmos5l_a221oi_1
* cell instance sg13cmos5l_a221oi_1_32 r0 *1 0,0
Xsg13cmos5l_a221oi_1_32 \$155 \$360 \$254 \$15 \$413 VPWR VGND \$344
+ sg13cmos5l_a221oi_1
* cell instance sg13cmos5l_a221oi_1_33 r0 *1 0,0
Xsg13cmos5l_a221oi_1_33 \$16 \$539 \$450 \$451 \$936 VPWR VGND \$528
+ sg13cmos5l_a221oi_1
* cell instance sg13cmos5l_a221oi_1_34 r0 *1 0,0
Xsg13cmos5l_a221oi_1_34 \$65 \$796 \$736 \$634 \$799 VPWR VGND \$803
+ sg13cmos5l_a221oi_1
* cell instance sg13cmos5l_a221oi_1_35 r0 *1 0,0
Xsg13cmos5l_a221oi_1_35 \$528 \$1034 \$970 \$898 \$1085 VPWR VGND \$1086
+ sg13cmos5l_a221oi_1
* cell instance sg13cmos5l_a221oi_1_36 r0 *1 0,0
Xsg13cmos5l_a221oi_1_36 \$155 \$576 \$575 \$160 \$260 VPWR VGND \$517
+ sg13cmos5l_a221oi_1
* cell instance sg13cmos5l_a221oi_1_37 r0 *1 0,0
Xsg13cmos5l_a221oi_1_37 \$450 \$469 \$468 \$155 \$416 VPWR VGND \$314
+ sg13cmos5l_a221oi_1
* cell instance sg13cmos5l_a221oi_1_38 r0 *1 0,0
Xsg13cmos5l_a221oi_1_38 \$155 \$511 \$973 \$981 \$982 VPWR VGND \$976
+ sg13cmos5l_a221oi_1
* cell instance sg13cmos5l_a221oi_1_39 r0 *1 0,0
Xsg13cmos5l_a221oi_1_39 \$1695 \$1874 \$2057 \$2488 \$1870 VPWR VGND \$1871
+ sg13cmos5l_a221oi_1
* cell instance sg13cmos5l_a221oi_1_40 r0 *1 0,0
Xsg13cmos5l_a221oi_1_40 \$171 \$76 \$209 \$167 \$165 VPWR VGND \$168
+ sg13cmos5l_a221oi_1
* cell instance sg13cmos5l_a221oi_1_41 r0 *1 0,0
Xsg13cmos5l_a221oi_1_41 \$861 \$205 \$1093 \$985 \$936 VPWR VGND \$919
+ sg13cmos5l_a221oi_1
* cell instance sg13cmos5l_a221oi_1_42 r0 *1 0,0
Xsg13cmos5l_a221oi_1_42 \$1695 \$1874 \$1897 \$2055 \$2189 VPWR VGND \$1869
+ sg13cmos5l_a221oi_1
* cell instance sg13cmos5l_a221oi_1_43 r0 *1 0,0
Xsg13cmos5l_a221oi_1_43 \$353 \$372 \$419 \$160 \$156 VPWR VGND \$373
+ sg13cmos5l_a221oi_1
* cell instance sg13cmos5l_a221oi_1_44 r0 *1 0,0
Xsg13cmos5l_a221oi_1_44 \$528 \$755 \$754 \$752 \$489 VPWR VGND \$748
+ sg13cmos5l_a221oi_1
* cell instance sg13cmos5l_a221oi_1_45 r0 *1 0,0
Xsg13cmos5l_a221oi_1_45 \$539 \$472 \$104 \$533 \$535 VPWR VGND \$536
+ sg13cmos5l_a221oi_1
* cell instance sg13cmos5l_a221oi_1_46 r0 *1 0,0
Xsg13cmos5l_a221oi_1_46 \$2781 \$2932 \$3229 \$3089 \$2765 VPWR VGND \$1883
+ sg13cmos5l_a221oi_1
* cell instance sg13cmos5l_a221oi_1_47 r0 *1 0,0
Xsg13cmos5l_a221oi_1_47 \$17295 \$3002 \$4376 \$17285 \$3299 VPWR VGND \$3237
+ sg13cmos5l_a221oi_1
* cell instance sg13cmos5l_a221oi_1_48 r0 *1 0,0
Xsg13cmos5l_a221oi_1_48 \$3089 \$3163 \$3091 \$2781 \$3094 VPWR VGND \$2767
+ sg13cmos5l_a221oi_1
* cell instance sg13cmos5l_a221oi_1_49 r0 *1 0,0
Xsg13cmos5l_a221oi_1_49 \$167 \$313 \$299 \$539 \$331 VPWR VGND \$478
+ sg13cmos5l_a221oi_1
* cell instance sg13cmos5l_a221oi_1_50 r0 *1 0,0
Xsg13cmos5l_a221oi_1_50 \$25 \$330 \$232 \$343 \$326 VPWR VGND \$762
+ sg13cmos5l_a221oi_1
* cell instance sg13cmos5l_a221oi_1_51 r0 *1 0,0
Xsg13cmos5l_a221oi_1_51 \$546 \$104 \$545 \$541 \$542 VPWR VGND \$485
+ sg13cmos5l_a221oi_1
* cell instance sg13cmos5l_a221oi_1_52 r0 *1 0,0
Xsg13cmos5l_a221oi_1_52 \$139 \$314 \$373 \$218 \$387 VPWR VGND \$384
+ sg13cmos5l_a221oi_1
* cell instance sg13cmos5l_a221oi_1_53 r0 *1 0,0
Xsg13cmos5l_a221oi_1_53 \$1180 \$2500 \$2651 \$2498 \$2071 VPWR VGND \$2563
+ sg13cmos5l_a221oi_1
* cell instance sg13cmos5l_a221oi_1_54 r0 *1 0,0
Xsg13cmos5l_a221oi_1_54 \$93 \$1213 \$1210 \$2 \$176 VPWR VGND \$1099
+ sg13cmos5l_a221oi_1
* cell instance sg13cmos5l_a221oi_1_55 r0 *1 0,0
Xsg13cmos5l_a221oi_1_55 \$999 \$267 \$425 \$91 \$39 VPWR VGND \$1002
+ sg13cmos5l_a221oi_1
* cell instance sg13cmos5l_a221oi_1_56 r0 *1 0,0
Xsg13cmos5l_a221oi_1_56 \$115 \$248 \$20 \$1 \$110 VPWR VGND \$112
+ sg13cmos5l_a221oi_1
* cell instance sg13cmos5l_a221oi_1_57 r0 *1 0,0
Xsg13cmos5l_a221oi_1_57 \$37 \$6 \$126 \$73 \$39 VPWR VGND \$23
+ sg13cmos5l_a221oi_1
* cell instance sg13cmos5l_a221oi_1_58 r0 *1 0,0
Xsg13cmos5l_a221oi_1_58 \$588 \$545 \$112 \$590 \$589 VPWR VGND \$592
+ sg13cmos5l_a221oi_1
* cell instance sg13cmos5l_a221oi_1_59 r0 *1 0,0
Xsg13cmos5l_a221oi_1_59 \$205 \$935 \$931 \$1008 \$78 VPWR VGND \$982
+ sg13cmos5l_a221oi_1
* cell instance sg13cmos5l_a221oi_1_60 r0 *1 0,0
Xsg13cmos5l_a221oi_1_60 \$99 \$159 \$10 \$7 \$110 VPWR VGND \$141
+ sg13cmos5l_a221oi_1
* cell instance sg13cmos5l_a221oi_1_61 r0 *1 0,0
Xsg13cmos5l_a221oi_1_61 \$329 \$308 \$284 \$591 \$655 VPWR VGND \$654
+ sg13cmos5l_a221oi_1
* cell instance sg13cmos5l_a221oi_1_62 r0 *1 0,0
Xsg13cmos5l_a221oi_1_62 \$3085 \$3006 \$7269 \$3237 \$2789 VPWR VGND \$3238
+ sg13cmos5l_a221oi_1
* cell instance sg13cmos5l_a221oi_1_63 r0 *1 0,0
Xsg13cmos5l_a221oi_1_63 \$230 \$183 \$124 \$228 \$304 VPWR VGND \$226
+ sg13cmos5l_a221oi_1
* cell instance sg13cmos5l_a221oi_1_64 r0 *1 0,0
Xsg13cmos5l_a221oi_1_64 \$2781 \$2426 \$3085 \$2509 \$2507 VPWR VGND \$2565
+ sg13cmos5l_a221oi_1
* cell instance sg13cmos5l_a221oi_1_65 r0 *1 0,0
Xsg13cmos5l_a221oi_1_65 \$115 \$301 \$126 \$238 \$300 VPWR VGND \$228
+ sg13cmos5l_a221oi_1
* cell instance sg13cmos5l_a221oi_1_66 r0 *1 0,0
Xsg13cmos5l_a221oi_1_66 \$556 \$508 \$560 \$205 \$304 VPWR VGND \$557
+ sg13cmos5l_a221oi_1
* cell instance sg13cmos5l_a221oi_1_67 r0 *1 0,0
Xsg13cmos5l_a221oi_1_67 \$660 \$777 \$1011 \$189 \$774 VPWR VGND \$484
+ sg13cmos5l_a221oi_1
* cell instance sg13cmos5l_a221oi_1_68 r0 *1 0,0
Xsg13cmos5l_a221oi_1_68 \$2382 \$1748 \$2219 \$2226 \$2099 VPWR VGND \$2380
+ sg13cmos5l_a221oi_1
* cell instance sg13cmos5l_a22oi_1_0 r0 *1 0,0
Xsg13cmos5l_a22oi_1_0 \$2284 \$2595 \$2437 \$1817 VPWR VGND \$2434
+ sg13cmos5l_a22oi_1
* cell instance sg13cmos5l_a22oi_1_1 r0 *1 0,0
Xsg13cmos5l_a22oi_1_1 \$2439 \$3203 \$3026 \$3028 VPWR VGND \$3151
+ sg13cmos5l_a22oi_1
* cell instance sg13cmos5l_a22oi_1_2 r0 *1 0,0
Xsg13cmos5l_a22oi_1_2 \$6365 \$3448 \$3450 \$9363 VPWR VGND \$5192
+ sg13cmos5l_a22oi_1
* cell instance sg13cmos5l_a22oi_1_3 r0 *1 0,0
Xsg13cmos5l_a22oi_1_3 \$3569 \$3345 \$5122 \$7255 VPWR VGND \$7209
+ sg13cmos5l_a22oi_1
* cell instance sg13cmos5l_a22oi_1_4 r0 *1 0,0
Xsg13cmos5l_a22oi_1_4 \$10172 \$3451 \$5122 \$7014 VPWR VGND \$6972
+ sg13cmos5l_a22oi_1
* cell instance sg13cmos5l_a22oi_1_5 r0 *1 0,0
Xsg13cmos5l_a22oi_1_5 \$9502 \$3451 \$3448 \$7529 VPWR VGND \$7585
+ sg13cmos5l_a22oi_1
* cell instance sg13cmos5l_a22oi_1_6 r0 *1 0,0
Xsg13cmos5l_a22oi_1_6 \$1436 \$2023 \$2156 \$2017 VPWR VGND \$2158
+ sg13cmos5l_a22oi_1
* cell instance sg13cmos5l_a22oi_1_7 r0 *1 0,0
Xsg13cmos5l_a22oi_1_7 \$3899 \$4356 \$5122 \$7262 VPWR VGND \$7211
+ sg13cmos5l_a22oi_1
* cell instance sg13cmos5l_a22oi_1_8 r0 *1 0,0
Xsg13cmos5l_a22oi_1_8 \$2446 \$1969 \$1849 \$2443 VPWR VGND \$2448
+ sg13cmos5l_a22oi_1
* cell instance sg13cmos5l_a22oi_1_9 r0 *1 0,0
Xsg13cmos5l_a22oi_1_9 \$5117 \$3435 \$3451 \$5116 VPWR VGND \$5119
+ sg13cmos5l_a22oi_1
* cell instance sg13cmos5l_a22oi_1_10 r0 *1 0,0
Xsg13cmos5l_a22oi_1_10 \$6562 \$3448 \$3450 \$7332 VPWR VGND \$7446
+ sg13cmos5l_a22oi_1
* cell instance sg13cmos5l_a22oi_1_11 r0 *1 0,0
Xsg13cmos5l_a22oi_1_11 \$7801 \$3451 \$3448 \$7254 VPWR VGND \$7719
+ sg13cmos5l_a22oi_1
* cell instance sg13cmos5l_a22oi_1_12 r0 *1 0,0
Xsg13cmos5l_a22oi_1_12 \$3745 \$4356 \$5122 \$5548 VPWR VGND \$5121
+ sg13cmos5l_a22oi_1
* cell instance sg13cmos5l_a22oi_1_13 r0 *1 0,0
Xsg13cmos5l_a22oi_1_13 \$5622 \$3443 \$3450 \$7584 VPWR VGND \$7554
+ sg13cmos5l_a22oi_1
* cell instance sg13cmos5l_a22oi_1_14 r0 *1 0,0
Xsg13cmos5l_a22oi_1_14 \$5233 \$3443 \$3450 \$10873 VPWR VGND \$7640
+ sg13cmos5l_a22oi_1
* cell instance sg13cmos5l_a22oi_1_15 r0 *1 0,0
Xsg13cmos5l_a22oi_1_15 \$2160 \$1991 \$2306 \$1837 VPWR VGND \$2450
+ sg13cmos5l_a22oi_1
* cell instance sg13cmos5l_a22oi_1_16 r0 *1 0,0
Xsg13cmos5l_a22oi_1_16 \$7888 \$3451 \$3448 \$7651 VPWR VGND \$7656
+ sg13cmos5l_a22oi_1
* cell instance sg13cmos5l_a22oi_1_17 r0 *1 0,0
Xsg13cmos5l_a22oi_1_17 \$5270 \$3443 \$3450 \$11314 VPWR VGND \$7641
+ sg13cmos5l_a22oi_1
* cell instance sg13cmos5l_a22oi_1_18 r0 *1 0,0
Xsg13cmos5l_a22oi_1_18 \$3912 \$4356 \$3450 \$7586 VPWR VGND \$7336
+ sg13cmos5l_a22oi_1
* cell instance sg13cmos5l_a22oi_1_19 r0 *1 0,0
Xsg13cmos5l_a22oi_1_19 \$6697 \$3448 \$5122 \$6572 VPWR VGND \$7218
+ sg13cmos5l_a22oi_1
* cell instance sg13cmos5l_a22oi_1_20 r0 *1 0,0
Xsg13cmos5l_a22oi_1_20 \$612 \$615 \$614 \$152 VPWR VGND \$445
+ sg13cmos5l_a22oi_1
* cell instance sg13cmos5l_a22oi_1_21 r0 *1 0,0
Xsg13cmos5l_a22oi_1_21 \$717 \$668 \$239 \$720 VPWR VGND \$719
+ sg13cmos5l_a22oi_1
* cell instance sg13cmos5l_a22oi_1_22 r0 *1 0,0
Xsg13cmos5l_a22oi_1_22 \$1287 \$1991 \$1646 \$1837 VPWR VGND \$1845
+ sg13cmos5l_a22oi_1
* cell instance sg13cmos5l_a22oi_1_23 r0 *1 0,0
Xsg13cmos5l_a22oi_1_23 \$3605 \$4356 \$5122 \$5308 VPWR VGND \$4358
+ sg13cmos5l_a22oi_1
* cell instance sg13cmos5l_a22oi_1_24 r0 *1 0,0
Xsg13cmos5l_a22oi_1_24 \$2569 \$1969 \$1849 \$1646 VPWR VGND \$1848
+ sg13cmos5l_a22oi_1
* cell instance sg13cmos5l_a22oi_1_25 r0 *1 0,0
Xsg13cmos5l_a22oi_1_25 \$6211 \$3451 \$3448 \$6178 VPWR VGND \$4598
+ sg13cmos5l_a22oi_1
* cell instance sg13cmos5l_a22oi_1_26 r0 *1 0,0
Xsg13cmos5l_a22oi_1_26 \$3751 \$4356 \$5122 \$6713 VPWR VGND \$6977
+ sg13cmos5l_a22oi_1
* cell instance sg13cmos5l_a22oi_1_27 r0 *1 0,0
Xsg13cmos5l_a22oi_1_27 \$4362 \$3451 \$3454 \$3205 VPWR VGND \$4361
+ sg13cmos5l_a22oi_1
* cell instance sg13cmos5l_a22oi_1_28 r0 *1 0,0
Xsg13cmos5l_a22oi_1_28 \$6204 \$5122 \$3450 \$6408 VPWR VGND \$4596
+ sg13cmos5l_a22oi_1
* cell instance sg13cmos5l_a22oi_1_29 r0 *1 0,0
Xsg13cmos5l_a22oi_1_29 \$3914 \$3918 \$3915 \$3743 VPWR VGND \$3917
+ sg13cmos5l_a22oi_1
* cell instance sg13cmos5l_a22oi_1_30 r0 *1 0,0
Xsg13cmos5l_a22oi_1_30 \$47 \$1 \$186 \$457 VPWR VGND \$456 sg13cmos5l_a22oi_1
* cell instance sg13cmos5l_a22oi_1_31 r0 *1 0,0
Xsg13cmos5l_a22oi_1_31 \$1166 \$1991 \$2168 \$2456 VPWR VGND \$2457
+ sg13cmos5l_a22oi_1
* cell instance sg13cmos5l_a22oi_1_32 r0 *1 0,0
Xsg13cmos5l_a22oi_1_32 \$24 \$148 \$49 \$48 VPWR VGND \$194 sg13cmos5l_a22oi_1
* cell instance sg13cmos5l_a22oi_1_33 r0 *1 0,0
Xsg13cmos5l_a22oi_1_33 \$2788 \$1969 \$1849 \$2168 VPWR VGND \$2454
+ sg13cmos5l_a22oi_1
* cell instance sg13cmos5l_a22oi_1_34 r0 *1 0,0
Xsg13cmos5l_a22oi_1_34 \$246 \$267 \$187 \$820 VPWR VGND \$244
+ sg13cmos5l_a22oi_1
* cell instance sg13cmos5l_a22oi_1_35 r0 *1 0,0
Xsg13cmos5l_a22oi_1_35 \$1307 \$1991 \$1853 \$1837 VPWR VGND \$1652
+ sg13cmos5l_a22oi_1
* cell instance sg13cmos5l_a22oi_1_36 r0 *1 0,0
Xsg13cmos5l_a22oi_1_36 \$1320 \$1310 \$1311 \$1312 VPWR VGND \$1075
+ sg13cmos5l_a22oi_1
* cell instance sg13cmos5l_a22oi_1_37 r0 *1 0,0
Xsg13cmos5l_a22oi_1_37 \$439 \$250 \$518 \$305 VPWR VGND \$515
+ sg13cmos5l_a22oi_1
* cell instance sg13cmos5l_a22oi_1_38 r0 *1 0,0
Xsg13cmos5l_a22oi_1_38 \$628 \$838 \$845 \$844 VPWR VGND \$841
+ sg13cmos5l_a22oi_1
* cell instance sg13cmos5l_a22oi_1_39 r0 *1 0,0
Xsg13cmos5l_a22oi_1_39 \$17249 \$3002 \$7558 \$7588 VPWR VGND \$17244
+ sg13cmos5l_a22oi_1
* cell instance sg13cmos5l_a22oi_1_40 r0 *1 0,0
Xsg13cmos5l_a22oi_1_40 \$153 \$439 \$409 \$96 VPWR VGND \$461 sg13cmos5l_a22oi_1
* cell instance sg13cmos5l_a22oi_1_41 r0 *1 0,0
Xsg13cmos5l_a22oi_1_41 \$4374 \$3211 \$4356 \$3938 VPWR VGND \$4156
+ sg13cmos5l_a22oi_1
* cell instance sg13cmos5l_a22oi_1_42 r0 *1 0,0
Xsg13cmos5l_a22oi_1_42 \$1321 \$1463 \$1320 \$1310 VPWR VGND \$611
+ sg13cmos5l_a22oi_1
* cell instance sg13cmos5l_a22oi_1_43 r0 *1 0,0
Xsg13cmos5l_a22oi_1_43 \$2495 \$2123 \$2624 \$2626 VPWR VGND \$2625
+ sg13cmos5l_a22oi_1
* cell instance sg13cmos5l_a22oi_1_44 r0 *1 0,0
Xsg13cmos5l_a22oi_1_44 \$1658 \$1969 \$1849 \$1193 VPWR VGND \$1662
+ sg13cmos5l_a22oi_1
* cell instance sg13cmos5l_a22oi_1_45 r0 *1 0,0
Xsg13cmos5l_a22oi_1_45 \$17250 \$3002 \$4376 \$17251 VPWR VGND \$8926
+ sg13cmos5l_a22oi_1
* cell instance sg13cmos5l_a22oi_1_46 r0 *1 0,0
Xsg13cmos5l_a22oi_1_46 \$4498 \$3119 \$4376 \$17252 VPWR VGND \$7589
+ sg13cmos5l_a22oi_1
* cell instance sg13cmos5l_a22oi_1_47 r0 *1 0,0
Xsg13cmos5l_a22oi_1_47 \$2176 \$1970 \$1849 \$2174 VPWR VGND \$1668
+ sg13cmos5l_a22oi_1
* cell instance sg13cmos5l_a22oi_1_48 r0 *1 0,0
Xsg13cmos5l_a22oi_1_48 \$268 \$632 \$912 \$308 VPWR VGND \$972
+ sg13cmos5l_a22oi_1
* cell instance sg13cmos5l_a22oi_1_49 r0 *1 0,0
Xsg13cmos5l_a22oi_1_49 \$539 \$360 \$912 \$1200 VPWR VGND \$1083
+ sg13cmos5l_a22oi_1
* cell instance sg13cmos5l_a22oi_1_50 r0 *1 0,0
Xsg13cmos5l_a22oi_1_50 \$745 \$439 \$268 \$632 VPWR VGND \$744
+ sg13cmos5l_a22oi_1
* cell instance sg13cmos5l_a22oi_1_51 r0 *1 0,0
Xsg13cmos5l_a22oi_1_51 \$363 \$263 \$361 \$254 VPWR VGND \$365
+ sg13cmos5l_a22oi_1
* cell instance sg13cmos5l_a22oi_1_52 r0 *1 0,0
Xsg13cmos5l_a22oi_1_52 \$7802 \$3002 \$4376 \$17271 VPWR VGND \$4566
+ sg13cmos5l_a22oi_1
* cell instance sg13cmos5l_a22oi_1_53 r0 *1 0,0
Xsg13cmos5l_a22oi_1_53 \$197 \$69 \$518 \$368 VPWR VGND \$367 sg13cmos5l_a22oi_1
* cell instance sg13cmos5l_a22oi_1_54 r0 *1 0,0
Xsg13cmos5l_a22oi_1_54 \$3218 \$4363 \$4376 \$2749 VPWR VGND \$4305
+ sg13cmos5l_a22oi_1
* cell instance sg13cmos5l_a22oi_1_55 r0 *1 0,0
Xsg13cmos5l_a22oi_1_55 \$17272 \$3002 \$4376 \$17265 VPWR VGND \$4622
+ sg13cmos5l_a22oi_1
* cell instance sg13cmos5l_a22oi_1_56 r0 *1 0,0
Xsg13cmos5l_a22oi_1_56 \$167 \$360 \$576 \$279 VPWR VGND \$1327
+ sg13cmos5l_a22oi_1
* cell instance sg13cmos5l_a22oi_1_57 r0 *1 0,0
Xsg13cmos5l_a22oi_1_57 \$155 \$576 \$469 \$539 VPWR VGND \$680
+ sg13cmos5l_a22oi_1
* cell instance sg13cmos5l_a22oi_1_58 r0 *1 0,0
Xsg13cmos5l_a22oi_1_58 \$2488 \$3083 \$3081 \$3082 VPWR VGND \$3079
+ sg13cmos5l_a22oi_1
* cell instance sg13cmos5l_a22oi_1_59 r0 *1 0,0
Xsg13cmos5l_a22oi_1_59 \$918 \$978 \$911 \$916 VPWR VGND \$984
+ sg13cmos5l_a22oi_1
* cell instance sg13cmos5l_a22oi_1_60 r0 *1 0,0
Xsg13cmos5l_a22oi_1_60 \$17280 \$3002 \$7337 \$7588 VPWR VGND \$17281
+ sg13cmos5l_a22oi_1
* cell instance sg13cmos5l_a22oi_1_61 r0 *1 0,0
Xsg13cmos5l_a22oi_1_61 \$735 \$676 \$1093 \$806 VPWR VGND \$1095
+ sg13cmos5l_a22oi_1
* cell instance sg13cmos5l_a22oi_1_62 r0 *1 0,0
Xsg13cmos5l_a22oi_1_62 \$97 \$580 \$86 \$268 VPWR VGND \$715 sg13cmos5l_a22oi_1
* cell instance sg13cmos5l_a22oi_1_63 r0 *1 0,0
Xsg13cmos5l_a22oi_1_63 \$3085 \$3099 \$3158 \$3084 VPWR VGND \$2929
+ sg13cmos5l_a22oi_1
* cell instance sg13cmos5l_a22oi_1_64 r0 *1 0,0
Xsg13cmos5l_a22oi_1_64 \$269 \$203 \$272 \$85 VPWR VGND \$36 sg13cmos5l_a22oi_1
* cell instance sg13cmos5l_a22oi_1_65 r0 *1 0,0
Xsg13cmos5l_a22oi_1_65 \$1096 \$528 \$920 \$1099 VPWR VGND \$1098
+ sg13cmos5l_a22oi_1
* cell instance sg13cmos5l_a22oi_1_66 r0 *1 0,0
Xsg13cmos5l_a22oi_1_66 \$276 \$281 \$278 \$205 VPWR VGND \$64 sg13cmos5l_a22oi_1
* cell instance sg13cmos5l_a22oi_1_67 r0 *1 0,0
Xsg13cmos5l_a22oi_1_67 \$167 \$378 \$377 \$261 VPWR VGND \$262
+ sg13cmos5l_a22oi_1
* cell instance sg13cmos5l_a22oi_1_68 r0 *1 0,0
Xsg13cmos5l_a22oi_1_68 \$259 \$540 \$581 \$91 VPWR VGND \$583 sg13cmos5l_a22oi_1
* cell instance sg13cmos5l_a22oi_1_69 r0 *1 0,0
Xsg13cmos5l_a22oi_1_69 \$807 \$757 \$810 \$803 VPWR VGND \$809
+ sg13cmos5l_a22oi_1
* cell instance sg13cmos5l_a22oi_1_70 r0 *1 0,0
Xsg13cmos5l_a22oi_1_70 \$3085 \$3502 \$3556 \$3084 VPWR VGND \$3367
+ sg13cmos5l_a22oi_1
* cell instance sg13cmos5l_a22oi_1_71 r0 *1 0,0
Xsg13cmos5l_a22oi_1_71 \$2619 \$2493 \$1929 \$2202 VPWR VGND \$2645
+ sg13cmos5l_a22oi_1
* cell instance sg13cmos5l_a22oi_1_72 r0 *1 0,0
Xsg13cmos5l_a22oi_1_72 \$100 \$167 \$70 \$695 VPWR VGND \$694 sg13cmos5l_a22oi_1
* cell instance sg13cmos5l_a22oi_1_73 r0 *1 0,0
Xsg13cmos5l_a22oi_1_73 \$2647 \$2501 \$2493 \$2717 VPWR VGND \$2772
+ sg13cmos5l_a22oi_1
* cell instance sg13cmos5l_a22oi_1_74 r0 *1 0,0
Xsg13cmos5l_a22oi_1_74 \$377 \$587 \$482 \$259 VPWR VGND \$586
+ sg13cmos5l_a22oi_1
* cell instance sg13cmos5l_a22oi_1_75 r0 *1 0,0
Xsg13cmos5l_a22oi_1_75 \$20 \$1 \$103 \$96 VPWR VGND \$26 sg13cmos5l_a22oi_1
* cell instance sg13cmos5l_a22oi_1_76 r0 *1 0,0
Xsg13cmos5l_a22oi_1_76 \$2935 \$3505 \$3231 \$2354 VPWR VGND \$3096
+ sg13cmos5l_a22oi_1
* cell instance sg13cmos5l_a22oi_1_77 r0 *1 0,0
Xsg13cmos5l_a22oi_1_77 \$91 \$210 \$267 \$999 VPWR VGND \$997 sg13cmos5l_a22oi_1
* cell instance sg13cmos5l_a22oi_1_78 r0 *1 0,0
Xsg13cmos5l_a22oi_1_78 \$2935 \$2776 \$2774 \$2354 VPWR VGND \$2778
+ sg13cmos5l_a22oi_1
* cell instance sg13cmos5l_a22oi_1_79 r0 *1 0,0
Xsg13cmos5l_a22oi_1_79 \$93 \$220 \$216 \$219 VPWR VGND \$218 sg13cmos5l_a22oi_1
* cell instance sg13cmos5l_a22oi_1_80 r0 *1 0,0
Xsg13cmos5l_a22oi_1_80 \$2935 \$3103 \$3233 \$2354 VPWR VGND \$2783
+ sg13cmos5l_a22oi_1
* cell instance sg13cmos5l_a22oi_1_81 r0 *1 0,0
Xsg13cmos5l_a22oi_1_81 \$2619 \$2501 \$2785 \$2345 VPWR VGND \$2854
+ sg13cmos5l_a22oi_1
* cell instance sg13cmos5l_a22oi_1_82 r0 *1 0,0
Xsg13cmos5l_a22oi_1_82 \$2935 \$3235 \$3234 \$2354 VPWR VGND \$3106
+ sg13cmos5l_a22oi_1
* cell instance sg13cmos5l_a22oi_1_83 r0 *1 0,0
Xsg13cmos5l_a22oi_1_83 \$2202 \$2352 \$2501 \$2351 VPWR VGND \$2350
+ sg13cmos5l_a22oi_1
* cell instance sg13cmos5l_a22oi_1_84 r0 *1 0,0
Xsg13cmos5l_a22oi_1_84 \$2788 \$2493 \$2669 \$2345 VPWR VGND \$2787
+ sg13cmos5l_a22oi_1
* cell instance sg13cmos5l_a22oi_1_85 r0 *1 0,0
Xsg13cmos5l_a22oi_1_85 \$2795 \$2501 \$2493 \$2502 VPWR VGND \$2504
+ sg13cmos5l_a22oi_1
* cell instance sg13cmos5l_a22oi_1_86 r0 *1 0,0
Xsg13cmos5l_a22oi_1_86 \$1008 \$1112 \$972 \$861 VPWR VGND \$1111
+ sg13cmos5l_a22oi_1
* cell instance sg13cmos5l_a22oi_1_87 r0 *1 0,0
Xsg13cmos5l_a22oi_1_87 \$497 \$550 \$392 \$597 VPWR VGND \$549
+ sg13cmos5l_a22oi_1
* cell instance sg13cmos5l_a22oi_1_88 r0 *1 0,0
Xsg13cmos5l_a22oi_1_88 \$498 \$86 \$261 \$518 VPWR VGND \$496 sg13cmos5l_a22oi_1
* cell instance sg13cmos5l_a22oi_1_89 r0 *1 0,0
Xsg13cmos5l_a22oi_1_89 \$2788 \$2501 \$2659 \$2202 VPWR VGND \$2658
+ sg13cmos5l_a22oi_1
* cell instance sg13cmos5l_a22oi_1_90 r0 *1 0,0
Xsg13cmos5l_a22oi_1_90 \$2569 \$2501 \$2942 \$2202 VPWR VGND \$2943
+ sg13cmos5l_a22oi_1
* cell instance sg13cmos5l_a22oi_1_91 r0 *1 0,0
Xsg13cmos5l_a22oi_1_91 \$2935 \$2797 \$2792 \$2354 VPWR VGND \$2790
+ sg13cmos5l_a22oi_1
* cell instance sg13cmos5l_a22oi_1_92 r0 *1 0,0
Xsg13cmos5l_a22oi_1_92 \$90 \$97 \$302 \$396 VPWR VGND \$339 sg13cmos5l_a22oi_1
* cell instance sg13cmos5l_a22oi_1_93 r0 *1 0,0
Xsg13cmos5l_a22oi_1_93 \$580 \$820 \$396 \$329 VPWR VGND \$501
+ sg13cmos5l_a22oi_1
* cell instance sg13cmos5l_a22oi_1_94 r0 *1 0,0
Xsg13cmos5l_a22oi_1_94 \$498 \$86 \$345 \$608 VPWR VGND \$605 sg13cmos5l_a22oi_1
* cell instance sg13cmos5l_a22oi_1_95 r0 *1 0,0
Xsg13cmos5l_a22oi_1_95 \$100 \$126 \$399 \$409 VPWR VGND \$404
+ sg13cmos5l_a22oi_1
* cell instance sg13cmos5l_a22oi_1_96 r0 *1 0,0
Xsg13cmos5l_a22oi_1_96 \$918 \$826 \$823 \$773 VPWR VGND \$825
+ sg13cmos5l_a22oi_1
* cell instance sg13cmos5l_a22oi_1_97 r0 *1 0,0
Xsg13cmos5l_a22oi_1_97 \$2091 \$2090 \$2083 \$1992 VPWR VGND \$2092
+ sg13cmos5l_a22oi_1
* cell instance sg13cmos5l_a22oi_1_98 r0 *1 0,0
Xsg13cmos5l_a22oi_1_98 \$2093 \$2090 \$2213 \$1992 VPWR VGND \$2215
+ sg13cmos5l_a22oi_1
* cell instance sg13cmos5l_a22oi_1_99 r0 *1 0,0
Xsg13cmos5l_a22oi_1_99 \$3246 \$3119 \$3120 \$3247 VPWR VGND \$3098
+ sg13cmos5l_a22oi_1
* cell instance sg13cmos5l_a22oi_1_100 r0 *1 0,0
Xsg13cmos5l_a22oi_1_100 \$3248 \$3292 \$3214 \$2965 VPWR VGND \$3247
+ sg13cmos5l_a22oi_1
* cell instance sg13cmos5l_a22oi_1_101 r0 *1 0,0
Xsg13cmos5l_a22oi_1_101 \$2961 \$1538 \$2096 \$3248 VPWR VGND \$2962
+ sg13cmos5l_a22oi_1
* cell instance sg13cmos5l_a22oi_1_102 r0 *1 0,0
Xsg13cmos5l_a22oi_1_102 \$2673 \$2099 \$2384 \$2380 VPWR VGND \$2569
+ sg13cmos5l_a22oi_1
* cell instance sg13cmos5l_a22oi_1_103 r0 *1 0,0
Xsg13cmos5l_a22oi_1_103 \$1139 \$2106 \$2096 \$1583 VPWR VGND \$2105
+ sg13cmos5l_a22oi_1
* cell instance sg13cmos5l_a22oi_1_104 r0 *1 0,0
Xsg13cmos5l_a22oi_1_104 \$2819 \$2096 \$2219 \$2817 VPWR VGND \$2818
+ sg13cmos5l_a22oi_1
* cell instance sg13cmos5l_a22oi_1_105 r0 *1 0,0
Xsg13cmos5l_a22oi_1_105 \$1774 \$2099 \$1940 \$1942 VPWR VGND \$1814
+ sg13cmos5l_a22oi_1
* cell instance sg13cmos5l_a22oi_1_106 r0 *1 0,0
Xsg13cmos5l_a22oi_1_106 \$1271 \$2106 \$2219 \$1592 VPWR VGND \$1942
+ sg13cmos5l_a22oi_1
* cell instance sg13cmos5l_and2_1_0 r0 *1 0,0
Xsg13cmos5l_and2_1_0 \$6066 \$5238 VPWR VGND \$5865 sg13cmos5l_and2_1
* cell instance sg13cmos5l_and2_1_1 r0 *1 0,0
Xsg13cmos5l_and2_1_1 \$6068 \$5238 VPWR VGND \$5907 sg13cmos5l_and2_1
* cell instance sg13cmos5l_and2_1_2 r0 *1 0,0
Xsg13cmos5l_and2_1_2 \$2153 \$2733 VPWR VGND \$2456 sg13cmos5l_and2_1
* cell instance sg13cmos5l_and2_1_3 r0 *1 0,0
Xsg13cmos5l_and2_1_3 \$1967 \$1841 VPWR VGND \$1838 sg13cmos5l_and2_1
* cell instance sg13cmos5l_and2_1_4 r0 *1 0,0
Xsg13cmos5l_and2_1_4 \$2880 \$2881 VPWR VGND \$1300 sg13cmos5l_and2_1
* cell instance sg13cmos5l_and2_1_5 r0 *1 0,0
Xsg13cmos5l_and2_1_5 \$2151 \$2156 VPWR VGND \$2163 sg13cmos5l_and2_1
* cell instance sg13cmos5l_and2_1_6 r0 *1 0,0
Xsg13cmos5l_and2_1_6 \$3931 \$4356 VPWR VGND \$4786 sg13cmos5l_and2_1
* cell instance sg13cmos5l_and2_1_7 r0 *1 0,0
Xsg13cmos5l_and2_1_7 \$1851 \$1654 VPWR VGND \$1853 sg13cmos5l_and2_1
* cell instance sg13cmos5l_and2_1_8 r0 *1 0,0
Xsg13cmos5l_and2_1_8 \$47 \$3 VPWR VGND \$511 sg13cmos5l_and2_1
* cell instance sg13cmos5l_and2_1_9 r0 *1 0,0
Xsg13cmos5l_and2_1_9 \$30 \$46 VPWR VGND \$75 sg13cmos5l_and2_1
* cell instance sg13cmos5l_and2_1_10 r0 *1 0,0
Xsg13cmos5l_and2_1_10 \$674 \$1199 VPWR VGND \$1197 sg13cmos5l_and2_1
* cell instance sg13cmos5l_and2_1_11 r0 *1 0,0
Xsg13cmos5l_and2_1_11 \$33 \$15 VPWR VGND \$18 sg13cmos5l_and2_1
* cell instance sg13cmos5l_and2_1_12 r0 *1 0,0
Xsg13cmos5l_and2_1_12 \$2849 \$3215 VPWR VGND \$1724 sg13cmos5l_and2_1
* cell instance sg13cmos5l_and2_1_13 r0 *1 0,0
Xsg13cmos5l_and2_1_13 \$302 \$396 VPWR VGND \$468 sg13cmos5l_and2_1
* cell instance sg13cmos5l_and2_1_14 r0 *1 0,0
Xsg13cmos5l_and2_1_14 \$2648 \$2774 VPWR VGND \$3099 sg13cmos5l_and2_1
* cell instance sg13cmos5l_and2_1_15 r0 *1 0,0
Xsg13cmos5l_and2_1_15 \$97 \$103 VPWR VGND \$95 sg13cmos5l_and2_1
* cell instance sg13cmos5l_and2_1_16 r0 *1 0,0
Xsg13cmos5l_and2_1_16 \$2619 \$3098 VPWR VGND \$3505 sg13cmos5l_and2_1
* cell instance sg13cmos5l_and2_1_17 r0 *1 0,0
Xsg13cmos5l_and2_1_17 \$37 \$1 VPWR VGND \$688 sg13cmos5l_and2_1
* cell instance sg13cmos5l_and2_1_18 r0 *1 0,0
Xsg13cmos5l_and2_1_18 \$2569 \$2669 VPWR VGND \$3235 sg13cmos5l_and2_1
* cell instance sg13cmos5l_and2_1_19 r0 *1 0,0
Xsg13cmos5l_and2_1_19 \$2788 \$2942 VPWR VGND \$3108 sg13cmos5l_and2_1
* cell instance sg13cmos5l_and2_1_20 r0 *1 0,0
Xsg13cmos5l_and2_1_20 \$591 \$248 VPWR VGND \$1116 sg13cmos5l_and2_1
* cell instance sg13cmos5l_and2_1_21 r0 *1 0,0
Xsg13cmos5l_and2_1_21 \$820 \$299 VPWR VGND \$608 sg13cmos5l_and2_1
* cell instance sg13cmos5l_and2_1_22 r0 *1 0,0
Xsg13cmos5l_and2_1_22 \$2795 \$2659 VPWR VGND \$2797 sg13cmos5l_and2_1
* cell instance sg13cmos5l_and2_1_23 r0 *1 0,0
Xsg13cmos5l_and2_1_23 \$403 \$436 VPWR VGND \$777 sg13cmos5l_and2_1
* cell instance sg13cmos5l_and2_1_24 r0 *1 0,0
Xsg13cmos5l_and2_1_24 \$899 \$2942 VPWR VGND \$3524 sg13cmos5l_and2_1
* cell instance sg13cmos5l_and2_1_25 r0 *1 0,0
Xsg13cmos5l_and2_1_25 \$3834 \$3529 VPWR VGND \$3832 sg13cmos5l_and2_1
* cell instance sg13cmos5l_and2_1_26 r0 *1 0,0
Xsg13cmos5l_and2_1_26 \$1920 \$1811 VPWR VGND \$3214 sg13cmos5l_and2_1
* cell instance sg13cmos5l_and2_1_27 r0 *1 0,0
Xsg13cmos5l_and2_1_27 \$3380 \$2963 VPWR VGND \$2619 sg13cmos5l_and2_1
* cell instance sg13cmos5l_and2_1_28 r0 *1 0,0
Xsg13cmos5l_and2_1_28 \$3382 \$3383 VPWR VGND \$2788 sg13cmos5l_and2_1
* cell instance sg13cmos5l_and2_1_29 r0 *1 0,0
Xsg13cmos5l_and2_1_29 \$4051 \$4498 VPWR VGND \$4515 sg13cmos5l_and2_1
* cell instance sg13cmos5l_and2_1_30 r0 *1 0,0
Xsg13cmos5l_and2_1_30 \$4512 \$4515 VPWR VGND \$4521 sg13cmos5l_and2_1
* cell instance sg13cmos5l_and2_1_31 r0 *1 0,0
Xsg13cmos5l_and2_1_31 \$4281 \$4069 VPWR VGND \$4523 sg13cmos5l_and2_1
* cell instance sg13cmos5l_and2_1_32 r0 *1 0,0
Xsg13cmos5l_and2_1_32 \$4530 \$4529 VPWR VGND \$4527 sg13cmos5l_and2_1
* cell instance sg13cmos5l_and3_1_0 r0 *1 0,0
Xsg13cmos5l_and3_1_0 \$2161 \$3192 \$3193 VPWR VGND \$3442 sg13cmos5l_and3_1
* cell instance sg13cmos5l_and3_1_1 r0 *1 0,0
Xsg13cmos5l_and3_1_1 \$3605 \$3931 \$3752 VPWR VGND \$3913 sg13cmos5l_and3_1
* cell instance sg13cmos5l_and3_1_2 r0 *1 0,0
Xsg13cmos5l_and3_1_2 \$1643 \$2329 \$2123 VPWR VGND \$2623 sg13cmos5l_and3_1
* cell instance sg13cmos5l_and3_1_3 r0 *1 0,0
Xsg13cmos5l_and3_1_3 \$522 \$160 \$863 VPWR VGND \$796 sg13cmos5l_and3_1
* cell instance sg13cmos5l_and3_1_4 r0 *1 0,0
Xsg13cmos5l_and3_1_4 \$171 \$329 \$396 VPWR VGND \$535 sg13cmos5l_and3_1
* cell instance sg13cmos5l_and3_1_5 r0 *1 0,0
Xsg13cmos5l_and3_1_5 \$42 \$154 \$539 VPWR VGND \$380 sg13cmos5l_and3_1
* cell instance sg13cmos5l_and3_1_6 r0 *1 0,0
Xsg13cmos5l_and3_1_6 \$4059 \$4523 \$4521 VPWR VGND \$3694 sg13cmos5l_and3_1
* cell instance sg13cmos5l_and4_1_0 r0 *1 0,0
Xsg13cmos5l_and4_1_0 \$2849 \$2908 \$3598 \$3474 VPWR VGND \$3471
+ sg13cmos5l_and4_1
* cell instance sg13cmos5l_and4_1_1 r0 *1 0,0
Xsg13cmos5l_and4_1_1 \$2354 \$3371 \$3370 \$3232 VPWR VGND \$3227
+ sg13cmos5l_and4_1
* cell instance sg13cmos5l_and4_1_2 r0 *1 0,0
Xsg13cmos5l_and4_1_2 \$2423 \$2511 \$3241 \$3375 VPWR VGND \$3370
+ sg13cmos5l_and4_1
* cell instance sg13cmos5l_and4_1_3 r0 *1 0,0
Xsg13cmos5l_and4_1_3 \$4525 \$3709 \$4522 \$4515 VPWR VGND \$4279
+ sg13cmos5l_and4_1
* cell instance sg13cmos5l_antennanp_0 r0 *1 0,0
Xsg13cmos5l_antennanp_0 \$5130 VPWR VGND sg13cmos5l_antennanp
* cell instance sg13cmos5l_buf_1_0 r0 *1 0,0
Xsg13cmos5l_buf_1_0 \$5587 VPWR VGND \$7251 sg13cmos5l_buf_1
* cell instance sg13cmos5l_buf_1_1 r0 *1 0,0
Xsg13cmos5l_buf_1_1 \$6233 VPWR VGND \$7576 sg13cmos5l_buf_1
* cell instance sg13cmos5l_buf_1_2 r0 *1 0,0
Xsg13cmos5l_buf_1_2 \$2153 VPWR VGND \$2604 sg13cmos5l_buf_1
* cell instance sg13cmos5l_buf_1_3 r0 *1 0,0
Xsg13cmos5l_buf_1_3 \$3886 VPWR VGND \$3883 sg13cmos5l_buf_1
* cell instance sg13cmos5l_buf_1_4 r0 *1 0,0
Xsg13cmos5l_buf_1_4 \$5861 VPWR VGND \$6233 sg13cmos5l_buf_1
* cell instance sg13cmos5l_buf_1_5 r0 *1 0,0
Xsg13cmos5l_buf_1_5 \$5587 VPWR VGND \$5238 sg13cmos5l_buf_1
* cell instance sg13cmos5l_buf_1_6 r0 *1 0,0
Xsg13cmos5l_buf_1_6 \$14111 VPWR VGND \$11737 sg13cmos5l_buf_1
* cell instance sg13cmos5l_buf_1_7 r0 *1 0,0
Xsg13cmos5l_buf_1_7 \$2604 VPWR VGND \$1833 sg13cmos5l_buf_1
* cell instance sg13cmos5l_buf_1_8 r0 *1 0,0
Xsg13cmos5l_buf_1_8 \$4438 VPWR VGND \$4318 sg13cmos5l_buf_1
* cell instance sg13cmos5l_buf_1_9 r0 *1 0,0
Xsg13cmos5l_buf_1_9 \$9367 VPWR VGND \$11312 sg13cmos5l_buf_1
* cell instance sg13cmos5l_buf_1_10 r0 *1 0,0
Xsg13cmos5l_buf_1_10 \$2865 VPWR VGND \$1817 sg13cmos5l_buf_1
* cell instance sg13cmos5l_buf_1_11 r0 *1 0,0
Xsg13cmos5l_buf_1_11 \$3314 VPWR VGND \$4323 sg13cmos5l_buf_1
* cell instance sg13cmos5l_buf_1_12 r0 *1 0,0
Xsg13cmos5l_buf_1_12 \$4567 VPWR VGND \$3886 sg13cmos5l_buf_1
* cell instance sg13cmos5l_buf_1_13 r0 *1 0,0
Xsg13cmos5l_buf_1_13 \$1179 VPWR VGND \$2135 sg13cmos5l_buf_1
* cell instance sg13cmos5l_buf_1_14 r0 *1 0,0
Xsg13cmos5l_buf_1_14 \$2606 VPWR VGND \$2439 sg13cmos5l_buf_1
* cell instance sg13cmos5l_buf_1_15 r0 *1 0,0
Xsg13cmos5l_buf_1_15 \$2456 VPWR VGND \$1837 sg13cmos5l_buf_1
* cell instance sg13cmos5l_buf_1_16 r0 *1 0,0
Xsg13cmos5l_buf_1_16 \$4592 VPWR VGND \$5905 sg13cmos5l_buf_1
* cell instance sg13cmos5l_buf_1_17 r0 *1 0,0
Xsg13cmos5l_buf_1_17 \$3587 VPWR VGND \$3314 sg13cmos5l_buf_1
* cell instance sg13cmos5l_buf_1_18 r0 *1 0,0
Xsg13cmos5l_buf_1_18 \$11312 VPWR VGND \$10278 sg13cmos5l_buf_1
* cell instance sg13cmos5l_buf_1_19 r0 *1 0,0
Xsg13cmos5l_buf_1_19 \$3442 VPWR VGND \$3443 sg13cmos5l_buf_1
* cell instance sg13cmos5l_buf_1_20 r0 *1 0,0
Xsg13cmos5l_buf_1_20 \$3039 VPWR VGND \$1650 sg13cmos5l_buf_1
* cell instance sg13cmos5l_buf_1_21 r0 *1 0,0
Xsg13cmos5l_buf_1_21 \$1650 VPWR VGND \$2153 sg13cmos5l_buf_1
* cell instance sg13cmos5l_buf_1_22 r0 *1 0,0
Xsg13cmos5l_buf_1_22 \$3338 VPWR VGND \$3339 sg13cmos5l_buf_1
* cell instance sg13cmos5l_buf_1_23 r0 *1 0,0
Xsg13cmos5l_buf_1_23 \$4593 VPWR VGND \$5587 sg13cmos5l_buf_1
* cell instance sg13cmos5l_buf_1_24 r0 *1 0,0
Xsg13cmos5l_buf_1_24 \$3346 VPWR VGND \$13940 sg13cmos5l_buf_1
* cell instance sg13cmos5l_buf_1_25 r0 *1 0,0
Xsg13cmos5l_buf_1_25 \$3443 VPWR VGND \$3435 sg13cmos5l_buf_1
* cell instance sg13cmos5l_buf_1_26 r0 *1 0,0
Xsg13cmos5l_buf_1_26 \$918 VPWR VGND \$665 sg13cmos5l_buf_1
* cell instance sg13cmos5l_buf_1_27 r0 *1 0,0
Xsg13cmos5l_buf_1_27 \$9367 VPWR VGND \$5861 sg13cmos5l_buf_1
* cell instance sg13cmos5l_buf_1_28 r0 *1 0,0
Xsg13cmos5l_buf_1_28 \$7725 VPWR VGND \$8320 sg13cmos5l_buf_1
* cell instance sg13cmos5l_buf_1_29 r0 *1 0,0
Xsg13cmos5l_buf_1_29 \$2611 VPWR VGND \$918 sg13cmos5l_buf_1
* cell instance sg13cmos5l_buf_1_30 r0 *1 0,0
Xsg13cmos5l_buf_1_30 \$1316 VPWR VGND \$1299 sg13cmos5l_buf_1
* cell instance sg13cmos5l_buf_1_31 r0 *1 0,0
Xsg13cmos5l_buf_1_31 \$7725 VPWR VGND \$8922 sg13cmos5l_buf_1
* cell instance sg13cmos5l_buf_1_32 r0 *1 0,0
Xsg13cmos5l_buf_1_32 \$7722 VPWR VGND \$9804 sg13cmos5l_buf_1
* cell instance sg13cmos5l_buf_1_33 r0 *1 0,0
Xsg13cmos5l_buf_1_33 \$3195 VPWR VGND \$2880 sg13cmos5l_buf_1
* cell instance sg13cmos5l_buf_1_34 r0 *1 0,0
Xsg13cmos5l_buf_1_34 \$7722 VPWR VGND \$11895 sg13cmos5l_buf_1
* cell instance sg13cmos5l_buf_1_35 r0 *1 0,0
Xsg13cmos5l_buf_1_35 \$2 VPWR VGND \$144 sg13cmos5l_buf_1
* cell instance sg13cmos5l_buf_1_36 r0 *1 0,0
Xsg13cmos5l_buf_1_36 \$9367 VPWR VGND \$10031 sg13cmos5l_buf_1
* cell instance sg13cmos5l_buf_1_37 r0 *1 0,0
Xsg13cmos5l_buf_1_37 \$784 VPWR VGND \$172 sg13cmos5l_buf_1
* cell instance sg13cmos5l_buf_1_38 r0 *1 0,0
Xsg13cmos5l_buf_1_38 \$4142 VPWR VGND \$4592 sg13cmos5l_buf_1
* cell instance sg13cmos5l_buf_1_39 r0 *1 0,0
Xsg13cmos5l_buf_1_39 \$898 VPWR VGND \$65 sg13cmos5l_buf_1
* cell instance sg13cmos5l_buf_1_40 r0 *1 0,0
Xsg13cmos5l_buf_1_40 \$901 VPWR VGND \$898 sg13cmos5l_buf_1
* cell instance sg13cmos5l_buf_1_41 r0 *1 0,0
Xsg13cmos5l_buf_1_41 \$830 VPWR VGND \$189 sg13cmos5l_buf_1
* cell instance sg13cmos5l_buf_1_42 r0 *1 0,0
Xsg13cmos5l_buf_1_42 \$65 VPWR VGND \$240 sg13cmos5l_buf_1
* cell instance sg13cmos5l_buf_1_43 r0 *1 0,0
Xsg13cmos5l_buf_1_43 \$7802 VPWR VGND \$6432 sg13cmos5l_buf_1
* cell instance sg13cmos5l_buf_1_44 r0 *1 0,0
Xsg13cmos5l_buf_1_44 \$9367 VPWR VGND \$15863 sg13cmos5l_buf_1
* cell instance sg13cmos5l_buf_1_45 r0 *1 0,0
Xsg13cmos5l_buf_1_45 \$786 VPWR VGND \$936 sg13cmos5l_buf_1
* cell instance sg13cmos5l_buf_1_46 r0 *1 0,0
Xsg13cmos5l_buf_1_46 \$3346 VPWR VGND \$10283 sg13cmos5l_buf_1
* cell instance sg13cmos5l_buf_1_47 r0 *1 0,0
Xsg13cmos5l_buf_1_47 \$3064 VPWR VGND \$14111 sg13cmos5l_buf_1
* cell instance sg13cmos5l_buf_1_48 r0 *1 0,0
Xsg13cmos5l_buf_1_48 \$4605 VPWR VGND \$9367 sg13cmos5l_buf_1
* cell instance sg13cmos5l_buf_1_49 r0 *1 0,0
Xsg13cmos5l_buf_1_49 \$189 VPWR VGND \$785 sg13cmos5l_buf_1
* cell instance sg13cmos5l_buf_1_50 r0 *1 0,0
Xsg13cmos5l_buf_1_50 \$2748 VPWR VGND \$1447 sg13cmos5l_buf_1
* cell instance sg13cmos5l_buf_1_51 r0 *1 0,0
Xsg13cmos5l_buf_1_51 \$172 VPWR VGND \$145 sg13cmos5l_buf_1
* cell instance sg13cmos5l_buf_1_52 r0 *1 0,0
Xsg13cmos5l_buf_1_52 \$153 VPWR VGND \$54 sg13cmos5l_buf_1
* cell instance sg13cmos5l_buf_1_53 r0 *1 0,0
Xsg13cmos5l_buf_1_53 \$304 VPWR VGND \$128 sg13cmos5l_buf_1
* cell instance sg13cmos5l_buf_1_54 r0 *1 0,0
Xsg13cmos5l_buf_1_54 \$1179 VPWR VGND \$3587 sg13cmos5l_buf_1
* cell instance sg13cmos5l_buf_1_55 r0 *1 0,0
Xsg13cmos5l_buf_1_55 \$143 VPWR VGND \$304 sg13cmos5l_buf_1
* cell instance sg13cmos5l_buf_1_56 r0 *1 0,0
Xsg13cmos5l_buf_1_56 \$453 VPWR VGND \$50 sg13cmos5l_buf_1
* cell instance sg13cmos5l_buf_1_57 r0 *1 0,0
Xsg13cmos5l_buf_1_57 \$1659 VPWR VGND \$7588 sg13cmos5l_buf_1
* cell instance sg13cmos5l_buf_1_58 r0 *1 0,0
Xsg13cmos5l_buf_1_58 \$666 VPWR VGND \$669 sg13cmos5l_buf_1
* cell instance sg13cmos5l_buf_1_59 r0 *1 0,0
Xsg13cmos5l_buf_1_59 \$1179 VPWR VGND \$949 sg13cmos5l_buf_1
* cell instance sg13cmos5l_buf_1_60 r0 *1 0,0
Xsg13cmos5l_buf_1_60 \$836 VPWR VGND \$279 sg13cmos5l_buf_1
* cell instance sg13cmos5l_buf_1_61 r0 *1 0,0
Xsg13cmos5l_buf_1_61 \$279 VPWR VGND \$130 sg13cmos5l_buf_1
* cell instance sg13cmos5l_buf_1_62 r0 *1 0,0
Xsg13cmos5l_buf_1_62 \$147 VPWR VGND \$148 sg13cmos5l_buf_1
* cell instance sg13cmos5l_buf_1_63 r0 *1 0,0
Xsg13cmos5l_buf_1_63 \$147 VPWR VGND \$621 sg13cmos5l_buf_1
* cell instance sg13cmos5l_buf_1_64 r0 *1 0,0
Xsg13cmos5l_buf_1_64 \$3459 VPWR VGND \$1179 sg13cmos5l_buf_1
* cell instance sg13cmos5l_buf_1_65 r0 *1 0,0
Xsg13cmos5l_buf_1_65 \$6 VPWR VGND \$1 sg13cmos5l_buf_1
* cell instance sg13cmos5l_buf_1_66 r0 *1 0,0
Xsg13cmos5l_buf_1_66 \$3345 VPWR VGND \$4356 sg13cmos5l_buf_1
* cell instance sg13cmos5l_buf_1_67 r0 *1 0,0
Xsg13cmos5l_buf_1_67 \$29 VPWR VGND \$147 sg13cmos5l_buf_1
* cell instance sg13cmos5l_buf_1_68 r0 *1 0,0
Xsg13cmos5l_buf_1_68 \$151 VPWR VGND \$30 sg13cmos5l_buf_1
* cell instance sg13cmos5l_buf_1_69 r0 *1 0,0
Xsg13cmos5l_buf_1_69 \$3058 VPWR VGND \$2319 sg13cmos5l_buf_1
* cell instance sg13cmos5l_buf_1_70 r0 *1 0,0
Xsg13cmos5l_buf_1_70 \$10 VPWR VGND \$457 sg13cmos5l_buf_1
* cell instance sg13cmos5l_buf_1_71 r0 *1 0,0
Xsg13cmos5l_buf_1_71 \$45 VPWR VGND \$197 sg13cmos5l_buf_1
* cell instance sg13cmos5l_buf_1_72 r0 *1 0,0
Xsg13cmos5l_buf_1_72 \$745 VPWR VGND \$153 sg13cmos5l_buf_1
* cell instance sg13cmos5l_buf_1_73 r0 *1 0,0
Xsg13cmos5l_buf_1_73 \$30 VPWR VGND \$49 sg13cmos5l_buf_1
* cell instance sg13cmos5l_buf_1_74 r0 *1 0,0
Xsg13cmos5l_buf_1_74 \$14 VPWR VGND \$48 sg13cmos5l_buf_1
* cell instance sg13cmos5l_buf_1_75 r0 *1 0,0
Xsg13cmos5l_buf_1_75 \$306 VPWR VGND \$405 sg13cmos5l_buf_1
* cell instance sg13cmos5l_buf_1_76 r0 *1 0,0
Xsg13cmos5l_buf_1_76 \$925 VPWR VGND \$14 sg13cmos5l_buf_1
* cell instance sg13cmos5l_buf_1_77 r0 *1 0,0
Xsg13cmos5l_buf_1_77 \$886 VPWR VGND \$267 sg13cmos5l_buf_1
* cell instance sg13cmos5l_buf_1_78 r0 *1 0,0
Xsg13cmos5l_buf_1_78 \$3062 VPWR VGND \$1461 sg13cmos5l_buf_1
* cell instance sg13cmos5l_buf_1_79 r0 *1 0,0
Xsg13cmos5l_buf_1_79 \$248 VPWR VGND \$246 sg13cmos5l_buf_1
* cell instance sg13cmos5l_buf_1_80 r0 *1 0,0
Xsg13cmos5l_buf_1_80 \$1063 VPWR VGND \$925 sg13cmos5l_buf_1
* cell instance sg13cmos5l_buf_1_81 r0 *1 0,0
Xsg13cmos5l_buf_1_81 \$197 VPWR VGND \$151 sg13cmos5l_buf_1
* cell instance sg13cmos5l_buf_1_82 r0 *1 0,0
Xsg13cmos5l_buf_1_82 \$1060 VPWR VGND \$745 sg13cmos5l_buf_1
* cell instance sg13cmos5l_buf_1_83 r0 *1 0,0
Xsg13cmos5l_buf_1_83 \$909 VPWR VGND \$248 sg13cmos5l_buf_1
* cell instance sg13cmos5l_buf_1_84 r0 *1 0,0
Xsg13cmos5l_buf_1_84 \$353 VPWR VGND \$47 sg13cmos5l_buf_1
* cell instance sg13cmos5l_buf_1_85 r0 *1 0,0
Xsg13cmos5l_buf_1_85 \$1192 VPWR VGND \$922 sg13cmos5l_buf_1
* cell instance sg13cmos5l_buf_1_86 r0 *1 0,0
Xsg13cmos5l_buf_1_86 \$922 VPWR VGND \$353 sg13cmos5l_buf_1
* cell instance sg13cmos5l_buf_1_87 r0 *1 0,0
Xsg13cmos5l_buf_1_87 \$343 VPWR VGND \$518 sg13cmos5l_buf_1
* cell instance sg13cmos5l_buf_1_88 r0 *1 0,0
Xsg13cmos5l_buf_1_88 \$53 VPWR VGND \$90 sg13cmos5l_buf_1
* cell instance sg13cmos5l_buf_1_89 r0 *1 0,0
Xsg13cmos5l_buf_1_89 \$90 VPWR VGND \$310 sg13cmos5l_buf_1
* cell instance sg13cmos5l_buf_1_90 r0 *1 0,0
Xsg13cmos5l_buf_1_90 \$301 VPWR VGND \$3 sg13cmos5l_buf_1
* cell instance sg13cmos5l_buf_1_91 r0 *1 0,0
Xsg13cmos5l_buf_1_91 \$8 VPWR VGND \$186 sg13cmos5l_buf_1
* cell instance sg13cmos5l_buf_1_92 r0 *1 0,0
Xsg13cmos5l_buf_1_92 \$52 VPWR VGND \$32 sg13cmos5l_buf_1
* cell instance sg13cmos5l_buf_1_93 r0 *1 0,0
Xsg13cmos5l_buf_1_93 \$1075 VPWR VGND \$238 sg13cmos5l_buf_1
* cell instance sg13cmos5l_buf_1_94 r0 *1 0,0
Xsg13cmos5l_buf_1_94 \$1970 VPWR VGND \$1969 sg13cmos5l_buf_1
* cell instance sg13cmos5l_buf_1_95 r0 *1 0,0
Xsg13cmos5l_buf_1_95 \$3443 VPWR VGND \$3211 sg13cmos5l_buf_1
* cell instance sg13cmos5l_buf_1_96 r0 *1 0,0
Xsg13cmos5l_buf_1_96 \$793 VPWR VGND \$210 sg13cmos5l_buf_1
* cell instance sg13cmos5l_buf_1_97 r0 *1 0,0
Xsg13cmos5l_buf_1_97 \$967 VPWR VGND \$24 sg13cmos5l_buf_1
* cell instance sg13cmos5l_buf_1_98 r0 *1 0,0
Xsg13cmos5l_buf_1_98 uio_in[7] VPWR VGND \$17252 sg13cmos5l_buf_1
* cell instance sg13cmos5l_buf_1_99 r0 *1 0,0
Xsg13cmos5l_buf_1_99 \$611 VPWR VGND \$57 sg13cmos5l_buf_1
* cell instance sg13cmos5l_buf_1_100 r0 *1 0,0
Xsg13cmos5l_buf_1_100 \$3338 VPWR VGND \$3491 sg13cmos5l_buf_1
* cell instance sg13cmos5l_buf_1_101 r0 *1 0,0
Xsg13cmos5l_buf_1_101 uio_in[6] VPWR VGND \$17251 sg13cmos5l_buf_1
* cell instance sg13cmos5l_buf_1_102 r0 *1 0,0
Xsg13cmos5l_buf_1_102 uio_in[5] VPWR VGND \$17259 sg13cmos5l_buf_1
* cell instance sg13cmos5l_buf_1_103 r0 *1 0,0
Xsg13cmos5l_buf_1_103 \$3471 VPWR VGND \$3579 sg13cmos5l_buf_1
* cell instance sg13cmos5l_buf_1_104 r0 *1 0,0
Xsg13cmos5l_buf_1_104 \$189 VPWR VGND \$156 sg13cmos5l_buf_1
* cell instance sg13cmos5l_buf_1_105 r0 *1 0,0
Xsg13cmos5l_buf_1_105 \$2190 VPWR VGND \$1303 sg13cmos5l_buf_1
* cell instance sg13cmos5l_buf_1_106 r0 *1 0,0
Xsg13cmos5l_buf_1_106 \$3067 VPWR VGND \$1074 sg13cmos5l_buf_1
* cell instance sg13cmos5l_buf_1_107 r0 *1 0,0
Xsg13cmos5l_buf_1_107 \$1877 VPWR VGND \$3205 sg13cmos5l_buf_1
* cell instance sg13cmos5l_buf_1_108 r0 *1 0,0
Xsg13cmos5l_buf_1_108 \$3355 VPWR VGND \$3601 sg13cmos5l_buf_1
* cell instance sg13cmos5l_buf_1_109 r0 *1 0,0
Xsg13cmos5l_buf_1_109 uio_in[4] VPWR VGND \$17265 sg13cmos5l_buf_1
* cell instance sg13cmos5l_buf_1_110 r0 *1 0,0
Xsg13cmos5l_buf_1_110 \$2756 VPWR VGND \$2495 sg13cmos5l_buf_1
* cell instance sg13cmos5l_buf_1_111 r0 *1 0,0
Xsg13cmos5l_buf_1_111 \$2495 VPWR VGND \$1643 sg13cmos5l_buf_1
* cell instance sg13cmos5l_buf_1_112 r0 *1 0,0
Xsg13cmos5l_buf_1_112 uio_in[3] VPWR VGND \$17262 sg13cmos5l_buf_1
* cell instance sg13cmos5l_buf_1_113 r0 *1 0,0
Xsg13cmos5l_buf_1_113 uio_in[2] VPWR VGND \$17246 sg13cmos5l_buf_1
* cell instance sg13cmos5l_buf_1_114 r0 *1 0,0
Xsg13cmos5l_buf_1_114 \$2049 VPWR VGND \$1201 sg13cmos5l_buf_1
* cell instance sg13cmos5l_buf_1_115 r0 *1 0,0
Xsg13cmos5l_buf_1_115 uio_in[1] VPWR VGND \$17271 sg13cmos5l_buf_1
* cell instance sg13cmos5l_buf_1_116 r0 *1 0,0
Xsg13cmos5l_buf_1_116 \$162 VPWR VGND \$152 sg13cmos5l_buf_1
* cell instance sg13cmos5l_buf_1_117 r0 *1 0,0
Xsg13cmos5l_buf_1_117 \$3067 VPWR VGND \$1497 sg13cmos5l_buf_1
* cell instance sg13cmos5l_buf_1_118 r0 *1 0,0
Xsg13cmos5l_buf_1_118 \$745 VPWR VGND \$166 sg13cmos5l_buf_1
* cell instance sg13cmos5l_buf_1_119 r0 *1 0,0
Xsg13cmos5l_buf_1_119 \$3601 VPWR VGND \$3358 sg13cmos5l_buf_1
* cell instance sg13cmos5l_buf_1_120 r0 *1 0,0
Xsg13cmos5l_buf_1_120 \$3292 VPWR VGND \$4376 sg13cmos5l_buf_1
* cell instance sg13cmos5l_buf_1_121 r0 *1 0,0
Xsg13cmos5l_buf_1_121 \$967 VPWR VGND \$804 sg13cmos5l_buf_1
* cell instance sg13cmos5l_buf_1_122 r0 *1 0,0
Xsg13cmos5l_buf_1_122 uio_in[0] VPWR VGND \$2749 sg13cmos5l_buf_1
* cell instance sg13cmos5l_buf_1_123 r0 *1 0,0
Xsg13cmos5l_buf_1_123 ui_in[7] VPWR VGND \$4498 sg13cmos5l_buf_1
* cell instance sg13cmos5l_buf_1_124 r0 *1 0,0
Xsg13cmos5l_buf_1_124 \$3459 VPWR VGND \$3067 sg13cmos5l_buf_1
* cell instance sg13cmos5l_buf_1_125 r0 *1 0,0
Xsg13cmos5l_buf_1_125 \$2362 VPWR VGND \$1658 sg13cmos5l_buf_1
* cell instance sg13cmos5l_buf_1_126 r0 *1 0,0
Xsg13cmos5l_buf_1_126 \$2 VPWR VGND \$78 sg13cmos5l_buf_1
* cell instance sg13cmos5l_buf_1_127 r0 *1 0,0
Xsg13cmos5l_buf_1_127 \$2637 VPWR VGND \$2060 sg13cmos5l_buf_1
* cell instance sg13cmos5l_buf_1_128 r0 *1 0,0
Xsg13cmos5l_buf_1_128 ui_in[6] VPWR VGND \$17250 sg13cmos5l_buf_1
* cell instance sg13cmos5l_buf_1_129 r0 *1 0,0
Xsg13cmos5l_buf_1_129 ui_in[5] VPWR VGND \$17280 sg13cmos5l_buf_1
* cell instance sg13cmos5l_buf_1_130 r0 *1 0,0
Xsg13cmos5l_buf_1_130 \$3496 VPWR VGND \$3772 sg13cmos5l_buf_1
* cell instance sg13cmos5l_buf_1_131 r0 *1 0,0
Xsg13cmos5l_buf_1_131 ui_in[4] VPWR VGND \$17272 sg13cmos5l_buf_1
* cell instance sg13cmos5l_buf_1_132 r0 *1 0,0
Xsg13cmos5l_buf_1_132 ui_in[3] VPWR VGND \$17249 sg13cmos5l_buf_1
* cell instance sg13cmos5l_buf_1_133 r0 *1 0,0
Xsg13cmos5l_buf_1_133 ui_in[2] VPWR VGND \$17288 sg13cmos5l_buf_1
* cell instance sg13cmos5l_buf_1_134 r0 *1 0,0
Xsg13cmos5l_buf_1_134 \$1877 VPWR VGND \$2182 sg13cmos5l_buf_1
* cell instance sg13cmos5l_buf_1_135 r0 *1 0,0
Xsg13cmos5l_buf_1_135 \$197 VPWR VGND \$645 sg13cmos5l_buf_1
* cell instance sg13cmos5l_buf_1_136 r0 *1 0,0
Xsg13cmos5l_buf_1_136 \$918 VPWR VGND \$489 sg13cmos5l_buf_1
* cell instance sg13cmos5l_buf_1_137 r0 *1 0,0
Xsg13cmos5l_buf_1_137 ui_in[1] VPWR VGND \$7802 sg13cmos5l_buf_1
* cell instance sg13cmos5l_buf_1_138 r0 *1 0,0
Xsg13cmos5l_buf_1_138 \$3119 VPWR VGND \$3002 sg13cmos5l_buf_1
* cell instance sg13cmos5l_buf_1_139 r0 *1 0,0
Xsg13cmos5l_buf_1_139 \$666 VPWR VGND \$387 sg13cmos5l_buf_1
* cell instance sg13cmos5l_buf_1_140 r0 *1 0,0
Xsg13cmos5l_buf_1_140 \$4605 VPWR VGND \$3459 sg13cmos5l_buf_1
* cell instance sg13cmos5l_buf_1_141 r0 *1 0,0
Xsg13cmos5l_buf_1_141 ui_in[0] VPWR VGND \$2744 sg13cmos5l_buf_1
* cell instance sg13cmos5l_buf_1_142 r0 *1 0,0
Xsg13cmos5l_buf_1_142 \$645 VPWR VGND \$107 sg13cmos5l_buf_1
* cell instance sg13cmos5l_buf_1_143 r0 *1 0,0
Xsg13cmos5l_buf_1_143 \$836 VPWR VGND \$1102 sg13cmos5l_buf_1
* cell instance sg13cmos5l_buf_1_144 r0 *1 0,0
Xsg13cmos5l_buf_1_144 \$90 VPWR VGND \$42 sg13cmos5l_buf_1
* cell instance sg13cmos5l_buf_1_145 r0 *1 0,0
Xsg13cmos5l_buf_1_145 rst_n VPWR VGND \$4605 sg13cmos5l_buf_1
* cell instance sg13cmos5l_buf_1_146 r0 *1 0,0
Xsg13cmos5l_buf_1_146 \$1700 VPWR VGND \$2190 sg13cmos5l_buf_1
* cell instance sg13cmos5l_buf_1_147 r0 *1 0,0
Xsg13cmos5l_buf_1_147 \$4406 VPWR VGND \$4626 sg13cmos5l_buf_1
* cell instance sg13cmos5l_buf_1_148 r0 *1 0,0
Xsg13cmos5l_buf_1_148 \$329 VPWR VGND \$268 sg13cmos5l_buf_1
* cell instance sg13cmos5l_buf_1_149 r0 *1 0,0
Xsg13cmos5l_buf_1_149 \$1102 VPWR VGND \$697 sg13cmos5l_buf_1
* cell instance sg13cmos5l_buf_1_150 r0 *1 0,0
Xsg13cmos5l_buf_1_150 \$4199 VPWR VGND \$4567 sg13cmos5l_buf_1
* cell instance sg13cmos5l_buf_1_151 r0 *1 0,0
Xsg13cmos5l_buf_1_151 \$925 VPWR VGND \$27 sg13cmos5l_buf_1
* cell instance sg13cmos5l_buf_1_152 r0 *1 0,0
Xsg13cmos5l_buf_1_152 \$2495 VPWR VGND \$1701 sg13cmos5l_buf_1
* cell instance sg13cmos5l_buf_1_153 r0 *1 0,0
Xsg13cmos5l_buf_1_153 \$927 VPWR VGND \$329 sg13cmos5l_buf_1
* cell instance sg13cmos5l_buf_1_154 r0 *1 0,0
Xsg13cmos5l_buf_1_154 \$189 VPWR VGND \$176 sg13cmos5l_buf_1
* cell instance sg13cmos5l_buf_1_155 r0 *1 0,0
Xsg13cmos5l_buf_1_155 \$936 VPWR VGND \$589 sg13cmos5l_buf_1
* cell instance sg13cmos5l_buf_1_156 r0 *1 0,0
Xsg13cmos5l_buf_1_156 \$1901 VPWR VGND \$1633 sg13cmos5l_buf_1
* cell instance sg13cmos5l_buf_1_157 r0 *1 0,0
Xsg13cmos5l_buf_1_157 \$1694 VPWR VGND \$1704 sg13cmos5l_buf_1
* cell instance sg13cmos5l_buf_1_158 r0 *1 0,0
Xsg13cmos5l_buf_1_158 \$898 VPWR VGND \$811 sg13cmos5l_buf_1
* cell instance sg13cmos5l_buf_1_159 r0 *1 0,0
Xsg13cmos5l_buf_1_159 \$1114 VPWR VGND \$1345 sg13cmos5l_buf_1
* cell instance sg13cmos5l_buf_1_160 r0 *1 0,0
Xsg13cmos5l_buf_1_160 \$1659 VPWR VGND \$3218 sg13cmos5l_buf_1
* cell instance sg13cmos5l_buf_1_161 r0 *1 0,0
Xsg13cmos5l_buf_1_161 \$238 VPWR VGND \$100 sg13cmos5l_buf_1
* cell instance sg13cmos5l_buf_1_162 r0 *1 0,0
Xsg13cmos5l_buf_1_162 \$1890 VPWR VGND \$1659 sg13cmos5l_buf_1
* cell instance sg13cmos5l_buf_1_163 r0 *1 0,0
Xsg13cmos5l_buf_1_163 \$99 VPWR VGND \$97 sg13cmos5l_buf_1
* cell instance sg13cmos5l_buf_1_164 r0 *1 0,0
Xsg13cmos5l_buf_1_164 \$861 VPWR VGND \$171 sg13cmos5l_buf_1
* cell instance sg13cmos5l_buf_1_165 r0 *1 0,0
Xsg13cmos5l_buf_1_165 \$2058 VPWR VGND \$3299 sg13cmos5l_buf_1
* cell instance sg13cmos5l_buf_1_166 r0 *1 0,0
Xsg13cmos5l_buf_1_166 \$1060 VPWR VGND \$1001 sg13cmos5l_buf_1
* cell instance sg13cmos5l_buf_1_167 r0 *1 0,0
Xsg13cmos5l_buf_1_167 \$611 VPWR VGND \$7 sg13cmos5l_buf_1
* cell instance sg13cmos5l_buf_1_168 r0 *1 0,0
Xsg13cmos5l_buf_1_168 \$886 VPWR VGND \$330 sg13cmos5l_buf_1
* cell instance sg13cmos5l_buf_1_169 r0 *1 0,0
Xsg13cmos5l_buf_1_169 \$304 VPWR VGND \$326 sg13cmos5l_buf_1
* cell instance sg13cmos5l_buf_1_170 r0 *1 0,0
Xsg13cmos5l_buf_1_170 \$697 VPWR VGND \$39 sg13cmos5l_buf_1
* cell instance sg13cmos5l_buf_1_171 r0 *1 0,0
Xsg13cmos5l_buf_1_171 \$923 VPWR VGND \$539 sg13cmos5l_buf_1
* cell instance sg13cmos5l_buf_1_172 r0 *1 0,0
Xsg13cmos5l_buf_1_172 \$453 VPWR VGND \$102 sg13cmos5l_buf_1
* cell instance sg13cmos5l_buf_1_173 r0 *1 0,0
Xsg13cmos5l_buf_1_173 \$2494 VPWR VGND \$2935 sg13cmos5l_buf_1
* cell instance sg13cmos5l_buf_1_174 r0 *1 0,0
Xsg13cmos5l_buf_1_174 \$2103 VPWR VGND \$2446 sg13cmos5l_buf_1
* cell instance sg13cmos5l_buf_1_175 r0 *1 0,0
Xsg13cmos5l_buf_1_175 \$2346 VPWR VGND \$2354 sg13cmos5l_buf_1
* cell instance sg13cmos5l_buf_1_176 r0 *1 0,0
Xsg13cmos5l_buf_1_176 \$1877 VPWR VGND \$1884 sg13cmos5l_buf_1
* cell instance sg13cmos5l_buf_1_177 r0 *1 0,0
Xsg13cmos5l_buf_1_177 \$4953 VPWR VGND \$3970 sg13cmos5l_buf_1
* cell instance sg13cmos5l_buf_1_178 r0 *1 0,0
Xsg13cmos5l_buf_1_178 \$8 VPWR VGND \$188 sg13cmos5l_buf_1
* cell instance sg13cmos5l_buf_1_179 r0 *1 0,0
Xsg13cmos5l_buf_1_179 \$2495 VPWR VGND \$2071 sg13cmos5l_buf_1
* cell instance sg13cmos5l_buf_1_180 r0 *1 0,0
Xsg13cmos5l_buf_1_180 \$1001 VPWR VGND \$91 sg13cmos5l_buf_1
* cell instance sg13cmos5l_buf_1_181 r0 *1 0,0
Xsg13cmos5l_buf_1_181 \$29 VPWR VGND \$5 sg13cmos5l_buf_1
* cell instance sg13cmos5l_buf_1_182 r0 *1 0,0
Xsg13cmos5l_buf_1_182 \$102 VPWR VGND \$12 sg13cmos5l_buf_1
* cell instance sg13cmos5l_buf_1_183 r0 *1 0,0
Xsg13cmos5l_buf_1_183 \$91 VPWR VGND \$115 sg13cmos5l_buf_1
* cell instance sg13cmos5l_buf_1_184 r0 *1 0,0
Xsg13cmos5l_buf_1_184 \$331 VPWR VGND \$290 sg13cmos5l_buf_1
* cell instance sg13cmos5l_buf_1_185 r0 *1 0,0
Xsg13cmos5l_buf_1_185 \$4220 VPWR VGND \$1114 sg13cmos5l_buf_1
* cell instance sg13cmos5l_buf_1_186 r0 *1 0,0
Xsg13cmos5l_buf_1_186 \$4605 VPWR VGND \$4220 sg13cmos5l_buf_1
* cell instance sg13cmos5l_buf_1_187 r0 *1 0,0
Xsg13cmos5l_buf_1_187 \$645 VPWR VGND \$591 sg13cmos5l_buf_1
* cell instance sg13cmos5l_buf_1_188 r0 *1 0,0
Xsg13cmos5l_buf_1_188 \$922 VPWR VGND \$25 sg13cmos5l_buf_1
* cell instance sg13cmos5l_buf_1_189 r0 *1 0,0
Xsg13cmos5l_buf_1_189 \$1877 VPWR VGND \$1721 sg13cmos5l_buf_1
* cell instance sg13cmos5l_buf_1_190 r0 *1 0,0
Xsg13cmos5l_buf_1_190 \$2345 VPWR VGND \$2202 sg13cmos5l_buf_1
* cell instance sg13cmos5l_buf_1_191 r0 *1 0,0
Xsg13cmos5l_buf_1_191 \$5 VPWR VGND \$41 sg13cmos5l_buf_1
* cell instance sg13cmos5l_buf_1_192 r0 *1 0,0
Xsg13cmos5l_buf_1_192 \$697 VPWR VGND \$655 sg13cmos5l_buf_1
* cell instance sg13cmos5l_buf_1_193 r0 *1 0,0
Xsg13cmos5l_buf_1_193 \$1814 VPWR VGND \$2717 sg13cmos5l_buf_1
* cell instance sg13cmos5l_buf_1_194 r0 *1 0,0
Xsg13cmos5l_buf_1_194 \$2958 VPWR VGND \$1855 sg13cmos5l_buf_1
* cell instance sg13cmos5l_buf_1_195 r0 *1 0,0
Xsg13cmos5l_buf_1_195 \$1723 VPWR VGND \$1877 sg13cmos5l_buf_1
* cell instance sg13cmos5l_buf_1_196 r0 *1 0,0
Xsg13cmos5l_buf_1_196 \$91 VPWR VGND \$932 sg13cmos5l_buf_1
* cell instance sg13cmos5l_buf_1_197 r0 *1 0,0
Xsg13cmos5l_buf_1_197 \$142 VPWR VGND \$542 sg13cmos5l_buf_1
* cell instance sg13cmos5l_buf_1_198 r0 *1 0,0
Xsg13cmos5l_buf_1_198 \$861 VPWR VGND \$504 sg13cmos5l_buf_1
* cell instance sg13cmos5l_buf_1_199 r0 *1 0,0
Xsg13cmos5l_buf_1_199 \$1536 VPWR VGND \$162 sg13cmos5l_buf_1
* cell instance sg13cmos5l_buf_1_200 r0 *1 0,0
Xsg13cmos5l_buf_1_200 \$293 VPWR VGND \$299 sg13cmos5l_buf_1
* cell instance sg13cmos5l_buf_1_201 r0 *1 0,0
Xsg13cmos5l_buf_1_201 \$4953 VPWR VGND \$3812 sg13cmos5l_buf_1
* cell instance sg13cmos5l_buf_1_202 r0 *1 0,0
Xsg13cmos5l_buf_1_202 \$162 VPWR VGND \$861 sg13cmos5l_buf_1
* cell instance sg13cmos5l_buf_1_203 r0 *1 0,0
Xsg13cmos5l_buf_1_203 \$645 VPWR VGND \$185 sg13cmos5l_buf_1
* cell instance sg13cmos5l_buf_1_204 r0 *1 0,0
Xsg13cmos5l_buf_1_204 \$232 VPWR VGND \$159 sg13cmos5l_buf_1
* cell instance sg13cmos5l_buf_1_205 r0 *1 0,0
Xsg13cmos5l_buf_1_205 \$504 VPWR VGND \$110 sg13cmos5l_buf_1
* cell instance sg13cmos5l_buf_1_206 r0 *1 0,0
Xsg13cmos5l_buf_1_206 \$292 VPWR VGND \$820 sg13cmos5l_buf_1
* cell instance sg13cmos5l_buf_1_207 r0 *1 0,0
Xsg13cmos5l_buf_1_207 \$1915 VPWR VGND \$1283 sg13cmos5l_buf_1
* cell instance sg13cmos5l_buf_1_208 r0 *1 0,0
Xsg13cmos5l_buf_1_208 \$4673 VPWR VGND \$3652 sg13cmos5l_buf_1
* cell instance sg13cmos5l_buf_1_209 r0 *1 0,0
Xsg13cmos5l_buf_1_209 \$3496 VPWR VGND \$3638 sg13cmos5l_buf_1
* cell instance sg13cmos5l_buf_1_210 r0 *1 0,0
Xsg13cmos5l_buf_1_210 \$4220 VPWR VGND \$4673 sg13cmos5l_buf_1
* cell instance sg13cmos5l_buf_1_211 r0 *1 0,0
Xsg13cmos5l_buf_1_211 \$1659 VPWR VGND \$1920 sg13cmos5l_buf_1
* cell instance sg13cmos5l_buf_1_212 r0 *1 0,0
Xsg13cmos5l_buf_1_212 \$697 VPWR VGND \$182 sg13cmos5l_buf_1
* cell instance sg13cmos5l_buf_1_213 r0 *1 0,0
Xsg13cmos5l_buf_1_213 \$1745 VPWR VGND \$1566 sg13cmos5l_buf_1
* cell instance sg13cmos5l_buf_1_214 r0 *1 0,0
Xsg13cmos5l_buf_1_214 \$1918 VPWR VGND \$1748 sg13cmos5l_buf_1
* cell instance sg13cmos5l_buf_1_215 r0 *1 0,0
Xsg13cmos5l_buf_1_215 \$2657 VPWR VGND \$2351 sg13cmos5l_buf_1
* cell instance sg13cmos5l_buf_1_216 r0 *1 0,0
Xsg13cmos5l_buf_1_216 \$2958 VPWR VGND \$2795 sg13cmos5l_buf_1
* cell instance sg13cmos5l_buf_1_217 r0 *1 0,0
Xsg13cmos5l_buf_1_217 \$2802 VPWR VGND \$1556 sg13cmos5l_buf_1
* cell instance sg13cmos5l_buf_1_218 r0 *1 0,0
Xsg13cmos5l_buf_1_218 \$1633 VPWR VGND \$1811 sg13cmos5l_buf_1
* cell instance sg13cmos5l_buf_1_219 r0 *1 0,0
Xsg13cmos5l_buf_1_219 \$4220 VPWR VGND \$2802 sg13cmos5l_buf_1
* cell instance sg13cmos5l_buf_1_220 r0 *1 0,0
Xsg13cmos5l_buf_1_220 \$3117 VPWR VGND \$3119 sg13cmos5l_buf_1
* cell instance sg13cmos5l_buf_1_221 r0 *1 0,0
Xsg13cmos5l_buf_1_221 \$4257 VPWR VGND \$1718 sg13cmos5l_buf_1
* cell instance sg13cmos5l_buf_1_222 r0 *1 0,0
Xsg13cmos5l_buf_1_222 \$4259 VPWR VGND \$3195 sg13cmos5l_buf_1
* cell instance sg13cmos5l_buf_1_223 r0 *1 0,0
Xsg13cmos5l_buf_1_223 \$4953 VPWR VGND \$4051 sg13cmos5l_buf_1
* cell instance sg13cmos5l_buf_1_224 r0 *1 0,0
Xsg13cmos5l_buf_1_224 \$4199 VPWR VGND \$4953 sg13cmos5l_buf_1
* cell instance sg13cmos5l_buf_1_225 r0 *1 0,0
Xsg13cmos5l_buf_1_225 \$2802 VPWR VGND \$1261 sg13cmos5l_buf_1
* cell instance sg13cmos5l_buf_1_226 r0 *1 0,0
Xsg13cmos5l_buf_1_226 \$3542 VPWR VGND \$3274 sg13cmos5l_buf_1
* cell instance sg13cmos5l_buf_1_227 r0 *1 0,0
Xsg13cmos5l_buf_1_227 \$2802 VPWR VGND \$2540 sg13cmos5l_buf_1
* cell instance sg13cmos5l_buf_1_228 r0 *1 0,0
Xsg13cmos5l_buf_1_228 \$4673 VPWR VGND \$3542 sg13cmos5l_buf_1
* cell instance sg13cmos5l_buf_1_229 r0 *1 0,0
Xsg13cmos5l_buf_1_229 \$4049 VPWR VGND \$4438 sg13cmos5l_buf_1
* cell instance sg13cmos5l_buf_1_230 r0 *1 0,0
Xsg13cmos5l_buf_1_230 \$4953 VPWR VGND \$4035 sg13cmos5l_buf_1
* cell instance sg13cmos5l_buf_1_231 r0 *1 0,0
Xsg13cmos5l_buf_1_231 \$1814 VPWR VGND \$2026 sg13cmos5l_buf_1
* cell instance sg13cmos5l_buf_4_0 r0 *1 0,0
Xsg13cmos5l_buf_4_0 \$4408 VPWR VGND \$4410 sg13cmos5l_buf_4
* cell instance sg13cmos5l_buf_8_0 r0 *1 0,0
Xsg13cmos5l_buf_8_0 \$4589 VPWR VGND \$5177 sg13cmos5l_buf_8
* cell instance sg13cmos5l_buf_8_1 r0 *1 0,0
Xsg13cmos5l_buf_8_1 \$6508 VPWR VGND \$6235 sg13cmos5l_buf_8
* cell instance sg13cmos5l_buf_8_2 r0 *1 0,0
Xsg13cmos5l_buf_8_2 \$4587 VPWR VGND \$2277 sg13cmos5l_buf_8
* cell instance sg13cmos5l_buf_8_3 r0 *1 0,0
Xsg13cmos5l_buf_8_3 \$6508 VPWR VGND \$7250 sg13cmos5l_buf_8
* cell instance sg13cmos5l_buf_8_4 r0 *1 0,0
Xsg13cmos5l_buf_8_4 \$6376 VPWR VGND \$7328 sg13cmos5l_buf_8
* cell instance sg13cmos5l_buf_8_5 r0 *1 0,0
Xsg13cmos5l_buf_8_5 \$2668 VPWR VGND \$4587 sg13cmos5l_buf_8
* cell instance sg13cmos5l_buf_8_6 r0 *1 0,0
Xsg13cmos5l_buf_8_6 \$2668 VPWR VGND \$6508 sg13cmos5l_buf_8
* cell instance sg13cmos5l_buf_8_7 r0 *1 0,0
Xsg13cmos5l_buf_8_7 \$6513 VPWR VGND \$7330 sg13cmos5l_buf_8
* cell instance sg13cmos5l_buf_8_8 r0 *1 0,0
Xsg13cmos5l_buf_8_8 \$3336 VPWR VGND \$3018 sg13cmos5l_buf_8
* cell instance sg13cmos5l_buf_8_9 r0 *1 0,0
Xsg13cmos5l_buf_8_9 \$2668 VPWR VGND \$4589 sg13cmos5l_buf_8
* cell instance sg13cmos5l_buf_8_10 r0 *1 0,0
Xsg13cmos5l_buf_8_10 \$2668 VPWR VGND \$7213 sg13cmos5l_buf_8
* cell instance sg13cmos5l_buf_8_11 r0 *1 0,0
Xsg13cmos5l_buf_8_11 \$2668 VPWR VGND \$6376 sg13cmos5l_buf_8
* cell instance sg13cmos5l_buf_8_12 r0 *1 0,0
Xsg13cmos5l_buf_8_12 \$6513 VPWR VGND \$7621 sg13cmos5l_buf_8
* cell instance sg13cmos5l_buf_8_13 r0 *1 0,0
Xsg13cmos5l_buf_8_13 \$4587 VPWR VGND \$3895 sg13cmos5l_buf_8
* cell instance sg13cmos5l_buf_8_14 r0 *1 0,0
Xsg13cmos5l_buf_8_14 \$4589 VPWR VGND \$5340 sg13cmos5l_buf_8
* cell instance sg13cmos5l_buf_8_15 r0 *1 0,0
Xsg13cmos5l_buf_8_15 \$6376 VPWR VGND \$7335 sg13cmos5l_buf_8
* cell instance sg13cmos5l_buf_8_16 r0 *1 0,0
Xsg13cmos5l_buf_8_16 \$2668 VPWR VGND \$6513 sg13cmos5l_buf_8
* cell instance sg13cmos5l_buf_8_17 r0 *1 0,0
Xsg13cmos5l_buf_8_17 \$2620 VPWR VGND \$2585 sg13cmos5l_buf_8
* cell instance sg13cmos5l_buf_8_18 r0 *1 0,0
Xsg13cmos5l_buf_8_18 \$2668 VPWR VGND \$3336 sg13cmos5l_buf_8
* cell instance sg13cmos5l_buf_8_19 r0 *1 0,0
Xsg13cmos5l_buf_8_19 \$7213 VPWR VGND \$7587 sg13cmos5l_buf_8
* cell instance sg13cmos5l_buf_8_20 r0 *1 0,0
Xsg13cmos5l_buf_8_20 \$7213 VPWR VGND \$8180 sg13cmos5l_buf_8
* cell instance sg13cmos5l_buf_8_21 r0 *1 0,0
Xsg13cmos5l_buf_8_21 \$3336 VPWR VGND \$944 sg13cmos5l_buf_8
* cell instance sg13cmos5l_buf_8_22 r0 *1 0,0
Xsg13cmos5l_buf_8_22 \$2668 VPWR VGND \$2620 sg13cmos5l_buf_8
* cell instance sg13cmos5l_buf_8_23 r0 *1 0,0
Xsg13cmos5l_buf_8_23 \$2620 VPWR VGND \$1055 sg13cmos5l_buf_8
* cell instance sg13cmos5l_buf_8_24 r0 *1 0,0
Xsg13cmos5l_buf_8_24 \$2769 VPWR VGND \$2899 sg13cmos5l_buf_8
* cell instance sg13cmos5l_buf_8_25 r0 *1 0,0
Xsg13cmos5l_buf_8_25 \$4898 VPWR VGND \$2668 sg13cmos5l_buf_8
* cell instance sg13cmos5l_buf_8_26 r0 *1 0,0
Xsg13cmos5l_buf_8_26 clk VPWR VGND \$4898 sg13cmos5l_buf_8
* cell instance sg13cmos5l_buf_8_27 r0 *1 0,0
Xsg13cmos5l_buf_8_27 clk VPWR VGND \$17299 sg13cmos5l_buf_8
* cell instance sg13cmos5l_buf_8_28 r0 *1 0,0
Xsg13cmos5l_buf_8_28 \$2491 VPWR VGND \$1682 sg13cmos5l_buf_8
* cell instance sg13cmos5l_buf_8_29 r0 *1 0,0
Xsg13cmos5l_buf_8_29 \$17299 VPWR VGND \$3552 sg13cmos5l_buf_8
* cell instance sg13cmos5l_buf_8_30 r0 *1 0,0
Xsg13cmos5l_buf_8_30 \$4629 VPWR VGND \$4627 sg13cmos5l_buf_8
* cell instance sg13cmos5l_buf_8_31 r0 *1 0,0
Xsg13cmos5l_buf_8_31 \$3552 VPWR VGND \$4906 sg13cmos5l_buf_8
* cell instance sg13cmos5l_buf_8_32 r0 *1 0,0
Xsg13cmos5l_buf_8_32 \$4906 VPWR VGND \$4637 sg13cmos5l_buf_8
* cell instance sg13cmos5l_buf_8_33 r0 *1 0,0
Xsg13cmos5l_buf_8_33 \$2668 VPWR VGND \$2769 sg13cmos5l_buf_8
* cell instance sg13cmos5l_buf_8_34 r0 *1 0,0
Xsg13cmos5l_buf_8_34 \$4637 VPWR VGND \$4629 sg13cmos5l_buf_8
* cell instance sg13cmos5l_buf_8_35 r0 *1 0,0
Xsg13cmos5l_buf_8_35 \$2668 VPWR VGND \$2491 sg13cmos5l_buf_8
* cell instance sg13cmos5l_buf_8_36 r0 *1 0,0
Xsg13cmos5l_buf_8_36 \$2769 VPWR VGND \$1507 sg13cmos5l_buf_8
* cell instance sg13cmos5l_buf_8_37 r0 *1 0,0
Xsg13cmos5l_buf_8_37 \$3985 VPWR VGND \$3944 sg13cmos5l_buf_8
* cell instance sg13cmos5l_buf_8_38 r0 *1 0,0
Xsg13cmos5l_buf_8_38 \$2491 VPWR VGND \$1520 sg13cmos5l_buf_8
* cell instance sg13cmos5l_buf_8_39 r0 *1 0,0
Xsg13cmos5l_buf_8_39 \$2668 VPWR VGND \$3985 sg13cmos5l_buf_8
* cell instance sg13cmos5l_buf_8_40 r0 *1 0,0
Xsg13cmos5l_buf_8_40 \$3985 VPWR VGND \$4228 sg13cmos5l_buf_8
* cell instance sg13cmos5l_buf_8_41 r0 *1 0,0
Xsg13cmos5l_buf_8_41 \$2668 VPWR VGND \$3808 sg13cmos5l_buf_8
* cell instance sg13cmos5l_buf_8_42 r0 *1 0,0
Xsg13cmos5l_buf_8_42 \$3808 VPWR VGND \$3377 sg13cmos5l_buf_8
* cell instance sg13cmos5l_buf_8_43 r0 *1 0,0
Xsg13cmos5l_buf_8_43 \$3808 VPWR VGND \$3636 sg13cmos5l_buf_8
* cell instance sg13cmos5l_buf_8_44 r0 *1 0,0
Xsg13cmos5l_buf_8_44 \$2668 VPWR VGND \$2670 sg13cmos5l_buf_8
* cell instance sg13cmos5l_buf_8_45 r0 *1 0,0
Xsg13cmos5l_buf_8_45 \$2668 VPWR VGND \$2519 sg13cmos5l_buf_8
* cell instance sg13cmos5l_buf_8_46 r0 *1 0,0
Xsg13cmos5l_buf_8_46 \$2670 VPWR VGND \$1375 sg13cmos5l_buf_8
* cell instance sg13cmos5l_buf_8_47 r0 *1 0,0
Xsg13cmos5l_buf_8_47 \$2670 VPWR VGND \$1765 sg13cmos5l_buf_8
* cell instance sg13cmos5l_buf_8_48 r0 *1 0,0
Xsg13cmos5l_buf_8_48 \$2519 VPWR VGND \$2522 sg13cmos5l_buf_8
* cell instance sg13cmos5l_buf_8_49 r0 *1 0,0
Xsg13cmos5l_buf_8_49 \$2668 VPWR VGND \$3386 sg13cmos5l_buf_8
* cell instance sg13cmos5l_buf_8_50 r0 *1 0,0
Xsg13cmos5l_buf_8_50 \$2668 VPWR VGND \$3537 sg13cmos5l_buf_8
* cell instance sg13cmos5l_buf_8_51 r0 *1 0,0
Xsg13cmos5l_buf_8_51 \$2519 VPWR VGND \$1252 sg13cmos5l_buf_8
* cell instance sg13cmos5l_buf_8_52 r0 *1 0,0
Xsg13cmos5l_buf_8_52 \$3537 VPWR VGND \$3264 sg13cmos5l_buf_8
* cell instance sg13cmos5l_buf_8_53 r0 *1 0,0
Xsg13cmos5l_buf_8_53 \$3386 VPWR VGND \$4053 sg13cmos5l_buf_8
* cell instance sg13cmos5l_buf_8_54 r0 *1 0,0
Xsg13cmos5l_buf_8_54 \$3537 VPWR VGND \$1127 sg13cmos5l_buf_8
* cell instance sg13cmos5l_buf_8_55 r0 *1 0,0
Xsg13cmos5l_buf_8_55 \$3386 VPWR VGND \$4047 sg13cmos5l_buf_8
* cell instance sg13cmos5l_decap_4_0 r0 *1 0,0
Xsg13cmos5l_decap_4_0 VPWR VGND sg13cmos5l_decap_4
* cell instance sg13cmos5l_decap_4_1 r0 *1 0,0
Xsg13cmos5l_decap_4_1 VPWR VGND sg13cmos5l_decap_4
* cell instance sg13cmos5l_decap_4_2 r0 *1 0,0
Xsg13cmos5l_decap_4_2 VPWR VGND sg13cmos5l_decap_4
* cell instance sg13cmos5l_decap_4_3 r0 *1 0,0
Xsg13cmos5l_decap_4_3 VPWR VGND sg13cmos5l_decap_4
* cell instance sg13cmos5l_decap_4_4 r0 *1 0,0
Xsg13cmos5l_decap_4_4 VPWR VGND sg13cmos5l_decap_4
* cell instance sg13cmos5l_decap_4_5 r0 *1 0,0
Xsg13cmos5l_decap_4_5 VPWR VGND sg13cmos5l_decap_4
* cell instance sg13cmos5l_decap_4_6 r0 *1 0,0
Xsg13cmos5l_decap_4_6 VPWR VGND sg13cmos5l_decap_4
* cell instance sg13cmos5l_decap_4_7 r0 *1 0,0
Xsg13cmos5l_decap_4_7 VPWR VGND sg13cmos5l_decap_4
* cell instance sg13cmos5l_decap_4_8 r0 *1 0,0
Xsg13cmos5l_decap_4_8 VPWR VGND sg13cmos5l_decap_4
* cell instance sg13cmos5l_decap_4_9 r0 *1 0,0
Xsg13cmos5l_decap_4_9 VPWR VGND sg13cmos5l_decap_4
* cell instance sg13cmos5l_decap_4_10 r0 *1 0,0
Xsg13cmos5l_decap_4_10 VPWR VGND sg13cmos5l_decap_4
* cell instance sg13cmos5l_decap_4_11 r0 *1 0,0
Xsg13cmos5l_decap_4_11 VPWR VGND sg13cmos5l_decap_4
* cell instance sg13cmos5l_decap_4_12 r0 *1 0,0
Xsg13cmos5l_decap_4_12 VPWR VGND sg13cmos5l_decap_4
* cell instance sg13cmos5l_decap_4_13 r0 *1 0,0
Xsg13cmos5l_decap_4_13 VPWR VGND sg13cmos5l_decap_4
* cell instance sg13cmos5l_decap_4_14 r0 *1 0,0
Xsg13cmos5l_decap_4_14 VPWR VGND sg13cmos5l_decap_4
* cell instance sg13cmos5l_decap_4_15 r0 *1 0,0
Xsg13cmos5l_decap_4_15 VPWR VGND sg13cmos5l_decap_4
* cell instance sg13cmos5l_decap_4_16 r0 *1 0,0
Xsg13cmos5l_decap_4_16 VPWR VGND sg13cmos5l_decap_4
* cell instance sg13cmos5l_decap_4_17 r0 *1 0,0
Xsg13cmos5l_decap_4_17 VPWR VGND sg13cmos5l_decap_4
* cell instance sg13cmos5l_decap_4_18 r0 *1 0,0
Xsg13cmos5l_decap_4_18 VPWR VGND sg13cmos5l_decap_4
* cell instance sg13cmos5l_decap_4_19 r0 *1 0,0
Xsg13cmos5l_decap_4_19 VPWR VGND sg13cmos5l_decap_4
* cell instance sg13cmos5l_decap_4_20 r0 *1 0,0
Xsg13cmos5l_decap_4_20 VPWR VGND sg13cmos5l_decap_4
* cell instance sg13cmos5l_decap_4_21 r0 *1 0,0
Xsg13cmos5l_decap_4_21 VPWR VGND sg13cmos5l_decap_4
* cell instance sg13cmos5l_decap_4_22 r0 *1 0,0
Xsg13cmos5l_decap_4_22 VPWR VGND sg13cmos5l_decap_4
* cell instance sg13cmos5l_decap_4_23 r0 *1 0,0
Xsg13cmos5l_decap_4_23 VPWR VGND sg13cmos5l_decap_4
* cell instance sg13cmos5l_decap_4_24 r0 *1 0,0
Xsg13cmos5l_decap_4_24 VPWR VGND sg13cmos5l_decap_4
* cell instance sg13cmos5l_decap_4_25 r0 *1 0,0
Xsg13cmos5l_decap_4_25 VPWR VGND sg13cmos5l_decap_4
* cell instance sg13cmos5l_decap_4_26 r0 *1 0,0
Xsg13cmos5l_decap_4_26 VPWR VGND sg13cmos5l_decap_4
* cell instance sg13cmos5l_decap_4_27 r0 *1 0,0
Xsg13cmos5l_decap_4_27 VPWR VGND sg13cmos5l_decap_4
* cell instance sg13cmos5l_decap_4_28 r0 *1 0,0
Xsg13cmos5l_decap_4_28 VPWR VGND sg13cmos5l_decap_4
* cell instance sg13cmos5l_decap_4_29 r0 *1 0,0
Xsg13cmos5l_decap_4_29 VPWR VGND sg13cmos5l_decap_4
* cell instance sg13cmos5l_decap_4_30 r0 *1 0,0
Xsg13cmos5l_decap_4_30 VPWR VGND sg13cmos5l_decap_4
* cell instance sg13cmos5l_decap_4_31 r0 *1 0,0
Xsg13cmos5l_decap_4_31 VPWR VGND sg13cmos5l_decap_4
* cell instance sg13cmos5l_decap_4_32 r0 *1 0,0
Xsg13cmos5l_decap_4_32 VPWR VGND sg13cmos5l_decap_4
* cell instance sg13cmos5l_decap_4_33 r0 *1 0,0
Xsg13cmos5l_decap_4_33 VPWR VGND sg13cmos5l_decap_4
* cell instance sg13cmos5l_decap_4_34 r0 *1 0,0
Xsg13cmos5l_decap_4_34 VPWR VGND sg13cmos5l_decap_4
* cell instance sg13cmos5l_decap_4_35 r0 *1 0,0
Xsg13cmos5l_decap_4_35 VPWR VGND sg13cmos5l_decap_4
* cell instance sg13cmos5l_decap_4_36 r0 *1 0,0
Xsg13cmos5l_decap_4_36 VPWR VGND sg13cmos5l_decap_4
* cell instance sg13cmos5l_decap_4_37 r0 *1 0,0
Xsg13cmos5l_decap_4_37 VPWR VGND sg13cmos5l_decap_4
* cell instance sg13cmos5l_decap_4_38 r0 *1 0,0
Xsg13cmos5l_decap_4_38 VPWR VGND sg13cmos5l_decap_4
* cell instance sg13cmos5l_decap_4_39 r0 *1 0,0
Xsg13cmos5l_decap_4_39 VPWR VGND sg13cmos5l_decap_4
* cell instance sg13cmos5l_decap_4_40 r0 *1 0,0
Xsg13cmos5l_decap_4_40 VPWR VGND sg13cmos5l_decap_4
* cell instance sg13cmos5l_decap_4_41 r0 *1 0,0
Xsg13cmos5l_decap_4_41 VPWR VGND sg13cmos5l_decap_4
* cell instance sg13cmos5l_decap_4_42 r0 *1 0,0
Xsg13cmos5l_decap_4_42 VPWR VGND sg13cmos5l_decap_4
* cell instance sg13cmos5l_decap_4_43 r0 *1 0,0
Xsg13cmos5l_decap_4_43 VPWR VGND sg13cmos5l_decap_4
* cell instance sg13cmos5l_decap_4_44 r0 *1 0,0
Xsg13cmos5l_decap_4_44 VPWR VGND sg13cmos5l_decap_4
* cell instance sg13cmos5l_decap_4_45 r0 *1 0,0
Xsg13cmos5l_decap_4_45 VPWR VGND sg13cmos5l_decap_4
* cell instance sg13cmos5l_decap_4_46 r0 *1 0,0
Xsg13cmos5l_decap_4_46 VPWR VGND sg13cmos5l_decap_4
* cell instance sg13cmos5l_decap_4_47 r0 *1 0,0
Xsg13cmos5l_decap_4_47 VPWR VGND sg13cmos5l_decap_4
* cell instance sg13cmos5l_decap_4_48 r0 *1 0,0
Xsg13cmos5l_decap_4_48 VPWR VGND sg13cmos5l_decap_4
* cell instance sg13cmos5l_decap_4_49 r0 *1 0,0
Xsg13cmos5l_decap_4_49 VPWR VGND sg13cmos5l_decap_4
* cell instance sg13cmos5l_decap_4_50 r0 *1 0,0
Xsg13cmos5l_decap_4_50 VPWR VGND sg13cmos5l_decap_4
* cell instance sg13cmos5l_decap_4_51 r0 *1 0,0
Xsg13cmos5l_decap_4_51 VPWR VGND sg13cmos5l_decap_4
* cell instance sg13cmos5l_decap_4_52 r0 *1 0,0
Xsg13cmos5l_decap_4_52 VPWR VGND sg13cmos5l_decap_4
* cell instance sg13cmos5l_decap_4_53 r0 *1 0,0
Xsg13cmos5l_decap_4_53 VPWR VGND sg13cmos5l_decap_4
* cell instance sg13cmos5l_decap_4_54 r0 *1 0,0
Xsg13cmos5l_decap_4_54 VPWR VGND sg13cmos5l_decap_4
* cell instance sg13cmos5l_decap_4_55 r0 *1 0,0
Xsg13cmos5l_decap_4_55 VPWR VGND sg13cmos5l_decap_4
* cell instance sg13cmos5l_decap_4_56 r0 *1 0,0
Xsg13cmos5l_decap_4_56 VPWR VGND sg13cmos5l_decap_4
* cell instance sg13cmos5l_decap_4_57 r0 *1 0,0
Xsg13cmos5l_decap_4_57 VPWR VGND sg13cmos5l_decap_4
* cell instance sg13cmos5l_decap_4_58 r0 *1 0,0
Xsg13cmos5l_decap_4_58 VPWR VGND sg13cmos5l_decap_4
* cell instance sg13cmos5l_decap_4_59 r0 *1 0,0
Xsg13cmos5l_decap_4_59 VPWR VGND sg13cmos5l_decap_4
* cell instance sg13cmos5l_decap_4_60 r0 *1 0,0
Xsg13cmos5l_decap_4_60 VPWR VGND sg13cmos5l_decap_4
* cell instance sg13cmos5l_decap_4_61 r0 *1 0,0
Xsg13cmos5l_decap_4_61 VPWR VGND sg13cmos5l_decap_4
* cell instance sg13cmos5l_decap_4_62 r0 *1 0,0
Xsg13cmos5l_decap_4_62 VPWR VGND sg13cmos5l_decap_4
* cell instance sg13cmos5l_decap_4_63 r0 *1 0,0
Xsg13cmos5l_decap_4_63 VPWR VGND sg13cmos5l_decap_4
* cell instance sg13cmos5l_decap_4_64 r0 *1 0,0
Xsg13cmos5l_decap_4_64 VPWR VGND sg13cmos5l_decap_4
* cell instance sg13cmos5l_decap_4_65 r0 *1 0,0
Xsg13cmos5l_decap_4_65 VPWR VGND sg13cmos5l_decap_4
* cell instance sg13cmos5l_decap_4_66 r0 *1 0,0
Xsg13cmos5l_decap_4_66 VPWR VGND sg13cmos5l_decap_4
* cell instance sg13cmos5l_decap_4_67 r0 *1 0,0
Xsg13cmos5l_decap_4_67 VPWR VGND sg13cmos5l_decap_4
* cell instance sg13cmos5l_decap_4_68 r0 *1 0,0
Xsg13cmos5l_decap_4_68 VPWR VGND sg13cmos5l_decap_4
* cell instance sg13cmos5l_decap_4_69 r0 *1 0,0
Xsg13cmos5l_decap_4_69 VPWR VGND sg13cmos5l_decap_4
* cell instance sg13cmos5l_decap_4_70 r0 *1 0,0
Xsg13cmos5l_decap_4_70 VPWR VGND sg13cmos5l_decap_4
* cell instance sg13cmos5l_decap_4_71 r0 *1 0,0
Xsg13cmos5l_decap_4_71 VPWR VGND sg13cmos5l_decap_4
* cell instance sg13cmos5l_decap_4_72 r0 *1 0,0
Xsg13cmos5l_decap_4_72 VPWR VGND sg13cmos5l_decap_4
* cell instance sg13cmos5l_decap_4_73 r0 *1 0,0
Xsg13cmos5l_decap_4_73 VPWR VGND sg13cmos5l_decap_4
* cell instance sg13cmos5l_decap_4_74 r0 *1 0,0
Xsg13cmos5l_decap_4_74 VPWR VGND sg13cmos5l_decap_4
* cell instance sg13cmos5l_decap_4_75 r0 *1 0,0
Xsg13cmos5l_decap_4_75 VPWR VGND sg13cmos5l_decap_4
* cell instance sg13cmos5l_decap_4_76 r0 *1 0,0
Xsg13cmos5l_decap_4_76 VPWR VGND sg13cmos5l_decap_4
* cell instance sg13cmos5l_decap_4_77 r0 *1 0,0
Xsg13cmos5l_decap_4_77 VPWR VGND sg13cmos5l_decap_4
* cell instance sg13cmos5l_decap_4_78 r0 *1 0,0
Xsg13cmos5l_decap_4_78 VPWR VGND sg13cmos5l_decap_4
* cell instance sg13cmos5l_decap_4_79 r0 *1 0,0
Xsg13cmos5l_decap_4_79 VPWR VGND sg13cmos5l_decap_4
* cell instance sg13cmos5l_decap_4_80 r0 *1 0,0
Xsg13cmos5l_decap_4_80 VPWR VGND sg13cmos5l_decap_4
* cell instance sg13cmos5l_decap_4_81 r0 *1 0,0
Xsg13cmos5l_decap_4_81 VPWR VGND sg13cmos5l_decap_4
* cell instance sg13cmos5l_decap_4_82 r0 *1 0,0
Xsg13cmos5l_decap_4_82 VPWR VGND sg13cmos5l_decap_4
* cell instance sg13cmos5l_decap_4_83 r0 *1 0,0
Xsg13cmos5l_decap_4_83 VPWR VGND sg13cmos5l_decap_4
* cell instance sg13cmos5l_decap_4_84 r0 *1 0,0
Xsg13cmos5l_decap_4_84 VPWR VGND sg13cmos5l_decap_4
* cell instance sg13cmos5l_decap_4_85 r0 *1 0,0
Xsg13cmos5l_decap_4_85 VPWR VGND sg13cmos5l_decap_4
* cell instance sg13cmos5l_decap_4_86 r0 *1 0,0
Xsg13cmos5l_decap_4_86 VPWR VGND sg13cmos5l_decap_4
* cell instance sg13cmos5l_decap_4_87 r0 *1 0,0
Xsg13cmos5l_decap_4_87 VPWR VGND sg13cmos5l_decap_4
* cell instance sg13cmos5l_decap_4_88 r0 *1 0,0
Xsg13cmos5l_decap_4_88 VPWR VGND sg13cmos5l_decap_4
* cell instance sg13cmos5l_decap_4_89 r0 *1 0,0
Xsg13cmos5l_decap_4_89 VPWR VGND sg13cmos5l_decap_4
* cell instance sg13cmos5l_decap_4_90 r0 *1 0,0
Xsg13cmos5l_decap_4_90 VPWR VGND sg13cmos5l_decap_4
* cell instance sg13cmos5l_decap_4_91 r0 *1 0,0
Xsg13cmos5l_decap_4_91 VPWR VGND sg13cmos5l_decap_4
* cell instance sg13cmos5l_decap_4_92 r0 *1 0,0
Xsg13cmos5l_decap_4_92 VPWR VGND sg13cmos5l_decap_4
* cell instance sg13cmos5l_decap_4_93 r0 *1 0,0
Xsg13cmos5l_decap_4_93 VPWR VGND sg13cmos5l_decap_4
* cell instance sg13cmos5l_decap_4_94 r0 *1 0,0
Xsg13cmos5l_decap_4_94 VPWR VGND sg13cmos5l_decap_4
* cell instance sg13cmos5l_decap_4_95 r0 *1 0,0
Xsg13cmos5l_decap_4_95 VPWR VGND sg13cmos5l_decap_4
* cell instance sg13cmos5l_decap_4_96 r0 *1 0,0
Xsg13cmos5l_decap_4_96 VPWR VGND sg13cmos5l_decap_4
* cell instance sg13cmos5l_decap_4_97 r0 *1 0,0
Xsg13cmos5l_decap_4_97 VPWR VGND sg13cmos5l_decap_4
* cell instance sg13cmos5l_decap_4_98 r0 *1 0,0
Xsg13cmos5l_decap_4_98 VPWR VGND sg13cmos5l_decap_4
* cell instance sg13cmos5l_decap_4_99 r0 *1 0,0
Xsg13cmos5l_decap_4_99 VPWR VGND sg13cmos5l_decap_4
* cell instance sg13cmos5l_decap_4_100 r0 *1 0,0
Xsg13cmos5l_decap_4_100 VPWR VGND sg13cmos5l_decap_4
* cell instance sg13cmos5l_decap_4_101 r0 *1 0,0
Xsg13cmos5l_decap_4_101 VPWR VGND sg13cmos5l_decap_4
* cell instance sg13cmos5l_decap_4_102 r0 *1 0,0
Xsg13cmos5l_decap_4_102 VPWR VGND sg13cmos5l_decap_4
* cell instance sg13cmos5l_decap_4_103 r0 *1 0,0
Xsg13cmos5l_decap_4_103 VPWR VGND sg13cmos5l_decap_4
* cell instance sg13cmos5l_decap_4_104 r0 *1 0,0
Xsg13cmos5l_decap_4_104 VPWR VGND sg13cmos5l_decap_4
* cell instance sg13cmos5l_decap_4_105 r0 *1 0,0
Xsg13cmos5l_decap_4_105 VPWR VGND sg13cmos5l_decap_4
* cell instance sg13cmos5l_decap_4_106 r0 *1 0,0
Xsg13cmos5l_decap_4_106 VPWR VGND sg13cmos5l_decap_4
* cell instance sg13cmos5l_decap_4_107 r0 *1 0,0
Xsg13cmos5l_decap_4_107 VPWR VGND sg13cmos5l_decap_4
* cell instance sg13cmos5l_decap_4_108 r0 *1 0,0
Xsg13cmos5l_decap_4_108 VPWR VGND sg13cmos5l_decap_4
* cell instance sg13cmos5l_decap_4_109 r0 *1 0,0
Xsg13cmos5l_decap_4_109 VPWR VGND sg13cmos5l_decap_4
* cell instance sg13cmos5l_decap_4_110 r0 *1 0,0
Xsg13cmos5l_decap_4_110 VPWR VGND sg13cmos5l_decap_4
* cell instance sg13cmos5l_decap_4_111 r0 *1 0,0
Xsg13cmos5l_decap_4_111 VPWR VGND sg13cmos5l_decap_4
* cell instance sg13cmos5l_decap_4_112 r0 *1 0,0
Xsg13cmos5l_decap_4_112 VPWR VGND sg13cmos5l_decap_4
* cell instance sg13cmos5l_decap_4_113 r0 *1 0,0
Xsg13cmos5l_decap_4_113 VPWR VGND sg13cmos5l_decap_4
* cell instance sg13cmos5l_decap_4_114 r0 *1 0,0
Xsg13cmos5l_decap_4_114 VPWR VGND sg13cmos5l_decap_4
* cell instance sg13cmos5l_decap_4_115 r0 *1 0,0
Xsg13cmos5l_decap_4_115 VPWR VGND sg13cmos5l_decap_4
* cell instance sg13cmos5l_decap_4_116 r0 *1 0,0
Xsg13cmos5l_decap_4_116 VPWR VGND sg13cmos5l_decap_4
* cell instance sg13cmos5l_decap_4_117 r0 *1 0,0
Xsg13cmos5l_decap_4_117 VPWR VGND sg13cmos5l_decap_4
* cell instance sg13cmos5l_decap_4_118 r0 *1 0,0
Xsg13cmos5l_decap_4_118 VPWR VGND sg13cmos5l_decap_4
* cell instance sg13cmos5l_decap_4_119 r0 *1 0,0
Xsg13cmos5l_decap_4_119 VPWR VGND sg13cmos5l_decap_4
* cell instance sg13cmos5l_decap_4_120 r0 *1 0,0
Xsg13cmos5l_decap_4_120 VPWR VGND sg13cmos5l_decap_4
* cell instance sg13cmos5l_decap_4_121 r0 *1 0,0
Xsg13cmos5l_decap_4_121 VPWR VGND sg13cmos5l_decap_4
* cell instance sg13cmos5l_decap_4_122 r0 *1 0,0
Xsg13cmos5l_decap_4_122 VPWR VGND sg13cmos5l_decap_4
* cell instance sg13cmos5l_decap_4_123 r0 *1 0,0
Xsg13cmos5l_decap_4_123 VPWR VGND sg13cmos5l_decap_4
* cell instance sg13cmos5l_decap_4_124 r0 *1 0,0
Xsg13cmos5l_decap_4_124 VPWR VGND sg13cmos5l_decap_4
* cell instance sg13cmos5l_decap_4_125 r0 *1 0,0
Xsg13cmos5l_decap_4_125 VPWR VGND sg13cmos5l_decap_4
* cell instance sg13cmos5l_decap_4_126 r0 *1 0,0
Xsg13cmos5l_decap_4_126 VPWR VGND sg13cmos5l_decap_4
* cell instance sg13cmos5l_decap_4_127 r0 *1 0,0
Xsg13cmos5l_decap_4_127 VPWR VGND sg13cmos5l_decap_4
* cell instance sg13cmos5l_decap_4_128 r0 *1 0,0
Xsg13cmos5l_decap_4_128 VPWR VGND sg13cmos5l_decap_4
* cell instance sg13cmos5l_decap_4_129 r0 *1 0,0
Xsg13cmos5l_decap_4_129 VPWR VGND sg13cmos5l_decap_4
* cell instance sg13cmos5l_decap_4_130 r0 *1 0,0
Xsg13cmos5l_decap_4_130 VPWR VGND sg13cmos5l_decap_4
* cell instance sg13cmos5l_decap_4_131 r0 *1 0,0
Xsg13cmos5l_decap_4_131 VPWR VGND sg13cmos5l_decap_4
* cell instance sg13cmos5l_decap_4_132 r0 *1 0,0
Xsg13cmos5l_decap_4_132 VPWR VGND sg13cmos5l_decap_4
* cell instance sg13cmos5l_decap_4_133 r0 *1 0,0
Xsg13cmos5l_decap_4_133 VPWR VGND sg13cmos5l_decap_4
* cell instance sg13cmos5l_decap_4_134 r0 *1 0,0
Xsg13cmos5l_decap_4_134 VPWR VGND sg13cmos5l_decap_4
* cell instance sg13cmos5l_decap_4_135 r0 *1 0,0
Xsg13cmos5l_decap_4_135 VPWR VGND sg13cmos5l_decap_4
* cell instance sg13cmos5l_decap_4_136 r0 *1 0,0
Xsg13cmos5l_decap_4_136 VPWR VGND sg13cmos5l_decap_4
* cell instance sg13cmos5l_decap_4_137 r0 *1 0,0
Xsg13cmos5l_decap_4_137 VPWR VGND sg13cmos5l_decap_4
* cell instance sg13cmos5l_decap_4_138 r0 *1 0,0
Xsg13cmos5l_decap_4_138 VPWR VGND sg13cmos5l_decap_4
* cell instance sg13cmos5l_decap_4_139 r0 *1 0,0
Xsg13cmos5l_decap_4_139 VPWR VGND sg13cmos5l_decap_4
* cell instance sg13cmos5l_decap_4_140 r0 *1 0,0
Xsg13cmos5l_decap_4_140 VPWR VGND sg13cmos5l_decap_4
* cell instance sg13cmos5l_decap_4_141 r0 *1 0,0
Xsg13cmos5l_decap_4_141 VPWR VGND sg13cmos5l_decap_4
* cell instance sg13cmos5l_decap_4_142 r0 *1 0,0
Xsg13cmos5l_decap_4_142 VPWR VGND sg13cmos5l_decap_4
* cell instance sg13cmos5l_decap_4_143 r0 *1 0,0
Xsg13cmos5l_decap_4_143 VPWR VGND sg13cmos5l_decap_4
* cell instance sg13cmos5l_decap_4_144 r0 *1 0,0
Xsg13cmos5l_decap_4_144 VPWR VGND sg13cmos5l_decap_4
* cell instance sg13cmos5l_decap_4_145 r0 *1 0,0
Xsg13cmos5l_decap_4_145 VPWR VGND sg13cmos5l_decap_4
* cell instance sg13cmos5l_decap_4_146 r0 *1 0,0
Xsg13cmos5l_decap_4_146 VPWR VGND sg13cmos5l_decap_4
* cell instance sg13cmos5l_decap_4_147 r0 *1 0,0
Xsg13cmos5l_decap_4_147 VPWR VGND sg13cmos5l_decap_4
* cell instance sg13cmos5l_decap_4_148 r0 *1 0,0
Xsg13cmos5l_decap_4_148 VPWR VGND sg13cmos5l_decap_4
* cell instance sg13cmos5l_decap_4_149 r0 *1 0,0
Xsg13cmos5l_decap_4_149 VPWR VGND sg13cmos5l_decap_4
* cell instance sg13cmos5l_decap_4_150 r0 *1 0,0
Xsg13cmos5l_decap_4_150 VPWR VGND sg13cmos5l_decap_4
* cell instance sg13cmos5l_decap_4_151 r0 *1 0,0
Xsg13cmos5l_decap_4_151 VPWR VGND sg13cmos5l_decap_4
* cell instance sg13cmos5l_decap_4_152 r0 *1 0,0
Xsg13cmos5l_decap_4_152 VPWR VGND sg13cmos5l_decap_4
* cell instance sg13cmos5l_decap_4_153 r0 *1 0,0
Xsg13cmos5l_decap_4_153 VPWR VGND sg13cmos5l_decap_4
* cell instance sg13cmos5l_decap_4_154 r0 *1 0,0
Xsg13cmos5l_decap_4_154 VPWR VGND sg13cmos5l_decap_4
* cell instance sg13cmos5l_decap_4_155 r0 *1 0,0
Xsg13cmos5l_decap_4_155 VPWR VGND sg13cmos5l_decap_4
* cell instance sg13cmos5l_decap_4_156 r0 *1 0,0
Xsg13cmos5l_decap_4_156 VPWR VGND sg13cmos5l_decap_4
* cell instance sg13cmos5l_decap_4_157 r0 *1 0,0
Xsg13cmos5l_decap_4_157 VPWR VGND sg13cmos5l_decap_4
* cell instance sg13cmos5l_decap_4_158 r0 *1 0,0
Xsg13cmos5l_decap_4_158 VPWR VGND sg13cmos5l_decap_4
* cell instance sg13cmos5l_decap_4_159 r0 *1 0,0
Xsg13cmos5l_decap_4_159 VPWR VGND sg13cmos5l_decap_4
* cell instance sg13cmos5l_decap_4_160 r0 *1 0,0
Xsg13cmos5l_decap_4_160 VPWR VGND sg13cmos5l_decap_4
* cell instance sg13cmos5l_decap_4_161 r0 *1 0,0
Xsg13cmos5l_decap_4_161 VPWR VGND sg13cmos5l_decap_4
* cell instance sg13cmos5l_decap_4_162 r0 *1 0,0
Xsg13cmos5l_decap_4_162 VPWR VGND sg13cmos5l_decap_4
* cell instance sg13cmos5l_decap_4_163 r0 *1 0,0
Xsg13cmos5l_decap_4_163 VPWR VGND sg13cmos5l_decap_4
* cell instance sg13cmos5l_decap_4_164 r0 *1 0,0
Xsg13cmos5l_decap_4_164 VPWR VGND sg13cmos5l_decap_4
* cell instance sg13cmos5l_decap_4_165 r0 *1 0,0
Xsg13cmos5l_decap_4_165 VPWR VGND sg13cmos5l_decap_4
* cell instance sg13cmos5l_decap_4_166 r0 *1 0,0
Xsg13cmos5l_decap_4_166 VPWR VGND sg13cmos5l_decap_4
* cell instance sg13cmos5l_decap_4_167 r0 *1 0,0
Xsg13cmos5l_decap_4_167 VPWR VGND sg13cmos5l_decap_4
* cell instance sg13cmos5l_decap_4_168 r0 *1 0,0
Xsg13cmos5l_decap_4_168 VPWR VGND sg13cmos5l_decap_4
* cell instance sg13cmos5l_decap_4_169 r0 *1 0,0
Xsg13cmos5l_decap_4_169 VPWR VGND sg13cmos5l_decap_4
* cell instance sg13cmos5l_decap_4_170 r0 *1 0,0
Xsg13cmos5l_decap_4_170 VPWR VGND sg13cmos5l_decap_4
* cell instance sg13cmos5l_decap_4_171 r0 *1 0,0
Xsg13cmos5l_decap_4_171 VPWR VGND sg13cmos5l_decap_4
* cell instance sg13cmos5l_decap_4_172 r0 *1 0,0
Xsg13cmos5l_decap_4_172 VPWR VGND sg13cmos5l_decap_4
* cell instance sg13cmos5l_decap_4_173 r0 *1 0,0
Xsg13cmos5l_decap_4_173 VPWR VGND sg13cmos5l_decap_4
* cell instance sg13cmos5l_decap_4_174 r0 *1 0,0
Xsg13cmos5l_decap_4_174 VPWR VGND sg13cmos5l_decap_4
* cell instance sg13cmos5l_decap_4_175 r0 *1 0,0
Xsg13cmos5l_decap_4_175 VPWR VGND sg13cmos5l_decap_4
* cell instance sg13cmos5l_decap_4_176 r0 *1 0,0
Xsg13cmos5l_decap_4_176 VPWR VGND sg13cmos5l_decap_4
* cell instance sg13cmos5l_decap_4_177 r0 *1 0,0
Xsg13cmos5l_decap_4_177 VPWR VGND sg13cmos5l_decap_4
* cell instance sg13cmos5l_decap_4_178 r0 *1 0,0
Xsg13cmos5l_decap_4_178 VPWR VGND sg13cmos5l_decap_4
* cell instance sg13cmos5l_decap_4_179 r0 *1 0,0
Xsg13cmos5l_decap_4_179 VPWR VGND sg13cmos5l_decap_4
* cell instance sg13cmos5l_decap_4_180 r0 *1 0,0
Xsg13cmos5l_decap_4_180 VPWR VGND sg13cmos5l_decap_4
* cell instance sg13cmos5l_decap_4_181 r0 *1 0,0
Xsg13cmos5l_decap_4_181 VPWR VGND sg13cmos5l_decap_4
* cell instance sg13cmos5l_decap_4_182 r0 *1 0,0
Xsg13cmos5l_decap_4_182 VPWR VGND sg13cmos5l_decap_4
* cell instance sg13cmos5l_decap_4_183 r0 *1 0,0
Xsg13cmos5l_decap_4_183 VPWR VGND sg13cmos5l_decap_4
* cell instance sg13cmos5l_decap_4_184 r0 *1 0,0
Xsg13cmos5l_decap_4_184 VPWR VGND sg13cmos5l_decap_4
* cell instance sg13cmos5l_decap_4_185 r0 *1 0,0
Xsg13cmos5l_decap_4_185 VPWR VGND sg13cmos5l_decap_4
* cell instance sg13cmos5l_decap_4_186 r0 *1 0,0
Xsg13cmos5l_decap_4_186 VPWR VGND sg13cmos5l_decap_4
* cell instance sg13cmos5l_decap_4_187 r0 *1 0,0
Xsg13cmos5l_decap_4_187 VPWR VGND sg13cmos5l_decap_4
* cell instance sg13cmos5l_decap_4_188 r0 *1 0,0
Xsg13cmos5l_decap_4_188 VPWR VGND sg13cmos5l_decap_4
* cell instance sg13cmos5l_decap_4_189 r0 *1 0,0
Xsg13cmos5l_decap_4_189 VPWR VGND sg13cmos5l_decap_4
* cell instance sg13cmos5l_decap_4_190 r0 *1 0,0
Xsg13cmos5l_decap_4_190 VPWR VGND sg13cmos5l_decap_4
* cell instance sg13cmos5l_decap_4_191 r0 *1 0,0
Xsg13cmos5l_decap_4_191 VPWR VGND sg13cmos5l_decap_4
* cell instance sg13cmos5l_decap_4_192 r0 *1 0,0
Xsg13cmos5l_decap_4_192 VPWR VGND sg13cmos5l_decap_4
* cell instance sg13cmos5l_decap_4_193 r0 *1 0,0
Xsg13cmos5l_decap_4_193 VPWR VGND sg13cmos5l_decap_4
* cell instance sg13cmos5l_decap_4_194 r0 *1 0,0
Xsg13cmos5l_decap_4_194 VPWR VGND sg13cmos5l_decap_4
* cell instance sg13cmos5l_decap_4_195 r0 *1 0,0
Xsg13cmos5l_decap_4_195 VPWR VGND sg13cmos5l_decap_4
* cell instance sg13cmos5l_decap_4_196 r0 *1 0,0
Xsg13cmos5l_decap_4_196 VPWR VGND sg13cmos5l_decap_4
* cell instance sg13cmos5l_decap_4_197 r0 *1 0,0
Xsg13cmos5l_decap_4_197 VPWR VGND sg13cmos5l_decap_4
* cell instance sg13cmos5l_decap_4_198 r0 *1 0,0
Xsg13cmos5l_decap_4_198 VPWR VGND sg13cmos5l_decap_4
* cell instance sg13cmos5l_decap_4_199 r0 *1 0,0
Xsg13cmos5l_decap_4_199 VPWR VGND sg13cmos5l_decap_4
* cell instance sg13cmos5l_decap_4_200 r0 *1 0,0
Xsg13cmos5l_decap_4_200 VPWR VGND sg13cmos5l_decap_4
* cell instance sg13cmos5l_decap_4_201 r0 *1 0,0
Xsg13cmos5l_decap_4_201 VPWR VGND sg13cmos5l_decap_4
* cell instance sg13cmos5l_decap_4_202 r0 *1 0,0
Xsg13cmos5l_decap_4_202 VPWR VGND sg13cmos5l_decap_4
* cell instance sg13cmos5l_decap_4_203 r0 *1 0,0
Xsg13cmos5l_decap_4_203 VPWR VGND sg13cmos5l_decap_4
* cell instance sg13cmos5l_decap_4_204 r0 *1 0,0
Xsg13cmos5l_decap_4_204 VPWR VGND sg13cmos5l_decap_4
* cell instance sg13cmos5l_decap_4_205 r0 *1 0,0
Xsg13cmos5l_decap_4_205 VPWR VGND sg13cmos5l_decap_4
* cell instance sg13cmos5l_decap_4_206 r0 *1 0,0
Xsg13cmos5l_decap_4_206 VPWR VGND sg13cmos5l_decap_4
* cell instance sg13cmos5l_decap_4_207 r0 *1 0,0
Xsg13cmos5l_decap_4_207 VPWR VGND sg13cmos5l_decap_4
* cell instance sg13cmos5l_decap_4_208 r0 *1 0,0
Xsg13cmos5l_decap_4_208 VPWR VGND sg13cmos5l_decap_4
* cell instance sg13cmos5l_decap_4_209 r0 *1 0,0
Xsg13cmos5l_decap_4_209 VPWR VGND sg13cmos5l_decap_4
* cell instance sg13cmos5l_decap_4_210 r0 *1 0,0
Xsg13cmos5l_decap_4_210 VPWR VGND sg13cmos5l_decap_4
* cell instance sg13cmos5l_decap_4_211 r0 *1 0,0
Xsg13cmos5l_decap_4_211 VPWR VGND sg13cmos5l_decap_4
* cell instance sg13cmos5l_decap_4_212 r0 *1 0,0
Xsg13cmos5l_decap_4_212 VPWR VGND sg13cmos5l_decap_4
* cell instance sg13cmos5l_decap_4_213 r0 *1 0,0
Xsg13cmos5l_decap_4_213 VPWR VGND sg13cmos5l_decap_4
* cell instance sg13cmos5l_decap_4_214 r0 *1 0,0
Xsg13cmos5l_decap_4_214 VPWR VGND sg13cmos5l_decap_4
* cell instance sg13cmos5l_decap_4_215 r0 *1 0,0
Xsg13cmos5l_decap_4_215 VPWR VGND sg13cmos5l_decap_4
* cell instance sg13cmos5l_decap_4_216 r0 *1 0,0
Xsg13cmos5l_decap_4_216 VPWR VGND sg13cmos5l_decap_4
* cell instance sg13cmos5l_decap_4_217 r0 *1 0,0
Xsg13cmos5l_decap_4_217 VPWR VGND sg13cmos5l_decap_4
* cell instance sg13cmos5l_decap_4_218 r0 *1 0,0
Xsg13cmos5l_decap_4_218 VPWR VGND sg13cmos5l_decap_4
* cell instance sg13cmos5l_decap_4_219 r0 *1 0,0
Xsg13cmos5l_decap_4_219 VPWR VGND sg13cmos5l_decap_4
* cell instance sg13cmos5l_decap_4_220 r0 *1 0,0
Xsg13cmos5l_decap_4_220 VPWR VGND sg13cmos5l_decap_4
* cell instance sg13cmos5l_decap_4_221 r0 *1 0,0
Xsg13cmos5l_decap_4_221 VPWR VGND sg13cmos5l_decap_4
* cell instance sg13cmos5l_decap_4_222 r0 *1 0,0
Xsg13cmos5l_decap_4_222 VPWR VGND sg13cmos5l_decap_4
* cell instance sg13cmos5l_decap_4_223 r0 *1 0,0
Xsg13cmos5l_decap_4_223 VPWR VGND sg13cmos5l_decap_4
* cell instance sg13cmos5l_decap_4_224 r0 *1 0,0
Xsg13cmos5l_decap_4_224 VPWR VGND sg13cmos5l_decap_4
* cell instance sg13cmos5l_decap_4_225 r0 *1 0,0
Xsg13cmos5l_decap_4_225 VPWR VGND sg13cmos5l_decap_4
* cell instance sg13cmos5l_decap_4_226 r0 *1 0,0
Xsg13cmos5l_decap_4_226 VPWR VGND sg13cmos5l_decap_4
* cell instance sg13cmos5l_decap_4_227 r0 *1 0,0
Xsg13cmos5l_decap_4_227 VPWR VGND sg13cmos5l_decap_4
* cell instance sg13cmos5l_decap_4_228 r0 *1 0,0
Xsg13cmos5l_decap_4_228 VPWR VGND sg13cmos5l_decap_4
* cell instance sg13cmos5l_decap_4_229 r0 *1 0,0
Xsg13cmos5l_decap_4_229 VPWR VGND sg13cmos5l_decap_4
* cell instance sg13cmos5l_decap_4_230 r0 *1 0,0
Xsg13cmos5l_decap_4_230 VPWR VGND sg13cmos5l_decap_4
* cell instance sg13cmos5l_decap_4_231 r0 *1 0,0
Xsg13cmos5l_decap_4_231 VPWR VGND sg13cmos5l_decap_4
* cell instance sg13cmos5l_decap_4_232 r0 *1 0,0
Xsg13cmos5l_decap_4_232 VPWR VGND sg13cmos5l_decap_4
* cell instance sg13cmos5l_decap_4_233 r0 *1 0,0
Xsg13cmos5l_decap_4_233 VPWR VGND sg13cmos5l_decap_4
* cell instance sg13cmos5l_decap_4_234 r0 *1 0,0
Xsg13cmos5l_decap_4_234 VPWR VGND sg13cmos5l_decap_4
* cell instance sg13cmos5l_decap_4_235 r0 *1 0,0
Xsg13cmos5l_decap_4_235 VPWR VGND sg13cmos5l_decap_4
* cell instance sg13cmos5l_decap_4_236 r0 *1 0,0
Xsg13cmos5l_decap_4_236 VPWR VGND sg13cmos5l_decap_4
* cell instance sg13cmos5l_decap_4_237 r0 *1 0,0
Xsg13cmos5l_decap_4_237 VPWR VGND sg13cmos5l_decap_4
* cell instance sg13cmos5l_decap_4_238 r0 *1 0,0
Xsg13cmos5l_decap_4_238 VPWR VGND sg13cmos5l_decap_4
* cell instance sg13cmos5l_decap_4_239 r0 *1 0,0
Xsg13cmos5l_decap_4_239 VPWR VGND sg13cmos5l_decap_4
* cell instance sg13cmos5l_decap_4_240 r0 *1 0,0
Xsg13cmos5l_decap_4_240 VPWR VGND sg13cmos5l_decap_4
* cell instance sg13cmos5l_decap_4_241 r0 *1 0,0
Xsg13cmos5l_decap_4_241 VPWR VGND sg13cmos5l_decap_4
* cell instance sg13cmos5l_decap_4_242 r0 *1 0,0
Xsg13cmos5l_decap_4_242 VPWR VGND sg13cmos5l_decap_4
* cell instance sg13cmos5l_decap_4_243 r0 *1 0,0
Xsg13cmos5l_decap_4_243 VPWR VGND sg13cmos5l_decap_4
* cell instance sg13cmos5l_decap_4_244 r0 *1 0,0
Xsg13cmos5l_decap_4_244 VPWR VGND sg13cmos5l_decap_4
* cell instance sg13cmos5l_decap_4_245 r0 *1 0,0
Xsg13cmos5l_decap_4_245 VPWR VGND sg13cmos5l_decap_4
* cell instance sg13cmos5l_decap_4_246 r0 *1 0,0
Xsg13cmos5l_decap_4_246 VPWR VGND sg13cmos5l_decap_4
* cell instance sg13cmos5l_decap_4_247 r0 *1 0,0
Xsg13cmos5l_decap_4_247 VPWR VGND sg13cmos5l_decap_4
* cell instance sg13cmos5l_decap_4_248 r0 *1 0,0
Xsg13cmos5l_decap_4_248 VPWR VGND sg13cmos5l_decap_4
* cell instance sg13cmos5l_decap_4_249 r0 *1 0,0
Xsg13cmos5l_decap_4_249 VPWR VGND sg13cmos5l_decap_4
* cell instance sg13cmos5l_decap_4_250 r0 *1 0,0
Xsg13cmos5l_decap_4_250 VPWR VGND sg13cmos5l_decap_4
* cell instance sg13cmos5l_decap_4_251 r0 *1 0,0
Xsg13cmos5l_decap_4_251 VPWR VGND sg13cmos5l_decap_4
* cell instance sg13cmos5l_decap_4_252 r0 *1 0,0
Xsg13cmos5l_decap_4_252 VPWR VGND sg13cmos5l_decap_4
* cell instance sg13cmos5l_decap_4_253 r0 *1 0,0
Xsg13cmos5l_decap_4_253 VPWR VGND sg13cmos5l_decap_4
* cell instance sg13cmos5l_decap_4_254 r0 *1 0,0
Xsg13cmos5l_decap_4_254 VPWR VGND sg13cmos5l_decap_4
* cell instance sg13cmos5l_decap_4_255 r0 *1 0,0
Xsg13cmos5l_decap_4_255 VPWR VGND sg13cmos5l_decap_4
* cell instance sg13cmos5l_decap_4_256 r0 *1 0,0
Xsg13cmos5l_decap_4_256 VPWR VGND sg13cmos5l_decap_4
* cell instance sg13cmos5l_decap_4_257 r0 *1 0,0
Xsg13cmos5l_decap_4_257 VPWR VGND sg13cmos5l_decap_4
* cell instance sg13cmos5l_decap_4_258 r0 *1 0,0
Xsg13cmos5l_decap_4_258 VPWR VGND sg13cmos5l_decap_4
* cell instance sg13cmos5l_decap_4_259 r0 *1 0,0
Xsg13cmos5l_decap_4_259 VPWR VGND sg13cmos5l_decap_4
* cell instance sg13cmos5l_decap_4_260 r0 *1 0,0
Xsg13cmos5l_decap_4_260 VPWR VGND sg13cmos5l_decap_4
* cell instance sg13cmos5l_decap_4_261 r0 *1 0,0
Xsg13cmos5l_decap_4_261 VPWR VGND sg13cmos5l_decap_4
* cell instance sg13cmos5l_decap_4_262 r0 *1 0,0
Xsg13cmos5l_decap_4_262 VPWR VGND sg13cmos5l_decap_4
* cell instance sg13cmos5l_decap_4_263 r0 *1 0,0
Xsg13cmos5l_decap_4_263 VPWR VGND sg13cmos5l_decap_4
* cell instance sg13cmos5l_decap_4_264 r0 *1 0,0
Xsg13cmos5l_decap_4_264 VPWR VGND sg13cmos5l_decap_4
* cell instance sg13cmos5l_decap_4_265 r0 *1 0,0
Xsg13cmos5l_decap_4_265 VPWR VGND sg13cmos5l_decap_4
* cell instance sg13cmos5l_decap_4_266 r0 *1 0,0
Xsg13cmos5l_decap_4_266 VPWR VGND sg13cmos5l_decap_4
* cell instance sg13cmos5l_decap_4_267 r0 *1 0,0
Xsg13cmos5l_decap_4_267 VPWR VGND sg13cmos5l_decap_4
* cell instance sg13cmos5l_decap_4_268 r0 *1 0,0
Xsg13cmos5l_decap_4_268 VPWR VGND sg13cmos5l_decap_4
* cell instance sg13cmos5l_decap_4_269 r0 *1 0,0
Xsg13cmos5l_decap_4_269 VPWR VGND sg13cmos5l_decap_4
* cell instance sg13cmos5l_decap_4_270 r0 *1 0,0
Xsg13cmos5l_decap_4_270 VPWR VGND sg13cmos5l_decap_4
* cell instance sg13cmos5l_decap_4_271 r0 *1 0,0
Xsg13cmos5l_decap_4_271 VPWR VGND sg13cmos5l_decap_4
* cell instance sg13cmos5l_decap_4_272 r0 *1 0,0
Xsg13cmos5l_decap_4_272 VPWR VGND sg13cmos5l_decap_4
* cell instance sg13cmos5l_decap_4_273 r0 *1 0,0
Xsg13cmos5l_decap_4_273 VPWR VGND sg13cmos5l_decap_4
* cell instance sg13cmos5l_decap_4_274 r0 *1 0,0
Xsg13cmos5l_decap_4_274 VPWR VGND sg13cmos5l_decap_4
* cell instance sg13cmos5l_decap_4_275 r0 *1 0,0
Xsg13cmos5l_decap_4_275 VPWR VGND sg13cmos5l_decap_4
* cell instance sg13cmos5l_decap_4_276 r0 *1 0,0
Xsg13cmos5l_decap_4_276 VPWR VGND sg13cmos5l_decap_4
* cell instance sg13cmos5l_decap_4_277 r0 *1 0,0
Xsg13cmos5l_decap_4_277 VPWR VGND sg13cmos5l_decap_4
* cell instance sg13cmos5l_decap_4_278 r0 *1 0,0
Xsg13cmos5l_decap_4_278 VPWR VGND sg13cmos5l_decap_4
* cell instance sg13cmos5l_decap_4_279 r0 *1 0,0
Xsg13cmos5l_decap_4_279 VPWR VGND sg13cmos5l_decap_4
* cell instance sg13cmos5l_decap_4_280 r0 *1 0,0
Xsg13cmos5l_decap_4_280 VPWR VGND sg13cmos5l_decap_4
* cell instance sg13cmos5l_decap_4_281 r0 *1 0,0
Xsg13cmos5l_decap_4_281 VPWR VGND sg13cmos5l_decap_4
* cell instance sg13cmos5l_decap_4_282 r0 *1 0,0
Xsg13cmos5l_decap_4_282 VPWR VGND sg13cmos5l_decap_4
* cell instance sg13cmos5l_decap_4_283 r0 *1 0,0
Xsg13cmos5l_decap_4_283 VPWR VGND sg13cmos5l_decap_4
* cell instance sg13cmos5l_decap_4_284 r0 *1 0,0
Xsg13cmos5l_decap_4_284 VPWR VGND sg13cmos5l_decap_4
* cell instance sg13cmos5l_decap_4_285 r0 *1 0,0
Xsg13cmos5l_decap_4_285 VPWR VGND sg13cmos5l_decap_4
* cell instance sg13cmos5l_decap_4_286 r0 *1 0,0
Xsg13cmos5l_decap_4_286 VPWR VGND sg13cmos5l_decap_4
* cell instance sg13cmos5l_decap_4_287 r0 *1 0,0
Xsg13cmos5l_decap_4_287 VPWR VGND sg13cmos5l_decap_4
* cell instance sg13cmos5l_decap_4_288 r0 *1 0,0
Xsg13cmos5l_decap_4_288 VPWR VGND sg13cmos5l_decap_4
* cell instance sg13cmos5l_decap_4_289 r0 *1 0,0
Xsg13cmos5l_decap_4_289 VPWR VGND sg13cmos5l_decap_4
* cell instance sg13cmos5l_decap_4_290 r0 *1 0,0
Xsg13cmos5l_decap_4_290 VPWR VGND sg13cmos5l_decap_4
* cell instance sg13cmos5l_decap_4_291 r0 *1 0,0
Xsg13cmos5l_decap_4_291 VPWR VGND sg13cmos5l_decap_4
* cell instance sg13cmos5l_decap_4_292 r0 *1 0,0
Xsg13cmos5l_decap_4_292 VPWR VGND sg13cmos5l_decap_4
* cell instance sg13cmos5l_decap_4_293 r0 *1 0,0
Xsg13cmos5l_decap_4_293 VPWR VGND sg13cmos5l_decap_4
* cell instance sg13cmos5l_decap_4_294 r0 *1 0,0
Xsg13cmos5l_decap_4_294 VPWR VGND sg13cmos5l_decap_4
* cell instance sg13cmos5l_decap_4_295 r0 *1 0,0
Xsg13cmos5l_decap_4_295 VPWR VGND sg13cmos5l_decap_4
* cell instance sg13cmos5l_decap_4_296 r0 *1 0,0
Xsg13cmos5l_decap_4_296 VPWR VGND sg13cmos5l_decap_4
* cell instance sg13cmos5l_decap_4_297 r0 *1 0,0
Xsg13cmos5l_decap_4_297 VPWR VGND sg13cmos5l_decap_4
* cell instance sg13cmos5l_decap_4_298 r0 *1 0,0
Xsg13cmos5l_decap_4_298 VPWR VGND sg13cmos5l_decap_4
* cell instance sg13cmos5l_decap_4_299 r0 *1 0,0
Xsg13cmos5l_decap_4_299 VPWR VGND sg13cmos5l_decap_4
* cell instance sg13cmos5l_decap_4_300 r0 *1 0,0
Xsg13cmos5l_decap_4_300 VPWR VGND sg13cmos5l_decap_4
* cell instance sg13cmos5l_decap_4_301 r0 *1 0,0
Xsg13cmos5l_decap_4_301 VPWR VGND sg13cmos5l_decap_4
* cell instance sg13cmos5l_decap_4_302 r0 *1 0,0
Xsg13cmos5l_decap_4_302 VPWR VGND sg13cmos5l_decap_4
* cell instance sg13cmos5l_decap_4_303 r0 *1 0,0
Xsg13cmos5l_decap_4_303 VPWR VGND sg13cmos5l_decap_4
* cell instance sg13cmos5l_decap_4_304 r0 *1 0,0
Xsg13cmos5l_decap_4_304 VPWR VGND sg13cmos5l_decap_4
* cell instance sg13cmos5l_decap_4_305 r0 *1 0,0
Xsg13cmos5l_decap_4_305 VPWR VGND sg13cmos5l_decap_4
* cell instance sg13cmos5l_decap_4_306 r0 *1 0,0
Xsg13cmos5l_decap_4_306 VPWR VGND sg13cmos5l_decap_4
* cell instance sg13cmos5l_decap_4_307 r0 *1 0,0
Xsg13cmos5l_decap_4_307 VPWR VGND sg13cmos5l_decap_4
* cell instance sg13cmos5l_decap_4_308 r0 *1 0,0
Xsg13cmos5l_decap_4_308 VPWR VGND sg13cmos5l_decap_4
* cell instance sg13cmos5l_decap_4_309 r0 *1 0,0
Xsg13cmos5l_decap_4_309 VPWR VGND sg13cmos5l_decap_4
* cell instance sg13cmos5l_decap_4_310 r0 *1 0,0
Xsg13cmos5l_decap_4_310 VPWR VGND sg13cmos5l_decap_4
* cell instance sg13cmos5l_decap_4_311 r0 *1 0,0
Xsg13cmos5l_decap_4_311 VPWR VGND sg13cmos5l_decap_4
* cell instance sg13cmos5l_decap_4_312 r0 *1 0,0
Xsg13cmos5l_decap_4_312 VPWR VGND sg13cmos5l_decap_4
* cell instance sg13cmos5l_decap_4_313 r0 *1 0,0
Xsg13cmos5l_decap_4_313 VPWR VGND sg13cmos5l_decap_4
* cell instance sg13cmos5l_decap_4_314 r0 *1 0,0
Xsg13cmos5l_decap_4_314 VPWR VGND sg13cmos5l_decap_4
* cell instance sg13cmos5l_decap_4_315 r0 *1 0,0
Xsg13cmos5l_decap_4_315 VPWR VGND sg13cmos5l_decap_4
* cell instance sg13cmos5l_decap_4_316 r0 *1 0,0
Xsg13cmos5l_decap_4_316 VPWR VGND sg13cmos5l_decap_4
* cell instance sg13cmos5l_decap_4_317 r0 *1 0,0
Xsg13cmos5l_decap_4_317 VPWR VGND sg13cmos5l_decap_4
* cell instance sg13cmos5l_decap_4_318 r0 *1 0,0
Xsg13cmos5l_decap_4_318 VPWR VGND sg13cmos5l_decap_4
* cell instance sg13cmos5l_decap_4_319 r0 *1 0,0
Xsg13cmos5l_decap_4_319 VPWR VGND sg13cmos5l_decap_4
* cell instance sg13cmos5l_decap_4_320 r0 *1 0,0
Xsg13cmos5l_decap_4_320 VPWR VGND sg13cmos5l_decap_4
* cell instance sg13cmos5l_decap_4_321 r0 *1 0,0
Xsg13cmos5l_decap_4_321 VPWR VGND sg13cmos5l_decap_4
* cell instance sg13cmos5l_decap_4_322 r0 *1 0,0
Xsg13cmos5l_decap_4_322 VPWR VGND sg13cmos5l_decap_4
* cell instance sg13cmos5l_decap_4_323 r0 *1 0,0
Xsg13cmos5l_decap_4_323 VPWR VGND sg13cmos5l_decap_4
* cell instance sg13cmos5l_decap_4_324 r0 *1 0,0
Xsg13cmos5l_decap_4_324 VPWR VGND sg13cmos5l_decap_4
* cell instance sg13cmos5l_decap_4_325 r0 *1 0,0
Xsg13cmos5l_decap_4_325 VPWR VGND sg13cmos5l_decap_4
* cell instance sg13cmos5l_decap_4_326 r0 *1 0,0
Xsg13cmos5l_decap_4_326 VPWR VGND sg13cmos5l_decap_4
* cell instance sg13cmos5l_decap_4_327 r0 *1 0,0
Xsg13cmos5l_decap_4_327 VPWR VGND sg13cmos5l_decap_4
* cell instance sg13cmos5l_decap_4_328 r0 *1 0,0
Xsg13cmos5l_decap_4_328 VPWR VGND sg13cmos5l_decap_4
* cell instance sg13cmos5l_decap_4_329 r0 *1 0,0
Xsg13cmos5l_decap_4_329 VPWR VGND sg13cmos5l_decap_4
* cell instance sg13cmos5l_decap_4_330 r0 *1 0,0
Xsg13cmos5l_decap_4_330 VPWR VGND sg13cmos5l_decap_4
* cell instance sg13cmos5l_decap_4_331 r0 *1 0,0
Xsg13cmos5l_decap_4_331 VPWR VGND sg13cmos5l_decap_4
* cell instance sg13cmos5l_decap_4_332 r0 *1 0,0
Xsg13cmos5l_decap_4_332 VPWR VGND sg13cmos5l_decap_4
* cell instance sg13cmos5l_decap_4_333 r0 *1 0,0
Xsg13cmos5l_decap_4_333 VPWR VGND sg13cmos5l_decap_4
* cell instance sg13cmos5l_decap_4_334 r0 *1 0,0
Xsg13cmos5l_decap_4_334 VPWR VGND sg13cmos5l_decap_4
* cell instance sg13cmos5l_decap_4_335 r0 *1 0,0
Xsg13cmos5l_decap_4_335 VPWR VGND sg13cmos5l_decap_4
* cell instance sg13cmos5l_decap_4_336 r0 *1 0,0
Xsg13cmos5l_decap_4_336 VPWR VGND sg13cmos5l_decap_4
* cell instance sg13cmos5l_decap_4_337 r0 *1 0,0
Xsg13cmos5l_decap_4_337 VPWR VGND sg13cmos5l_decap_4
* cell instance sg13cmos5l_decap_4_338 r0 *1 0,0
Xsg13cmos5l_decap_4_338 VPWR VGND sg13cmos5l_decap_4
* cell instance sg13cmos5l_decap_4_339 r0 *1 0,0
Xsg13cmos5l_decap_4_339 VPWR VGND sg13cmos5l_decap_4
* cell instance sg13cmos5l_decap_4_340 r0 *1 0,0
Xsg13cmos5l_decap_4_340 VPWR VGND sg13cmos5l_decap_4
* cell instance sg13cmos5l_decap_4_341 r0 *1 0,0
Xsg13cmos5l_decap_4_341 VPWR VGND sg13cmos5l_decap_4
* cell instance sg13cmos5l_decap_4_342 r0 *1 0,0
Xsg13cmos5l_decap_4_342 VPWR VGND sg13cmos5l_decap_4
* cell instance sg13cmos5l_decap_4_343 r0 *1 0,0
Xsg13cmos5l_decap_4_343 VPWR VGND sg13cmos5l_decap_4
* cell instance sg13cmos5l_decap_4_344 r0 *1 0,0
Xsg13cmos5l_decap_4_344 VPWR VGND sg13cmos5l_decap_4
* cell instance sg13cmos5l_decap_4_345 r0 *1 0,0
Xsg13cmos5l_decap_4_345 VPWR VGND sg13cmos5l_decap_4
* cell instance sg13cmos5l_decap_4_346 r0 *1 0,0
Xsg13cmos5l_decap_4_346 VPWR VGND sg13cmos5l_decap_4
* cell instance sg13cmos5l_decap_4_347 r0 *1 0,0
Xsg13cmos5l_decap_4_347 VPWR VGND sg13cmos5l_decap_4
* cell instance sg13cmos5l_decap_4_348 r0 *1 0,0
Xsg13cmos5l_decap_4_348 VPWR VGND sg13cmos5l_decap_4
* cell instance sg13cmos5l_decap_4_349 r0 *1 0,0
Xsg13cmos5l_decap_4_349 VPWR VGND sg13cmos5l_decap_4
* cell instance sg13cmos5l_decap_4_350 r0 *1 0,0
Xsg13cmos5l_decap_4_350 VPWR VGND sg13cmos5l_decap_4
* cell instance sg13cmos5l_decap_4_351 r0 *1 0,0
Xsg13cmos5l_decap_4_351 VPWR VGND sg13cmos5l_decap_4
* cell instance sg13cmos5l_decap_4_352 r0 *1 0,0
Xsg13cmos5l_decap_4_352 VPWR VGND sg13cmos5l_decap_4
* cell instance sg13cmos5l_decap_4_353 r0 *1 0,0
Xsg13cmos5l_decap_4_353 VPWR VGND sg13cmos5l_decap_4
* cell instance sg13cmos5l_decap_4_354 r0 *1 0,0
Xsg13cmos5l_decap_4_354 VPWR VGND sg13cmos5l_decap_4
* cell instance sg13cmos5l_decap_4_355 r0 *1 0,0
Xsg13cmos5l_decap_4_355 VPWR VGND sg13cmos5l_decap_4
* cell instance sg13cmos5l_decap_4_356 r0 *1 0,0
Xsg13cmos5l_decap_4_356 VPWR VGND sg13cmos5l_decap_4
* cell instance sg13cmos5l_decap_4_357 r0 *1 0,0
Xsg13cmos5l_decap_4_357 VPWR VGND sg13cmos5l_decap_4
* cell instance sg13cmos5l_decap_4_358 r0 *1 0,0
Xsg13cmos5l_decap_4_358 VPWR VGND sg13cmos5l_decap_4
* cell instance sg13cmos5l_decap_4_359 r0 *1 0,0
Xsg13cmos5l_decap_4_359 VPWR VGND sg13cmos5l_decap_4
* cell instance sg13cmos5l_decap_4_360 r0 *1 0,0
Xsg13cmos5l_decap_4_360 VPWR VGND sg13cmos5l_decap_4
* cell instance sg13cmos5l_decap_4_361 r0 *1 0,0
Xsg13cmos5l_decap_4_361 VPWR VGND sg13cmos5l_decap_4
* cell instance sg13cmos5l_decap_4_362 r0 *1 0,0
Xsg13cmos5l_decap_4_362 VPWR VGND sg13cmos5l_decap_4
* cell instance sg13cmos5l_decap_4_363 r0 *1 0,0
Xsg13cmos5l_decap_4_363 VPWR VGND sg13cmos5l_decap_4
* cell instance sg13cmos5l_decap_4_364 r0 *1 0,0
Xsg13cmos5l_decap_4_364 VPWR VGND sg13cmos5l_decap_4
* cell instance sg13cmos5l_decap_4_365 r0 *1 0,0
Xsg13cmos5l_decap_4_365 VPWR VGND sg13cmos5l_decap_4
* cell instance sg13cmos5l_decap_4_366 r0 *1 0,0
Xsg13cmos5l_decap_4_366 VPWR VGND sg13cmos5l_decap_4
* cell instance sg13cmos5l_decap_4_367 r0 *1 0,0
Xsg13cmos5l_decap_4_367 VPWR VGND sg13cmos5l_decap_4
* cell instance sg13cmos5l_decap_4_368 r0 *1 0,0
Xsg13cmos5l_decap_4_368 VPWR VGND sg13cmos5l_decap_4
* cell instance sg13cmos5l_decap_4_369 r0 *1 0,0
Xsg13cmos5l_decap_4_369 VPWR VGND sg13cmos5l_decap_4
* cell instance sg13cmos5l_decap_4_370 r0 *1 0,0
Xsg13cmos5l_decap_4_370 VPWR VGND sg13cmos5l_decap_4
* cell instance sg13cmos5l_decap_4_371 r0 *1 0,0
Xsg13cmos5l_decap_4_371 VPWR VGND sg13cmos5l_decap_4
* cell instance sg13cmos5l_decap_4_372 r0 *1 0,0
Xsg13cmos5l_decap_4_372 VPWR VGND sg13cmos5l_decap_4
* cell instance sg13cmos5l_decap_4_373 r0 *1 0,0
Xsg13cmos5l_decap_4_373 VPWR VGND sg13cmos5l_decap_4
* cell instance sg13cmos5l_decap_4_374 r0 *1 0,0
Xsg13cmos5l_decap_4_374 VPWR VGND sg13cmos5l_decap_4
* cell instance sg13cmos5l_decap_4_375 r0 *1 0,0
Xsg13cmos5l_decap_4_375 VPWR VGND sg13cmos5l_decap_4
* cell instance sg13cmos5l_decap_4_376 r0 *1 0,0
Xsg13cmos5l_decap_4_376 VPWR VGND sg13cmos5l_decap_4
* cell instance sg13cmos5l_decap_4_377 r0 *1 0,0
Xsg13cmos5l_decap_4_377 VPWR VGND sg13cmos5l_decap_4
* cell instance sg13cmos5l_decap_4_378 r0 *1 0,0
Xsg13cmos5l_decap_4_378 VPWR VGND sg13cmos5l_decap_4
* cell instance sg13cmos5l_decap_4_379 r0 *1 0,0
Xsg13cmos5l_decap_4_379 VPWR VGND sg13cmos5l_decap_4
* cell instance sg13cmos5l_decap_4_380 r0 *1 0,0
Xsg13cmos5l_decap_4_380 VPWR VGND sg13cmos5l_decap_4
* cell instance sg13cmos5l_decap_4_381 r0 *1 0,0
Xsg13cmos5l_decap_4_381 VPWR VGND sg13cmos5l_decap_4
* cell instance sg13cmos5l_decap_4_382 r0 *1 0,0
Xsg13cmos5l_decap_4_382 VPWR VGND sg13cmos5l_decap_4
* cell instance sg13cmos5l_decap_4_383 r0 *1 0,0
Xsg13cmos5l_decap_4_383 VPWR VGND sg13cmos5l_decap_4
* cell instance sg13cmos5l_decap_4_384 r0 *1 0,0
Xsg13cmos5l_decap_4_384 VPWR VGND sg13cmos5l_decap_4
* cell instance sg13cmos5l_decap_4_385 r0 *1 0,0
Xsg13cmos5l_decap_4_385 VPWR VGND sg13cmos5l_decap_4
* cell instance sg13cmos5l_decap_4_386 r0 *1 0,0
Xsg13cmos5l_decap_4_386 VPWR VGND sg13cmos5l_decap_4
* cell instance sg13cmos5l_decap_4_387 r0 *1 0,0
Xsg13cmos5l_decap_4_387 VPWR VGND sg13cmos5l_decap_4
* cell instance sg13cmos5l_decap_4_388 r0 *1 0,0
Xsg13cmos5l_decap_4_388 VPWR VGND sg13cmos5l_decap_4
* cell instance sg13cmos5l_decap_4_389 r0 *1 0,0
Xsg13cmos5l_decap_4_389 VPWR VGND sg13cmos5l_decap_4
* cell instance sg13cmos5l_decap_4_390 r0 *1 0,0
Xsg13cmos5l_decap_4_390 VPWR VGND sg13cmos5l_decap_4
* cell instance sg13cmos5l_decap_4_391 r0 *1 0,0
Xsg13cmos5l_decap_4_391 VPWR VGND sg13cmos5l_decap_4
* cell instance sg13cmos5l_decap_4_392 r0 *1 0,0
Xsg13cmos5l_decap_4_392 VPWR VGND sg13cmos5l_decap_4
* cell instance sg13cmos5l_decap_4_393 r0 *1 0,0
Xsg13cmos5l_decap_4_393 VPWR VGND sg13cmos5l_decap_4
* cell instance sg13cmos5l_decap_4_394 r0 *1 0,0
Xsg13cmos5l_decap_4_394 VPWR VGND sg13cmos5l_decap_4
* cell instance sg13cmos5l_decap_4_395 r0 *1 0,0
Xsg13cmos5l_decap_4_395 VPWR VGND sg13cmos5l_decap_4
* cell instance sg13cmos5l_decap_4_396 r0 *1 0,0
Xsg13cmos5l_decap_4_396 VPWR VGND sg13cmos5l_decap_4
* cell instance sg13cmos5l_decap_4_397 r0 *1 0,0
Xsg13cmos5l_decap_4_397 VPWR VGND sg13cmos5l_decap_4
* cell instance sg13cmos5l_decap_4_398 r0 *1 0,0
Xsg13cmos5l_decap_4_398 VPWR VGND sg13cmos5l_decap_4
* cell instance sg13cmos5l_decap_4_399 r0 *1 0,0
Xsg13cmos5l_decap_4_399 VPWR VGND sg13cmos5l_decap_4
* cell instance sg13cmos5l_decap_4_400 r0 *1 0,0
Xsg13cmos5l_decap_4_400 VPWR VGND sg13cmos5l_decap_4
* cell instance sg13cmos5l_decap_4_401 r0 *1 0,0
Xsg13cmos5l_decap_4_401 VPWR VGND sg13cmos5l_decap_4
* cell instance sg13cmos5l_decap_4_402 r0 *1 0,0
Xsg13cmos5l_decap_4_402 VPWR VGND sg13cmos5l_decap_4
* cell instance sg13cmos5l_decap_4_403 r0 *1 0,0
Xsg13cmos5l_decap_4_403 VPWR VGND sg13cmos5l_decap_4
* cell instance sg13cmos5l_decap_4_404 r0 *1 0,0
Xsg13cmos5l_decap_4_404 VPWR VGND sg13cmos5l_decap_4
* cell instance sg13cmos5l_decap_4_405 r0 *1 0,0
Xsg13cmos5l_decap_4_405 VPWR VGND sg13cmos5l_decap_4
* cell instance sg13cmos5l_decap_4_406 r0 *1 0,0
Xsg13cmos5l_decap_4_406 VPWR VGND sg13cmos5l_decap_4
* cell instance sg13cmos5l_decap_4_407 r0 *1 0,0
Xsg13cmos5l_decap_4_407 VPWR VGND sg13cmos5l_decap_4
* cell instance sg13cmos5l_decap_4_408 r0 *1 0,0
Xsg13cmos5l_decap_4_408 VPWR VGND sg13cmos5l_decap_4
* cell instance sg13cmos5l_decap_4_409 r0 *1 0,0
Xsg13cmos5l_decap_4_409 VPWR VGND sg13cmos5l_decap_4
* cell instance sg13cmos5l_decap_4_410 r0 *1 0,0
Xsg13cmos5l_decap_4_410 VPWR VGND sg13cmos5l_decap_4
* cell instance sg13cmos5l_decap_4_411 r0 *1 0,0
Xsg13cmos5l_decap_4_411 VPWR VGND sg13cmos5l_decap_4
* cell instance sg13cmos5l_decap_4_412 r0 *1 0,0
Xsg13cmos5l_decap_4_412 VPWR VGND sg13cmos5l_decap_4
* cell instance sg13cmos5l_decap_4_413 r0 *1 0,0
Xsg13cmos5l_decap_4_413 VPWR VGND sg13cmos5l_decap_4
* cell instance sg13cmos5l_decap_4_414 r0 *1 0,0
Xsg13cmos5l_decap_4_414 VPWR VGND sg13cmos5l_decap_4
* cell instance sg13cmos5l_decap_4_415 r0 *1 0,0
Xsg13cmos5l_decap_4_415 VPWR VGND sg13cmos5l_decap_4
* cell instance sg13cmos5l_decap_4_416 r0 *1 0,0
Xsg13cmos5l_decap_4_416 VPWR VGND sg13cmos5l_decap_4
* cell instance sg13cmos5l_decap_4_417 r0 *1 0,0
Xsg13cmos5l_decap_4_417 VPWR VGND sg13cmos5l_decap_4
* cell instance sg13cmos5l_decap_4_418 r0 *1 0,0
Xsg13cmos5l_decap_4_418 VPWR VGND sg13cmos5l_decap_4
* cell instance sg13cmos5l_decap_4_419 r0 *1 0,0
Xsg13cmos5l_decap_4_419 VPWR VGND sg13cmos5l_decap_4
* cell instance sg13cmos5l_decap_4_420 r0 *1 0,0
Xsg13cmos5l_decap_4_420 VPWR VGND sg13cmos5l_decap_4
* cell instance sg13cmos5l_decap_4_421 r0 *1 0,0
Xsg13cmos5l_decap_4_421 VPWR VGND sg13cmos5l_decap_4
* cell instance sg13cmos5l_decap_4_422 r0 *1 0,0
Xsg13cmos5l_decap_4_422 VPWR VGND sg13cmos5l_decap_4
* cell instance sg13cmos5l_decap_4_423 r0 *1 0,0
Xsg13cmos5l_decap_4_423 VPWR VGND sg13cmos5l_decap_4
* cell instance sg13cmos5l_decap_4_424 r0 *1 0,0
Xsg13cmos5l_decap_4_424 VPWR VGND sg13cmos5l_decap_4
* cell instance sg13cmos5l_decap_4_425 r0 *1 0,0
Xsg13cmos5l_decap_4_425 VPWR VGND sg13cmos5l_decap_4
* cell instance sg13cmos5l_decap_4_426 r0 *1 0,0
Xsg13cmos5l_decap_4_426 VPWR VGND sg13cmos5l_decap_4
* cell instance sg13cmos5l_decap_4_427 r0 *1 0,0
Xsg13cmos5l_decap_4_427 VPWR VGND sg13cmos5l_decap_4
* cell instance sg13cmos5l_decap_4_428 r0 *1 0,0
Xsg13cmos5l_decap_4_428 VPWR VGND sg13cmos5l_decap_4
* cell instance sg13cmos5l_decap_4_429 r0 *1 0,0
Xsg13cmos5l_decap_4_429 VPWR VGND sg13cmos5l_decap_4
* cell instance sg13cmos5l_decap_4_430 r0 *1 0,0
Xsg13cmos5l_decap_4_430 VPWR VGND sg13cmos5l_decap_4
* cell instance sg13cmos5l_decap_4_431 r0 *1 0,0
Xsg13cmos5l_decap_4_431 VPWR VGND sg13cmos5l_decap_4
* cell instance sg13cmos5l_decap_4_432 r0 *1 0,0
Xsg13cmos5l_decap_4_432 VPWR VGND sg13cmos5l_decap_4
* cell instance sg13cmos5l_decap_4_433 r0 *1 0,0
Xsg13cmos5l_decap_4_433 VPWR VGND sg13cmos5l_decap_4
* cell instance sg13cmos5l_decap_4_434 r0 *1 0,0
Xsg13cmos5l_decap_4_434 VPWR VGND sg13cmos5l_decap_4
* cell instance sg13cmos5l_decap_4_435 r0 *1 0,0
Xsg13cmos5l_decap_4_435 VPWR VGND sg13cmos5l_decap_4
* cell instance sg13cmos5l_decap_4_436 r0 *1 0,0
Xsg13cmos5l_decap_4_436 VPWR VGND sg13cmos5l_decap_4
* cell instance sg13cmos5l_decap_4_437 r0 *1 0,0
Xsg13cmos5l_decap_4_437 VPWR VGND sg13cmos5l_decap_4
* cell instance sg13cmos5l_decap_4_438 r0 *1 0,0
Xsg13cmos5l_decap_4_438 VPWR VGND sg13cmos5l_decap_4
* cell instance sg13cmos5l_decap_4_439 r0 *1 0,0
Xsg13cmos5l_decap_4_439 VPWR VGND sg13cmos5l_decap_4
* cell instance sg13cmos5l_decap_4_440 r0 *1 0,0
Xsg13cmos5l_decap_4_440 VPWR VGND sg13cmos5l_decap_4
* cell instance sg13cmos5l_decap_4_441 r0 *1 0,0
Xsg13cmos5l_decap_4_441 VPWR VGND sg13cmos5l_decap_4
* cell instance sg13cmos5l_decap_4_442 r0 *1 0,0
Xsg13cmos5l_decap_4_442 VPWR VGND sg13cmos5l_decap_4
* cell instance sg13cmos5l_decap_4_443 r0 *1 0,0
Xsg13cmos5l_decap_4_443 VPWR VGND sg13cmos5l_decap_4
* cell instance sg13cmos5l_decap_4_444 r0 *1 0,0
Xsg13cmos5l_decap_4_444 VPWR VGND sg13cmos5l_decap_4
* cell instance sg13cmos5l_decap_4_445 r0 *1 0,0
Xsg13cmos5l_decap_4_445 VPWR VGND sg13cmos5l_decap_4
* cell instance sg13cmos5l_decap_4_446 r0 *1 0,0
Xsg13cmos5l_decap_4_446 VPWR VGND sg13cmos5l_decap_4
* cell instance sg13cmos5l_decap_4_447 r0 *1 0,0
Xsg13cmos5l_decap_4_447 VPWR VGND sg13cmos5l_decap_4
* cell instance sg13cmos5l_decap_4_448 r0 *1 0,0
Xsg13cmos5l_decap_4_448 VPWR VGND sg13cmos5l_decap_4
* cell instance sg13cmos5l_decap_4_449 r0 *1 0,0
Xsg13cmos5l_decap_4_449 VPWR VGND sg13cmos5l_decap_4
* cell instance sg13cmos5l_decap_4_450 r0 *1 0,0
Xsg13cmos5l_decap_4_450 VPWR VGND sg13cmos5l_decap_4
* cell instance sg13cmos5l_decap_4_451 r0 *1 0,0
Xsg13cmos5l_decap_4_451 VPWR VGND sg13cmos5l_decap_4
* cell instance sg13cmos5l_decap_4_452 r0 *1 0,0
Xsg13cmos5l_decap_4_452 VPWR VGND sg13cmos5l_decap_4
* cell instance sg13cmos5l_decap_4_453 r0 *1 0,0
Xsg13cmos5l_decap_4_453 VPWR VGND sg13cmos5l_decap_4
* cell instance sg13cmos5l_decap_4_454 r0 *1 0,0
Xsg13cmos5l_decap_4_454 VPWR VGND sg13cmos5l_decap_4
* cell instance sg13cmos5l_decap_4_455 r0 *1 0,0
Xsg13cmos5l_decap_4_455 VPWR VGND sg13cmos5l_decap_4
* cell instance sg13cmos5l_decap_4_456 r0 *1 0,0
Xsg13cmos5l_decap_4_456 VPWR VGND sg13cmos5l_decap_4
* cell instance sg13cmos5l_decap_4_457 r0 *1 0,0
Xsg13cmos5l_decap_4_457 VPWR VGND sg13cmos5l_decap_4
* cell instance sg13cmos5l_decap_4_458 r0 *1 0,0
Xsg13cmos5l_decap_4_458 VPWR VGND sg13cmos5l_decap_4
* cell instance sg13cmos5l_decap_4_459 r0 *1 0,0
Xsg13cmos5l_decap_4_459 VPWR VGND sg13cmos5l_decap_4
* cell instance sg13cmos5l_decap_4_460 r0 *1 0,0
Xsg13cmos5l_decap_4_460 VPWR VGND sg13cmos5l_decap_4
* cell instance sg13cmos5l_decap_4_461 r0 *1 0,0
Xsg13cmos5l_decap_4_461 VPWR VGND sg13cmos5l_decap_4
* cell instance sg13cmos5l_decap_4_462 r0 *1 0,0
Xsg13cmos5l_decap_4_462 VPWR VGND sg13cmos5l_decap_4
* cell instance sg13cmos5l_decap_4_463 r0 *1 0,0
Xsg13cmos5l_decap_4_463 VPWR VGND sg13cmos5l_decap_4
* cell instance sg13cmos5l_decap_4_464 r0 *1 0,0
Xsg13cmos5l_decap_4_464 VPWR VGND sg13cmos5l_decap_4
* cell instance sg13cmos5l_decap_4_465 r0 *1 0,0
Xsg13cmos5l_decap_4_465 VPWR VGND sg13cmos5l_decap_4
* cell instance sg13cmos5l_decap_4_466 r0 *1 0,0
Xsg13cmos5l_decap_4_466 VPWR VGND sg13cmos5l_decap_4
* cell instance sg13cmos5l_decap_4_467 r0 *1 0,0
Xsg13cmos5l_decap_4_467 VPWR VGND sg13cmos5l_decap_4
* cell instance sg13cmos5l_decap_4_468 r0 *1 0,0
Xsg13cmos5l_decap_4_468 VPWR VGND sg13cmos5l_decap_4
* cell instance sg13cmos5l_decap_4_469 r0 *1 0,0
Xsg13cmos5l_decap_4_469 VPWR VGND sg13cmos5l_decap_4
* cell instance sg13cmos5l_decap_4_470 r0 *1 0,0
Xsg13cmos5l_decap_4_470 VPWR VGND sg13cmos5l_decap_4
* cell instance sg13cmos5l_decap_4_471 r0 *1 0,0
Xsg13cmos5l_decap_4_471 VPWR VGND sg13cmos5l_decap_4
* cell instance sg13cmos5l_decap_4_472 r0 *1 0,0
Xsg13cmos5l_decap_4_472 VPWR VGND sg13cmos5l_decap_4
* cell instance sg13cmos5l_decap_4_473 r0 *1 0,0
Xsg13cmos5l_decap_4_473 VPWR VGND sg13cmos5l_decap_4
* cell instance sg13cmos5l_decap_4_474 r0 *1 0,0
Xsg13cmos5l_decap_4_474 VPWR VGND sg13cmos5l_decap_4
* cell instance sg13cmos5l_decap_4_475 r0 *1 0,0
Xsg13cmos5l_decap_4_475 VPWR VGND sg13cmos5l_decap_4
* cell instance sg13cmos5l_decap_4_476 r0 *1 0,0
Xsg13cmos5l_decap_4_476 VPWR VGND sg13cmos5l_decap_4
* cell instance sg13cmos5l_decap_4_477 r0 *1 0,0
Xsg13cmos5l_decap_4_477 VPWR VGND sg13cmos5l_decap_4
* cell instance sg13cmos5l_decap_4_478 r0 *1 0,0
Xsg13cmos5l_decap_4_478 VPWR VGND sg13cmos5l_decap_4
* cell instance sg13cmos5l_decap_4_479 r0 *1 0,0
Xsg13cmos5l_decap_4_479 VPWR VGND sg13cmos5l_decap_4
* cell instance sg13cmos5l_decap_4_480 r0 *1 0,0
Xsg13cmos5l_decap_4_480 VPWR VGND sg13cmos5l_decap_4
* cell instance sg13cmos5l_decap_4_481 r0 *1 0,0
Xsg13cmos5l_decap_4_481 VPWR VGND sg13cmos5l_decap_4
* cell instance sg13cmos5l_decap_4_482 r0 *1 0,0
Xsg13cmos5l_decap_4_482 VPWR VGND sg13cmos5l_decap_4
* cell instance sg13cmos5l_decap_4_483 r0 *1 0,0
Xsg13cmos5l_decap_4_483 VPWR VGND sg13cmos5l_decap_4
* cell instance sg13cmos5l_decap_4_484 r0 *1 0,0
Xsg13cmos5l_decap_4_484 VPWR VGND sg13cmos5l_decap_4
* cell instance sg13cmos5l_decap_4_485 r0 *1 0,0
Xsg13cmos5l_decap_4_485 VPWR VGND sg13cmos5l_decap_4
* cell instance sg13cmos5l_decap_4_486 r0 *1 0,0
Xsg13cmos5l_decap_4_486 VPWR VGND sg13cmos5l_decap_4
* cell instance sg13cmos5l_decap_4_487 r0 *1 0,0
Xsg13cmos5l_decap_4_487 VPWR VGND sg13cmos5l_decap_4
* cell instance sg13cmos5l_decap_4_488 r0 *1 0,0
Xsg13cmos5l_decap_4_488 VPWR VGND sg13cmos5l_decap_4
* cell instance sg13cmos5l_decap_8_0 r0 *1 0,0
Xsg13cmos5l_decap_8_0 VPWR VGND sg13cmos5l_decap_8
* cell instance sg13cmos5l_decap_8_1 r0 *1 0,0
Xsg13cmos5l_decap_8_1 VPWR VGND sg13cmos5l_decap_8
* cell instance sg13cmos5l_decap_8_2 r0 *1 0,0
Xsg13cmos5l_decap_8_2 VPWR VGND sg13cmos5l_decap_8
* cell instance sg13cmos5l_decap_8_3 r0 *1 0,0
Xsg13cmos5l_decap_8_3 VPWR VGND sg13cmos5l_decap_8
* cell instance sg13cmos5l_decap_8_4 r0 *1 0,0
Xsg13cmos5l_decap_8_4 VPWR VGND sg13cmos5l_decap_8
* cell instance sg13cmos5l_decap_8_5 r0 *1 0,0
Xsg13cmos5l_decap_8_5 VPWR VGND sg13cmos5l_decap_8
* cell instance sg13cmos5l_decap_8_6 r0 *1 0,0
Xsg13cmos5l_decap_8_6 VPWR VGND sg13cmos5l_decap_8
* cell instance sg13cmos5l_decap_8_7 r0 *1 0,0
Xsg13cmos5l_decap_8_7 VPWR VGND sg13cmos5l_decap_8
* cell instance sg13cmos5l_decap_8_8 r0 *1 0,0
Xsg13cmos5l_decap_8_8 VPWR VGND sg13cmos5l_decap_8
* cell instance sg13cmos5l_decap_8_9 r0 *1 0,0
Xsg13cmos5l_decap_8_9 VPWR VGND sg13cmos5l_decap_8
* cell instance sg13cmos5l_decap_8_10 r0 *1 0,0
Xsg13cmos5l_decap_8_10 VPWR VGND sg13cmos5l_decap_8
* cell instance sg13cmos5l_decap_8_11 r0 *1 0,0
Xsg13cmos5l_decap_8_11 VPWR VGND sg13cmos5l_decap_8
* cell instance sg13cmos5l_decap_8_12 r0 *1 0,0
Xsg13cmos5l_decap_8_12 VPWR VGND sg13cmos5l_decap_8
* cell instance sg13cmos5l_decap_8_13 r0 *1 0,0
Xsg13cmos5l_decap_8_13 VPWR VGND sg13cmos5l_decap_8
* cell instance sg13cmos5l_decap_8_14 r0 *1 0,0
Xsg13cmos5l_decap_8_14 VPWR VGND sg13cmos5l_decap_8
* cell instance sg13cmos5l_decap_8_15 r0 *1 0,0
Xsg13cmos5l_decap_8_15 VPWR VGND sg13cmos5l_decap_8
* cell instance sg13cmos5l_decap_8_16 r0 *1 0,0
Xsg13cmos5l_decap_8_16 VPWR VGND sg13cmos5l_decap_8
* cell instance sg13cmos5l_decap_8_17 r0 *1 0,0
Xsg13cmos5l_decap_8_17 VPWR VGND sg13cmos5l_decap_8
* cell instance sg13cmos5l_decap_8_18 r0 *1 0,0
Xsg13cmos5l_decap_8_18 VPWR VGND sg13cmos5l_decap_8
* cell instance sg13cmos5l_decap_8_19 r0 *1 0,0
Xsg13cmos5l_decap_8_19 VPWR VGND sg13cmos5l_decap_8
* cell instance sg13cmos5l_decap_8_20 r0 *1 0,0
Xsg13cmos5l_decap_8_20 VPWR VGND sg13cmos5l_decap_8
* cell instance sg13cmos5l_decap_8_21 r0 *1 0,0
Xsg13cmos5l_decap_8_21 VPWR VGND sg13cmos5l_decap_8
* cell instance sg13cmos5l_decap_8_22 r0 *1 0,0
Xsg13cmos5l_decap_8_22 VPWR VGND sg13cmos5l_decap_8
* cell instance sg13cmos5l_decap_8_23 r0 *1 0,0
Xsg13cmos5l_decap_8_23 VPWR VGND sg13cmos5l_decap_8
* cell instance sg13cmos5l_decap_8_24 r0 *1 0,0
Xsg13cmos5l_decap_8_24 VPWR VGND sg13cmos5l_decap_8
* cell instance sg13cmos5l_decap_8_25 r0 *1 0,0
Xsg13cmos5l_decap_8_25 VPWR VGND sg13cmos5l_decap_8
* cell instance sg13cmos5l_decap_8_26 r0 *1 0,0
Xsg13cmos5l_decap_8_26 VPWR VGND sg13cmos5l_decap_8
* cell instance sg13cmos5l_decap_8_27 r0 *1 0,0
Xsg13cmos5l_decap_8_27 VPWR VGND sg13cmos5l_decap_8
* cell instance sg13cmos5l_decap_8_28 r0 *1 0,0
Xsg13cmos5l_decap_8_28 VPWR VGND sg13cmos5l_decap_8
* cell instance sg13cmos5l_decap_8_29 r0 *1 0,0
Xsg13cmos5l_decap_8_29 VPWR VGND sg13cmos5l_decap_8
* cell instance sg13cmos5l_decap_8_30 r0 *1 0,0
Xsg13cmos5l_decap_8_30 VPWR VGND sg13cmos5l_decap_8
* cell instance sg13cmos5l_decap_8_31 r0 *1 0,0
Xsg13cmos5l_decap_8_31 VPWR VGND sg13cmos5l_decap_8
* cell instance sg13cmos5l_decap_8_32 r0 *1 0,0
Xsg13cmos5l_decap_8_32 VPWR VGND sg13cmos5l_decap_8
* cell instance sg13cmos5l_decap_8_33 r0 *1 0,0
Xsg13cmos5l_decap_8_33 VPWR VGND sg13cmos5l_decap_8
* cell instance sg13cmos5l_decap_8_34 r0 *1 0,0
Xsg13cmos5l_decap_8_34 VPWR VGND sg13cmos5l_decap_8
* cell instance sg13cmos5l_decap_8_35 r0 *1 0,0
Xsg13cmos5l_decap_8_35 VPWR VGND sg13cmos5l_decap_8
* cell instance sg13cmos5l_decap_8_36 r0 *1 0,0
Xsg13cmos5l_decap_8_36 VPWR VGND sg13cmos5l_decap_8
* cell instance sg13cmos5l_decap_8_37 r0 *1 0,0
Xsg13cmos5l_decap_8_37 VPWR VGND sg13cmos5l_decap_8
* cell instance sg13cmos5l_decap_8_38 r0 *1 0,0
Xsg13cmos5l_decap_8_38 VPWR VGND sg13cmos5l_decap_8
* cell instance sg13cmos5l_decap_8_39 r0 *1 0,0
Xsg13cmos5l_decap_8_39 VPWR VGND sg13cmos5l_decap_8
* cell instance sg13cmos5l_decap_8_40 r0 *1 0,0
Xsg13cmos5l_decap_8_40 VPWR VGND sg13cmos5l_decap_8
* cell instance sg13cmos5l_decap_8_41 r0 *1 0,0
Xsg13cmos5l_decap_8_41 VPWR VGND sg13cmos5l_decap_8
* cell instance sg13cmos5l_decap_8_42 r0 *1 0,0
Xsg13cmos5l_decap_8_42 VPWR VGND sg13cmos5l_decap_8
* cell instance sg13cmos5l_decap_8_43 r0 *1 0,0
Xsg13cmos5l_decap_8_43 VPWR VGND sg13cmos5l_decap_8
* cell instance sg13cmos5l_decap_8_44 r0 *1 0,0
Xsg13cmos5l_decap_8_44 VPWR VGND sg13cmos5l_decap_8
* cell instance sg13cmos5l_decap_8_45 r0 *1 0,0
Xsg13cmos5l_decap_8_45 VPWR VGND sg13cmos5l_decap_8
* cell instance sg13cmos5l_decap_8_46 r0 *1 0,0
Xsg13cmos5l_decap_8_46 VPWR VGND sg13cmos5l_decap_8
* cell instance sg13cmos5l_decap_8_47 r0 *1 0,0
Xsg13cmos5l_decap_8_47 VPWR VGND sg13cmos5l_decap_8
* cell instance sg13cmos5l_decap_8_48 r0 *1 0,0
Xsg13cmos5l_decap_8_48 VPWR VGND sg13cmos5l_decap_8
* cell instance sg13cmos5l_decap_8_49 r0 *1 0,0
Xsg13cmos5l_decap_8_49 VPWR VGND sg13cmos5l_decap_8
* cell instance sg13cmos5l_decap_8_50 r0 *1 0,0
Xsg13cmos5l_decap_8_50 VPWR VGND sg13cmos5l_decap_8
* cell instance sg13cmos5l_decap_8_51 r0 *1 0,0
Xsg13cmos5l_decap_8_51 VPWR VGND sg13cmos5l_decap_8
* cell instance sg13cmos5l_decap_8_52 r0 *1 0,0
Xsg13cmos5l_decap_8_52 VPWR VGND sg13cmos5l_decap_8
* cell instance sg13cmos5l_decap_8_53 r0 *1 0,0
Xsg13cmos5l_decap_8_53 VPWR VGND sg13cmos5l_decap_8
* cell instance sg13cmos5l_decap_8_54 r0 *1 0,0
Xsg13cmos5l_decap_8_54 VPWR VGND sg13cmos5l_decap_8
* cell instance sg13cmos5l_decap_8_55 r0 *1 0,0
Xsg13cmos5l_decap_8_55 VPWR VGND sg13cmos5l_decap_8
* cell instance sg13cmos5l_decap_8_56 r0 *1 0,0
Xsg13cmos5l_decap_8_56 VPWR VGND sg13cmos5l_decap_8
* cell instance sg13cmos5l_decap_8_57 r0 *1 0,0
Xsg13cmos5l_decap_8_57 VPWR VGND sg13cmos5l_decap_8
* cell instance sg13cmos5l_decap_8_58 r0 *1 0,0
Xsg13cmos5l_decap_8_58 VPWR VGND sg13cmos5l_decap_8
* cell instance sg13cmos5l_decap_8_59 r0 *1 0,0
Xsg13cmos5l_decap_8_59 VPWR VGND sg13cmos5l_decap_8
* cell instance sg13cmos5l_decap_8_60 r0 *1 0,0
Xsg13cmos5l_decap_8_60 VPWR VGND sg13cmos5l_decap_8
* cell instance sg13cmos5l_decap_8_61 r0 *1 0,0
Xsg13cmos5l_decap_8_61 VPWR VGND sg13cmos5l_decap_8
* cell instance sg13cmos5l_decap_8_62 r0 *1 0,0
Xsg13cmos5l_decap_8_62 VPWR VGND sg13cmos5l_decap_8
* cell instance sg13cmos5l_decap_8_63 r0 *1 0,0
Xsg13cmos5l_decap_8_63 VPWR VGND sg13cmos5l_decap_8
* cell instance sg13cmos5l_decap_8_64 r0 *1 0,0
Xsg13cmos5l_decap_8_64 VPWR VGND sg13cmos5l_decap_8
* cell instance sg13cmos5l_decap_8_65 r0 *1 0,0
Xsg13cmos5l_decap_8_65 VPWR VGND sg13cmos5l_decap_8
* cell instance sg13cmos5l_decap_8_66 r0 *1 0,0
Xsg13cmos5l_decap_8_66 VPWR VGND sg13cmos5l_decap_8
* cell instance sg13cmos5l_decap_8_67 r0 *1 0,0
Xsg13cmos5l_decap_8_67 VPWR VGND sg13cmos5l_decap_8
* cell instance sg13cmos5l_decap_8_68 r0 *1 0,0
Xsg13cmos5l_decap_8_68 VPWR VGND sg13cmos5l_decap_8
* cell instance sg13cmos5l_decap_8_69 r0 *1 0,0
Xsg13cmos5l_decap_8_69 VPWR VGND sg13cmos5l_decap_8
* cell instance sg13cmos5l_decap_8_70 r0 *1 0,0
Xsg13cmos5l_decap_8_70 VPWR VGND sg13cmos5l_decap_8
* cell instance sg13cmos5l_decap_8_71 r0 *1 0,0
Xsg13cmos5l_decap_8_71 VPWR VGND sg13cmos5l_decap_8
* cell instance sg13cmos5l_decap_8_72 r0 *1 0,0
Xsg13cmos5l_decap_8_72 VPWR VGND sg13cmos5l_decap_8
* cell instance sg13cmos5l_decap_8_73 r0 *1 0,0
Xsg13cmos5l_decap_8_73 VPWR VGND sg13cmos5l_decap_8
* cell instance sg13cmos5l_decap_8_74 r0 *1 0,0
Xsg13cmos5l_decap_8_74 VPWR VGND sg13cmos5l_decap_8
* cell instance sg13cmos5l_decap_8_75 r0 *1 0,0
Xsg13cmos5l_decap_8_75 VPWR VGND sg13cmos5l_decap_8
* cell instance sg13cmos5l_decap_8_76 r0 *1 0,0
Xsg13cmos5l_decap_8_76 VPWR VGND sg13cmos5l_decap_8
* cell instance sg13cmos5l_decap_8_77 r0 *1 0,0
Xsg13cmos5l_decap_8_77 VPWR VGND sg13cmos5l_decap_8
* cell instance sg13cmos5l_decap_8_78 r0 *1 0,0
Xsg13cmos5l_decap_8_78 VPWR VGND sg13cmos5l_decap_8
* cell instance sg13cmos5l_decap_8_79 r0 *1 0,0
Xsg13cmos5l_decap_8_79 VPWR VGND sg13cmos5l_decap_8
* cell instance sg13cmos5l_decap_8_80 r0 *1 0,0
Xsg13cmos5l_decap_8_80 VPWR VGND sg13cmos5l_decap_8
* cell instance sg13cmos5l_decap_8_81 r0 *1 0,0
Xsg13cmos5l_decap_8_81 VPWR VGND sg13cmos5l_decap_8
* cell instance sg13cmos5l_decap_8_82 r0 *1 0,0
Xsg13cmos5l_decap_8_82 VPWR VGND sg13cmos5l_decap_8
* cell instance sg13cmos5l_decap_8_83 r0 *1 0,0
Xsg13cmos5l_decap_8_83 VPWR VGND sg13cmos5l_decap_8
* cell instance sg13cmos5l_decap_8_84 r0 *1 0,0
Xsg13cmos5l_decap_8_84 VPWR VGND sg13cmos5l_decap_8
* cell instance sg13cmos5l_decap_8_85 r0 *1 0,0
Xsg13cmos5l_decap_8_85 VPWR VGND sg13cmos5l_decap_8
* cell instance sg13cmos5l_decap_8_86 r0 *1 0,0
Xsg13cmos5l_decap_8_86 VPWR VGND sg13cmos5l_decap_8
* cell instance sg13cmos5l_decap_8_87 r0 *1 0,0
Xsg13cmos5l_decap_8_87 VPWR VGND sg13cmos5l_decap_8
* cell instance sg13cmos5l_decap_8_88 r0 *1 0,0
Xsg13cmos5l_decap_8_88 VPWR VGND sg13cmos5l_decap_8
* cell instance sg13cmos5l_decap_8_89 r0 *1 0,0
Xsg13cmos5l_decap_8_89 VPWR VGND sg13cmos5l_decap_8
* cell instance sg13cmos5l_decap_8_90 r0 *1 0,0
Xsg13cmos5l_decap_8_90 VPWR VGND sg13cmos5l_decap_8
* cell instance sg13cmos5l_decap_8_91 r0 *1 0,0
Xsg13cmos5l_decap_8_91 VPWR VGND sg13cmos5l_decap_8
* cell instance sg13cmos5l_decap_8_92 r0 *1 0,0
Xsg13cmos5l_decap_8_92 VPWR VGND sg13cmos5l_decap_8
* cell instance sg13cmos5l_decap_8_93 r0 *1 0,0
Xsg13cmos5l_decap_8_93 VPWR VGND sg13cmos5l_decap_8
* cell instance sg13cmos5l_decap_8_94 r0 *1 0,0
Xsg13cmos5l_decap_8_94 VPWR VGND sg13cmos5l_decap_8
* cell instance sg13cmos5l_decap_8_95 r0 *1 0,0
Xsg13cmos5l_decap_8_95 VPWR VGND sg13cmos5l_decap_8
* cell instance sg13cmos5l_decap_8_96 r0 *1 0,0
Xsg13cmos5l_decap_8_96 VPWR VGND sg13cmos5l_decap_8
* cell instance sg13cmos5l_decap_8_97 r0 *1 0,0
Xsg13cmos5l_decap_8_97 VPWR VGND sg13cmos5l_decap_8
* cell instance sg13cmos5l_decap_8_98 r0 *1 0,0
Xsg13cmos5l_decap_8_98 VPWR VGND sg13cmos5l_decap_8
* cell instance sg13cmos5l_decap_8_99 r0 *1 0,0
Xsg13cmos5l_decap_8_99 VPWR VGND sg13cmos5l_decap_8
* cell instance sg13cmos5l_decap_8_100 r0 *1 0,0
Xsg13cmos5l_decap_8_100 VPWR VGND sg13cmos5l_decap_8
* cell instance sg13cmos5l_decap_8_101 r0 *1 0,0
Xsg13cmos5l_decap_8_101 VPWR VGND sg13cmos5l_decap_8
* cell instance sg13cmos5l_decap_8_102 r0 *1 0,0
Xsg13cmos5l_decap_8_102 VPWR VGND sg13cmos5l_decap_8
* cell instance sg13cmos5l_decap_8_103 r0 *1 0,0
Xsg13cmos5l_decap_8_103 VPWR VGND sg13cmos5l_decap_8
* cell instance sg13cmos5l_decap_8_104 r0 *1 0,0
Xsg13cmos5l_decap_8_104 VPWR VGND sg13cmos5l_decap_8
* cell instance sg13cmos5l_decap_8_105 r0 *1 0,0
Xsg13cmos5l_decap_8_105 VPWR VGND sg13cmos5l_decap_8
* cell instance sg13cmos5l_decap_8_106 r0 *1 0,0
Xsg13cmos5l_decap_8_106 VPWR VGND sg13cmos5l_decap_8
* cell instance sg13cmos5l_decap_8_107 r0 *1 0,0
Xsg13cmos5l_decap_8_107 VPWR VGND sg13cmos5l_decap_8
* cell instance sg13cmos5l_decap_8_108 r0 *1 0,0
Xsg13cmos5l_decap_8_108 VPWR VGND sg13cmos5l_decap_8
* cell instance sg13cmos5l_decap_8_109 r0 *1 0,0
Xsg13cmos5l_decap_8_109 VPWR VGND sg13cmos5l_decap_8
* cell instance sg13cmos5l_decap_8_110 r0 *1 0,0
Xsg13cmos5l_decap_8_110 VPWR VGND sg13cmos5l_decap_8
* cell instance sg13cmos5l_decap_8_111 r0 *1 0,0
Xsg13cmos5l_decap_8_111 VPWR VGND sg13cmos5l_decap_8
* cell instance sg13cmos5l_decap_8_112 r0 *1 0,0
Xsg13cmos5l_decap_8_112 VPWR VGND sg13cmos5l_decap_8
* cell instance sg13cmos5l_decap_8_113 r0 *1 0,0
Xsg13cmos5l_decap_8_113 VPWR VGND sg13cmos5l_decap_8
* cell instance sg13cmos5l_decap_8_114 r0 *1 0,0
Xsg13cmos5l_decap_8_114 VPWR VGND sg13cmos5l_decap_8
* cell instance sg13cmos5l_decap_8_115 r0 *1 0,0
Xsg13cmos5l_decap_8_115 VPWR VGND sg13cmos5l_decap_8
* cell instance sg13cmos5l_decap_8_116 r0 *1 0,0
Xsg13cmos5l_decap_8_116 VPWR VGND sg13cmos5l_decap_8
* cell instance sg13cmos5l_decap_8_117 r0 *1 0,0
Xsg13cmos5l_decap_8_117 VPWR VGND sg13cmos5l_decap_8
* cell instance sg13cmos5l_decap_8_118 r0 *1 0,0
Xsg13cmos5l_decap_8_118 VPWR VGND sg13cmos5l_decap_8
* cell instance sg13cmos5l_decap_8_119 r0 *1 0,0
Xsg13cmos5l_decap_8_119 VPWR VGND sg13cmos5l_decap_8
* cell instance sg13cmos5l_decap_8_120 r0 *1 0,0
Xsg13cmos5l_decap_8_120 VPWR VGND sg13cmos5l_decap_8
* cell instance sg13cmos5l_decap_8_121 r0 *1 0,0
Xsg13cmos5l_decap_8_121 VPWR VGND sg13cmos5l_decap_8
* cell instance sg13cmos5l_decap_8_122 r0 *1 0,0
Xsg13cmos5l_decap_8_122 VPWR VGND sg13cmos5l_decap_8
* cell instance sg13cmos5l_decap_8_123 r0 *1 0,0
Xsg13cmos5l_decap_8_123 VPWR VGND sg13cmos5l_decap_8
* cell instance sg13cmos5l_decap_8_124 r0 *1 0,0
Xsg13cmos5l_decap_8_124 VPWR VGND sg13cmos5l_decap_8
* cell instance sg13cmos5l_decap_8_125 r0 *1 0,0
Xsg13cmos5l_decap_8_125 VPWR VGND sg13cmos5l_decap_8
* cell instance sg13cmos5l_decap_8_126 r0 *1 0,0
Xsg13cmos5l_decap_8_126 VPWR VGND sg13cmos5l_decap_8
* cell instance sg13cmos5l_decap_8_127 r0 *1 0,0
Xsg13cmos5l_decap_8_127 VPWR VGND sg13cmos5l_decap_8
* cell instance sg13cmos5l_decap_8_128 r0 *1 0,0
Xsg13cmos5l_decap_8_128 VPWR VGND sg13cmos5l_decap_8
* cell instance sg13cmos5l_decap_8_129 r0 *1 0,0
Xsg13cmos5l_decap_8_129 VPWR VGND sg13cmos5l_decap_8
* cell instance sg13cmos5l_decap_8_130 r0 *1 0,0
Xsg13cmos5l_decap_8_130 VPWR VGND sg13cmos5l_decap_8
* cell instance sg13cmos5l_decap_8_131 r0 *1 0,0
Xsg13cmos5l_decap_8_131 VPWR VGND sg13cmos5l_decap_8
* cell instance sg13cmos5l_decap_8_132 r0 *1 0,0
Xsg13cmos5l_decap_8_132 VPWR VGND sg13cmos5l_decap_8
* cell instance sg13cmos5l_decap_8_133 r0 *1 0,0
Xsg13cmos5l_decap_8_133 VPWR VGND sg13cmos5l_decap_8
* cell instance sg13cmos5l_decap_8_134 r0 *1 0,0
Xsg13cmos5l_decap_8_134 VPWR VGND sg13cmos5l_decap_8
* cell instance sg13cmos5l_decap_8_135 r0 *1 0,0
Xsg13cmos5l_decap_8_135 VPWR VGND sg13cmos5l_decap_8
* cell instance sg13cmos5l_decap_8_136 r0 *1 0,0
Xsg13cmos5l_decap_8_136 VPWR VGND sg13cmos5l_decap_8
* cell instance sg13cmos5l_decap_8_137 r0 *1 0,0
Xsg13cmos5l_decap_8_137 VPWR VGND sg13cmos5l_decap_8
* cell instance sg13cmos5l_decap_8_138 r0 *1 0,0
Xsg13cmos5l_decap_8_138 VPWR VGND sg13cmos5l_decap_8
* cell instance sg13cmos5l_decap_8_139 r0 *1 0,0
Xsg13cmos5l_decap_8_139 VPWR VGND sg13cmos5l_decap_8
* cell instance sg13cmos5l_decap_8_140 r0 *1 0,0
Xsg13cmos5l_decap_8_140 VPWR VGND sg13cmos5l_decap_8
* cell instance sg13cmos5l_decap_8_141 r0 *1 0,0
Xsg13cmos5l_decap_8_141 VPWR VGND sg13cmos5l_decap_8
* cell instance sg13cmos5l_decap_8_142 r0 *1 0,0
Xsg13cmos5l_decap_8_142 VPWR VGND sg13cmos5l_decap_8
* cell instance sg13cmos5l_decap_8_143 r0 *1 0,0
Xsg13cmos5l_decap_8_143 VPWR VGND sg13cmos5l_decap_8
* cell instance sg13cmos5l_decap_8_144 r0 *1 0,0
Xsg13cmos5l_decap_8_144 VPWR VGND sg13cmos5l_decap_8
* cell instance sg13cmos5l_decap_8_145 r0 *1 0,0
Xsg13cmos5l_decap_8_145 VPWR VGND sg13cmos5l_decap_8
* cell instance sg13cmos5l_decap_8_146 r0 *1 0,0
Xsg13cmos5l_decap_8_146 VPWR VGND sg13cmos5l_decap_8
* cell instance sg13cmos5l_decap_8_147 r0 *1 0,0
Xsg13cmos5l_decap_8_147 VPWR VGND sg13cmos5l_decap_8
* cell instance sg13cmos5l_decap_8_148 r0 *1 0,0
Xsg13cmos5l_decap_8_148 VPWR VGND sg13cmos5l_decap_8
* cell instance sg13cmos5l_decap_8_149 r0 *1 0,0
Xsg13cmos5l_decap_8_149 VPWR VGND sg13cmos5l_decap_8
* cell instance sg13cmos5l_decap_8_150 r0 *1 0,0
Xsg13cmos5l_decap_8_150 VPWR VGND sg13cmos5l_decap_8
* cell instance sg13cmos5l_decap_8_151 r0 *1 0,0
Xsg13cmos5l_decap_8_151 VPWR VGND sg13cmos5l_decap_8
* cell instance sg13cmos5l_decap_8_152 r0 *1 0,0
Xsg13cmos5l_decap_8_152 VPWR VGND sg13cmos5l_decap_8
* cell instance sg13cmos5l_decap_8_153 r0 *1 0,0
Xsg13cmos5l_decap_8_153 VPWR VGND sg13cmos5l_decap_8
* cell instance sg13cmos5l_decap_8_154 r0 *1 0,0
Xsg13cmos5l_decap_8_154 VPWR VGND sg13cmos5l_decap_8
* cell instance sg13cmos5l_decap_8_155 r0 *1 0,0
Xsg13cmos5l_decap_8_155 VPWR VGND sg13cmos5l_decap_8
* cell instance sg13cmos5l_decap_8_156 r0 *1 0,0
Xsg13cmos5l_decap_8_156 VPWR VGND sg13cmos5l_decap_8
* cell instance sg13cmos5l_decap_8_157 r0 *1 0,0
Xsg13cmos5l_decap_8_157 VPWR VGND sg13cmos5l_decap_8
* cell instance sg13cmos5l_decap_8_158 r0 *1 0,0
Xsg13cmos5l_decap_8_158 VPWR VGND sg13cmos5l_decap_8
* cell instance sg13cmos5l_decap_8_159 r0 *1 0,0
Xsg13cmos5l_decap_8_159 VPWR VGND sg13cmos5l_decap_8
* cell instance sg13cmos5l_decap_8_160 r0 *1 0,0
Xsg13cmos5l_decap_8_160 VPWR VGND sg13cmos5l_decap_8
* cell instance sg13cmos5l_decap_8_161 r0 *1 0,0
Xsg13cmos5l_decap_8_161 VPWR VGND sg13cmos5l_decap_8
* cell instance sg13cmos5l_decap_8_162 r0 *1 0,0
Xsg13cmos5l_decap_8_162 VPWR VGND sg13cmos5l_decap_8
* cell instance sg13cmos5l_decap_8_163 r0 *1 0,0
Xsg13cmos5l_decap_8_163 VPWR VGND sg13cmos5l_decap_8
* cell instance sg13cmos5l_decap_8_164 r0 *1 0,0
Xsg13cmos5l_decap_8_164 VPWR VGND sg13cmos5l_decap_8
* cell instance sg13cmos5l_decap_8_165 r0 *1 0,0
Xsg13cmos5l_decap_8_165 VPWR VGND sg13cmos5l_decap_8
* cell instance sg13cmos5l_decap_8_166 r0 *1 0,0
Xsg13cmos5l_decap_8_166 VPWR VGND sg13cmos5l_decap_8
* cell instance sg13cmos5l_decap_8_167 r0 *1 0,0
Xsg13cmos5l_decap_8_167 VPWR VGND sg13cmos5l_decap_8
* cell instance sg13cmos5l_decap_8_168 r0 *1 0,0
Xsg13cmos5l_decap_8_168 VPWR VGND sg13cmos5l_decap_8
* cell instance sg13cmos5l_decap_8_169 r0 *1 0,0
Xsg13cmos5l_decap_8_169 VPWR VGND sg13cmos5l_decap_8
* cell instance sg13cmos5l_decap_8_170 r0 *1 0,0
Xsg13cmos5l_decap_8_170 VPWR VGND sg13cmos5l_decap_8
* cell instance sg13cmos5l_decap_8_171 r0 *1 0,0
Xsg13cmos5l_decap_8_171 VPWR VGND sg13cmos5l_decap_8
* cell instance sg13cmos5l_decap_8_172 r0 *1 0,0
Xsg13cmos5l_decap_8_172 VPWR VGND sg13cmos5l_decap_8
* cell instance sg13cmos5l_decap_8_173 r0 *1 0,0
Xsg13cmos5l_decap_8_173 VPWR VGND sg13cmos5l_decap_8
* cell instance sg13cmos5l_decap_8_174 r0 *1 0,0
Xsg13cmos5l_decap_8_174 VPWR VGND sg13cmos5l_decap_8
* cell instance sg13cmos5l_decap_8_175 r0 *1 0,0
Xsg13cmos5l_decap_8_175 VPWR VGND sg13cmos5l_decap_8
* cell instance sg13cmos5l_decap_8_176 r0 *1 0,0
Xsg13cmos5l_decap_8_176 VPWR VGND sg13cmos5l_decap_8
* cell instance sg13cmos5l_decap_8_177 r0 *1 0,0
Xsg13cmos5l_decap_8_177 VPWR VGND sg13cmos5l_decap_8
* cell instance sg13cmos5l_decap_8_178 r0 *1 0,0
Xsg13cmos5l_decap_8_178 VPWR VGND sg13cmos5l_decap_8
* cell instance sg13cmos5l_decap_8_179 r0 *1 0,0
Xsg13cmos5l_decap_8_179 VPWR VGND sg13cmos5l_decap_8
* cell instance sg13cmos5l_decap_8_180 r0 *1 0,0
Xsg13cmos5l_decap_8_180 VPWR VGND sg13cmos5l_decap_8
* cell instance sg13cmos5l_decap_8_181 r0 *1 0,0
Xsg13cmos5l_decap_8_181 VPWR VGND sg13cmos5l_decap_8
* cell instance sg13cmos5l_decap_8_182 r0 *1 0,0
Xsg13cmos5l_decap_8_182 VPWR VGND sg13cmos5l_decap_8
* cell instance sg13cmos5l_decap_8_183 r0 *1 0,0
Xsg13cmos5l_decap_8_183 VPWR VGND sg13cmos5l_decap_8
* cell instance sg13cmos5l_decap_8_184 r0 *1 0,0
Xsg13cmos5l_decap_8_184 VPWR VGND sg13cmos5l_decap_8
* cell instance sg13cmos5l_decap_8_185 r0 *1 0,0
Xsg13cmos5l_decap_8_185 VPWR VGND sg13cmos5l_decap_8
* cell instance sg13cmos5l_decap_8_186 r0 *1 0,0
Xsg13cmos5l_decap_8_186 VPWR VGND sg13cmos5l_decap_8
* cell instance sg13cmos5l_decap_8_187 r0 *1 0,0
Xsg13cmos5l_decap_8_187 VPWR VGND sg13cmos5l_decap_8
* cell instance sg13cmos5l_decap_8_188 r0 *1 0,0
Xsg13cmos5l_decap_8_188 VPWR VGND sg13cmos5l_decap_8
* cell instance sg13cmos5l_decap_8_189 r0 *1 0,0
Xsg13cmos5l_decap_8_189 VPWR VGND sg13cmos5l_decap_8
* cell instance sg13cmos5l_decap_8_190 r0 *1 0,0
Xsg13cmos5l_decap_8_190 VPWR VGND sg13cmos5l_decap_8
* cell instance sg13cmos5l_decap_8_191 r0 *1 0,0
Xsg13cmos5l_decap_8_191 VPWR VGND sg13cmos5l_decap_8
* cell instance sg13cmos5l_decap_8_192 r0 *1 0,0
Xsg13cmos5l_decap_8_192 VPWR VGND sg13cmos5l_decap_8
* cell instance sg13cmos5l_decap_8_193 r0 *1 0,0
Xsg13cmos5l_decap_8_193 VPWR VGND sg13cmos5l_decap_8
* cell instance sg13cmos5l_decap_8_194 r0 *1 0,0
Xsg13cmos5l_decap_8_194 VPWR VGND sg13cmos5l_decap_8
* cell instance sg13cmos5l_decap_8_195 r0 *1 0,0
Xsg13cmos5l_decap_8_195 VPWR VGND sg13cmos5l_decap_8
* cell instance sg13cmos5l_decap_8_196 r0 *1 0,0
Xsg13cmos5l_decap_8_196 VPWR VGND sg13cmos5l_decap_8
* cell instance sg13cmos5l_decap_8_197 r0 *1 0,0
Xsg13cmos5l_decap_8_197 VPWR VGND sg13cmos5l_decap_8
* cell instance sg13cmos5l_decap_8_198 r0 *1 0,0
Xsg13cmos5l_decap_8_198 VPWR VGND sg13cmos5l_decap_8
* cell instance sg13cmos5l_decap_8_199 r0 *1 0,0
Xsg13cmos5l_decap_8_199 VPWR VGND sg13cmos5l_decap_8
* cell instance sg13cmos5l_decap_8_200 r0 *1 0,0
Xsg13cmos5l_decap_8_200 VPWR VGND sg13cmos5l_decap_8
* cell instance sg13cmos5l_decap_8_201 r0 *1 0,0
Xsg13cmos5l_decap_8_201 VPWR VGND sg13cmos5l_decap_8
* cell instance sg13cmos5l_decap_8_202 r0 *1 0,0
Xsg13cmos5l_decap_8_202 VPWR VGND sg13cmos5l_decap_8
* cell instance sg13cmos5l_decap_8_203 r0 *1 0,0
Xsg13cmos5l_decap_8_203 VPWR VGND sg13cmos5l_decap_8
* cell instance sg13cmos5l_decap_8_204 r0 *1 0,0
Xsg13cmos5l_decap_8_204 VPWR VGND sg13cmos5l_decap_8
* cell instance sg13cmos5l_decap_8_205 r0 *1 0,0
Xsg13cmos5l_decap_8_205 VPWR VGND sg13cmos5l_decap_8
* cell instance sg13cmos5l_decap_8_206 r0 *1 0,0
Xsg13cmos5l_decap_8_206 VPWR VGND sg13cmos5l_decap_8
* cell instance sg13cmos5l_decap_8_207 r0 *1 0,0
Xsg13cmos5l_decap_8_207 VPWR VGND sg13cmos5l_decap_8
* cell instance sg13cmos5l_decap_8_208 r0 *1 0,0
Xsg13cmos5l_decap_8_208 VPWR VGND sg13cmos5l_decap_8
* cell instance sg13cmos5l_decap_8_209 r0 *1 0,0
Xsg13cmos5l_decap_8_209 VPWR VGND sg13cmos5l_decap_8
* cell instance sg13cmos5l_decap_8_210 r0 *1 0,0
Xsg13cmos5l_decap_8_210 VPWR VGND sg13cmos5l_decap_8
* cell instance sg13cmos5l_decap_8_211 r0 *1 0,0
Xsg13cmos5l_decap_8_211 VPWR VGND sg13cmos5l_decap_8
* cell instance sg13cmos5l_decap_8_212 r0 *1 0,0
Xsg13cmos5l_decap_8_212 VPWR VGND sg13cmos5l_decap_8
* cell instance sg13cmos5l_decap_8_213 r0 *1 0,0
Xsg13cmos5l_decap_8_213 VPWR VGND sg13cmos5l_decap_8
* cell instance sg13cmos5l_decap_8_214 r0 *1 0,0
Xsg13cmos5l_decap_8_214 VPWR VGND sg13cmos5l_decap_8
* cell instance sg13cmos5l_decap_8_215 r0 *1 0,0
Xsg13cmos5l_decap_8_215 VPWR VGND sg13cmos5l_decap_8
* cell instance sg13cmos5l_decap_8_216 r0 *1 0,0
Xsg13cmos5l_decap_8_216 VPWR VGND sg13cmos5l_decap_8
* cell instance sg13cmos5l_decap_8_217 r0 *1 0,0
Xsg13cmos5l_decap_8_217 VPWR VGND sg13cmos5l_decap_8
* cell instance sg13cmos5l_decap_8_218 r0 *1 0,0
Xsg13cmos5l_decap_8_218 VPWR VGND sg13cmos5l_decap_8
* cell instance sg13cmos5l_decap_8_219 r0 *1 0,0
Xsg13cmos5l_decap_8_219 VPWR VGND sg13cmos5l_decap_8
* cell instance sg13cmos5l_decap_8_220 r0 *1 0,0
Xsg13cmos5l_decap_8_220 VPWR VGND sg13cmos5l_decap_8
* cell instance sg13cmos5l_decap_8_221 r0 *1 0,0
Xsg13cmos5l_decap_8_221 VPWR VGND sg13cmos5l_decap_8
* cell instance sg13cmos5l_decap_8_222 r0 *1 0,0
Xsg13cmos5l_decap_8_222 VPWR VGND sg13cmos5l_decap_8
* cell instance sg13cmos5l_decap_8_223 r0 *1 0,0
Xsg13cmos5l_decap_8_223 VPWR VGND sg13cmos5l_decap_8
* cell instance sg13cmos5l_decap_8_224 r0 *1 0,0
Xsg13cmos5l_decap_8_224 VPWR VGND sg13cmos5l_decap_8
* cell instance sg13cmos5l_decap_8_225 r0 *1 0,0
Xsg13cmos5l_decap_8_225 VPWR VGND sg13cmos5l_decap_8
* cell instance sg13cmos5l_decap_8_226 r0 *1 0,0
Xsg13cmos5l_decap_8_226 VPWR VGND sg13cmos5l_decap_8
* cell instance sg13cmos5l_decap_8_227 r0 *1 0,0
Xsg13cmos5l_decap_8_227 VPWR VGND sg13cmos5l_decap_8
* cell instance sg13cmos5l_decap_8_228 r0 *1 0,0
Xsg13cmos5l_decap_8_228 VPWR VGND sg13cmos5l_decap_8
* cell instance sg13cmos5l_decap_8_229 r0 *1 0,0
Xsg13cmos5l_decap_8_229 VPWR VGND sg13cmos5l_decap_8
* cell instance sg13cmos5l_decap_8_230 r0 *1 0,0
Xsg13cmos5l_decap_8_230 VPWR VGND sg13cmos5l_decap_8
* cell instance sg13cmos5l_decap_8_231 r0 *1 0,0
Xsg13cmos5l_decap_8_231 VPWR VGND sg13cmos5l_decap_8
* cell instance sg13cmos5l_decap_8_232 r0 *1 0,0
Xsg13cmos5l_decap_8_232 VPWR VGND sg13cmos5l_decap_8
* cell instance sg13cmos5l_decap_8_233 r0 *1 0,0
Xsg13cmos5l_decap_8_233 VPWR VGND sg13cmos5l_decap_8
* cell instance sg13cmos5l_decap_8_234 r0 *1 0,0
Xsg13cmos5l_decap_8_234 VPWR VGND sg13cmos5l_decap_8
* cell instance sg13cmos5l_decap_8_235 r0 *1 0,0
Xsg13cmos5l_decap_8_235 VPWR VGND sg13cmos5l_decap_8
* cell instance sg13cmos5l_decap_8_236 r0 *1 0,0
Xsg13cmos5l_decap_8_236 VPWR VGND sg13cmos5l_decap_8
* cell instance sg13cmos5l_decap_8_237 r0 *1 0,0
Xsg13cmos5l_decap_8_237 VPWR VGND sg13cmos5l_decap_8
* cell instance sg13cmos5l_decap_8_238 r0 *1 0,0
Xsg13cmos5l_decap_8_238 VPWR VGND sg13cmos5l_decap_8
* cell instance sg13cmos5l_decap_8_239 r0 *1 0,0
Xsg13cmos5l_decap_8_239 VPWR VGND sg13cmos5l_decap_8
* cell instance sg13cmos5l_decap_8_240 r0 *1 0,0
Xsg13cmos5l_decap_8_240 VPWR VGND sg13cmos5l_decap_8
* cell instance sg13cmos5l_decap_8_241 r0 *1 0,0
Xsg13cmos5l_decap_8_241 VPWR VGND sg13cmos5l_decap_8
* cell instance sg13cmos5l_decap_8_242 r0 *1 0,0
Xsg13cmos5l_decap_8_242 VPWR VGND sg13cmos5l_decap_8
* cell instance sg13cmos5l_decap_8_243 r0 *1 0,0
Xsg13cmos5l_decap_8_243 VPWR VGND sg13cmos5l_decap_8
* cell instance sg13cmos5l_decap_8_244 r0 *1 0,0
Xsg13cmos5l_decap_8_244 VPWR VGND sg13cmos5l_decap_8
* cell instance sg13cmos5l_decap_8_245 r0 *1 0,0
Xsg13cmos5l_decap_8_245 VPWR VGND sg13cmos5l_decap_8
* cell instance sg13cmos5l_decap_8_246 r0 *1 0,0
Xsg13cmos5l_decap_8_246 VPWR VGND sg13cmos5l_decap_8
* cell instance sg13cmos5l_decap_8_247 r0 *1 0,0
Xsg13cmos5l_decap_8_247 VPWR VGND sg13cmos5l_decap_8
* cell instance sg13cmos5l_decap_8_248 r0 *1 0,0
Xsg13cmos5l_decap_8_248 VPWR VGND sg13cmos5l_decap_8
* cell instance sg13cmos5l_decap_8_249 r0 *1 0,0
Xsg13cmos5l_decap_8_249 VPWR VGND sg13cmos5l_decap_8
* cell instance sg13cmos5l_decap_8_250 r0 *1 0,0
Xsg13cmos5l_decap_8_250 VPWR VGND sg13cmos5l_decap_8
* cell instance sg13cmos5l_decap_8_251 r0 *1 0,0
Xsg13cmos5l_decap_8_251 VPWR VGND sg13cmos5l_decap_8
* cell instance sg13cmos5l_decap_8_252 r0 *1 0,0
Xsg13cmos5l_decap_8_252 VPWR VGND sg13cmos5l_decap_8
* cell instance sg13cmos5l_decap_8_253 r0 *1 0,0
Xsg13cmos5l_decap_8_253 VPWR VGND sg13cmos5l_decap_8
* cell instance sg13cmos5l_decap_8_254 r0 *1 0,0
Xsg13cmos5l_decap_8_254 VPWR VGND sg13cmos5l_decap_8
* cell instance sg13cmos5l_decap_8_255 r0 *1 0,0
Xsg13cmos5l_decap_8_255 VPWR VGND sg13cmos5l_decap_8
* cell instance sg13cmos5l_decap_8_256 r0 *1 0,0
Xsg13cmos5l_decap_8_256 VPWR VGND sg13cmos5l_decap_8
* cell instance sg13cmos5l_decap_8_257 r0 *1 0,0
Xsg13cmos5l_decap_8_257 VPWR VGND sg13cmos5l_decap_8
* cell instance sg13cmos5l_decap_8_258 r0 *1 0,0
Xsg13cmos5l_decap_8_258 VPWR VGND sg13cmos5l_decap_8
* cell instance sg13cmos5l_decap_8_259 r0 *1 0,0
Xsg13cmos5l_decap_8_259 VPWR VGND sg13cmos5l_decap_8
* cell instance sg13cmos5l_decap_8_260 r0 *1 0,0
Xsg13cmos5l_decap_8_260 VPWR VGND sg13cmos5l_decap_8
* cell instance sg13cmos5l_decap_8_261 r0 *1 0,0
Xsg13cmos5l_decap_8_261 VPWR VGND sg13cmos5l_decap_8
* cell instance sg13cmos5l_decap_8_262 r0 *1 0,0
Xsg13cmos5l_decap_8_262 VPWR VGND sg13cmos5l_decap_8
* cell instance sg13cmos5l_decap_8_263 r0 *1 0,0
Xsg13cmos5l_decap_8_263 VPWR VGND sg13cmos5l_decap_8
* cell instance sg13cmos5l_decap_8_264 r0 *1 0,0
Xsg13cmos5l_decap_8_264 VPWR VGND sg13cmos5l_decap_8
* cell instance sg13cmos5l_decap_8_265 r0 *1 0,0
Xsg13cmos5l_decap_8_265 VPWR VGND sg13cmos5l_decap_8
* cell instance sg13cmos5l_decap_8_266 r0 *1 0,0
Xsg13cmos5l_decap_8_266 VPWR VGND sg13cmos5l_decap_8
* cell instance sg13cmos5l_decap_8_267 r0 *1 0,0
Xsg13cmos5l_decap_8_267 VPWR VGND sg13cmos5l_decap_8
* cell instance sg13cmos5l_decap_8_268 r0 *1 0,0
Xsg13cmos5l_decap_8_268 VPWR VGND sg13cmos5l_decap_8
* cell instance sg13cmos5l_decap_8_269 r0 *1 0,0
Xsg13cmos5l_decap_8_269 VPWR VGND sg13cmos5l_decap_8
* cell instance sg13cmos5l_decap_8_270 r0 *1 0,0
Xsg13cmos5l_decap_8_270 VPWR VGND sg13cmos5l_decap_8
* cell instance sg13cmos5l_decap_8_271 r0 *1 0,0
Xsg13cmos5l_decap_8_271 VPWR VGND sg13cmos5l_decap_8
* cell instance sg13cmos5l_decap_8_272 r0 *1 0,0
Xsg13cmos5l_decap_8_272 VPWR VGND sg13cmos5l_decap_8
* cell instance sg13cmos5l_decap_8_273 r0 *1 0,0
Xsg13cmos5l_decap_8_273 VPWR VGND sg13cmos5l_decap_8
* cell instance sg13cmos5l_decap_8_274 r0 *1 0,0
Xsg13cmos5l_decap_8_274 VPWR VGND sg13cmos5l_decap_8
* cell instance sg13cmos5l_decap_8_275 r0 *1 0,0
Xsg13cmos5l_decap_8_275 VPWR VGND sg13cmos5l_decap_8
* cell instance sg13cmos5l_decap_8_276 r0 *1 0,0
Xsg13cmos5l_decap_8_276 VPWR VGND sg13cmos5l_decap_8
* cell instance sg13cmos5l_decap_8_277 r0 *1 0,0
Xsg13cmos5l_decap_8_277 VPWR VGND sg13cmos5l_decap_8
* cell instance sg13cmos5l_decap_8_278 r0 *1 0,0
Xsg13cmos5l_decap_8_278 VPWR VGND sg13cmos5l_decap_8
* cell instance sg13cmos5l_decap_8_279 r0 *1 0,0
Xsg13cmos5l_decap_8_279 VPWR VGND sg13cmos5l_decap_8
* cell instance sg13cmos5l_decap_8_280 r0 *1 0,0
Xsg13cmos5l_decap_8_280 VPWR VGND sg13cmos5l_decap_8
* cell instance sg13cmos5l_decap_8_281 r0 *1 0,0
Xsg13cmos5l_decap_8_281 VPWR VGND sg13cmos5l_decap_8
* cell instance sg13cmos5l_decap_8_282 r0 *1 0,0
Xsg13cmos5l_decap_8_282 VPWR VGND sg13cmos5l_decap_8
* cell instance sg13cmos5l_decap_8_283 r0 *1 0,0
Xsg13cmos5l_decap_8_283 VPWR VGND sg13cmos5l_decap_8
* cell instance sg13cmos5l_decap_8_284 r0 *1 0,0
Xsg13cmos5l_decap_8_284 VPWR VGND sg13cmos5l_decap_8
* cell instance sg13cmos5l_decap_8_285 r0 *1 0,0
Xsg13cmos5l_decap_8_285 VPWR VGND sg13cmos5l_decap_8
* cell instance sg13cmos5l_decap_8_286 r0 *1 0,0
Xsg13cmos5l_decap_8_286 VPWR VGND sg13cmos5l_decap_8
* cell instance sg13cmos5l_decap_8_287 r0 *1 0,0
Xsg13cmos5l_decap_8_287 VPWR VGND sg13cmos5l_decap_8
* cell instance sg13cmos5l_decap_8_288 r0 *1 0,0
Xsg13cmos5l_decap_8_288 VPWR VGND sg13cmos5l_decap_8
* cell instance sg13cmos5l_decap_8_289 r0 *1 0,0
Xsg13cmos5l_decap_8_289 VPWR VGND sg13cmos5l_decap_8
* cell instance sg13cmos5l_decap_8_290 r0 *1 0,0
Xsg13cmos5l_decap_8_290 VPWR VGND sg13cmos5l_decap_8
* cell instance sg13cmos5l_decap_8_291 r0 *1 0,0
Xsg13cmos5l_decap_8_291 VPWR VGND sg13cmos5l_decap_8
* cell instance sg13cmos5l_decap_8_292 r0 *1 0,0
Xsg13cmos5l_decap_8_292 VPWR VGND sg13cmos5l_decap_8
* cell instance sg13cmos5l_decap_8_293 r0 *1 0,0
Xsg13cmos5l_decap_8_293 VPWR VGND sg13cmos5l_decap_8
* cell instance sg13cmos5l_decap_8_294 r0 *1 0,0
Xsg13cmos5l_decap_8_294 VPWR VGND sg13cmos5l_decap_8
* cell instance sg13cmos5l_decap_8_295 r0 *1 0,0
Xsg13cmos5l_decap_8_295 VPWR VGND sg13cmos5l_decap_8
* cell instance sg13cmos5l_decap_8_296 r0 *1 0,0
Xsg13cmos5l_decap_8_296 VPWR VGND sg13cmos5l_decap_8
* cell instance sg13cmos5l_decap_8_297 r0 *1 0,0
Xsg13cmos5l_decap_8_297 VPWR VGND sg13cmos5l_decap_8
* cell instance sg13cmos5l_decap_8_298 r0 *1 0,0
Xsg13cmos5l_decap_8_298 VPWR VGND sg13cmos5l_decap_8
* cell instance sg13cmos5l_decap_8_299 r0 *1 0,0
Xsg13cmos5l_decap_8_299 VPWR VGND sg13cmos5l_decap_8
* cell instance sg13cmos5l_decap_8_300 r0 *1 0,0
Xsg13cmos5l_decap_8_300 VPWR VGND sg13cmos5l_decap_8
* cell instance sg13cmos5l_decap_8_301 r0 *1 0,0
Xsg13cmos5l_decap_8_301 VPWR VGND sg13cmos5l_decap_8
* cell instance sg13cmos5l_decap_8_302 r0 *1 0,0
Xsg13cmos5l_decap_8_302 VPWR VGND sg13cmos5l_decap_8
* cell instance sg13cmos5l_decap_8_303 r0 *1 0,0
Xsg13cmos5l_decap_8_303 VPWR VGND sg13cmos5l_decap_8
* cell instance sg13cmos5l_decap_8_304 r0 *1 0,0
Xsg13cmos5l_decap_8_304 VPWR VGND sg13cmos5l_decap_8
* cell instance sg13cmos5l_decap_8_305 r0 *1 0,0
Xsg13cmos5l_decap_8_305 VPWR VGND sg13cmos5l_decap_8
* cell instance sg13cmos5l_decap_8_306 r0 *1 0,0
Xsg13cmos5l_decap_8_306 VPWR VGND sg13cmos5l_decap_8
* cell instance sg13cmos5l_decap_8_307 r0 *1 0,0
Xsg13cmos5l_decap_8_307 VPWR VGND sg13cmos5l_decap_8
* cell instance sg13cmos5l_decap_8_308 r0 *1 0,0
Xsg13cmos5l_decap_8_308 VPWR VGND sg13cmos5l_decap_8
* cell instance sg13cmos5l_decap_8_309 r0 *1 0,0
Xsg13cmos5l_decap_8_309 VPWR VGND sg13cmos5l_decap_8
* cell instance sg13cmos5l_decap_8_310 r0 *1 0,0
Xsg13cmos5l_decap_8_310 VPWR VGND sg13cmos5l_decap_8
* cell instance sg13cmos5l_decap_8_311 r0 *1 0,0
Xsg13cmos5l_decap_8_311 VPWR VGND sg13cmos5l_decap_8
* cell instance sg13cmos5l_decap_8_312 r0 *1 0,0
Xsg13cmos5l_decap_8_312 VPWR VGND sg13cmos5l_decap_8
* cell instance sg13cmos5l_decap_8_313 r0 *1 0,0
Xsg13cmos5l_decap_8_313 VPWR VGND sg13cmos5l_decap_8
* cell instance sg13cmos5l_decap_8_314 r0 *1 0,0
Xsg13cmos5l_decap_8_314 VPWR VGND sg13cmos5l_decap_8
* cell instance sg13cmos5l_decap_8_315 r0 *1 0,0
Xsg13cmos5l_decap_8_315 VPWR VGND sg13cmos5l_decap_8
* cell instance sg13cmos5l_decap_8_316 r0 *1 0,0
Xsg13cmos5l_decap_8_316 VPWR VGND sg13cmos5l_decap_8
* cell instance sg13cmos5l_decap_8_317 r0 *1 0,0
Xsg13cmos5l_decap_8_317 VPWR VGND sg13cmos5l_decap_8
* cell instance sg13cmos5l_decap_8_318 r0 *1 0,0
Xsg13cmos5l_decap_8_318 VPWR VGND sg13cmos5l_decap_8
* cell instance sg13cmos5l_decap_8_319 r0 *1 0,0
Xsg13cmos5l_decap_8_319 VPWR VGND sg13cmos5l_decap_8
* cell instance sg13cmos5l_decap_8_320 r0 *1 0,0
Xsg13cmos5l_decap_8_320 VPWR VGND sg13cmos5l_decap_8
* cell instance sg13cmos5l_decap_8_321 r0 *1 0,0
Xsg13cmos5l_decap_8_321 VPWR VGND sg13cmos5l_decap_8
* cell instance sg13cmos5l_decap_8_322 r0 *1 0,0
Xsg13cmos5l_decap_8_322 VPWR VGND sg13cmos5l_decap_8
* cell instance sg13cmos5l_decap_8_323 r0 *1 0,0
Xsg13cmos5l_decap_8_323 VPWR VGND sg13cmos5l_decap_8
* cell instance sg13cmos5l_decap_8_324 r0 *1 0,0
Xsg13cmos5l_decap_8_324 VPWR VGND sg13cmos5l_decap_8
* cell instance sg13cmos5l_decap_8_325 r0 *1 0,0
Xsg13cmos5l_decap_8_325 VPWR VGND sg13cmos5l_decap_8
* cell instance sg13cmos5l_decap_8_326 r0 *1 0,0
Xsg13cmos5l_decap_8_326 VPWR VGND sg13cmos5l_decap_8
* cell instance sg13cmos5l_decap_8_327 r0 *1 0,0
Xsg13cmos5l_decap_8_327 VPWR VGND sg13cmos5l_decap_8
* cell instance sg13cmos5l_decap_8_328 r0 *1 0,0
Xsg13cmos5l_decap_8_328 VPWR VGND sg13cmos5l_decap_8
* cell instance sg13cmos5l_decap_8_329 r0 *1 0,0
Xsg13cmos5l_decap_8_329 VPWR VGND sg13cmos5l_decap_8
* cell instance sg13cmos5l_decap_8_330 r0 *1 0,0
Xsg13cmos5l_decap_8_330 VPWR VGND sg13cmos5l_decap_8
* cell instance sg13cmos5l_decap_8_331 r0 *1 0,0
Xsg13cmos5l_decap_8_331 VPWR VGND sg13cmos5l_decap_8
* cell instance sg13cmos5l_decap_8_332 r0 *1 0,0
Xsg13cmos5l_decap_8_332 VPWR VGND sg13cmos5l_decap_8
* cell instance sg13cmos5l_decap_8_333 r0 *1 0,0
Xsg13cmos5l_decap_8_333 VPWR VGND sg13cmos5l_decap_8
* cell instance sg13cmos5l_decap_8_334 r0 *1 0,0
Xsg13cmos5l_decap_8_334 VPWR VGND sg13cmos5l_decap_8
* cell instance sg13cmos5l_decap_8_335 r0 *1 0,0
Xsg13cmos5l_decap_8_335 VPWR VGND sg13cmos5l_decap_8
* cell instance sg13cmos5l_decap_8_336 r0 *1 0,0
Xsg13cmos5l_decap_8_336 VPWR VGND sg13cmos5l_decap_8
* cell instance sg13cmos5l_decap_8_337 r0 *1 0,0
Xsg13cmos5l_decap_8_337 VPWR VGND sg13cmos5l_decap_8
* cell instance sg13cmos5l_decap_8_338 r0 *1 0,0
Xsg13cmos5l_decap_8_338 VPWR VGND sg13cmos5l_decap_8
* cell instance sg13cmos5l_decap_8_339 r0 *1 0,0
Xsg13cmos5l_decap_8_339 VPWR VGND sg13cmos5l_decap_8
* cell instance sg13cmos5l_decap_8_340 r0 *1 0,0
Xsg13cmos5l_decap_8_340 VPWR VGND sg13cmos5l_decap_8
* cell instance sg13cmos5l_decap_8_341 r0 *1 0,0
Xsg13cmos5l_decap_8_341 VPWR VGND sg13cmos5l_decap_8
* cell instance sg13cmos5l_decap_8_342 r0 *1 0,0
Xsg13cmos5l_decap_8_342 VPWR VGND sg13cmos5l_decap_8
* cell instance sg13cmos5l_decap_8_343 r0 *1 0,0
Xsg13cmos5l_decap_8_343 VPWR VGND sg13cmos5l_decap_8
* cell instance sg13cmos5l_decap_8_344 r0 *1 0,0
Xsg13cmos5l_decap_8_344 VPWR VGND sg13cmos5l_decap_8
* cell instance sg13cmos5l_decap_8_345 r0 *1 0,0
Xsg13cmos5l_decap_8_345 VPWR VGND sg13cmos5l_decap_8
* cell instance sg13cmos5l_decap_8_346 r0 *1 0,0
Xsg13cmos5l_decap_8_346 VPWR VGND sg13cmos5l_decap_8
* cell instance sg13cmos5l_decap_8_347 r0 *1 0,0
Xsg13cmos5l_decap_8_347 VPWR VGND sg13cmos5l_decap_8
* cell instance sg13cmos5l_decap_8_348 r0 *1 0,0
Xsg13cmos5l_decap_8_348 VPWR VGND sg13cmos5l_decap_8
* cell instance sg13cmos5l_decap_8_349 r0 *1 0,0
Xsg13cmos5l_decap_8_349 VPWR VGND sg13cmos5l_decap_8
* cell instance sg13cmos5l_decap_8_350 r0 *1 0,0
Xsg13cmos5l_decap_8_350 VPWR VGND sg13cmos5l_decap_8
* cell instance sg13cmos5l_decap_8_351 r0 *1 0,0
Xsg13cmos5l_decap_8_351 VPWR VGND sg13cmos5l_decap_8
* cell instance sg13cmos5l_decap_8_352 r0 *1 0,0
Xsg13cmos5l_decap_8_352 VPWR VGND sg13cmos5l_decap_8
* cell instance sg13cmos5l_decap_8_353 r0 *1 0,0
Xsg13cmos5l_decap_8_353 VPWR VGND sg13cmos5l_decap_8
* cell instance sg13cmos5l_decap_8_354 r0 *1 0,0
Xsg13cmos5l_decap_8_354 VPWR VGND sg13cmos5l_decap_8
* cell instance sg13cmos5l_decap_8_355 r0 *1 0,0
Xsg13cmos5l_decap_8_355 VPWR VGND sg13cmos5l_decap_8
* cell instance sg13cmos5l_decap_8_356 r0 *1 0,0
Xsg13cmos5l_decap_8_356 VPWR VGND sg13cmos5l_decap_8
* cell instance sg13cmos5l_decap_8_357 r0 *1 0,0
Xsg13cmos5l_decap_8_357 VPWR VGND sg13cmos5l_decap_8
* cell instance sg13cmos5l_decap_8_358 r0 *1 0,0
Xsg13cmos5l_decap_8_358 VPWR VGND sg13cmos5l_decap_8
* cell instance sg13cmos5l_decap_8_359 r0 *1 0,0
Xsg13cmos5l_decap_8_359 VPWR VGND sg13cmos5l_decap_8
* cell instance sg13cmos5l_decap_8_360 r0 *1 0,0
Xsg13cmos5l_decap_8_360 VPWR VGND sg13cmos5l_decap_8
* cell instance sg13cmos5l_decap_8_361 r0 *1 0,0
Xsg13cmos5l_decap_8_361 VPWR VGND sg13cmos5l_decap_8
* cell instance sg13cmos5l_decap_8_362 r0 *1 0,0
Xsg13cmos5l_decap_8_362 VPWR VGND sg13cmos5l_decap_8
* cell instance sg13cmos5l_decap_8_363 r0 *1 0,0
Xsg13cmos5l_decap_8_363 VPWR VGND sg13cmos5l_decap_8
* cell instance sg13cmos5l_decap_8_364 r0 *1 0,0
Xsg13cmos5l_decap_8_364 VPWR VGND sg13cmos5l_decap_8
* cell instance sg13cmos5l_decap_8_365 r0 *1 0,0
Xsg13cmos5l_decap_8_365 VPWR VGND sg13cmos5l_decap_8
* cell instance sg13cmos5l_decap_8_366 r0 *1 0,0
Xsg13cmos5l_decap_8_366 VPWR VGND sg13cmos5l_decap_8
* cell instance sg13cmos5l_decap_8_367 r0 *1 0,0
Xsg13cmos5l_decap_8_367 VPWR VGND sg13cmos5l_decap_8
* cell instance sg13cmos5l_decap_8_368 r0 *1 0,0
Xsg13cmos5l_decap_8_368 VPWR VGND sg13cmos5l_decap_8
* cell instance sg13cmos5l_decap_8_369 r0 *1 0,0
Xsg13cmos5l_decap_8_369 VPWR VGND sg13cmos5l_decap_8
* cell instance sg13cmos5l_decap_8_370 r0 *1 0,0
Xsg13cmos5l_decap_8_370 VPWR VGND sg13cmos5l_decap_8
* cell instance sg13cmos5l_decap_8_371 r0 *1 0,0
Xsg13cmos5l_decap_8_371 VPWR VGND sg13cmos5l_decap_8
* cell instance sg13cmos5l_decap_8_372 r0 *1 0,0
Xsg13cmos5l_decap_8_372 VPWR VGND sg13cmos5l_decap_8
* cell instance sg13cmos5l_decap_8_373 r0 *1 0,0
Xsg13cmos5l_decap_8_373 VPWR VGND sg13cmos5l_decap_8
* cell instance sg13cmos5l_decap_8_374 r0 *1 0,0
Xsg13cmos5l_decap_8_374 VPWR VGND sg13cmos5l_decap_8
* cell instance sg13cmos5l_decap_8_375 r0 *1 0,0
Xsg13cmos5l_decap_8_375 VPWR VGND sg13cmos5l_decap_8
* cell instance sg13cmos5l_decap_8_376 r0 *1 0,0
Xsg13cmos5l_decap_8_376 VPWR VGND sg13cmos5l_decap_8
* cell instance sg13cmos5l_decap_8_377 r0 *1 0,0
Xsg13cmos5l_decap_8_377 VPWR VGND sg13cmos5l_decap_8
* cell instance sg13cmos5l_decap_8_378 r0 *1 0,0
Xsg13cmos5l_decap_8_378 VPWR VGND sg13cmos5l_decap_8
* cell instance sg13cmos5l_decap_8_379 r0 *1 0,0
Xsg13cmos5l_decap_8_379 VPWR VGND sg13cmos5l_decap_8
* cell instance sg13cmos5l_decap_8_380 r0 *1 0,0
Xsg13cmos5l_decap_8_380 VPWR VGND sg13cmos5l_decap_8
* cell instance sg13cmos5l_decap_8_381 r0 *1 0,0
Xsg13cmos5l_decap_8_381 VPWR VGND sg13cmos5l_decap_8
* cell instance sg13cmos5l_decap_8_382 r0 *1 0,0
Xsg13cmos5l_decap_8_382 VPWR VGND sg13cmos5l_decap_8
* cell instance sg13cmos5l_decap_8_383 r0 *1 0,0
Xsg13cmos5l_decap_8_383 VPWR VGND sg13cmos5l_decap_8
* cell instance sg13cmos5l_decap_8_384 r0 *1 0,0
Xsg13cmos5l_decap_8_384 VPWR VGND sg13cmos5l_decap_8
* cell instance sg13cmos5l_decap_8_385 r0 *1 0,0
Xsg13cmos5l_decap_8_385 VPWR VGND sg13cmos5l_decap_8
* cell instance sg13cmos5l_decap_8_386 r0 *1 0,0
Xsg13cmos5l_decap_8_386 VPWR VGND sg13cmos5l_decap_8
* cell instance sg13cmos5l_decap_8_387 r0 *1 0,0
Xsg13cmos5l_decap_8_387 VPWR VGND sg13cmos5l_decap_8
* cell instance sg13cmos5l_decap_8_388 r0 *1 0,0
Xsg13cmos5l_decap_8_388 VPWR VGND sg13cmos5l_decap_8
* cell instance sg13cmos5l_decap_8_389 r0 *1 0,0
Xsg13cmos5l_decap_8_389 VPWR VGND sg13cmos5l_decap_8
* cell instance sg13cmos5l_decap_8_390 r0 *1 0,0
Xsg13cmos5l_decap_8_390 VPWR VGND sg13cmos5l_decap_8
* cell instance sg13cmos5l_decap_8_391 r0 *1 0,0
Xsg13cmos5l_decap_8_391 VPWR VGND sg13cmos5l_decap_8
* cell instance sg13cmos5l_decap_8_392 r0 *1 0,0
Xsg13cmos5l_decap_8_392 VPWR VGND sg13cmos5l_decap_8
* cell instance sg13cmos5l_decap_8_393 r0 *1 0,0
Xsg13cmos5l_decap_8_393 VPWR VGND sg13cmos5l_decap_8
* cell instance sg13cmos5l_decap_8_394 r0 *1 0,0
Xsg13cmos5l_decap_8_394 VPWR VGND sg13cmos5l_decap_8
* cell instance sg13cmos5l_decap_8_395 r0 *1 0,0
Xsg13cmos5l_decap_8_395 VPWR VGND sg13cmos5l_decap_8
* cell instance sg13cmos5l_decap_8_396 r0 *1 0,0
Xsg13cmos5l_decap_8_396 VPWR VGND sg13cmos5l_decap_8
* cell instance sg13cmos5l_decap_8_397 r0 *1 0,0
Xsg13cmos5l_decap_8_397 VPWR VGND sg13cmos5l_decap_8
* cell instance sg13cmos5l_decap_8_398 r0 *1 0,0
Xsg13cmos5l_decap_8_398 VPWR VGND sg13cmos5l_decap_8
* cell instance sg13cmos5l_decap_8_399 r0 *1 0,0
Xsg13cmos5l_decap_8_399 VPWR VGND sg13cmos5l_decap_8
* cell instance sg13cmos5l_decap_8_400 r0 *1 0,0
Xsg13cmos5l_decap_8_400 VPWR VGND sg13cmos5l_decap_8
* cell instance sg13cmos5l_decap_8_401 r0 *1 0,0
Xsg13cmos5l_decap_8_401 VPWR VGND sg13cmos5l_decap_8
* cell instance sg13cmos5l_decap_8_402 r0 *1 0,0
Xsg13cmos5l_decap_8_402 VPWR VGND sg13cmos5l_decap_8
* cell instance sg13cmos5l_decap_8_403 r0 *1 0,0
Xsg13cmos5l_decap_8_403 VPWR VGND sg13cmos5l_decap_8
* cell instance sg13cmos5l_decap_8_404 r0 *1 0,0
Xsg13cmos5l_decap_8_404 VPWR VGND sg13cmos5l_decap_8
* cell instance sg13cmos5l_decap_8_405 r0 *1 0,0
Xsg13cmos5l_decap_8_405 VPWR VGND sg13cmos5l_decap_8
* cell instance sg13cmos5l_decap_8_406 r0 *1 0,0
Xsg13cmos5l_decap_8_406 VPWR VGND sg13cmos5l_decap_8
* cell instance sg13cmos5l_decap_8_407 r0 *1 0,0
Xsg13cmos5l_decap_8_407 VPWR VGND sg13cmos5l_decap_8
* cell instance sg13cmos5l_decap_8_408 r0 *1 0,0
Xsg13cmos5l_decap_8_408 VPWR VGND sg13cmos5l_decap_8
* cell instance sg13cmos5l_decap_8_409 r0 *1 0,0
Xsg13cmos5l_decap_8_409 VPWR VGND sg13cmos5l_decap_8
* cell instance sg13cmos5l_decap_8_410 r0 *1 0,0
Xsg13cmos5l_decap_8_410 VPWR VGND sg13cmos5l_decap_8
* cell instance sg13cmos5l_decap_8_411 r0 *1 0,0
Xsg13cmos5l_decap_8_411 VPWR VGND sg13cmos5l_decap_8
* cell instance sg13cmos5l_decap_8_412 r0 *1 0,0
Xsg13cmos5l_decap_8_412 VPWR VGND sg13cmos5l_decap_8
* cell instance sg13cmos5l_decap_8_413 r0 *1 0,0
Xsg13cmos5l_decap_8_413 VPWR VGND sg13cmos5l_decap_8
* cell instance sg13cmos5l_decap_8_414 r0 *1 0,0
Xsg13cmos5l_decap_8_414 VPWR VGND sg13cmos5l_decap_8
* cell instance sg13cmos5l_decap_8_415 r0 *1 0,0
Xsg13cmos5l_decap_8_415 VPWR VGND sg13cmos5l_decap_8
* cell instance sg13cmos5l_decap_8_416 r0 *1 0,0
Xsg13cmos5l_decap_8_416 VPWR VGND sg13cmos5l_decap_8
* cell instance sg13cmos5l_decap_8_417 r0 *1 0,0
Xsg13cmos5l_decap_8_417 VPWR VGND sg13cmos5l_decap_8
* cell instance sg13cmos5l_decap_8_418 r0 *1 0,0
Xsg13cmos5l_decap_8_418 VPWR VGND sg13cmos5l_decap_8
* cell instance sg13cmos5l_decap_8_419 r0 *1 0,0
Xsg13cmos5l_decap_8_419 VPWR VGND sg13cmos5l_decap_8
* cell instance sg13cmos5l_decap_8_420 r0 *1 0,0
Xsg13cmos5l_decap_8_420 VPWR VGND sg13cmos5l_decap_8
* cell instance sg13cmos5l_decap_8_421 r0 *1 0,0
Xsg13cmos5l_decap_8_421 VPWR VGND sg13cmos5l_decap_8
* cell instance sg13cmos5l_decap_8_422 r0 *1 0,0
Xsg13cmos5l_decap_8_422 VPWR VGND sg13cmos5l_decap_8
* cell instance sg13cmos5l_decap_8_423 r0 *1 0,0
Xsg13cmos5l_decap_8_423 VPWR VGND sg13cmos5l_decap_8
* cell instance sg13cmos5l_decap_8_424 r0 *1 0,0
Xsg13cmos5l_decap_8_424 VPWR VGND sg13cmos5l_decap_8
* cell instance sg13cmos5l_decap_8_425 r0 *1 0,0
Xsg13cmos5l_decap_8_425 VPWR VGND sg13cmos5l_decap_8
* cell instance sg13cmos5l_decap_8_426 r0 *1 0,0
Xsg13cmos5l_decap_8_426 VPWR VGND sg13cmos5l_decap_8
* cell instance sg13cmos5l_decap_8_427 r0 *1 0,0
Xsg13cmos5l_decap_8_427 VPWR VGND sg13cmos5l_decap_8
* cell instance sg13cmos5l_decap_8_428 r0 *1 0,0
Xsg13cmos5l_decap_8_428 VPWR VGND sg13cmos5l_decap_8
* cell instance sg13cmos5l_decap_8_429 r0 *1 0,0
Xsg13cmos5l_decap_8_429 VPWR VGND sg13cmos5l_decap_8
* cell instance sg13cmos5l_decap_8_430 r0 *1 0,0
Xsg13cmos5l_decap_8_430 VPWR VGND sg13cmos5l_decap_8
* cell instance sg13cmos5l_decap_8_431 r0 *1 0,0
Xsg13cmos5l_decap_8_431 VPWR VGND sg13cmos5l_decap_8
* cell instance sg13cmos5l_decap_8_432 r0 *1 0,0
Xsg13cmos5l_decap_8_432 VPWR VGND sg13cmos5l_decap_8
* cell instance sg13cmos5l_decap_8_433 r0 *1 0,0
Xsg13cmos5l_decap_8_433 VPWR VGND sg13cmos5l_decap_8
* cell instance sg13cmos5l_decap_8_434 r0 *1 0,0
Xsg13cmos5l_decap_8_434 VPWR VGND sg13cmos5l_decap_8
* cell instance sg13cmos5l_decap_8_435 r0 *1 0,0
Xsg13cmos5l_decap_8_435 VPWR VGND sg13cmos5l_decap_8
* cell instance sg13cmos5l_decap_8_436 r0 *1 0,0
Xsg13cmos5l_decap_8_436 VPWR VGND sg13cmos5l_decap_8
* cell instance sg13cmos5l_decap_8_437 r0 *1 0,0
Xsg13cmos5l_decap_8_437 VPWR VGND sg13cmos5l_decap_8
* cell instance sg13cmos5l_decap_8_438 r0 *1 0,0
Xsg13cmos5l_decap_8_438 VPWR VGND sg13cmos5l_decap_8
* cell instance sg13cmos5l_decap_8_439 r0 *1 0,0
Xsg13cmos5l_decap_8_439 VPWR VGND sg13cmos5l_decap_8
* cell instance sg13cmos5l_decap_8_440 r0 *1 0,0
Xsg13cmos5l_decap_8_440 VPWR VGND sg13cmos5l_decap_8
* cell instance sg13cmos5l_decap_8_441 r0 *1 0,0
Xsg13cmos5l_decap_8_441 VPWR VGND sg13cmos5l_decap_8
* cell instance sg13cmos5l_decap_8_442 r0 *1 0,0
Xsg13cmos5l_decap_8_442 VPWR VGND sg13cmos5l_decap_8
* cell instance sg13cmos5l_decap_8_443 r0 *1 0,0
Xsg13cmos5l_decap_8_443 VPWR VGND sg13cmos5l_decap_8
* cell instance sg13cmos5l_decap_8_444 r0 *1 0,0
Xsg13cmos5l_decap_8_444 VPWR VGND sg13cmos5l_decap_8
* cell instance sg13cmos5l_decap_8_445 r0 *1 0,0
Xsg13cmos5l_decap_8_445 VPWR VGND sg13cmos5l_decap_8
* cell instance sg13cmos5l_decap_8_446 r0 *1 0,0
Xsg13cmos5l_decap_8_446 VPWR VGND sg13cmos5l_decap_8
* cell instance sg13cmos5l_decap_8_447 r0 *1 0,0
Xsg13cmos5l_decap_8_447 VPWR VGND sg13cmos5l_decap_8
* cell instance sg13cmos5l_decap_8_448 r0 *1 0,0
Xsg13cmos5l_decap_8_448 VPWR VGND sg13cmos5l_decap_8
* cell instance sg13cmos5l_decap_8_449 r0 *1 0,0
Xsg13cmos5l_decap_8_449 VPWR VGND sg13cmos5l_decap_8
* cell instance sg13cmos5l_decap_8_450 r0 *1 0,0
Xsg13cmos5l_decap_8_450 VPWR VGND sg13cmos5l_decap_8
* cell instance sg13cmos5l_decap_8_451 r0 *1 0,0
Xsg13cmos5l_decap_8_451 VPWR VGND sg13cmos5l_decap_8
* cell instance sg13cmos5l_decap_8_452 r0 *1 0,0
Xsg13cmos5l_decap_8_452 VPWR VGND sg13cmos5l_decap_8
* cell instance sg13cmos5l_decap_8_453 r0 *1 0,0
Xsg13cmos5l_decap_8_453 VPWR VGND sg13cmos5l_decap_8
* cell instance sg13cmos5l_decap_8_454 r0 *1 0,0
Xsg13cmos5l_decap_8_454 VPWR VGND sg13cmos5l_decap_8
* cell instance sg13cmos5l_decap_8_455 r0 *1 0,0
Xsg13cmos5l_decap_8_455 VPWR VGND sg13cmos5l_decap_8
* cell instance sg13cmos5l_decap_8_456 r0 *1 0,0
Xsg13cmos5l_decap_8_456 VPWR VGND sg13cmos5l_decap_8
* cell instance sg13cmos5l_decap_8_457 r0 *1 0,0
Xsg13cmos5l_decap_8_457 VPWR VGND sg13cmos5l_decap_8
* cell instance sg13cmos5l_decap_8_458 r0 *1 0,0
Xsg13cmos5l_decap_8_458 VPWR VGND sg13cmos5l_decap_8
* cell instance sg13cmos5l_decap_8_459 r0 *1 0,0
Xsg13cmos5l_decap_8_459 VPWR VGND sg13cmos5l_decap_8
* cell instance sg13cmos5l_decap_8_460 r0 *1 0,0
Xsg13cmos5l_decap_8_460 VPWR VGND sg13cmos5l_decap_8
* cell instance sg13cmos5l_decap_8_461 r0 *1 0,0
Xsg13cmos5l_decap_8_461 VPWR VGND sg13cmos5l_decap_8
* cell instance sg13cmos5l_decap_8_462 r0 *1 0,0
Xsg13cmos5l_decap_8_462 VPWR VGND sg13cmos5l_decap_8
* cell instance sg13cmos5l_decap_8_463 r0 *1 0,0
Xsg13cmos5l_decap_8_463 VPWR VGND sg13cmos5l_decap_8
* cell instance sg13cmos5l_decap_8_464 r0 *1 0,0
Xsg13cmos5l_decap_8_464 VPWR VGND sg13cmos5l_decap_8
* cell instance sg13cmos5l_decap_8_465 r0 *1 0,0
Xsg13cmos5l_decap_8_465 VPWR VGND sg13cmos5l_decap_8
* cell instance sg13cmos5l_decap_8_466 r0 *1 0,0
Xsg13cmos5l_decap_8_466 VPWR VGND sg13cmos5l_decap_8
* cell instance sg13cmos5l_decap_8_467 r0 *1 0,0
Xsg13cmos5l_decap_8_467 VPWR VGND sg13cmos5l_decap_8
* cell instance sg13cmos5l_decap_8_468 r0 *1 0,0
Xsg13cmos5l_decap_8_468 VPWR VGND sg13cmos5l_decap_8
* cell instance sg13cmos5l_decap_8_469 r0 *1 0,0
Xsg13cmos5l_decap_8_469 VPWR VGND sg13cmos5l_decap_8
* cell instance sg13cmos5l_decap_8_470 r0 *1 0,0
Xsg13cmos5l_decap_8_470 VPWR VGND sg13cmos5l_decap_8
* cell instance sg13cmos5l_decap_8_471 r0 *1 0,0
Xsg13cmos5l_decap_8_471 VPWR VGND sg13cmos5l_decap_8
* cell instance sg13cmos5l_decap_8_472 r0 *1 0,0
Xsg13cmos5l_decap_8_472 VPWR VGND sg13cmos5l_decap_8
* cell instance sg13cmos5l_decap_8_473 r0 *1 0,0
Xsg13cmos5l_decap_8_473 VPWR VGND sg13cmos5l_decap_8
* cell instance sg13cmos5l_decap_8_474 r0 *1 0,0
Xsg13cmos5l_decap_8_474 VPWR VGND sg13cmos5l_decap_8
* cell instance sg13cmos5l_decap_8_475 r0 *1 0,0
Xsg13cmos5l_decap_8_475 VPWR VGND sg13cmos5l_decap_8
* cell instance sg13cmos5l_decap_8_476 r0 *1 0,0
Xsg13cmos5l_decap_8_476 VPWR VGND sg13cmos5l_decap_8
* cell instance sg13cmos5l_decap_8_477 r0 *1 0,0
Xsg13cmos5l_decap_8_477 VPWR VGND sg13cmos5l_decap_8
* cell instance sg13cmos5l_decap_8_478 r0 *1 0,0
Xsg13cmos5l_decap_8_478 VPWR VGND sg13cmos5l_decap_8
* cell instance sg13cmos5l_decap_8_479 r0 *1 0,0
Xsg13cmos5l_decap_8_479 VPWR VGND sg13cmos5l_decap_8
* cell instance sg13cmos5l_decap_8_480 r0 *1 0,0
Xsg13cmos5l_decap_8_480 VPWR VGND sg13cmos5l_decap_8
* cell instance sg13cmos5l_decap_8_481 r0 *1 0,0
Xsg13cmos5l_decap_8_481 VPWR VGND sg13cmos5l_decap_8
* cell instance sg13cmos5l_decap_8_482 r0 *1 0,0
Xsg13cmos5l_decap_8_482 VPWR VGND sg13cmos5l_decap_8
* cell instance sg13cmos5l_decap_8_483 r0 *1 0,0
Xsg13cmos5l_decap_8_483 VPWR VGND sg13cmos5l_decap_8
* cell instance sg13cmos5l_decap_8_484 r0 *1 0,0
Xsg13cmos5l_decap_8_484 VPWR VGND sg13cmos5l_decap_8
* cell instance sg13cmos5l_decap_8_485 r0 *1 0,0
Xsg13cmos5l_decap_8_485 VPWR VGND sg13cmos5l_decap_8
* cell instance sg13cmos5l_decap_8_486 r0 *1 0,0
Xsg13cmos5l_decap_8_486 VPWR VGND sg13cmos5l_decap_8
* cell instance sg13cmos5l_decap_8_487 r0 *1 0,0
Xsg13cmos5l_decap_8_487 VPWR VGND sg13cmos5l_decap_8
* cell instance sg13cmos5l_decap_8_488 r0 *1 0,0
Xsg13cmos5l_decap_8_488 VPWR VGND sg13cmos5l_decap_8
* cell instance sg13cmos5l_decap_8_489 r0 *1 0,0
Xsg13cmos5l_decap_8_489 VPWR VGND sg13cmos5l_decap_8
* cell instance sg13cmos5l_decap_8_490 r0 *1 0,0
Xsg13cmos5l_decap_8_490 VPWR VGND sg13cmos5l_decap_8
* cell instance sg13cmos5l_decap_8_491 r0 *1 0,0
Xsg13cmos5l_decap_8_491 VPWR VGND sg13cmos5l_decap_8
* cell instance sg13cmos5l_decap_8_492 r0 *1 0,0
Xsg13cmos5l_decap_8_492 VPWR VGND sg13cmos5l_decap_8
* cell instance sg13cmos5l_decap_8_493 r0 *1 0,0
Xsg13cmos5l_decap_8_493 VPWR VGND sg13cmos5l_decap_8
* cell instance sg13cmos5l_decap_8_494 r0 *1 0,0
Xsg13cmos5l_decap_8_494 VPWR VGND sg13cmos5l_decap_8
* cell instance sg13cmos5l_decap_8_495 r0 *1 0,0
Xsg13cmos5l_decap_8_495 VPWR VGND sg13cmos5l_decap_8
* cell instance sg13cmos5l_decap_8_496 r0 *1 0,0
Xsg13cmos5l_decap_8_496 VPWR VGND sg13cmos5l_decap_8
* cell instance sg13cmos5l_decap_8_497 r0 *1 0,0
Xsg13cmos5l_decap_8_497 VPWR VGND sg13cmos5l_decap_8
* cell instance sg13cmos5l_decap_8_498 r0 *1 0,0
Xsg13cmos5l_decap_8_498 VPWR VGND sg13cmos5l_decap_8
* cell instance sg13cmos5l_decap_8_499 r0 *1 0,0
Xsg13cmos5l_decap_8_499 VPWR VGND sg13cmos5l_decap_8
* cell instance sg13cmos5l_decap_8_500 r0 *1 0,0
Xsg13cmos5l_decap_8_500 VPWR VGND sg13cmos5l_decap_8
* cell instance sg13cmos5l_decap_8_501 r0 *1 0,0
Xsg13cmos5l_decap_8_501 VPWR VGND sg13cmos5l_decap_8
* cell instance sg13cmos5l_decap_8_502 r0 *1 0,0
Xsg13cmos5l_decap_8_502 VPWR VGND sg13cmos5l_decap_8
* cell instance sg13cmos5l_decap_8_503 r0 *1 0,0
Xsg13cmos5l_decap_8_503 VPWR VGND sg13cmos5l_decap_8
* cell instance sg13cmos5l_decap_8_504 r0 *1 0,0
Xsg13cmos5l_decap_8_504 VPWR VGND sg13cmos5l_decap_8
* cell instance sg13cmos5l_decap_8_505 r0 *1 0,0
Xsg13cmos5l_decap_8_505 VPWR VGND sg13cmos5l_decap_8
* cell instance sg13cmos5l_decap_8_506 r0 *1 0,0
Xsg13cmos5l_decap_8_506 VPWR VGND sg13cmos5l_decap_8
* cell instance sg13cmos5l_decap_8_507 r0 *1 0,0
Xsg13cmos5l_decap_8_507 VPWR VGND sg13cmos5l_decap_8
* cell instance sg13cmos5l_decap_8_508 r0 *1 0,0
Xsg13cmos5l_decap_8_508 VPWR VGND sg13cmos5l_decap_8
* cell instance sg13cmos5l_decap_8_509 r0 *1 0,0
Xsg13cmos5l_decap_8_509 VPWR VGND sg13cmos5l_decap_8
* cell instance sg13cmos5l_decap_8_510 r0 *1 0,0
Xsg13cmos5l_decap_8_510 VPWR VGND sg13cmos5l_decap_8
* cell instance sg13cmos5l_decap_8_511 r0 *1 0,0
Xsg13cmos5l_decap_8_511 VPWR VGND sg13cmos5l_decap_8
* cell instance sg13cmos5l_decap_8_512 r0 *1 0,0
Xsg13cmos5l_decap_8_512 VPWR VGND sg13cmos5l_decap_8
* cell instance sg13cmos5l_decap_8_513 r0 *1 0,0
Xsg13cmos5l_decap_8_513 VPWR VGND sg13cmos5l_decap_8
* cell instance sg13cmos5l_decap_8_514 r0 *1 0,0
Xsg13cmos5l_decap_8_514 VPWR VGND sg13cmos5l_decap_8
* cell instance sg13cmos5l_decap_8_515 r0 *1 0,0
Xsg13cmos5l_decap_8_515 VPWR VGND sg13cmos5l_decap_8
* cell instance sg13cmos5l_decap_8_516 r0 *1 0,0
Xsg13cmos5l_decap_8_516 VPWR VGND sg13cmos5l_decap_8
* cell instance sg13cmos5l_decap_8_517 r0 *1 0,0
Xsg13cmos5l_decap_8_517 VPWR VGND sg13cmos5l_decap_8
* cell instance sg13cmos5l_decap_8_518 r0 *1 0,0
Xsg13cmos5l_decap_8_518 VPWR VGND sg13cmos5l_decap_8
* cell instance sg13cmos5l_decap_8_519 r0 *1 0,0
Xsg13cmos5l_decap_8_519 VPWR VGND sg13cmos5l_decap_8
* cell instance sg13cmos5l_decap_8_520 r0 *1 0,0
Xsg13cmos5l_decap_8_520 VPWR VGND sg13cmos5l_decap_8
* cell instance sg13cmos5l_decap_8_521 r0 *1 0,0
Xsg13cmos5l_decap_8_521 VPWR VGND sg13cmos5l_decap_8
* cell instance sg13cmos5l_decap_8_522 r0 *1 0,0
Xsg13cmos5l_decap_8_522 VPWR VGND sg13cmos5l_decap_8
* cell instance sg13cmos5l_decap_8_523 r0 *1 0,0
Xsg13cmos5l_decap_8_523 VPWR VGND sg13cmos5l_decap_8
* cell instance sg13cmos5l_decap_8_524 r0 *1 0,0
Xsg13cmos5l_decap_8_524 VPWR VGND sg13cmos5l_decap_8
* cell instance sg13cmos5l_decap_8_525 r0 *1 0,0
Xsg13cmos5l_decap_8_525 VPWR VGND sg13cmos5l_decap_8
* cell instance sg13cmos5l_decap_8_526 r0 *1 0,0
Xsg13cmos5l_decap_8_526 VPWR VGND sg13cmos5l_decap_8
* cell instance sg13cmos5l_decap_8_527 r0 *1 0,0
Xsg13cmos5l_decap_8_527 VPWR VGND sg13cmos5l_decap_8
* cell instance sg13cmos5l_decap_8_528 r0 *1 0,0
Xsg13cmos5l_decap_8_528 VPWR VGND sg13cmos5l_decap_8
* cell instance sg13cmos5l_decap_8_529 r0 *1 0,0
Xsg13cmos5l_decap_8_529 VPWR VGND sg13cmos5l_decap_8
* cell instance sg13cmos5l_decap_8_530 r0 *1 0,0
Xsg13cmos5l_decap_8_530 VPWR VGND sg13cmos5l_decap_8
* cell instance sg13cmos5l_decap_8_531 r0 *1 0,0
Xsg13cmos5l_decap_8_531 VPWR VGND sg13cmos5l_decap_8
* cell instance sg13cmos5l_decap_8_532 r0 *1 0,0
Xsg13cmos5l_decap_8_532 VPWR VGND sg13cmos5l_decap_8
* cell instance sg13cmos5l_decap_8_533 r0 *1 0,0
Xsg13cmos5l_decap_8_533 VPWR VGND sg13cmos5l_decap_8
* cell instance sg13cmos5l_decap_8_534 r0 *1 0,0
Xsg13cmos5l_decap_8_534 VPWR VGND sg13cmos5l_decap_8
* cell instance sg13cmos5l_decap_8_535 r0 *1 0,0
Xsg13cmos5l_decap_8_535 VPWR VGND sg13cmos5l_decap_8
* cell instance sg13cmos5l_decap_8_536 r0 *1 0,0
Xsg13cmos5l_decap_8_536 VPWR VGND sg13cmos5l_decap_8
* cell instance sg13cmos5l_decap_8_537 r0 *1 0,0
Xsg13cmos5l_decap_8_537 VPWR VGND sg13cmos5l_decap_8
* cell instance sg13cmos5l_decap_8_538 r0 *1 0,0
Xsg13cmos5l_decap_8_538 VPWR VGND sg13cmos5l_decap_8
* cell instance sg13cmos5l_decap_8_539 r0 *1 0,0
Xsg13cmos5l_decap_8_539 VPWR VGND sg13cmos5l_decap_8
* cell instance sg13cmos5l_decap_8_540 r0 *1 0,0
Xsg13cmos5l_decap_8_540 VPWR VGND sg13cmos5l_decap_8
* cell instance sg13cmos5l_decap_8_541 r0 *1 0,0
Xsg13cmos5l_decap_8_541 VPWR VGND sg13cmos5l_decap_8
* cell instance sg13cmos5l_decap_8_542 r0 *1 0,0
Xsg13cmos5l_decap_8_542 VPWR VGND sg13cmos5l_decap_8
* cell instance sg13cmos5l_decap_8_543 r0 *1 0,0
Xsg13cmos5l_decap_8_543 VPWR VGND sg13cmos5l_decap_8
* cell instance sg13cmos5l_decap_8_544 r0 *1 0,0
Xsg13cmos5l_decap_8_544 VPWR VGND sg13cmos5l_decap_8
* cell instance sg13cmos5l_decap_8_545 r0 *1 0,0
Xsg13cmos5l_decap_8_545 VPWR VGND sg13cmos5l_decap_8
* cell instance sg13cmos5l_decap_8_546 r0 *1 0,0
Xsg13cmos5l_decap_8_546 VPWR VGND sg13cmos5l_decap_8
* cell instance sg13cmos5l_decap_8_547 r0 *1 0,0
Xsg13cmos5l_decap_8_547 VPWR VGND sg13cmos5l_decap_8
* cell instance sg13cmos5l_decap_8_548 r0 *1 0,0
Xsg13cmos5l_decap_8_548 VPWR VGND sg13cmos5l_decap_8
* cell instance sg13cmos5l_decap_8_549 r0 *1 0,0
Xsg13cmos5l_decap_8_549 VPWR VGND sg13cmos5l_decap_8
* cell instance sg13cmos5l_decap_8_550 r0 *1 0,0
Xsg13cmos5l_decap_8_550 VPWR VGND sg13cmos5l_decap_8
* cell instance sg13cmos5l_decap_8_551 r0 *1 0,0
Xsg13cmos5l_decap_8_551 VPWR VGND sg13cmos5l_decap_8
* cell instance sg13cmos5l_decap_8_552 r0 *1 0,0
Xsg13cmos5l_decap_8_552 VPWR VGND sg13cmos5l_decap_8
* cell instance sg13cmos5l_decap_8_553 r0 *1 0,0
Xsg13cmos5l_decap_8_553 VPWR VGND sg13cmos5l_decap_8
* cell instance sg13cmos5l_decap_8_554 r0 *1 0,0
Xsg13cmos5l_decap_8_554 VPWR VGND sg13cmos5l_decap_8
* cell instance sg13cmos5l_decap_8_555 r0 *1 0,0
Xsg13cmos5l_decap_8_555 VPWR VGND sg13cmos5l_decap_8
* cell instance sg13cmos5l_decap_8_556 r0 *1 0,0
Xsg13cmos5l_decap_8_556 VPWR VGND sg13cmos5l_decap_8
* cell instance sg13cmos5l_decap_8_557 r0 *1 0,0
Xsg13cmos5l_decap_8_557 VPWR VGND sg13cmos5l_decap_8
* cell instance sg13cmos5l_decap_8_558 r0 *1 0,0
Xsg13cmos5l_decap_8_558 VPWR VGND sg13cmos5l_decap_8
* cell instance sg13cmos5l_decap_8_559 r0 *1 0,0
Xsg13cmos5l_decap_8_559 VPWR VGND sg13cmos5l_decap_8
* cell instance sg13cmos5l_decap_8_560 r0 *1 0,0
Xsg13cmos5l_decap_8_560 VPWR VGND sg13cmos5l_decap_8
* cell instance sg13cmos5l_decap_8_561 r0 *1 0,0
Xsg13cmos5l_decap_8_561 VPWR VGND sg13cmos5l_decap_8
* cell instance sg13cmos5l_decap_8_562 r0 *1 0,0
Xsg13cmos5l_decap_8_562 VPWR VGND sg13cmos5l_decap_8
* cell instance sg13cmos5l_decap_8_563 r0 *1 0,0
Xsg13cmos5l_decap_8_563 VPWR VGND sg13cmos5l_decap_8
* cell instance sg13cmos5l_decap_8_564 r0 *1 0,0
Xsg13cmos5l_decap_8_564 VPWR VGND sg13cmos5l_decap_8
* cell instance sg13cmos5l_decap_8_565 r0 *1 0,0
Xsg13cmos5l_decap_8_565 VPWR VGND sg13cmos5l_decap_8
* cell instance sg13cmos5l_decap_8_566 r0 *1 0,0
Xsg13cmos5l_decap_8_566 VPWR VGND sg13cmos5l_decap_8
* cell instance sg13cmos5l_decap_8_567 r0 *1 0,0
Xsg13cmos5l_decap_8_567 VPWR VGND sg13cmos5l_decap_8
* cell instance sg13cmos5l_decap_8_568 r0 *1 0,0
Xsg13cmos5l_decap_8_568 VPWR VGND sg13cmos5l_decap_8
* cell instance sg13cmos5l_decap_8_569 r0 *1 0,0
Xsg13cmos5l_decap_8_569 VPWR VGND sg13cmos5l_decap_8
* cell instance sg13cmos5l_decap_8_570 r0 *1 0,0
Xsg13cmos5l_decap_8_570 VPWR VGND sg13cmos5l_decap_8
* cell instance sg13cmos5l_decap_8_571 r0 *1 0,0
Xsg13cmos5l_decap_8_571 VPWR VGND sg13cmos5l_decap_8
* cell instance sg13cmos5l_decap_8_572 r0 *1 0,0
Xsg13cmos5l_decap_8_572 VPWR VGND sg13cmos5l_decap_8
* cell instance sg13cmos5l_decap_8_573 r0 *1 0,0
Xsg13cmos5l_decap_8_573 VPWR VGND sg13cmos5l_decap_8
* cell instance sg13cmos5l_decap_8_574 r0 *1 0,0
Xsg13cmos5l_decap_8_574 VPWR VGND sg13cmos5l_decap_8
* cell instance sg13cmos5l_decap_8_575 r0 *1 0,0
Xsg13cmos5l_decap_8_575 VPWR VGND sg13cmos5l_decap_8
* cell instance sg13cmos5l_decap_8_576 r0 *1 0,0
Xsg13cmos5l_decap_8_576 VPWR VGND sg13cmos5l_decap_8
* cell instance sg13cmos5l_decap_8_577 r0 *1 0,0
Xsg13cmos5l_decap_8_577 VPWR VGND sg13cmos5l_decap_8
* cell instance sg13cmos5l_decap_8_578 r0 *1 0,0
Xsg13cmos5l_decap_8_578 VPWR VGND sg13cmos5l_decap_8
* cell instance sg13cmos5l_decap_8_579 r0 *1 0,0
Xsg13cmos5l_decap_8_579 VPWR VGND sg13cmos5l_decap_8
* cell instance sg13cmos5l_decap_8_580 r0 *1 0,0
Xsg13cmos5l_decap_8_580 VPWR VGND sg13cmos5l_decap_8
* cell instance sg13cmos5l_decap_8_581 r0 *1 0,0
Xsg13cmos5l_decap_8_581 VPWR VGND sg13cmos5l_decap_8
* cell instance sg13cmos5l_decap_8_582 r0 *1 0,0
Xsg13cmos5l_decap_8_582 VPWR VGND sg13cmos5l_decap_8
* cell instance sg13cmos5l_decap_8_583 r0 *1 0,0
Xsg13cmos5l_decap_8_583 VPWR VGND sg13cmos5l_decap_8
* cell instance sg13cmos5l_decap_8_584 r0 *1 0,0
Xsg13cmos5l_decap_8_584 VPWR VGND sg13cmos5l_decap_8
* cell instance sg13cmos5l_decap_8_585 r0 *1 0,0
Xsg13cmos5l_decap_8_585 VPWR VGND sg13cmos5l_decap_8
* cell instance sg13cmos5l_decap_8_586 r0 *1 0,0
Xsg13cmos5l_decap_8_586 VPWR VGND sg13cmos5l_decap_8
* cell instance sg13cmos5l_decap_8_587 r0 *1 0,0
Xsg13cmos5l_decap_8_587 VPWR VGND sg13cmos5l_decap_8
* cell instance sg13cmos5l_decap_8_588 r0 *1 0,0
Xsg13cmos5l_decap_8_588 VPWR VGND sg13cmos5l_decap_8
* cell instance sg13cmos5l_decap_8_589 r0 *1 0,0
Xsg13cmos5l_decap_8_589 VPWR VGND sg13cmos5l_decap_8
* cell instance sg13cmos5l_decap_8_590 r0 *1 0,0
Xsg13cmos5l_decap_8_590 VPWR VGND sg13cmos5l_decap_8
* cell instance sg13cmos5l_decap_8_591 r0 *1 0,0
Xsg13cmos5l_decap_8_591 VPWR VGND sg13cmos5l_decap_8
* cell instance sg13cmos5l_decap_8_592 r0 *1 0,0
Xsg13cmos5l_decap_8_592 VPWR VGND sg13cmos5l_decap_8
* cell instance sg13cmos5l_decap_8_593 r0 *1 0,0
Xsg13cmos5l_decap_8_593 VPWR VGND sg13cmos5l_decap_8
* cell instance sg13cmos5l_decap_8_594 r0 *1 0,0
Xsg13cmos5l_decap_8_594 VPWR VGND sg13cmos5l_decap_8
* cell instance sg13cmos5l_decap_8_595 r0 *1 0,0
Xsg13cmos5l_decap_8_595 VPWR VGND sg13cmos5l_decap_8
* cell instance sg13cmos5l_decap_8_596 r0 *1 0,0
Xsg13cmos5l_decap_8_596 VPWR VGND sg13cmos5l_decap_8
* cell instance sg13cmos5l_decap_8_597 r0 *1 0,0
Xsg13cmos5l_decap_8_597 VPWR VGND sg13cmos5l_decap_8
* cell instance sg13cmos5l_decap_8_598 r0 *1 0,0
Xsg13cmos5l_decap_8_598 VPWR VGND sg13cmos5l_decap_8
* cell instance sg13cmos5l_decap_8_599 r0 *1 0,0
Xsg13cmos5l_decap_8_599 VPWR VGND sg13cmos5l_decap_8
* cell instance sg13cmos5l_decap_8_600 r0 *1 0,0
Xsg13cmos5l_decap_8_600 VPWR VGND sg13cmos5l_decap_8
* cell instance sg13cmos5l_decap_8_601 r0 *1 0,0
Xsg13cmos5l_decap_8_601 VPWR VGND sg13cmos5l_decap_8
* cell instance sg13cmos5l_decap_8_602 r0 *1 0,0
Xsg13cmos5l_decap_8_602 VPWR VGND sg13cmos5l_decap_8
* cell instance sg13cmos5l_decap_8_603 r0 *1 0,0
Xsg13cmos5l_decap_8_603 VPWR VGND sg13cmos5l_decap_8
* cell instance sg13cmos5l_decap_8_604 r0 *1 0,0
Xsg13cmos5l_decap_8_604 VPWR VGND sg13cmos5l_decap_8
* cell instance sg13cmos5l_decap_8_605 r0 *1 0,0
Xsg13cmos5l_decap_8_605 VPWR VGND sg13cmos5l_decap_8
* cell instance sg13cmos5l_decap_8_606 r0 *1 0,0
Xsg13cmos5l_decap_8_606 VPWR VGND sg13cmos5l_decap_8
* cell instance sg13cmos5l_decap_8_607 r0 *1 0,0
Xsg13cmos5l_decap_8_607 VPWR VGND sg13cmos5l_decap_8
* cell instance sg13cmos5l_decap_8_608 r0 *1 0,0
Xsg13cmos5l_decap_8_608 VPWR VGND sg13cmos5l_decap_8
* cell instance sg13cmos5l_decap_8_609 r0 *1 0,0
Xsg13cmos5l_decap_8_609 VPWR VGND sg13cmos5l_decap_8
* cell instance sg13cmos5l_decap_8_610 r0 *1 0,0
Xsg13cmos5l_decap_8_610 VPWR VGND sg13cmos5l_decap_8
* cell instance sg13cmos5l_decap_8_611 r0 *1 0,0
Xsg13cmos5l_decap_8_611 VPWR VGND sg13cmos5l_decap_8
* cell instance sg13cmos5l_decap_8_612 r0 *1 0,0
Xsg13cmos5l_decap_8_612 VPWR VGND sg13cmos5l_decap_8
* cell instance sg13cmos5l_decap_8_613 r0 *1 0,0
Xsg13cmos5l_decap_8_613 VPWR VGND sg13cmos5l_decap_8
* cell instance sg13cmos5l_decap_8_614 r0 *1 0,0
Xsg13cmos5l_decap_8_614 VPWR VGND sg13cmos5l_decap_8
* cell instance sg13cmos5l_decap_8_615 r0 *1 0,0
Xsg13cmos5l_decap_8_615 VPWR VGND sg13cmos5l_decap_8
* cell instance sg13cmos5l_decap_8_616 r0 *1 0,0
Xsg13cmos5l_decap_8_616 VPWR VGND sg13cmos5l_decap_8
* cell instance sg13cmos5l_decap_8_617 r0 *1 0,0
Xsg13cmos5l_decap_8_617 VPWR VGND sg13cmos5l_decap_8
* cell instance sg13cmos5l_decap_8_618 r0 *1 0,0
Xsg13cmos5l_decap_8_618 VPWR VGND sg13cmos5l_decap_8
* cell instance sg13cmos5l_decap_8_619 r0 *1 0,0
Xsg13cmos5l_decap_8_619 VPWR VGND sg13cmos5l_decap_8
* cell instance sg13cmos5l_decap_8_620 r0 *1 0,0
Xsg13cmos5l_decap_8_620 VPWR VGND sg13cmos5l_decap_8
* cell instance sg13cmos5l_decap_8_621 r0 *1 0,0
Xsg13cmos5l_decap_8_621 VPWR VGND sg13cmos5l_decap_8
* cell instance sg13cmos5l_decap_8_622 r0 *1 0,0
Xsg13cmos5l_decap_8_622 VPWR VGND sg13cmos5l_decap_8
* cell instance sg13cmos5l_decap_8_623 r0 *1 0,0
Xsg13cmos5l_decap_8_623 VPWR VGND sg13cmos5l_decap_8
* cell instance sg13cmos5l_decap_8_624 r0 *1 0,0
Xsg13cmos5l_decap_8_624 VPWR VGND sg13cmos5l_decap_8
* cell instance sg13cmos5l_decap_8_625 r0 *1 0,0
Xsg13cmos5l_decap_8_625 VPWR VGND sg13cmos5l_decap_8
* cell instance sg13cmos5l_decap_8_626 r0 *1 0,0
Xsg13cmos5l_decap_8_626 VPWR VGND sg13cmos5l_decap_8
* cell instance sg13cmos5l_decap_8_627 r0 *1 0,0
Xsg13cmos5l_decap_8_627 VPWR VGND sg13cmos5l_decap_8
* cell instance sg13cmos5l_decap_8_628 r0 *1 0,0
Xsg13cmos5l_decap_8_628 VPWR VGND sg13cmos5l_decap_8
* cell instance sg13cmos5l_decap_8_629 r0 *1 0,0
Xsg13cmos5l_decap_8_629 VPWR VGND sg13cmos5l_decap_8
* cell instance sg13cmos5l_decap_8_630 r0 *1 0,0
Xsg13cmos5l_decap_8_630 VPWR VGND sg13cmos5l_decap_8
* cell instance sg13cmos5l_decap_8_631 r0 *1 0,0
Xsg13cmos5l_decap_8_631 VPWR VGND sg13cmos5l_decap_8
* cell instance sg13cmos5l_decap_8_632 r0 *1 0,0
Xsg13cmos5l_decap_8_632 VPWR VGND sg13cmos5l_decap_8
* cell instance sg13cmos5l_decap_8_633 r0 *1 0,0
Xsg13cmos5l_decap_8_633 VPWR VGND sg13cmos5l_decap_8
* cell instance sg13cmos5l_decap_8_634 r0 *1 0,0
Xsg13cmos5l_decap_8_634 VPWR VGND sg13cmos5l_decap_8
* cell instance sg13cmos5l_decap_8_635 r0 *1 0,0
Xsg13cmos5l_decap_8_635 VPWR VGND sg13cmos5l_decap_8
* cell instance sg13cmos5l_decap_8_636 r0 *1 0,0
Xsg13cmos5l_decap_8_636 VPWR VGND sg13cmos5l_decap_8
* cell instance sg13cmos5l_decap_8_637 r0 *1 0,0
Xsg13cmos5l_decap_8_637 VPWR VGND sg13cmos5l_decap_8
* cell instance sg13cmos5l_decap_8_638 r0 *1 0,0
Xsg13cmos5l_decap_8_638 VPWR VGND sg13cmos5l_decap_8
* cell instance sg13cmos5l_decap_8_639 r0 *1 0,0
Xsg13cmos5l_decap_8_639 VPWR VGND sg13cmos5l_decap_8
* cell instance sg13cmos5l_decap_8_640 r0 *1 0,0
Xsg13cmos5l_decap_8_640 VPWR VGND sg13cmos5l_decap_8
* cell instance sg13cmos5l_decap_8_641 r0 *1 0,0
Xsg13cmos5l_decap_8_641 VPWR VGND sg13cmos5l_decap_8
* cell instance sg13cmos5l_decap_8_642 r0 *1 0,0
Xsg13cmos5l_decap_8_642 VPWR VGND sg13cmos5l_decap_8
* cell instance sg13cmos5l_decap_8_643 r0 *1 0,0
Xsg13cmos5l_decap_8_643 VPWR VGND sg13cmos5l_decap_8
* cell instance sg13cmos5l_decap_8_644 r0 *1 0,0
Xsg13cmos5l_decap_8_644 VPWR VGND sg13cmos5l_decap_8
* cell instance sg13cmos5l_decap_8_645 r0 *1 0,0
Xsg13cmos5l_decap_8_645 VPWR VGND sg13cmos5l_decap_8
* cell instance sg13cmos5l_decap_8_646 r0 *1 0,0
Xsg13cmos5l_decap_8_646 VPWR VGND sg13cmos5l_decap_8
* cell instance sg13cmos5l_decap_8_647 r0 *1 0,0
Xsg13cmos5l_decap_8_647 VPWR VGND sg13cmos5l_decap_8
* cell instance sg13cmos5l_decap_8_648 r0 *1 0,0
Xsg13cmos5l_decap_8_648 VPWR VGND sg13cmos5l_decap_8
* cell instance sg13cmos5l_decap_8_649 r0 *1 0,0
Xsg13cmos5l_decap_8_649 VPWR VGND sg13cmos5l_decap_8
* cell instance sg13cmos5l_decap_8_650 r0 *1 0,0
Xsg13cmos5l_decap_8_650 VPWR VGND sg13cmos5l_decap_8
* cell instance sg13cmos5l_decap_8_651 r0 *1 0,0
Xsg13cmos5l_decap_8_651 VPWR VGND sg13cmos5l_decap_8
* cell instance sg13cmos5l_decap_8_652 r0 *1 0,0
Xsg13cmos5l_decap_8_652 VPWR VGND sg13cmos5l_decap_8
* cell instance sg13cmos5l_decap_8_653 r0 *1 0,0
Xsg13cmos5l_decap_8_653 VPWR VGND sg13cmos5l_decap_8
* cell instance sg13cmos5l_decap_8_654 r0 *1 0,0
Xsg13cmos5l_decap_8_654 VPWR VGND sg13cmos5l_decap_8
* cell instance sg13cmos5l_decap_8_655 r0 *1 0,0
Xsg13cmos5l_decap_8_655 VPWR VGND sg13cmos5l_decap_8
* cell instance sg13cmos5l_decap_8_656 r0 *1 0,0
Xsg13cmos5l_decap_8_656 VPWR VGND sg13cmos5l_decap_8
* cell instance sg13cmos5l_decap_8_657 r0 *1 0,0
Xsg13cmos5l_decap_8_657 VPWR VGND sg13cmos5l_decap_8
* cell instance sg13cmos5l_decap_8_658 r0 *1 0,0
Xsg13cmos5l_decap_8_658 VPWR VGND sg13cmos5l_decap_8
* cell instance sg13cmos5l_decap_8_659 r0 *1 0,0
Xsg13cmos5l_decap_8_659 VPWR VGND sg13cmos5l_decap_8
* cell instance sg13cmos5l_decap_8_660 r0 *1 0,0
Xsg13cmos5l_decap_8_660 VPWR VGND sg13cmos5l_decap_8
* cell instance sg13cmos5l_decap_8_661 r0 *1 0,0
Xsg13cmos5l_decap_8_661 VPWR VGND sg13cmos5l_decap_8
* cell instance sg13cmos5l_decap_8_662 r0 *1 0,0
Xsg13cmos5l_decap_8_662 VPWR VGND sg13cmos5l_decap_8
* cell instance sg13cmos5l_decap_8_663 r0 *1 0,0
Xsg13cmos5l_decap_8_663 VPWR VGND sg13cmos5l_decap_8
* cell instance sg13cmos5l_decap_8_664 r0 *1 0,0
Xsg13cmos5l_decap_8_664 VPWR VGND sg13cmos5l_decap_8
* cell instance sg13cmos5l_decap_8_665 r0 *1 0,0
Xsg13cmos5l_decap_8_665 VPWR VGND sg13cmos5l_decap_8
* cell instance sg13cmos5l_decap_8_666 r0 *1 0,0
Xsg13cmos5l_decap_8_666 VPWR VGND sg13cmos5l_decap_8
* cell instance sg13cmos5l_decap_8_667 r0 *1 0,0
Xsg13cmos5l_decap_8_667 VPWR VGND sg13cmos5l_decap_8
* cell instance sg13cmos5l_decap_8_668 r0 *1 0,0
Xsg13cmos5l_decap_8_668 VPWR VGND sg13cmos5l_decap_8
* cell instance sg13cmos5l_decap_8_669 r0 *1 0,0
Xsg13cmos5l_decap_8_669 VPWR VGND sg13cmos5l_decap_8
* cell instance sg13cmos5l_decap_8_670 r0 *1 0,0
Xsg13cmos5l_decap_8_670 VPWR VGND sg13cmos5l_decap_8
* cell instance sg13cmos5l_decap_8_671 r0 *1 0,0
Xsg13cmos5l_decap_8_671 VPWR VGND sg13cmos5l_decap_8
* cell instance sg13cmos5l_decap_8_672 r0 *1 0,0
Xsg13cmos5l_decap_8_672 VPWR VGND sg13cmos5l_decap_8
* cell instance sg13cmos5l_decap_8_673 r0 *1 0,0
Xsg13cmos5l_decap_8_673 VPWR VGND sg13cmos5l_decap_8
* cell instance sg13cmos5l_decap_8_674 r0 *1 0,0
Xsg13cmos5l_decap_8_674 VPWR VGND sg13cmos5l_decap_8
* cell instance sg13cmos5l_decap_8_675 r0 *1 0,0
Xsg13cmos5l_decap_8_675 VPWR VGND sg13cmos5l_decap_8
* cell instance sg13cmos5l_decap_8_676 r0 *1 0,0
Xsg13cmos5l_decap_8_676 VPWR VGND sg13cmos5l_decap_8
* cell instance sg13cmos5l_decap_8_677 r0 *1 0,0
Xsg13cmos5l_decap_8_677 VPWR VGND sg13cmos5l_decap_8
* cell instance sg13cmos5l_decap_8_678 r0 *1 0,0
Xsg13cmos5l_decap_8_678 VPWR VGND sg13cmos5l_decap_8
* cell instance sg13cmos5l_decap_8_679 r0 *1 0,0
Xsg13cmos5l_decap_8_679 VPWR VGND sg13cmos5l_decap_8
* cell instance sg13cmos5l_decap_8_680 r0 *1 0,0
Xsg13cmos5l_decap_8_680 VPWR VGND sg13cmos5l_decap_8
* cell instance sg13cmos5l_decap_8_681 r0 *1 0,0
Xsg13cmos5l_decap_8_681 VPWR VGND sg13cmos5l_decap_8
* cell instance sg13cmos5l_decap_8_682 r0 *1 0,0
Xsg13cmos5l_decap_8_682 VPWR VGND sg13cmos5l_decap_8
* cell instance sg13cmos5l_decap_8_683 r0 *1 0,0
Xsg13cmos5l_decap_8_683 VPWR VGND sg13cmos5l_decap_8
* cell instance sg13cmos5l_decap_8_684 r0 *1 0,0
Xsg13cmos5l_decap_8_684 VPWR VGND sg13cmos5l_decap_8
* cell instance sg13cmos5l_decap_8_685 r0 *1 0,0
Xsg13cmos5l_decap_8_685 VPWR VGND sg13cmos5l_decap_8
* cell instance sg13cmos5l_decap_8_686 r0 *1 0,0
Xsg13cmos5l_decap_8_686 VPWR VGND sg13cmos5l_decap_8
* cell instance sg13cmos5l_decap_8_687 r0 *1 0,0
Xsg13cmos5l_decap_8_687 VPWR VGND sg13cmos5l_decap_8
* cell instance sg13cmos5l_decap_8_688 r0 *1 0,0
Xsg13cmos5l_decap_8_688 VPWR VGND sg13cmos5l_decap_8
* cell instance sg13cmos5l_decap_8_689 r0 *1 0,0
Xsg13cmos5l_decap_8_689 VPWR VGND sg13cmos5l_decap_8
* cell instance sg13cmos5l_decap_8_690 r0 *1 0,0
Xsg13cmos5l_decap_8_690 VPWR VGND sg13cmos5l_decap_8
* cell instance sg13cmos5l_decap_8_691 r0 *1 0,0
Xsg13cmos5l_decap_8_691 VPWR VGND sg13cmos5l_decap_8
* cell instance sg13cmos5l_decap_8_692 r0 *1 0,0
Xsg13cmos5l_decap_8_692 VPWR VGND sg13cmos5l_decap_8
* cell instance sg13cmos5l_decap_8_693 r0 *1 0,0
Xsg13cmos5l_decap_8_693 VPWR VGND sg13cmos5l_decap_8
* cell instance sg13cmos5l_decap_8_694 r0 *1 0,0
Xsg13cmos5l_decap_8_694 VPWR VGND sg13cmos5l_decap_8
* cell instance sg13cmos5l_decap_8_695 r0 *1 0,0
Xsg13cmos5l_decap_8_695 VPWR VGND sg13cmos5l_decap_8
* cell instance sg13cmos5l_decap_8_696 r0 *1 0,0
Xsg13cmos5l_decap_8_696 VPWR VGND sg13cmos5l_decap_8
* cell instance sg13cmos5l_decap_8_697 r0 *1 0,0
Xsg13cmos5l_decap_8_697 VPWR VGND sg13cmos5l_decap_8
* cell instance sg13cmos5l_decap_8_698 r0 *1 0,0
Xsg13cmos5l_decap_8_698 VPWR VGND sg13cmos5l_decap_8
* cell instance sg13cmos5l_decap_8_699 r0 *1 0,0
Xsg13cmos5l_decap_8_699 VPWR VGND sg13cmos5l_decap_8
* cell instance sg13cmos5l_decap_8_700 r0 *1 0,0
Xsg13cmos5l_decap_8_700 VPWR VGND sg13cmos5l_decap_8
* cell instance sg13cmos5l_decap_8_701 r0 *1 0,0
Xsg13cmos5l_decap_8_701 VPWR VGND sg13cmos5l_decap_8
* cell instance sg13cmos5l_decap_8_702 r0 *1 0,0
Xsg13cmos5l_decap_8_702 VPWR VGND sg13cmos5l_decap_8
* cell instance sg13cmos5l_decap_8_703 r0 *1 0,0
Xsg13cmos5l_decap_8_703 VPWR VGND sg13cmos5l_decap_8
* cell instance sg13cmos5l_decap_8_704 r0 *1 0,0
Xsg13cmos5l_decap_8_704 VPWR VGND sg13cmos5l_decap_8
* cell instance sg13cmos5l_decap_8_705 r0 *1 0,0
Xsg13cmos5l_decap_8_705 VPWR VGND sg13cmos5l_decap_8
* cell instance sg13cmos5l_decap_8_706 r0 *1 0,0
Xsg13cmos5l_decap_8_706 VPWR VGND sg13cmos5l_decap_8
* cell instance sg13cmos5l_decap_8_707 r0 *1 0,0
Xsg13cmos5l_decap_8_707 VPWR VGND sg13cmos5l_decap_8
* cell instance sg13cmos5l_decap_8_708 r0 *1 0,0
Xsg13cmos5l_decap_8_708 VPWR VGND sg13cmos5l_decap_8
* cell instance sg13cmos5l_decap_8_709 r0 *1 0,0
Xsg13cmos5l_decap_8_709 VPWR VGND sg13cmos5l_decap_8
* cell instance sg13cmos5l_decap_8_710 r0 *1 0,0
Xsg13cmos5l_decap_8_710 VPWR VGND sg13cmos5l_decap_8
* cell instance sg13cmos5l_decap_8_711 r0 *1 0,0
Xsg13cmos5l_decap_8_711 VPWR VGND sg13cmos5l_decap_8
* cell instance sg13cmos5l_decap_8_712 r0 *1 0,0
Xsg13cmos5l_decap_8_712 VPWR VGND sg13cmos5l_decap_8
* cell instance sg13cmos5l_decap_8_713 r0 *1 0,0
Xsg13cmos5l_decap_8_713 VPWR VGND sg13cmos5l_decap_8
* cell instance sg13cmos5l_decap_8_714 r0 *1 0,0
Xsg13cmos5l_decap_8_714 VPWR VGND sg13cmos5l_decap_8
* cell instance sg13cmos5l_decap_8_715 r0 *1 0,0
Xsg13cmos5l_decap_8_715 VPWR VGND sg13cmos5l_decap_8
* cell instance sg13cmos5l_decap_8_716 r0 *1 0,0
Xsg13cmos5l_decap_8_716 VPWR VGND sg13cmos5l_decap_8
* cell instance sg13cmos5l_decap_8_717 r0 *1 0,0
Xsg13cmos5l_decap_8_717 VPWR VGND sg13cmos5l_decap_8
* cell instance sg13cmos5l_decap_8_718 r0 *1 0,0
Xsg13cmos5l_decap_8_718 VPWR VGND sg13cmos5l_decap_8
* cell instance sg13cmos5l_decap_8_719 r0 *1 0,0
Xsg13cmos5l_decap_8_719 VPWR VGND sg13cmos5l_decap_8
* cell instance sg13cmos5l_decap_8_720 r0 *1 0,0
Xsg13cmos5l_decap_8_720 VPWR VGND sg13cmos5l_decap_8
* cell instance sg13cmos5l_decap_8_721 r0 *1 0,0
Xsg13cmos5l_decap_8_721 VPWR VGND sg13cmos5l_decap_8
* cell instance sg13cmos5l_decap_8_722 r0 *1 0,0
Xsg13cmos5l_decap_8_722 VPWR VGND sg13cmos5l_decap_8
* cell instance sg13cmos5l_decap_8_723 r0 *1 0,0
Xsg13cmos5l_decap_8_723 VPWR VGND sg13cmos5l_decap_8
* cell instance sg13cmos5l_decap_8_724 r0 *1 0,0
Xsg13cmos5l_decap_8_724 VPWR VGND sg13cmos5l_decap_8
* cell instance sg13cmos5l_decap_8_725 r0 *1 0,0
Xsg13cmos5l_decap_8_725 VPWR VGND sg13cmos5l_decap_8
* cell instance sg13cmos5l_decap_8_726 r0 *1 0,0
Xsg13cmos5l_decap_8_726 VPWR VGND sg13cmos5l_decap_8
* cell instance sg13cmos5l_decap_8_727 r0 *1 0,0
Xsg13cmos5l_decap_8_727 VPWR VGND sg13cmos5l_decap_8
* cell instance sg13cmos5l_decap_8_728 r0 *1 0,0
Xsg13cmos5l_decap_8_728 VPWR VGND sg13cmos5l_decap_8
* cell instance sg13cmos5l_decap_8_729 r0 *1 0,0
Xsg13cmos5l_decap_8_729 VPWR VGND sg13cmos5l_decap_8
* cell instance sg13cmos5l_decap_8_730 r0 *1 0,0
Xsg13cmos5l_decap_8_730 VPWR VGND sg13cmos5l_decap_8
* cell instance sg13cmos5l_decap_8_731 r0 *1 0,0
Xsg13cmos5l_decap_8_731 VPWR VGND sg13cmos5l_decap_8
* cell instance sg13cmos5l_decap_8_732 r0 *1 0,0
Xsg13cmos5l_decap_8_732 VPWR VGND sg13cmos5l_decap_8
* cell instance sg13cmos5l_decap_8_733 r0 *1 0,0
Xsg13cmos5l_decap_8_733 VPWR VGND sg13cmos5l_decap_8
* cell instance sg13cmos5l_decap_8_734 r0 *1 0,0
Xsg13cmos5l_decap_8_734 VPWR VGND sg13cmos5l_decap_8
* cell instance sg13cmos5l_decap_8_735 r0 *1 0,0
Xsg13cmos5l_decap_8_735 VPWR VGND sg13cmos5l_decap_8
* cell instance sg13cmos5l_decap_8_736 r0 *1 0,0
Xsg13cmos5l_decap_8_736 VPWR VGND sg13cmos5l_decap_8
* cell instance sg13cmos5l_decap_8_737 r0 *1 0,0
Xsg13cmos5l_decap_8_737 VPWR VGND sg13cmos5l_decap_8
* cell instance sg13cmos5l_decap_8_738 r0 *1 0,0
Xsg13cmos5l_decap_8_738 VPWR VGND sg13cmos5l_decap_8
* cell instance sg13cmos5l_decap_8_739 r0 *1 0,0
Xsg13cmos5l_decap_8_739 VPWR VGND sg13cmos5l_decap_8
* cell instance sg13cmos5l_decap_8_740 r0 *1 0,0
Xsg13cmos5l_decap_8_740 VPWR VGND sg13cmos5l_decap_8
* cell instance sg13cmos5l_decap_8_741 r0 *1 0,0
Xsg13cmos5l_decap_8_741 VPWR VGND sg13cmos5l_decap_8
* cell instance sg13cmos5l_decap_8_742 r0 *1 0,0
Xsg13cmos5l_decap_8_742 VPWR VGND sg13cmos5l_decap_8
* cell instance sg13cmos5l_decap_8_743 r0 *1 0,0
Xsg13cmos5l_decap_8_743 VPWR VGND sg13cmos5l_decap_8
* cell instance sg13cmos5l_decap_8_744 r0 *1 0,0
Xsg13cmos5l_decap_8_744 VPWR VGND sg13cmos5l_decap_8
* cell instance sg13cmos5l_decap_8_745 r0 *1 0,0
Xsg13cmos5l_decap_8_745 VPWR VGND sg13cmos5l_decap_8
* cell instance sg13cmos5l_decap_8_746 r0 *1 0,0
Xsg13cmos5l_decap_8_746 VPWR VGND sg13cmos5l_decap_8
* cell instance sg13cmos5l_decap_8_747 r0 *1 0,0
Xsg13cmos5l_decap_8_747 VPWR VGND sg13cmos5l_decap_8
* cell instance sg13cmos5l_decap_8_748 r0 *1 0,0
Xsg13cmos5l_decap_8_748 VPWR VGND sg13cmos5l_decap_8
* cell instance sg13cmos5l_decap_8_749 r0 *1 0,0
Xsg13cmos5l_decap_8_749 VPWR VGND sg13cmos5l_decap_8
* cell instance sg13cmos5l_decap_8_750 r0 *1 0,0
Xsg13cmos5l_decap_8_750 VPWR VGND sg13cmos5l_decap_8
* cell instance sg13cmos5l_decap_8_751 r0 *1 0,0
Xsg13cmos5l_decap_8_751 VPWR VGND sg13cmos5l_decap_8
* cell instance sg13cmos5l_decap_8_752 r0 *1 0,0
Xsg13cmos5l_decap_8_752 VPWR VGND sg13cmos5l_decap_8
* cell instance sg13cmos5l_decap_8_753 r0 *1 0,0
Xsg13cmos5l_decap_8_753 VPWR VGND sg13cmos5l_decap_8
* cell instance sg13cmos5l_decap_8_754 r0 *1 0,0
Xsg13cmos5l_decap_8_754 VPWR VGND sg13cmos5l_decap_8
* cell instance sg13cmos5l_decap_8_755 r0 *1 0,0
Xsg13cmos5l_decap_8_755 VPWR VGND sg13cmos5l_decap_8
* cell instance sg13cmos5l_decap_8_756 r0 *1 0,0
Xsg13cmos5l_decap_8_756 VPWR VGND sg13cmos5l_decap_8
* cell instance sg13cmos5l_decap_8_757 r0 *1 0,0
Xsg13cmos5l_decap_8_757 VPWR VGND sg13cmos5l_decap_8
* cell instance sg13cmos5l_decap_8_758 r0 *1 0,0
Xsg13cmos5l_decap_8_758 VPWR VGND sg13cmos5l_decap_8
* cell instance sg13cmos5l_decap_8_759 r0 *1 0,0
Xsg13cmos5l_decap_8_759 VPWR VGND sg13cmos5l_decap_8
* cell instance sg13cmos5l_decap_8_760 r0 *1 0,0
Xsg13cmos5l_decap_8_760 VPWR VGND sg13cmos5l_decap_8
* cell instance sg13cmos5l_decap_8_761 r0 *1 0,0
Xsg13cmos5l_decap_8_761 VPWR VGND sg13cmos5l_decap_8
* cell instance sg13cmos5l_decap_8_762 r0 *1 0,0
Xsg13cmos5l_decap_8_762 VPWR VGND sg13cmos5l_decap_8
* cell instance sg13cmos5l_decap_8_763 r0 *1 0,0
Xsg13cmos5l_decap_8_763 VPWR VGND sg13cmos5l_decap_8
* cell instance sg13cmos5l_decap_8_764 r0 *1 0,0
Xsg13cmos5l_decap_8_764 VPWR VGND sg13cmos5l_decap_8
* cell instance sg13cmos5l_decap_8_765 r0 *1 0,0
Xsg13cmos5l_decap_8_765 VPWR VGND sg13cmos5l_decap_8
* cell instance sg13cmos5l_decap_8_766 r0 *1 0,0
Xsg13cmos5l_decap_8_766 VPWR VGND sg13cmos5l_decap_8
* cell instance sg13cmos5l_decap_8_767 r0 *1 0,0
Xsg13cmos5l_decap_8_767 VPWR VGND sg13cmos5l_decap_8
* cell instance sg13cmos5l_decap_8_768 r0 *1 0,0
Xsg13cmos5l_decap_8_768 VPWR VGND sg13cmos5l_decap_8
* cell instance sg13cmos5l_decap_8_769 r0 *1 0,0
Xsg13cmos5l_decap_8_769 VPWR VGND sg13cmos5l_decap_8
* cell instance sg13cmos5l_decap_8_770 r0 *1 0,0
Xsg13cmos5l_decap_8_770 VPWR VGND sg13cmos5l_decap_8
* cell instance sg13cmos5l_decap_8_771 r0 *1 0,0
Xsg13cmos5l_decap_8_771 VPWR VGND sg13cmos5l_decap_8
* cell instance sg13cmos5l_decap_8_772 r0 *1 0,0
Xsg13cmos5l_decap_8_772 VPWR VGND sg13cmos5l_decap_8
* cell instance sg13cmos5l_decap_8_773 r0 *1 0,0
Xsg13cmos5l_decap_8_773 VPWR VGND sg13cmos5l_decap_8
* cell instance sg13cmos5l_decap_8_774 r0 *1 0,0
Xsg13cmos5l_decap_8_774 VPWR VGND sg13cmos5l_decap_8
* cell instance sg13cmos5l_decap_8_775 r0 *1 0,0
Xsg13cmos5l_decap_8_775 VPWR VGND sg13cmos5l_decap_8
* cell instance sg13cmos5l_decap_8_776 r0 *1 0,0
Xsg13cmos5l_decap_8_776 VPWR VGND sg13cmos5l_decap_8
* cell instance sg13cmos5l_decap_8_777 r0 *1 0,0
Xsg13cmos5l_decap_8_777 VPWR VGND sg13cmos5l_decap_8
* cell instance sg13cmos5l_decap_8_778 r0 *1 0,0
Xsg13cmos5l_decap_8_778 VPWR VGND sg13cmos5l_decap_8
* cell instance sg13cmos5l_decap_8_779 r0 *1 0,0
Xsg13cmos5l_decap_8_779 VPWR VGND sg13cmos5l_decap_8
* cell instance sg13cmos5l_decap_8_780 r0 *1 0,0
Xsg13cmos5l_decap_8_780 VPWR VGND sg13cmos5l_decap_8
* cell instance sg13cmos5l_decap_8_781 r0 *1 0,0
Xsg13cmos5l_decap_8_781 VPWR VGND sg13cmos5l_decap_8
* cell instance sg13cmos5l_decap_8_782 r0 *1 0,0
Xsg13cmos5l_decap_8_782 VPWR VGND sg13cmos5l_decap_8
* cell instance sg13cmos5l_decap_8_783 r0 *1 0,0
Xsg13cmos5l_decap_8_783 VPWR VGND sg13cmos5l_decap_8
* cell instance sg13cmos5l_decap_8_784 r0 *1 0,0
Xsg13cmos5l_decap_8_784 VPWR VGND sg13cmos5l_decap_8
* cell instance sg13cmos5l_decap_8_785 r0 *1 0,0
Xsg13cmos5l_decap_8_785 VPWR VGND sg13cmos5l_decap_8
* cell instance sg13cmos5l_decap_8_786 r0 *1 0,0
Xsg13cmos5l_decap_8_786 VPWR VGND sg13cmos5l_decap_8
* cell instance sg13cmos5l_decap_8_787 r0 *1 0,0
Xsg13cmos5l_decap_8_787 VPWR VGND sg13cmos5l_decap_8
* cell instance sg13cmos5l_decap_8_788 r0 *1 0,0
Xsg13cmos5l_decap_8_788 VPWR VGND sg13cmos5l_decap_8
* cell instance sg13cmos5l_decap_8_789 r0 *1 0,0
Xsg13cmos5l_decap_8_789 VPWR VGND sg13cmos5l_decap_8
* cell instance sg13cmos5l_decap_8_790 r0 *1 0,0
Xsg13cmos5l_decap_8_790 VPWR VGND sg13cmos5l_decap_8
* cell instance sg13cmos5l_decap_8_791 r0 *1 0,0
Xsg13cmos5l_decap_8_791 VPWR VGND sg13cmos5l_decap_8
* cell instance sg13cmos5l_decap_8_792 r0 *1 0,0
Xsg13cmos5l_decap_8_792 VPWR VGND sg13cmos5l_decap_8
* cell instance sg13cmos5l_decap_8_793 r0 *1 0,0
Xsg13cmos5l_decap_8_793 VPWR VGND sg13cmos5l_decap_8
* cell instance sg13cmos5l_decap_8_794 r0 *1 0,0
Xsg13cmos5l_decap_8_794 VPWR VGND sg13cmos5l_decap_8
* cell instance sg13cmos5l_decap_8_795 r0 *1 0,0
Xsg13cmos5l_decap_8_795 VPWR VGND sg13cmos5l_decap_8
* cell instance sg13cmos5l_decap_8_796 r0 *1 0,0
Xsg13cmos5l_decap_8_796 VPWR VGND sg13cmos5l_decap_8
* cell instance sg13cmos5l_decap_8_797 r0 *1 0,0
Xsg13cmos5l_decap_8_797 VPWR VGND sg13cmos5l_decap_8
* cell instance sg13cmos5l_decap_8_798 r0 *1 0,0
Xsg13cmos5l_decap_8_798 VPWR VGND sg13cmos5l_decap_8
* cell instance sg13cmos5l_decap_8_799 r0 *1 0,0
Xsg13cmos5l_decap_8_799 VPWR VGND sg13cmos5l_decap_8
* cell instance sg13cmos5l_decap_8_800 r0 *1 0,0
Xsg13cmos5l_decap_8_800 VPWR VGND sg13cmos5l_decap_8
* cell instance sg13cmos5l_decap_8_801 r0 *1 0,0
Xsg13cmos5l_decap_8_801 VPWR VGND sg13cmos5l_decap_8
* cell instance sg13cmos5l_decap_8_802 r0 *1 0,0
Xsg13cmos5l_decap_8_802 VPWR VGND sg13cmos5l_decap_8
* cell instance sg13cmos5l_decap_8_803 r0 *1 0,0
Xsg13cmos5l_decap_8_803 VPWR VGND sg13cmos5l_decap_8
* cell instance sg13cmos5l_decap_8_804 r0 *1 0,0
Xsg13cmos5l_decap_8_804 VPWR VGND sg13cmos5l_decap_8
* cell instance sg13cmos5l_decap_8_805 r0 *1 0,0
Xsg13cmos5l_decap_8_805 VPWR VGND sg13cmos5l_decap_8
* cell instance sg13cmos5l_decap_8_806 r0 *1 0,0
Xsg13cmos5l_decap_8_806 VPWR VGND sg13cmos5l_decap_8
* cell instance sg13cmos5l_decap_8_807 r0 *1 0,0
Xsg13cmos5l_decap_8_807 VPWR VGND sg13cmos5l_decap_8
* cell instance sg13cmos5l_decap_8_808 r0 *1 0,0
Xsg13cmos5l_decap_8_808 VPWR VGND sg13cmos5l_decap_8
* cell instance sg13cmos5l_decap_8_809 r0 *1 0,0
Xsg13cmos5l_decap_8_809 VPWR VGND sg13cmos5l_decap_8
* cell instance sg13cmos5l_decap_8_810 r0 *1 0,0
Xsg13cmos5l_decap_8_810 VPWR VGND sg13cmos5l_decap_8
* cell instance sg13cmos5l_decap_8_811 r0 *1 0,0
Xsg13cmos5l_decap_8_811 VPWR VGND sg13cmos5l_decap_8
* cell instance sg13cmos5l_decap_8_812 r0 *1 0,0
Xsg13cmos5l_decap_8_812 VPWR VGND sg13cmos5l_decap_8
* cell instance sg13cmos5l_decap_8_813 r0 *1 0,0
Xsg13cmos5l_decap_8_813 VPWR VGND sg13cmos5l_decap_8
* cell instance sg13cmos5l_decap_8_814 r0 *1 0,0
Xsg13cmos5l_decap_8_814 VPWR VGND sg13cmos5l_decap_8
* cell instance sg13cmos5l_decap_8_815 r0 *1 0,0
Xsg13cmos5l_decap_8_815 VPWR VGND sg13cmos5l_decap_8
* cell instance sg13cmos5l_decap_8_816 r0 *1 0,0
Xsg13cmos5l_decap_8_816 VPWR VGND sg13cmos5l_decap_8
* cell instance sg13cmos5l_decap_8_817 r0 *1 0,0
Xsg13cmos5l_decap_8_817 VPWR VGND sg13cmos5l_decap_8
* cell instance sg13cmos5l_decap_8_818 r0 *1 0,0
Xsg13cmos5l_decap_8_818 VPWR VGND sg13cmos5l_decap_8
* cell instance sg13cmos5l_decap_8_819 r0 *1 0,0
Xsg13cmos5l_decap_8_819 VPWR VGND sg13cmos5l_decap_8
* cell instance sg13cmos5l_decap_8_820 r0 *1 0,0
Xsg13cmos5l_decap_8_820 VPWR VGND sg13cmos5l_decap_8
* cell instance sg13cmos5l_decap_8_821 r0 *1 0,0
Xsg13cmos5l_decap_8_821 VPWR VGND sg13cmos5l_decap_8
* cell instance sg13cmos5l_decap_8_822 r0 *1 0,0
Xsg13cmos5l_decap_8_822 VPWR VGND sg13cmos5l_decap_8
* cell instance sg13cmos5l_decap_8_823 r0 *1 0,0
Xsg13cmos5l_decap_8_823 VPWR VGND sg13cmos5l_decap_8
* cell instance sg13cmos5l_decap_8_824 r0 *1 0,0
Xsg13cmos5l_decap_8_824 VPWR VGND sg13cmos5l_decap_8
* cell instance sg13cmos5l_decap_8_825 r0 *1 0,0
Xsg13cmos5l_decap_8_825 VPWR VGND sg13cmos5l_decap_8
* cell instance sg13cmos5l_decap_8_826 r0 *1 0,0
Xsg13cmos5l_decap_8_826 VPWR VGND sg13cmos5l_decap_8
* cell instance sg13cmos5l_decap_8_827 r0 *1 0,0
Xsg13cmos5l_decap_8_827 VPWR VGND sg13cmos5l_decap_8
* cell instance sg13cmos5l_decap_8_828 r0 *1 0,0
Xsg13cmos5l_decap_8_828 VPWR VGND sg13cmos5l_decap_8
* cell instance sg13cmos5l_decap_8_829 r0 *1 0,0
Xsg13cmos5l_decap_8_829 VPWR VGND sg13cmos5l_decap_8
* cell instance sg13cmos5l_decap_8_830 r0 *1 0,0
Xsg13cmos5l_decap_8_830 VPWR VGND sg13cmos5l_decap_8
* cell instance sg13cmos5l_decap_8_831 r0 *1 0,0
Xsg13cmos5l_decap_8_831 VPWR VGND sg13cmos5l_decap_8
* cell instance sg13cmos5l_decap_8_832 r0 *1 0,0
Xsg13cmos5l_decap_8_832 VPWR VGND sg13cmos5l_decap_8
* cell instance sg13cmos5l_decap_8_833 r0 *1 0,0
Xsg13cmos5l_decap_8_833 VPWR VGND sg13cmos5l_decap_8
* cell instance sg13cmos5l_decap_8_834 r0 *1 0,0
Xsg13cmos5l_decap_8_834 VPWR VGND sg13cmos5l_decap_8
* cell instance sg13cmos5l_decap_8_835 r0 *1 0,0
Xsg13cmos5l_decap_8_835 VPWR VGND sg13cmos5l_decap_8
* cell instance sg13cmos5l_decap_8_836 r0 *1 0,0
Xsg13cmos5l_decap_8_836 VPWR VGND sg13cmos5l_decap_8
* cell instance sg13cmos5l_decap_8_837 r0 *1 0,0
Xsg13cmos5l_decap_8_837 VPWR VGND sg13cmos5l_decap_8
* cell instance sg13cmos5l_decap_8_838 r0 *1 0,0
Xsg13cmos5l_decap_8_838 VPWR VGND sg13cmos5l_decap_8
* cell instance sg13cmos5l_decap_8_839 r0 *1 0,0
Xsg13cmos5l_decap_8_839 VPWR VGND sg13cmos5l_decap_8
* cell instance sg13cmos5l_decap_8_840 r0 *1 0,0
Xsg13cmos5l_decap_8_840 VPWR VGND sg13cmos5l_decap_8
* cell instance sg13cmos5l_decap_8_841 r0 *1 0,0
Xsg13cmos5l_decap_8_841 VPWR VGND sg13cmos5l_decap_8
* cell instance sg13cmos5l_decap_8_842 r0 *1 0,0
Xsg13cmos5l_decap_8_842 VPWR VGND sg13cmos5l_decap_8
* cell instance sg13cmos5l_decap_8_843 r0 *1 0,0
Xsg13cmos5l_decap_8_843 VPWR VGND sg13cmos5l_decap_8
* cell instance sg13cmos5l_decap_8_844 r0 *1 0,0
Xsg13cmos5l_decap_8_844 VPWR VGND sg13cmos5l_decap_8
* cell instance sg13cmos5l_decap_8_845 r0 *1 0,0
Xsg13cmos5l_decap_8_845 VPWR VGND sg13cmos5l_decap_8
* cell instance sg13cmos5l_decap_8_846 r0 *1 0,0
Xsg13cmos5l_decap_8_846 VPWR VGND sg13cmos5l_decap_8
* cell instance sg13cmos5l_decap_8_847 r0 *1 0,0
Xsg13cmos5l_decap_8_847 VPWR VGND sg13cmos5l_decap_8
* cell instance sg13cmos5l_decap_8_848 r0 *1 0,0
Xsg13cmos5l_decap_8_848 VPWR VGND sg13cmos5l_decap_8
* cell instance sg13cmos5l_decap_8_849 r0 *1 0,0
Xsg13cmos5l_decap_8_849 VPWR VGND sg13cmos5l_decap_8
* cell instance sg13cmos5l_decap_8_850 r0 *1 0,0
Xsg13cmos5l_decap_8_850 VPWR VGND sg13cmos5l_decap_8
* cell instance sg13cmos5l_decap_8_851 r0 *1 0,0
Xsg13cmos5l_decap_8_851 VPWR VGND sg13cmos5l_decap_8
* cell instance sg13cmos5l_decap_8_852 r0 *1 0,0
Xsg13cmos5l_decap_8_852 VPWR VGND sg13cmos5l_decap_8
* cell instance sg13cmos5l_decap_8_853 r0 *1 0,0
Xsg13cmos5l_decap_8_853 VPWR VGND sg13cmos5l_decap_8
* cell instance sg13cmos5l_decap_8_854 r0 *1 0,0
Xsg13cmos5l_decap_8_854 VPWR VGND sg13cmos5l_decap_8
* cell instance sg13cmos5l_decap_8_855 r0 *1 0,0
Xsg13cmos5l_decap_8_855 VPWR VGND sg13cmos5l_decap_8
* cell instance sg13cmos5l_decap_8_856 r0 *1 0,0
Xsg13cmos5l_decap_8_856 VPWR VGND sg13cmos5l_decap_8
* cell instance sg13cmos5l_decap_8_857 r0 *1 0,0
Xsg13cmos5l_decap_8_857 VPWR VGND sg13cmos5l_decap_8
* cell instance sg13cmos5l_decap_8_858 r0 *1 0,0
Xsg13cmos5l_decap_8_858 VPWR VGND sg13cmos5l_decap_8
* cell instance sg13cmos5l_decap_8_859 r0 *1 0,0
Xsg13cmos5l_decap_8_859 VPWR VGND sg13cmos5l_decap_8
* cell instance sg13cmos5l_decap_8_860 r0 *1 0,0
Xsg13cmos5l_decap_8_860 VPWR VGND sg13cmos5l_decap_8
* cell instance sg13cmos5l_decap_8_861 r0 *1 0,0
Xsg13cmos5l_decap_8_861 VPWR VGND sg13cmos5l_decap_8
* cell instance sg13cmos5l_decap_8_862 r0 *1 0,0
Xsg13cmos5l_decap_8_862 VPWR VGND sg13cmos5l_decap_8
* cell instance sg13cmos5l_decap_8_863 r0 *1 0,0
Xsg13cmos5l_decap_8_863 VPWR VGND sg13cmos5l_decap_8
* cell instance sg13cmos5l_decap_8_864 r0 *1 0,0
Xsg13cmos5l_decap_8_864 VPWR VGND sg13cmos5l_decap_8
* cell instance sg13cmos5l_decap_8_865 r0 *1 0,0
Xsg13cmos5l_decap_8_865 VPWR VGND sg13cmos5l_decap_8
* cell instance sg13cmos5l_decap_8_866 r0 *1 0,0
Xsg13cmos5l_decap_8_866 VPWR VGND sg13cmos5l_decap_8
* cell instance sg13cmos5l_decap_8_867 r0 *1 0,0
Xsg13cmos5l_decap_8_867 VPWR VGND sg13cmos5l_decap_8
* cell instance sg13cmos5l_decap_8_868 r0 *1 0,0
Xsg13cmos5l_decap_8_868 VPWR VGND sg13cmos5l_decap_8
* cell instance sg13cmos5l_decap_8_869 r0 *1 0,0
Xsg13cmos5l_decap_8_869 VPWR VGND sg13cmos5l_decap_8
* cell instance sg13cmos5l_decap_8_870 r0 *1 0,0
Xsg13cmos5l_decap_8_870 VPWR VGND sg13cmos5l_decap_8
* cell instance sg13cmos5l_decap_8_871 r0 *1 0,0
Xsg13cmos5l_decap_8_871 VPWR VGND sg13cmos5l_decap_8
* cell instance sg13cmos5l_decap_8_872 r0 *1 0,0
Xsg13cmos5l_decap_8_872 VPWR VGND sg13cmos5l_decap_8
* cell instance sg13cmos5l_decap_8_873 r0 *1 0,0
Xsg13cmos5l_decap_8_873 VPWR VGND sg13cmos5l_decap_8
* cell instance sg13cmos5l_decap_8_874 r0 *1 0,0
Xsg13cmos5l_decap_8_874 VPWR VGND sg13cmos5l_decap_8
* cell instance sg13cmos5l_decap_8_875 r0 *1 0,0
Xsg13cmos5l_decap_8_875 VPWR VGND sg13cmos5l_decap_8
* cell instance sg13cmos5l_decap_8_876 r0 *1 0,0
Xsg13cmos5l_decap_8_876 VPWR VGND sg13cmos5l_decap_8
* cell instance sg13cmos5l_decap_8_877 r0 *1 0,0
Xsg13cmos5l_decap_8_877 VPWR VGND sg13cmos5l_decap_8
* cell instance sg13cmos5l_decap_8_878 r0 *1 0,0
Xsg13cmos5l_decap_8_878 VPWR VGND sg13cmos5l_decap_8
* cell instance sg13cmos5l_decap_8_879 r0 *1 0,0
Xsg13cmos5l_decap_8_879 VPWR VGND sg13cmos5l_decap_8
* cell instance sg13cmos5l_decap_8_880 r0 *1 0,0
Xsg13cmos5l_decap_8_880 VPWR VGND sg13cmos5l_decap_8
* cell instance sg13cmos5l_decap_8_881 r0 *1 0,0
Xsg13cmos5l_decap_8_881 VPWR VGND sg13cmos5l_decap_8
* cell instance sg13cmos5l_decap_8_882 r0 *1 0,0
Xsg13cmos5l_decap_8_882 VPWR VGND sg13cmos5l_decap_8
* cell instance sg13cmos5l_decap_8_883 r0 *1 0,0
Xsg13cmos5l_decap_8_883 VPWR VGND sg13cmos5l_decap_8
* cell instance sg13cmos5l_decap_8_884 r0 *1 0,0
Xsg13cmos5l_decap_8_884 VPWR VGND sg13cmos5l_decap_8
* cell instance sg13cmos5l_decap_8_885 r0 *1 0,0
Xsg13cmos5l_decap_8_885 VPWR VGND sg13cmos5l_decap_8
* cell instance sg13cmos5l_decap_8_886 r0 *1 0,0
Xsg13cmos5l_decap_8_886 VPWR VGND sg13cmos5l_decap_8
* cell instance sg13cmos5l_decap_8_887 r0 *1 0,0
Xsg13cmos5l_decap_8_887 VPWR VGND sg13cmos5l_decap_8
* cell instance sg13cmos5l_decap_8_888 r0 *1 0,0
Xsg13cmos5l_decap_8_888 VPWR VGND sg13cmos5l_decap_8
* cell instance sg13cmos5l_decap_8_889 r0 *1 0,0
Xsg13cmos5l_decap_8_889 VPWR VGND sg13cmos5l_decap_8
* cell instance sg13cmos5l_decap_8_890 r0 *1 0,0
Xsg13cmos5l_decap_8_890 VPWR VGND sg13cmos5l_decap_8
* cell instance sg13cmos5l_decap_8_891 r0 *1 0,0
Xsg13cmos5l_decap_8_891 VPWR VGND sg13cmos5l_decap_8
* cell instance sg13cmos5l_decap_8_892 r0 *1 0,0
Xsg13cmos5l_decap_8_892 VPWR VGND sg13cmos5l_decap_8
* cell instance sg13cmos5l_decap_8_893 r0 *1 0,0
Xsg13cmos5l_decap_8_893 VPWR VGND sg13cmos5l_decap_8
* cell instance sg13cmos5l_decap_8_894 r0 *1 0,0
Xsg13cmos5l_decap_8_894 VPWR VGND sg13cmos5l_decap_8
* cell instance sg13cmos5l_decap_8_895 r0 *1 0,0
Xsg13cmos5l_decap_8_895 VPWR VGND sg13cmos5l_decap_8
* cell instance sg13cmos5l_decap_8_896 r0 *1 0,0
Xsg13cmos5l_decap_8_896 VPWR VGND sg13cmos5l_decap_8
* cell instance sg13cmos5l_decap_8_897 r0 *1 0,0
Xsg13cmos5l_decap_8_897 VPWR VGND sg13cmos5l_decap_8
* cell instance sg13cmos5l_decap_8_898 r0 *1 0,0
Xsg13cmos5l_decap_8_898 VPWR VGND sg13cmos5l_decap_8
* cell instance sg13cmos5l_decap_8_899 r0 *1 0,0
Xsg13cmos5l_decap_8_899 VPWR VGND sg13cmos5l_decap_8
* cell instance sg13cmos5l_decap_8_900 r0 *1 0,0
Xsg13cmos5l_decap_8_900 VPWR VGND sg13cmos5l_decap_8
* cell instance sg13cmos5l_decap_8_901 r0 *1 0,0
Xsg13cmos5l_decap_8_901 VPWR VGND sg13cmos5l_decap_8
* cell instance sg13cmos5l_decap_8_902 r0 *1 0,0
Xsg13cmos5l_decap_8_902 VPWR VGND sg13cmos5l_decap_8
* cell instance sg13cmos5l_decap_8_903 r0 *1 0,0
Xsg13cmos5l_decap_8_903 VPWR VGND sg13cmos5l_decap_8
* cell instance sg13cmos5l_decap_8_904 r0 *1 0,0
Xsg13cmos5l_decap_8_904 VPWR VGND sg13cmos5l_decap_8
* cell instance sg13cmos5l_decap_8_905 r0 *1 0,0
Xsg13cmos5l_decap_8_905 VPWR VGND sg13cmos5l_decap_8
* cell instance sg13cmos5l_decap_8_906 r0 *1 0,0
Xsg13cmos5l_decap_8_906 VPWR VGND sg13cmos5l_decap_8
* cell instance sg13cmos5l_decap_8_907 r0 *1 0,0
Xsg13cmos5l_decap_8_907 VPWR VGND sg13cmos5l_decap_8
* cell instance sg13cmos5l_decap_8_908 r0 *1 0,0
Xsg13cmos5l_decap_8_908 VPWR VGND sg13cmos5l_decap_8
* cell instance sg13cmos5l_decap_8_909 r0 *1 0,0
Xsg13cmos5l_decap_8_909 VPWR VGND sg13cmos5l_decap_8
* cell instance sg13cmos5l_decap_8_910 r0 *1 0,0
Xsg13cmos5l_decap_8_910 VPWR VGND sg13cmos5l_decap_8
* cell instance sg13cmos5l_decap_8_911 r0 *1 0,0
Xsg13cmos5l_decap_8_911 VPWR VGND sg13cmos5l_decap_8
* cell instance sg13cmos5l_decap_8_912 r0 *1 0,0
Xsg13cmos5l_decap_8_912 VPWR VGND sg13cmos5l_decap_8
* cell instance sg13cmos5l_decap_8_913 r0 *1 0,0
Xsg13cmos5l_decap_8_913 VPWR VGND sg13cmos5l_decap_8
* cell instance sg13cmos5l_decap_8_914 r0 *1 0,0
Xsg13cmos5l_decap_8_914 VPWR VGND sg13cmos5l_decap_8
* cell instance sg13cmos5l_decap_8_915 r0 *1 0,0
Xsg13cmos5l_decap_8_915 VPWR VGND sg13cmos5l_decap_8
* cell instance sg13cmos5l_decap_8_916 r0 *1 0,0
Xsg13cmos5l_decap_8_916 VPWR VGND sg13cmos5l_decap_8
* cell instance sg13cmos5l_decap_8_917 r0 *1 0,0
Xsg13cmos5l_decap_8_917 VPWR VGND sg13cmos5l_decap_8
* cell instance sg13cmos5l_decap_8_918 r0 *1 0,0
Xsg13cmos5l_decap_8_918 VPWR VGND sg13cmos5l_decap_8
* cell instance sg13cmos5l_decap_8_919 r0 *1 0,0
Xsg13cmos5l_decap_8_919 VPWR VGND sg13cmos5l_decap_8
* cell instance sg13cmos5l_decap_8_920 r0 *1 0,0
Xsg13cmos5l_decap_8_920 VPWR VGND sg13cmos5l_decap_8
* cell instance sg13cmos5l_decap_8_921 r0 *1 0,0
Xsg13cmos5l_decap_8_921 VPWR VGND sg13cmos5l_decap_8
* cell instance sg13cmos5l_decap_8_922 r0 *1 0,0
Xsg13cmos5l_decap_8_922 VPWR VGND sg13cmos5l_decap_8
* cell instance sg13cmos5l_decap_8_923 r0 *1 0,0
Xsg13cmos5l_decap_8_923 VPWR VGND sg13cmos5l_decap_8
* cell instance sg13cmos5l_decap_8_924 r0 *1 0,0
Xsg13cmos5l_decap_8_924 VPWR VGND sg13cmos5l_decap_8
* cell instance sg13cmos5l_decap_8_925 r0 *1 0,0
Xsg13cmos5l_decap_8_925 VPWR VGND sg13cmos5l_decap_8
* cell instance sg13cmos5l_decap_8_926 r0 *1 0,0
Xsg13cmos5l_decap_8_926 VPWR VGND sg13cmos5l_decap_8
* cell instance sg13cmos5l_decap_8_927 r0 *1 0,0
Xsg13cmos5l_decap_8_927 VPWR VGND sg13cmos5l_decap_8
* cell instance sg13cmos5l_decap_8_928 r0 *1 0,0
Xsg13cmos5l_decap_8_928 VPWR VGND sg13cmos5l_decap_8
* cell instance sg13cmos5l_decap_8_929 r0 *1 0,0
Xsg13cmos5l_decap_8_929 VPWR VGND sg13cmos5l_decap_8
* cell instance sg13cmos5l_decap_8_930 r0 *1 0,0
Xsg13cmos5l_decap_8_930 VPWR VGND sg13cmos5l_decap_8
* cell instance sg13cmos5l_decap_8_931 r0 *1 0,0
Xsg13cmos5l_decap_8_931 VPWR VGND sg13cmos5l_decap_8
* cell instance sg13cmos5l_decap_8_932 r0 *1 0,0
Xsg13cmos5l_decap_8_932 VPWR VGND sg13cmos5l_decap_8
* cell instance sg13cmos5l_decap_8_933 r0 *1 0,0
Xsg13cmos5l_decap_8_933 VPWR VGND sg13cmos5l_decap_8
* cell instance sg13cmos5l_decap_8_934 r0 *1 0,0
Xsg13cmos5l_decap_8_934 VPWR VGND sg13cmos5l_decap_8
* cell instance sg13cmos5l_decap_8_935 r0 *1 0,0
Xsg13cmos5l_decap_8_935 VPWR VGND sg13cmos5l_decap_8
* cell instance sg13cmos5l_decap_8_936 r0 *1 0,0
Xsg13cmos5l_decap_8_936 VPWR VGND sg13cmos5l_decap_8
* cell instance sg13cmos5l_decap_8_937 r0 *1 0,0
Xsg13cmos5l_decap_8_937 VPWR VGND sg13cmos5l_decap_8
* cell instance sg13cmos5l_decap_8_938 r0 *1 0,0
Xsg13cmos5l_decap_8_938 VPWR VGND sg13cmos5l_decap_8
* cell instance sg13cmos5l_decap_8_939 r0 *1 0,0
Xsg13cmos5l_decap_8_939 VPWR VGND sg13cmos5l_decap_8
* cell instance sg13cmos5l_decap_8_940 r0 *1 0,0
Xsg13cmos5l_decap_8_940 VPWR VGND sg13cmos5l_decap_8
* cell instance sg13cmos5l_decap_8_941 r0 *1 0,0
Xsg13cmos5l_decap_8_941 VPWR VGND sg13cmos5l_decap_8
* cell instance sg13cmos5l_decap_8_942 r0 *1 0,0
Xsg13cmos5l_decap_8_942 VPWR VGND sg13cmos5l_decap_8
* cell instance sg13cmos5l_decap_8_943 r0 *1 0,0
Xsg13cmos5l_decap_8_943 VPWR VGND sg13cmos5l_decap_8
* cell instance sg13cmos5l_decap_8_944 r0 *1 0,0
Xsg13cmos5l_decap_8_944 VPWR VGND sg13cmos5l_decap_8
* cell instance sg13cmos5l_decap_8_945 r0 *1 0,0
Xsg13cmos5l_decap_8_945 VPWR VGND sg13cmos5l_decap_8
* cell instance sg13cmos5l_decap_8_946 r0 *1 0,0
Xsg13cmos5l_decap_8_946 VPWR VGND sg13cmos5l_decap_8
* cell instance sg13cmos5l_decap_8_947 r0 *1 0,0
Xsg13cmos5l_decap_8_947 VPWR VGND sg13cmos5l_decap_8
* cell instance sg13cmos5l_decap_8_948 r0 *1 0,0
Xsg13cmos5l_decap_8_948 VPWR VGND sg13cmos5l_decap_8
* cell instance sg13cmos5l_decap_8_949 r0 *1 0,0
Xsg13cmos5l_decap_8_949 VPWR VGND sg13cmos5l_decap_8
* cell instance sg13cmos5l_decap_8_950 r0 *1 0,0
Xsg13cmos5l_decap_8_950 VPWR VGND sg13cmos5l_decap_8
* cell instance sg13cmos5l_decap_8_951 r0 *1 0,0
Xsg13cmos5l_decap_8_951 VPWR VGND sg13cmos5l_decap_8
* cell instance sg13cmos5l_decap_8_952 r0 *1 0,0
Xsg13cmos5l_decap_8_952 VPWR VGND sg13cmos5l_decap_8
* cell instance sg13cmos5l_decap_8_953 r0 *1 0,0
Xsg13cmos5l_decap_8_953 VPWR VGND sg13cmos5l_decap_8
* cell instance sg13cmos5l_decap_8_954 r0 *1 0,0
Xsg13cmos5l_decap_8_954 VPWR VGND sg13cmos5l_decap_8
* cell instance sg13cmos5l_decap_8_955 r0 *1 0,0
Xsg13cmos5l_decap_8_955 VPWR VGND sg13cmos5l_decap_8
* cell instance sg13cmos5l_decap_8_956 r0 *1 0,0
Xsg13cmos5l_decap_8_956 VPWR VGND sg13cmos5l_decap_8
* cell instance sg13cmos5l_decap_8_957 r0 *1 0,0
Xsg13cmos5l_decap_8_957 VPWR VGND sg13cmos5l_decap_8
* cell instance sg13cmos5l_decap_8_958 r0 *1 0,0
Xsg13cmos5l_decap_8_958 VPWR VGND sg13cmos5l_decap_8
* cell instance sg13cmos5l_decap_8_959 r0 *1 0,0
Xsg13cmos5l_decap_8_959 VPWR VGND sg13cmos5l_decap_8
* cell instance sg13cmos5l_decap_8_960 r0 *1 0,0
Xsg13cmos5l_decap_8_960 VPWR VGND sg13cmos5l_decap_8
* cell instance sg13cmos5l_decap_8_961 r0 *1 0,0
Xsg13cmos5l_decap_8_961 VPWR VGND sg13cmos5l_decap_8
* cell instance sg13cmos5l_decap_8_962 r0 *1 0,0
Xsg13cmos5l_decap_8_962 VPWR VGND sg13cmos5l_decap_8
* cell instance sg13cmos5l_decap_8_963 r0 *1 0,0
Xsg13cmos5l_decap_8_963 VPWR VGND sg13cmos5l_decap_8
* cell instance sg13cmos5l_decap_8_964 r0 *1 0,0
Xsg13cmos5l_decap_8_964 VPWR VGND sg13cmos5l_decap_8
* cell instance sg13cmos5l_decap_8_965 r0 *1 0,0
Xsg13cmos5l_decap_8_965 VPWR VGND sg13cmos5l_decap_8
* cell instance sg13cmos5l_decap_8_966 r0 *1 0,0
Xsg13cmos5l_decap_8_966 VPWR VGND sg13cmos5l_decap_8
* cell instance sg13cmos5l_decap_8_967 r0 *1 0,0
Xsg13cmos5l_decap_8_967 VPWR VGND sg13cmos5l_decap_8
* cell instance sg13cmos5l_decap_8_968 r0 *1 0,0
Xsg13cmos5l_decap_8_968 VPWR VGND sg13cmos5l_decap_8
* cell instance sg13cmos5l_decap_8_969 r0 *1 0,0
Xsg13cmos5l_decap_8_969 VPWR VGND sg13cmos5l_decap_8
* cell instance sg13cmos5l_decap_8_970 r0 *1 0,0
Xsg13cmos5l_decap_8_970 VPWR VGND sg13cmos5l_decap_8
* cell instance sg13cmos5l_decap_8_971 r0 *1 0,0
Xsg13cmos5l_decap_8_971 VPWR VGND sg13cmos5l_decap_8
* cell instance sg13cmos5l_decap_8_972 r0 *1 0,0
Xsg13cmos5l_decap_8_972 VPWR VGND sg13cmos5l_decap_8
* cell instance sg13cmos5l_decap_8_973 r0 *1 0,0
Xsg13cmos5l_decap_8_973 VPWR VGND sg13cmos5l_decap_8
* cell instance sg13cmos5l_decap_8_974 r0 *1 0,0
Xsg13cmos5l_decap_8_974 VPWR VGND sg13cmos5l_decap_8
* cell instance sg13cmos5l_decap_8_975 r0 *1 0,0
Xsg13cmos5l_decap_8_975 VPWR VGND sg13cmos5l_decap_8
* cell instance sg13cmos5l_decap_8_976 r0 *1 0,0
Xsg13cmos5l_decap_8_976 VPWR VGND sg13cmos5l_decap_8
* cell instance sg13cmos5l_decap_8_977 r0 *1 0,0
Xsg13cmos5l_decap_8_977 VPWR VGND sg13cmos5l_decap_8
* cell instance sg13cmos5l_decap_8_978 r0 *1 0,0
Xsg13cmos5l_decap_8_978 VPWR VGND sg13cmos5l_decap_8
* cell instance sg13cmos5l_decap_8_979 r0 *1 0,0
Xsg13cmos5l_decap_8_979 VPWR VGND sg13cmos5l_decap_8
* cell instance sg13cmos5l_decap_8_980 r0 *1 0,0
Xsg13cmos5l_decap_8_980 VPWR VGND sg13cmos5l_decap_8
* cell instance sg13cmos5l_decap_8_981 r0 *1 0,0
Xsg13cmos5l_decap_8_981 VPWR VGND sg13cmos5l_decap_8
* cell instance sg13cmos5l_decap_8_982 r0 *1 0,0
Xsg13cmos5l_decap_8_982 VPWR VGND sg13cmos5l_decap_8
* cell instance sg13cmos5l_decap_8_983 r0 *1 0,0
Xsg13cmos5l_decap_8_983 VPWR VGND sg13cmos5l_decap_8
* cell instance sg13cmos5l_decap_8_984 r0 *1 0,0
Xsg13cmos5l_decap_8_984 VPWR VGND sg13cmos5l_decap_8
* cell instance sg13cmos5l_decap_8_985 r0 *1 0,0
Xsg13cmos5l_decap_8_985 VPWR VGND sg13cmos5l_decap_8
* cell instance sg13cmos5l_decap_8_986 r0 *1 0,0
Xsg13cmos5l_decap_8_986 VPWR VGND sg13cmos5l_decap_8
* cell instance sg13cmos5l_decap_8_987 r0 *1 0,0
Xsg13cmos5l_decap_8_987 VPWR VGND sg13cmos5l_decap_8
* cell instance sg13cmos5l_decap_8_988 r0 *1 0,0
Xsg13cmos5l_decap_8_988 VPWR VGND sg13cmos5l_decap_8
* cell instance sg13cmos5l_decap_8_989 r0 *1 0,0
Xsg13cmos5l_decap_8_989 VPWR VGND sg13cmos5l_decap_8
* cell instance sg13cmos5l_decap_8_990 r0 *1 0,0
Xsg13cmos5l_decap_8_990 VPWR VGND sg13cmos5l_decap_8
* cell instance sg13cmos5l_decap_8_991 r0 *1 0,0
Xsg13cmos5l_decap_8_991 VPWR VGND sg13cmos5l_decap_8
* cell instance sg13cmos5l_decap_8_992 r0 *1 0,0
Xsg13cmos5l_decap_8_992 VPWR VGND sg13cmos5l_decap_8
* cell instance sg13cmos5l_decap_8_993 r0 *1 0,0
Xsg13cmos5l_decap_8_993 VPWR VGND sg13cmos5l_decap_8
* cell instance sg13cmos5l_decap_8_994 r0 *1 0,0
Xsg13cmos5l_decap_8_994 VPWR VGND sg13cmos5l_decap_8
* cell instance sg13cmos5l_decap_8_995 r0 *1 0,0
Xsg13cmos5l_decap_8_995 VPWR VGND sg13cmos5l_decap_8
* cell instance sg13cmos5l_decap_8_996 r0 *1 0,0
Xsg13cmos5l_decap_8_996 VPWR VGND sg13cmos5l_decap_8
* cell instance sg13cmos5l_decap_8_997 r0 *1 0,0
Xsg13cmos5l_decap_8_997 VPWR VGND sg13cmos5l_decap_8
* cell instance sg13cmos5l_decap_8_998 r0 *1 0,0
Xsg13cmos5l_decap_8_998 VPWR VGND sg13cmos5l_decap_8
* cell instance sg13cmos5l_decap_8_999 r0 *1 0,0
Xsg13cmos5l_decap_8_999 VPWR VGND sg13cmos5l_decap_8
* cell instance sg13cmos5l_decap_8_1000 r0 *1 0,0
Xsg13cmos5l_decap_8_1000 VPWR VGND sg13cmos5l_decap_8
* cell instance sg13cmos5l_decap_8_1001 r0 *1 0,0
Xsg13cmos5l_decap_8_1001 VPWR VGND sg13cmos5l_decap_8
* cell instance sg13cmos5l_decap_8_1002 r0 *1 0,0
Xsg13cmos5l_decap_8_1002 VPWR VGND sg13cmos5l_decap_8
* cell instance sg13cmos5l_decap_8_1003 r0 *1 0,0
Xsg13cmos5l_decap_8_1003 VPWR VGND sg13cmos5l_decap_8
* cell instance sg13cmos5l_decap_8_1004 r0 *1 0,0
Xsg13cmos5l_decap_8_1004 VPWR VGND sg13cmos5l_decap_8
* cell instance sg13cmos5l_decap_8_1005 r0 *1 0,0
Xsg13cmos5l_decap_8_1005 VPWR VGND sg13cmos5l_decap_8
* cell instance sg13cmos5l_decap_8_1006 r0 *1 0,0
Xsg13cmos5l_decap_8_1006 VPWR VGND sg13cmos5l_decap_8
* cell instance sg13cmos5l_decap_8_1007 r0 *1 0,0
Xsg13cmos5l_decap_8_1007 VPWR VGND sg13cmos5l_decap_8
* cell instance sg13cmos5l_decap_8_1008 r0 *1 0,0
Xsg13cmos5l_decap_8_1008 VPWR VGND sg13cmos5l_decap_8
* cell instance sg13cmos5l_decap_8_1009 r0 *1 0,0
Xsg13cmos5l_decap_8_1009 VPWR VGND sg13cmos5l_decap_8
* cell instance sg13cmos5l_decap_8_1010 r0 *1 0,0
Xsg13cmos5l_decap_8_1010 VPWR VGND sg13cmos5l_decap_8
* cell instance sg13cmos5l_decap_8_1011 r0 *1 0,0
Xsg13cmos5l_decap_8_1011 VPWR VGND sg13cmos5l_decap_8
* cell instance sg13cmos5l_decap_8_1012 r0 *1 0,0
Xsg13cmos5l_decap_8_1012 VPWR VGND sg13cmos5l_decap_8
* cell instance sg13cmos5l_decap_8_1013 r0 *1 0,0
Xsg13cmos5l_decap_8_1013 VPWR VGND sg13cmos5l_decap_8
* cell instance sg13cmos5l_decap_8_1014 r0 *1 0,0
Xsg13cmos5l_decap_8_1014 VPWR VGND sg13cmos5l_decap_8
* cell instance sg13cmos5l_decap_8_1015 r0 *1 0,0
Xsg13cmos5l_decap_8_1015 VPWR VGND sg13cmos5l_decap_8
* cell instance sg13cmos5l_decap_8_1016 r0 *1 0,0
Xsg13cmos5l_decap_8_1016 VPWR VGND sg13cmos5l_decap_8
* cell instance sg13cmos5l_decap_8_1017 r0 *1 0,0
Xsg13cmos5l_decap_8_1017 VPWR VGND sg13cmos5l_decap_8
* cell instance sg13cmos5l_decap_8_1018 r0 *1 0,0
Xsg13cmos5l_decap_8_1018 VPWR VGND sg13cmos5l_decap_8
* cell instance sg13cmos5l_decap_8_1019 r0 *1 0,0
Xsg13cmos5l_decap_8_1019 VPWR VGND sg13cmos5l_decap_8
* cell instance sg13cmos5l_decap_8_1020 r0 *1 0,0
Xsg13cmos5l_decap_8_1020 VPWR VGND sg13cmos5l_decap_8
* cell instance sg13cmos5l_decap_8_1021 r0 *1 0,0
Xsg13cmos5l_decap_8_1021 VPWR VGND sg13cmos5l_decap_8
* cell instance sg13cmos5l_decap_8_1022 r0 *1 0,0
Xsg13cmos5l_decap_8_1022 VPWR VGND sg13cmos5l_decap_8
* cell instance sg13cmos5l_decap_8_1023 r0 *1 0,0
Xsg13cmos5l_decap_8_1023 VPWR VGND sg13cmos5l_decap_8
* cell instance sg13cmos5l_decap_8_1024 r0 *1 0,0
Xsg13cmos5l_decap_8_1024 VPWR VGND sg13cmos5l_decap_8
* cell instance sg13cmos5l_decap_8_1025 r0 *1 0,0
Xsg13cmos5l_decap_8_1025 VPWR VGND sg13cmos5l_decap_8
* cell instance sg13cmos5l_decap_8_1026 r0 *1 0,0
Xsg13cmos5l_decap_8_1026 VPWR VGND sg13cmos5l_decap_8
* cell instance sg13cmos5l_decap_8_1027 r0 *1 0,0
Xsg13cmos5l_decap_8_1027 VPWR VGND sg13cmos5l_decap_8
* cell instance sg13cmos5l_decap_8_1028 r0 *1 0,0
Xsg13cmos5l_decap_8_1028 VPWR VGND sg13cmos5l_decap_8
* cell instance sg13cmos5l_decap_8_1029 r0 *1 0,0
Xsg13cmos5l_decap_8_1029 VPWR VGND sg13cmos5l_decap_8
* cell instance sg13cmos5l_decap_8_1030 r0 *1 0,0
Xsg13cmos5l_decap_8_1030 VPWR VGND sg13cmos5l_decap_8
* cell instance sg13cmos5l_decap_8_1031 r0 *1 0,0
Xsg13cmos5l_decap_8_1031 VPWR VGND sg13cmos5l_decap_8
* cell instance sg13cmos5l_decap_8_1032 r0 *1 0,0
Xsg13cmos5l_decap_8_1032 VPWR VGND sg13cmos5l_decap_8
* cell instance sg13cmos5l_decap_8_1033 r0 *1 0,0
Xsg13cmos5l_decap_8_1033 VPWR VGND sg13cmos5l_decap_8
* cell instance sg13cmos5l_decap_8_1034 r0 *1 0,0
Xsg13cmos5l_decap_8_1034 VPWR VGND sg13cmos5l_decap_8
* cell instance sg13cmos5l_decap_8_1035 r0 *1 0,0
Xsg13cmos5l_decap_8_1035 VPWR VGND sg13cmos5l_decap_8
* cell instance sg13cmos5l_decap_8_1036 r0 *1 0,0
Xsg13cmos5l_decap_8_1036 VPWR VGND sg13cmos5l_decap_8
* cell instance sg13cmos5l_decap_8_1037 r0 *1 0,0
Xsg13cmos5l_decap_8_1037 VPWR VGND sg13cmos5l_decap_8
* cell instance sg13cmos5l_decap_8_1038 r0 *1 0,0
Xsg13cmos5l_decap_8_1038 VPWR VGND sg13cmos5l_decap_8
* cell instance sg13cmos5l_decap_8_1039 r0 *1 0,0
Xsg13cmos5l_decap_8_1039 VPWR VGND sg13cmos5l_decap_8
* cell instance sg13cmos5l_decap_8_1040 r0 *1 0,0
Xsg13cmos5l_decap_8_1040 VPWR VGND sg13cmos5l_decap_8
* cell instance sg13cmos5l_decap_8_1041 r0 *1 0,0
Xsg13cmos5l_decap_8_1041 VPWR VGND sg13cmos5l_decap_8
* cell instance sg13cmos5l_decap_8_1042 r0 *1 0,0
Xsg13cmos5l_decap_8_1042 VPWR VGND sg13cmos5l_decap_8
* cell instance sg13cmos5l_decap_8_1043 r0 *1 0,0
Xsg13cmos5l_decap_8_1043 VPWR VGND sg13cmos5l_decap_8
* cell instance sg13cmos5l_decap_8_1044 r0 *1 0,0
Xsg13cmos5l_decap_8_1044 VPWR VGND sg13cmos5l_decap_8
* cell instance sg13cmos5l_decap_8_1045 r0 *1 0,0
Xsg13cmos5l_decap_8_1045 VPWR VGND sg13cmos5l_decap_8
* cell instance sg13cmos5l_decap_8_1046 r0 *1 0,0
Xsg13cmos5l_decap_8_1046 VPWR VGND sg13cmos5l_decap_8
* cell instance sg13cmos5l_decap_8_1047 r0 *1 0,0
Xsg13cmos5l_decap_8_1047 VPWR VGND sg13cmos5l_decap_8
* cell instance sg13cmos5l_decap_8_1048 r0 *1 0,0
Xsg13cmos5l_decap_8_1048 VPWR VGND sg13cmos5l_decap_8
* cell instance sg13cmos5l_decap_8_1049 r0 *1 0,0
Xsg13cmos5l_decap_8_1049 VPWR VGND sg13cmos5l_decap_8
* cell instance sg13cmos5l_decap_8_1050 r0 *1 0,0
Xsg13cmos5l_decap_8_1050 VPWR VGND sg13cmos5l_decap_8
* cell instance sg13cmos5l_decap_8_1051 r0 *1 0,0
Xsg13cmos5l_decap_8_1051 VPWR VGND sg13cmos5l_decap_8
* cell instance sg13cmos5l_decap_8_1052 r0 *1 0,0
Xsg13cmos5l_decap_8_1052 VPWR VGND sg13cmos5l_decap_8
* cell instance sg13cmos5l_decap_8_1053 r0 *1 0,0
Xsg13cmos5l_decap_8_1053 VPWR VGND sg13cmos5l_decap_8
* cell instance sg13cmos5l_decap_8_1054 r0 *1 0,0
Xsg13cmos5l_decap_8_1054 VPWR VGND sg13cmos5l_decap_8
* cell instance sg13cmos5l_decap_8_1055 r0 *1 0,0
Xsg13cmos5l_decap_8_1055 VPWR VGND sg13cmos5l_decap_8
* cell instance sg13cmos5l_decap_8_1056 r0 *1 0,0
Xsg13cmos5l_decap_8_1056 VPWR VGND sg13cmos5l_decap_8
* cell instance sg13cmos5l_decap_8_1057 r0 *1 0,0
Xsg13cmos5l_decap_8_1057 VPWR VGND sg13cmos5l_decap_8
* cell instance sg13cmos5l_decap_8_1058 r0 *1 0,0
Xsg13cmos5l_decap_8_1058 VPWR VGND sg13cmos5l_decap_8
* cell instance sg13cmos5l_decap_8_1059 r0 *1 0,0
Xsg13cmos5l_decap_8_1059 VPWR VGND sg13cmos5l_decap_8
* cell instance sg13cmos5l_decap_8_1060 r0 *1 0,0
Xsg13cmos5l_decap_8_1060 VPWR VGND sg13cmos5l_decap_8
* cell instance sg13cmos5l_decap_8_1061 r0 *1 0,0
Xsg13cmos5l_decap_8_1061 VPWR VGND sg13cmos5l_decap_8
* cell instance sg13cmos5l_decap_8_1062 r0 *1 0,0
Xsg13cmos5l_decap_8_1062 VPWR VGND sg13cmos5l_decap_8
* cell instance sg13cmos5l_decap_8_1063 r0 *1 0,0
Xsg13cmos5l_decap_8_1063 VPWR VGND sg13cmos5l_decap_8
* cell instance sg13cmos5l_decap_8_1064 r0 *1 0,0
Xsg13cmos5l_decap_8_1064 VPWR VGND sg13cmos5l_decap_8
* cell instance sg13cmos5l_decap_8_1065 r0 *1 0,0
Xsg13cmos5l_decap_8_1065 VPWR VGND sg13cmos5l_decap_8
* cell instance sg13cmos5l_decap_8_1066 r0 *1 0,0
Xsg13cmos5l_decap_8_1066 VPWR VGND sg13cmos5l_decap_8
* cell instance sg13cmos5l_decap_8_1067 r0 *1 0,0
Xsg13cmos5l_decap_8_1067 VPWR VGND sg13cmos5l_decap_8
* cell instance sg13cmos5l_decap_8_1068 r0 *1 0,0
Xsg13cmos5l_decap_8_1068 VPWR VGND sg13cmos5l_decap_8
* cell instance sg13cmos5l_decap_8_1069 r0 *1 0,0
Xsg13cmos5l_decap_8_1069 VPWR VGND sg13cmos5l_decap_8
* cell instance sg13cmos5l_decap_8_1070 r0 *1 0,0
Xsg13cmos5l_decap_8_1070 VPWR VGND sg13cmos5l_decap_8
* cell instance sg13cmos5l_decap_8_1071 r0 *1 0,0
Xsg13cmos5l_decap_8_1071 VPWR VGND sg13cmos5l_decap_8
* cell instance sg13cmos5l_decap_8_1072 r0 *1 0,0
Xsg13cmos5l_decap_8_1072 VPWR VGND sg13cmos5l_decap_8
* cell instance sg13cmos5l_decap_8_1073 r0 *1 0,0
Xsg13cmos5l_decap_8_1073 VPWR VGND sg13cmos5l_decap_8
* cell instance sg13cmos5l_decap_8_1074 r0 *1 0,0
Xsg13cmos5l_decap_8_1074 VPWR VGND sg13cmos5l_decap_8
* cell instance sg13cmos5l_decap_8_1075 r0 *1 0,0
Xsg13cmos5l_decap_8_1075 VPWR VGND sg13cmos5l_decap_8
* cell instance sg13cmos5l_decap_8_1076 r0 *1 0,0
Xsg13cmos5l_decap_8_1076 VPWR VGND sg13cmos5l_decap_8
* cell instance sg13cmos5l_decap_8_1077 r0 *1 0,0
Xsg13cmos5l_decap_8_1077 VPWR VGND sg13cmos5l_decap_8
* cell instance sg13cmos5l_decap_8_1078 r0 *1 0,0
Xsg13cmos5l_decap_8_1078 VPWR VGND sg13cmos5l_decap_8
* cell instance sg13cmos5l_decap_8_1079 r0 *1 0,0
Xsg13cmos5l_decap_8_1079 VPWR VGND sg13cmos5l_decap_8
* cell instance sg13cmos5l_decap_8_1080 r0 *1 0,0
Xsg13cmos5l_decap_8_1080 VPWR VGND sg13cmos5l_decap_8
* cell instance sg13cmos5l_decap_8_1081 r0 *1 0,0
Xsg13cmos5l_decap_8_1081 VPWR VGND sg13cmos5l_decap_8
* cell instance sg13cmos5l_decap_8_1082 r0 *1 0,0
Xsg13cmos5l_decap_8_1082 VPWR VGND sg13cmos5l_decap_8
* cell instance sg13cmos5l_decap_8_1083 r0 *1 0,0
Xsg13cmos5l_decap_8_1083 VPWR VGND sg13cmos5l_decap_8
* cell instance sg13cmos5l_decap_8_1084 r0 *1 0,0
Xsg13cmos5l_decap_8_1084 VPWR VGND sg13cmos5l_decap_8
* cell instance sg13cmos5l_decap_8_1085 r0 *1 0,0
Xsg13cmos5l_decap_8_1085 VPWR VGND sg13cmos5l_decap_8
* cell instance sg13cmos5l_decap_8_1086 r0 *1 0,0
Xsg13cmos5l_decap_8_1086 VPWR VGND sg13cmos5l_decap_8
* cell instance sg13cmos5l_decap_8_1087 r0 *1 0,0
Xsg13cmos5l_decap_8_1087 VPWR VGND sg13cmos5l_decap_8
* cell instance sg13cmos5l_decap_8_1088 r0 *1 0,0
Xsg13cmos5l_decap_8_1088 VPWR VGND sg13cmos5l_decap_8
* cell instance sg13cmos5l_decap_8_1089 r0 *1 0,0
Xsg13cmos5l_decap_8_1089 VPWR VGND sg13cmos5l_decap_8
* cell instance sg13cmos5l_decap_8_1090 r0 *1 0,0
Xsg13cmos5l_decap_8_1090 VPWR VGND sg13cmos5l_decap_8
* cell instance sg13cmos5l_decap_8_1091 r0 *1 0,0
Xsg13cmos5l_decap_8_1091 VPWR VGND sg13cmos5l_decap_8
* cell instance sg13cmos5l_decap_8_1092 r0 *1 0,0
Xsg13cmos5l_decap_8_1092 VPWR VGND sg13cmos5l_decap_8
* cell instance sg13cmos5l_decap_8_1093 r0 *1 0,0
Xsg13cmos5l_decap_8_1093 VPWR VGND sg13cmos5l_decap_8
* cell instance sg13cmos5l_decap_8_1094 r0 *1 0,0
Xsg13cmos5l_decap_8_1094 VPWR VGND sg13cmos5l_decap_8
* cell instance sg13cmos5l_decap_8_1095 r0 *1 0,0
Xsg13cmos5l_decap_8_1095 VPWR VGND sg13cmos5l_decap_8
* cell instance sg13cmos5l_decap_8_1096 r0 *1 0,0
Xsg13cmos5l_decap_8_1096 VPWR VGND sg13cmos5l_decap_8
* cell instance sg13cmos5l_decap_8_1097 r0 *1 0,0
Xsg13cmos5l_decap_8_1097 VPWR VGND sg13cmos5l_decap_8
* cell instance sg13cmos5l_decap_8_1098 r0 *1 0,0
Xsg13cmos5l_decap_8_1098 VPWR VGND sg13cmos5l_decap_8
* cell instance sg13cmos5l_decap_8_1099 r0 *1 0,0
Xsg13cmos5l_decap_8_1099 VPWR VGND sg13cmos5l_decap_8
* cell instance sg13cmos5l_decap_8_1100 r0 *1 0,0
Xsg13cmos5l_decap_8_1100 VPWR VGND sg13cmos5l_decap_8
* cell instance sg13cmos5l_decap_8_1101 r0 *1 0,0
Xsg13cmos5l_decap_8_1101 VPWR VGND sg13cmos5l_decap_8
* cell instance sg13cmos5l_decap_8_1102 r0 *1 0,0
Xsg13cmos5l_decap_8_1102 VPWR VGND sg13cmos5l_decap_8
* cell instance sg13cmos5l_decap_8_1103 r0 *1 0,0
Xsg13cmos5l_decap_8_1103 VPWR VGND sg13cmos5l_decap_8
* cell instance sg13cmos5l_decap_8_1104 r0 *1 0,0
Xsg13cmos5l_decap_8_1104 VPWR VGND sg13cmos5l_decap_8
* cell instance sg13cmos5l_decap_8_1105 r0 *1 0,0
Xsg13cmos5l_decap_8_1105 VPWR VGND sg13cmos5l_decap_8
* cell instance sg13cmos5l_decap_8_1106 r0 *1 0,0
Xsg13cmos5l_decap_8_1106 VPWR VGND sg13cmos5l_decap_8
* cell instance sg13cmos5l_decap_8_1107 r0 *1 0,0
Xsg13cmos5l_decap_8_1107 VPWR VGND sg13cmos5l_decap_8
* cell instance sg13cmos5l_decap_8_1108 r0 *1 0,0
Xsg13cmos5l_decap_8_1108 VPWR VGND sg13cmos5l_decap_8
* cell instance sg13cmos5l_decap_8_1109 r0 *1 0,0
Xsg13cmos5l_decap_8_1109 VPWR VGND sg13cmos5l_decap_8
* cell instance sg13cmos5l_decap_8_1110 r0 *1 0,0
Xsg13cmos5l_decap_8_1110 VPWR VGND sg13cmos5l_decap_8
* cell instance sg13cmos5l_decap_8_1111 r0 *1 0,0
Xsg13cmos5l_decap_8_1111 VPWR VGND sg13cmos5l_decap_8
* cell instance sg13cmos5l_decap_8_1112 r0 *1 0,0
Xsg13cmos5l_decap_8_1112 VPWR VGND sg13cmos5l_decap_8
* cell instance sg13cmos5l_decap_8_1113 r0 *1 0,0
Xsg13cmos5l_decap_8_1113 VPWR VGND sg13cmos5l_decap_8
* cell instance sg13cmos5l_decap_8_1114 r0 *1 0,0
Xsg13cmos5l_decap_8_1114 VPWR VGND sg13cmos5l_decap_8
* cell instance sg13cmos5l_decap_8_1115 r0 *1 0,0
Xsg13cmos5l_decap_8_1115 VPWR VGND sg13cmos5l_decap_8
* cell instance sg13cmos5l_decap_8_1116 r0 *1 0,0
Xsg13cmos5l_decap_8_1116 VPWR VGND sg13cmos5l_decap_8
* cell instance sg13cmos5l_decap_8_1117 r0 *1 0,0
Xsg13cmos5l_decap_8_1117 VPWR VGND sg13cmos5l_decap_8
* cell instance sg13cmos5l_decap_8_1118 r0 *1 0,0
Xsg13cmos5l_decap_8_1118 VPWR VGND sg13cmos5l_decap_8
* cell instance sg13cmos5l_decap_8_1119 r0 *1 0,0
Xsg13cmos5l_decap_8_1119 VPWR VGND sg13cmos5l_decap_8
* cell instance sg13cmos5l_decap_8_1120 r0 *1 0,0
Xsg13cmos5l_decap_8_1120 VPWR VGND sg13cmos5l_decap_8
* cell instance sg13cmos5l_decap_8_1121 r0 *1 0,0
Xsg13cmos5l_decap_8_1121 VPWR VGND sg13cmos5l_decap_8
* cell instance sg13cmos5l_decap_8_1122 r0 *1 0,0
Xsg13cmos5l_decap_8_1122 VPWR VGND sg13cmos5l_decap_8
* cell instance sg13cmos5l_decap_8_1123 r0 *1 0,0
Xsg13cmos5l_decap_8_1123 VPWR VGND sg13cmos5l_decap_8
* cell instance sg13cmos5l_decap_8_1124 r0 *1 0,0
Xsg13cmos5l_decap_8_1124 VPWR VGND sg13cmos5l_decap_8
* cell instance sg13cmos5l_decap_8_1125 r0 *1 0,0
Xsg13cmos5l_decap_8_1125 VPWR VGND sg13cmos5l_decap_8
* cell instance sg13cmos5l_decap_8_1126 r0 *1 0,0
Xsg13cmos5l_decap_8_1126 VPWR VGND sg13cmos5l_decap_8
* cell instance sg13cmos5l_decap_8_1127 r0 *1 0,0
Xsg13cmos5l_decap_8_1127 VPWR VGND sg13cmos5l_decap_8
* cell instance sg13cmos5l_decap_8_1128 r0 *1 0,0
Xsg13cmos5l_decap_8_1128 VPWR VGND sg13cmos5l_decap_8
* cell instance sg13cmos5l_decap_8_1129 r0 *1 0,0
Xsg13cmos5l_decap_8_1129 VPWR VGND sg13cmos5l_decap_8
* cell instance sg13cmos5l_decap_8_1130 r0 *1 0,0
Xsg13cmos5l_decap_8_1130 VPWR VGND sg13cmos5l_decap_8
* cell instance sg13cmos5l_decap_8_1131 r0 *1 0,0
Xsg13cmos5l_decap_8_1131 VPWR VGND sg13cmos5l_decap_8
* cell instance sg13cmos5l_decap_8_1132 r0 *1 0,0
Xsg13cmos5l_decap_8_1132 VPWR VGND sg13cmos5l_decap_8
* cell instance sg13cmos5l_decap_8_1133 r0 *1 0,0
Xsg13cmos5l_decap_8_1133 VPWR VGND sg13cmos5l_decap_8
* cell instance sg13cmos5l_decap_8_1134 r0 *1 0,0
Xsg13cmos5l_decap_8_1134 VPWR VGND sg13cmos5l_decap_8
* cell instance sg13cmos5l_decap_8_1135 r0 *1 0,0
Xsg13cmos5l_decap_8_1135 VPWR VGND sg13cmos5l_decap_8
* cell instance sg13cmos5l_decap_8_1136 r0 *1 0,0
Xsg13cmos5l_decap_8_1136 VPWR VGND sg13cmos5l_decap_8
* cell instance sg13cmos5l_decap_8_1137 r0 *1 0,0
Xsg13cmos5l_decap_8_1137 VPWR VGND sg13cmos5l_decap_8
* cell instance sg13cmos5l_decap_8_1138 r0 *1 0,0
Xsg13cmos5l_decap_8_1138 VPWR VGND sg13cmos5l_decap_8
* cell instance sg13cmos5l_decap_8_1139 r0 *1 0,0
Xsg13cmos5l_decap_8_1139 VPWR VGND sg13cmos5l_decap_8
* cell instance sg13cmos5l_decap_8_1140 r0 *1 0,0
Xsg13cmos5l_decap_8_1140 VPWR VGND sg13cmos5l_decap_8
* cell instance sg13cmos5l_decap_8_1141 r0 *1 0,0
Xsg13cmos5l_decap_8_1141 VPWR VGND sg13cmos5l_decap_8
* cell instance sg13cmos5l_decap_8_1142 r0 *1 0,0
Xsg13cmos5l_decap_8_1142 VPWR VGND sg13cmos5l_decap_8
* cell instance sg13cmos5l_decap_8_1143 r0 *1 0,0
Xsg13cmos5l_decap_8_1143 VPWR VGND sg13cmos5l_decap_8
* cell instance sg13cmos5l_decap_8_1144 r0 *1 0,0
Xsg13cmos5l_decap_8_1144 VPWR VGND sg13cmos5l_decap_8
* cell instance sg13cmos5l_decap_8_1145 r0 *1 0,0
Xsg13cmos5l_decap_8_1145 VPWR VGND sg13cmos5l_decap_8
* cell instance sg13cmos5l_decap_8_1146 r0 *1 0,0
Xsg13cmos5l_decap_8_1146 VPWR VGND sg13cmos5l_decap_8
* cell instance sg13cmos5l_decap_8_1147 r0 *1 0,0
Xsg13cmos5l_decap_8_1147 VPWR VGND sg13cmos5l_decap_8
* cell instance sg13cmos5l_decap_8_1148 r0 *1 0,0
Xsg13cmos5l_decap_8_1148 VPWR VGND sg13cmos5l_decap_8
* cell instance sg13cmos5l_decap_8_1149 r0 *1 0,0
Xsg13cmos5l_decap_8_1149 VPWR VGND sg13cmos5l_decap_8
* cell instance sg13cmos5l_decap_8_1150 r0 *1 0,0
Xsg13cmos5l_decap_8_1150 VPWR VGND sg13cmos5l_decap_8
* cell instance sg13cmos5l_decap_8_1151 r0 *1 0,0
Xsg13cmos5l_decap_8_1151 VPWR VGND sg13cmos5l_decap_8
* cell instance sg13cmos5l_decap_8_1152 r0 *1 0,0
Xsg13cmos5l_decap_8_1152 VPWR VGND sg13cmos5l_decap_8
* cell instance sg13cmos5l_decap_8_1153 r0 *1 0,0
Xsg13cmos5l_decap_8_1153 VPWR VGND sg13cmos5l_decap_8
* cell instance sg13cmos5l_decap_8_1154 r0 *1 0,0
Xsg13cmos5l_decap_8_1154 VPWR VGND sg13cmos5l_decap_8
* cell instance sg13cmos5l_decap_8_1155 r0 *1 0,0
Xsg13cmos5l_decap_8_1155 VPWR VGND sg13cmos5l_decap_8
* cell instance sg13cmos5l_decap_8_1156 r0 *1 0,0
Xsg13cmos5l_decap_8_1156 VPWR VGND sg13cmos5l_decap_8
* cell instance sg13cmos5l_decap_8_1157 r0 *1 0,0
Xsg13cmos5l_decap_8_1157 VPWR VGND sg13cmos5l_decap_8
* cell instance sg13cmos5l_decap_8_1158 r0 *1 0,0
Xsg13cmos5l_decap_8_1158 VPWR VGND sg13cmos5l_decap_8
* cell instance sg13cmos5l_decap_8_1159 r0 *1 0,0
Xsg13cmos5l_decap_8_1159 VPWR VGND sg13cmos5l_decap_8
* cell instance sg13cmos5l_decap_8_1160 r0 *1 0,0
Xsg13cmos5l_decap_8_1160 VPWR VGND sg13cmos5l_decap_8
* cell instance sg13cmos5l_decap_8_1161 r0 *1 0,0
Xsg13cmos5l_decap_8_1161 VPWR VGND sg13cmos5l_decap_8
* cell instance sg13cmos5l_decap_8_1162 r0 *1 0,0
Xsg13cmos5l_decap_8_1162 VPWR VGND sg13cmos5l_decap_8
* cell instance sg13cmos5l_decap_8_1163 r0 *1 0,0
Xsg13cmos5l_decap_8_1163 VPWR VGND sg13cmos5l_decap_8
* cell instance sg13cmos5l_decap_8_1164 r0 *1 0,0
Xsg13cmos5l_decap_8_1164 VPWR VGND sg13cmos5l_decap_8
* cell instance sg13cmos5l_decap_8_1165 r0 *1 0,0
Xsg13cmos5l_decap_8_1165 VPWR VGND sg13cmos5l_decap_8
* cell instance sg13cmos5l_decap_8_1166 r0 *1 0,0
Xsg13cmos5l_decap_8_1166 VPWR VGND sg13cmos5l_decap_8
* cell instance sg13cmos5l_decap_8_1167 r0 *1 0,0
Xsg13cmos5l_decap_8_1167 VPWR VGND sg13cmos5l_decap_8
* cell instance sg13cmos5l_decap_8_1168 r0 *1 0,0
Xsg13cmos5l_decap_8_1168 VPWR VGND sg13cmos5l_decap_8
* cell instance sg13cmos5l_decap_8_1169 r0 *1 0,0
Xsg13cmos5l_decap_8_1169 VPWR VGND sg13cmos5l_decap_8
* cell instance sg13cmos5l_decap_8_1170 r0 *1 0,0
Xsg13cmos5l_decap_8_1170 VPWR VGND sg13cmos5l_decap_8
* cell instance sg13cmos5l_decap_8_1171 r0 *1 0,0
Xsg13cmos5l_decap_8_1171 VPWR VGND sg13cmos5l_decap_8
* cell instance sg13cmos5l_decap_8_1172 r0 *1 0,0
Xsg13cmos5l_decap_8_1172 VPWR VGND sg13cmos5l_decap_8
* cell instance sg13cmos5l_decap_8_1173 r0 *1 0,0
Xsg13cmos5l_decap_8_1173 VPWR VGND sg13cmos5l_decap_8
* cell instance sg13cmos5l_decap_8_1174 r0 *1 0,0
Xsg13cmos5l_decap_8_1174 VPWR VGND sg13cmos5l_decap_8
* cell instance sg13cmos5l_decap_8_1175 r0 *1 0,0
Xsg13cmos5l_decap_8_1175 VPWR VGND sg13cmos5l_decap_8
* cell instance sg13cmos5l_decap_8_1176 r0 *1 0,0
Xsg13cmos5l_decap_8_1176 VPWR VGND sg13cmos5l_decap_8
* cell instance sg13cmos5l_decap_8_1177 r0 *1 0,0
Xsg13cmos5l_decap_8_1177 VPWR VGND sg13cmos5l_decap_8
* cell instance sg13cmos5l_decap_8_1178 r0 *1 0,0
Xsg13cmos5l_decap_8_1178 VPWR VGND sg13cmos5l_decap_8
* cell instance sg13cmos5l_decap_8_1179 r0 *1 0,0
Xsg13cmos5l_decap_8_1179 VPWR VGND sg13cmos5l_decap_8
* cell instance sg13cmos5l_decap_8_1180 r0 *1 0,0
Xsg13cmos5l_decap_8_1180 VPWR VGND sg13cmos5l_decap_8
* cell instance sg13cmos5l_decap_8_1181 r0 *1 0,0
Xsg13cmos5l_decap_8_1181 VPWR VGND sg13cmos5l_decap_8
* cell instance sg13cmos5l_decap_8_1182 r0 *1 0,0
Xsg13cmos5l_decap_8_1182 VPWR VGND sg13cmos5l_decap_8
* cell instance sg13cmos5l_decap_8_1183 r0 *1 0,0
Xsg13cmos5l_decap_8_1183 VPWR VGND sg13cmos5l_decap_8
* cell instance sg13cmos5l_decap_8_1184 r0 *1 0,0
Xsg13cmos5l_decap_8_1184 VPWR VGND sg13cmos5l_decap_8
* cell instance sg13cmos5l_decap_8_1185 r0 *1 0,0
Xsg13cmos5l_decap_8_1185 VPWR VGND sg13cmos5l_decap_8
* cell instance sg13cmos5l_decap_8_1186 r0 *1 0,0
Xsg13cmos5l_decap_8_1186 VPWR VGND sg13cmos5l_decap_8
* cell instance sg13cmos5l_decap_8_1187 r0 *1 0,0
Xsg13cmos5l_decap_8_1187 VPWR VGND sg13cmos5l_decap_8
* cell instance sg13cmos5l_decap_8_1188 r0 *1 0,0
Xsg13cmos5l_decap_8_1188 VPWR VGND sg13cmos5l_decap_8
* cell instance sg13cmos5l_decap_8_1189 r0 *1 0,0
Xsg13cmos5l_decap_8_1189 VPWR VGND sg13cmos5l_decap_8
* cell instance sg13cmos5l_decap_8_1190 r0 *1 0,0
Xsg13cmos5l_decap_8_1190 VPWR VGND sg13cmos5l_decap_8
* cell instance sg13cmos5l_decap_8_1191 r0 *1 0,0
Xsg13cmos5l_decap_8_1191 VPWR VGND sg13cmos5l_decap_8
* cell instance sg13cmos5l_decap_8_1192 r0 *1 0,0
Xsg13cmos5l_decap_8_1192 VPWR VGND sg13cmos5l_decap_8
* cell instance sg13cmos5l_decap_8_1193 r0 *1 0,0
Xsg13cmos5l_decap_8_1193 VPWR VGND sg13cmos5l_decap_8
* cell instance sg13cmos5l_decap_8_1194 r0 *1 0,0
Xsg13cmos5l_decap_8_1194 VPWR VGND sg13cmos5l_decap_8
* cell instance sg13cmos5l_decap_8_1195 r0 *1 0,0
Xsg13cmos5l_decap_8_1195 VPWR VGND sg13cmos5l_decap_8
* cell instance sg13cmos5l_decap_8_1196 r0 *1 0,0
Xsg13cmos5l_decap_8_1196 VPWR VGND sg13cmos5l_decap_8
* cell instance sg13cmos5l_decap_8_1197 r0 *1 0,0
Xsg13cmos5l_decap_8_1197 VPWR VGND sg13cmos5l_decap_8
* cell instance sg13cmos5l_decap_8_1198 r0 *1 0,0
Xsg13cmos5l_decap_8_1198 VPWR VGND sg13cmos5l_decap_8
* cell instance sg13cmos5l_decap_8_1199 r0 *1 0,0
Xsg13cmos5l_decap_8_1199 VPWR VGND sg13cmos5l_decap_8
* cell instance sg13cmos5l_decap_8_1200 r0 *1 0,0
Xsg13cmos5l_decap_8_1200 VPWR VGND sg13cmos5l_decap_8
* cell instance sg13cmos5l_decap_8_1201 r0 *1 0,0
Xsg13cmos5l_decap_8_1201 VPWR VGND sg13cmos5l_decap_8
* cell instance sg13cmos5l_decap_8_1202 r0 *1 0,0
Xsg13cmos5l_decap_8_1202 VPWR VGND sg13cmos5l_decap_8
* cell instance sg13cmos5l_decap_8_1203 r0 *1 0,0
Xsg13cmos5l_decap_8_1203 VPWR VGND sg13cmos5l_decap_8
* cell instance sg13cmos5l_decap_8_1204 r0 *1 0,0
Xsg13cmos5l_decap_8_1204 VPWR VGND sg13cmos5l_decap_8
* cell instance sg13cmos5l_decap_8_1205 r0 *1 0,0
Xsg13cmos5l_decap_8_1205 VPWR VGND sg13cmos5l_decap_8
* cell instance sg13cmos5l_decap_8_1206 r0 *1 0,0
Xsg13cmos5l_decap_8_1206 VPWR VGND sg13cmos5l_decap_8
* cell instance sg13cmos5l_decap_8_1207 r0 *1 0,0
Xsg13cmos5l_decap_8_1207 VPWR VGND sg13cmos5l_decap_8
* cell instance sg13cmos5l_decap_8_1208 r0 *1 0,0
Xsg13cmos5l_decap_8_1208 VPWR VGND sg13cmos5l_decap_8
* cell instance sg13cmos5l_decap_8_1209 r0 *1 0,0
Xsg13cmos5l_decap_8_1209 VPWR VGND sg13cmos5l_decap_8
* cell instance sg13cmos5l_decap_8_1210 r0 *1 0,0
Xsg13cmos5l_decap_8_1210 VPWR VGND sg13cmos5l_decap_8
* cell instance sg13cmos5l_decap_8_1211 r0 *1 0,0
Xsg13cmos5l_decap_8_1211 VPWR VGND sg13cmos5l_decap_8
* cell instance sg13cmos5l_decap_8_1212 r0 *1 0,0
Xsg13cmos5l_decap_8_1212 VPWR VGND sg13cmos5l_decap_8
* cell instance sg13cmos5l_decap_8_1213 r0 *1 0,0
Xsg13cmos5l_decap_8_1213 VPWR VGND sg13cmos5l_decap_8
* cell instance sg13cmos5l_decap_8_1214 r0 *1 0,0
Xsg13cmos5l_decap_8_1214 VPWR VGND sg13cmos5l_decap_8
* cell instance sg13cmos5l_decap_8_1215 r0 *1 0,0
Xsg13cmos5l_decap_8_1215 VPWR VGND sg13cmos5l_decap_8
* cell instance sg13cmos5l_decap_8_1216 r0 *1 0,0
Xsg13cmos5l_decap_8_1216 VPWR VGND sg13cmos5l_decap_8
* cell instance sg13cmos5l_decap_8_1217 r0 *1 0,0
Xsg13cmos5l_decap_8_1217 VPWR VGND sg13cmos5l_decap_8
* cell instance sg13cmos5l_decap_8_1218 r0 *1 0,0
Xsg13cmos5l_decap_8_1218 VPWR VGND sg13cmos5l_decap_8
* cell instance sg13cmos5l_decap_8_1219 r0 *1 0,0
Xsg13cmos5l_decap_8_1219 VPWR VGND sg13cmos5l_decap_8
* cell instance sg13cmos5l_decap_8_1220 r0 *1 0,0
Xsg13cmos5l_decap_8_1220 VPWR VGND sg13cmos5l_decap_8
* cell instance sg13cmos5l_decap_8_1221 r0 *1 0,0
Xsg13cmos5l_decap_8_1221 VPWR VGND sg13cmos5l_decap_8
* cell instance sg13cmos5l_decap_8_1222 r0 *1 0,0
Xsg13cmos5l_decap_8_1222 VPWR VGND sg13cmos5l_decap_8
* cell instance sg13cmos5l_decap_8_1223 r0 *1 0,0
Xsg13cmos5l_decap_8_1223 VPWR VGND sg13cmos5l_decap_8
* cell instance sg13cmos5l_decap_8_1224 r0 *1 0,0
Xsg13cmos5l_decap_8_1224 VPWR VGND sg13cmos5l_decap_8
* cell instance sg13cmos5l_decap_8_1225 r0 *1 0,0
Xsg13cmos5l_decap_8_1225 VPWR VGND sg13cmos5l_decap_8
* cell instance sg13cmos5l_decap_8_1226 r0 *1 0,0
Xsg13cmos5l_decap_8_1226 VPWR VGND sg13cmos5l_decap_8
* cell instance sg13cmos5l_decap_8_1227 r0 *1 0,0
Xsg13cmos5l_decap_8_1227 VPWR VGND sg13cmos5l_decap_8
* cell instance sg13cmos5l_decap_8_1228 r0 *1 0,0
Xsg13cmos5l_decap_8_1228 VPWR VGND sg13cmos5l_decap_8
* cell instance sg13cmos5l_decap_8_1229 r0 *1 0,0
Xsg13cmos5l_decap_8_1229 VPWR VGND sg13cmos5l_decap_8
* cell instance sg13cmos5l_decap_8_1230 r0 *1 0,0
Xsg13cmos5l_decap_8_1230 VPWR VGND sg13cmos5l_decap_8
* cell instance sg13cmos5l_decap_8_1231 r0 *1 0,0
Xsg13cmos5l_decap_8_1231 VPWR VGND sg13cmos5l_decap_8
* cell instance sg13cmos5l_decap_8_1232 r0 *1 0,0
Xsg13cmos5l_decap_8_1232 VPWR VGND sg13cmos5l_decap_8
* cell instance sg13cmos5l_decap_8_1233 r0 *1 0,0
Xsg13cmos5l_decap_8_1233 VPWR VGND sg13cmos5l_decap_8
* cell instance sg13cmos5l_decap_8_1234 r0 *1 0,0
Xsg13cmos5l_decap_8_1234 VPWR VGND sg13cmos5l_decap_8
* cell instance sg13cmos5l_decap_8_1235 r0 *1 0,0
Xsg13cmos5l_decap_8_1235 VPWR VGND sg13cmos5l_decap_8
* cell instance sg13cmos5l_decap_8_1236 r0 *1 0,0
Xsg13cmos5l_decap_8_1236 VPWR VGND sg13cmos5l_decap_8
* cell instance sg13cmos5l_decap_8_1237 r0 *1 0,0
Xsg13cmos5l_decap_8_1237 VPWR VGND sg13cmos5l_decap_8
* cell instance sg13cmos5l_decap_8_1238 r0 *1 0,0
Xsg13cmos5l_decap_8_1238 VPWR VGND sg13cmos5l_decap_8
* cell instance sg13cmos5l_decap_8_1239 r0 *1 0,0
Xsg13cmos5l_decap_8_1239 VPWR VGND sg13cmos5l_decap_8
* cell instance sg13cmos5l_decap_8_1240 r0 *1 0,0
Xsg13cmos5l_decap_8_1240 VPWR VGND sg13cmos5l_decap_8
* cell instance sg13cmos5l_decap_8_1241 r0 *1 0,0
Xsg13cmos5l_decap_8_1241 VPWR VGND sg13cmos5l_decap_8
* cell instance sg13cmos5l_decap_8_1242 r0 *1 0,0
Xsg13cmos5l_decap_8_1242 VPWR VGND sg13cmos5l_decap_8
* cell instance sg13cmos5l_decap_8_1243 r0 *1 0,0
Xsg13cmos5l_decap_8_1243 VPWR VGND sg13cmos5l_decap_8
* cell instance sg13cmos5l_decap_8_1244 r0 *1 0,0
Xsg13cmos5l_decap_8_1244 VPWR VGND sg13cmos5l_decap_8
* cell instance sg13cmos5l_decap_8_1245 r0 *1 0,0
Xsg13cmos5l_decap_8_1245 VPWR VGND sg13cmos5l_decap_8
* cell instance sg13cmos5l_decap_8_1246 r0 *1 0,0
Xsg13cmos5l_decap_8_1246 VPWR VGND sg13cmos5l_decap_8
* cell instance sg13cmos5l_decap_8_1247 r0 *1 0,0
Xsg13cmos5l_decap_8_1247 VPWR VGND sg13cmos5l_decap_8
* cell instance sg13cmos5l_decap_8_1248 r0 *1 0,0
Xsg13cmos5l_decap_8_1248 VPWR VGND sg13cmos5l_decap_8
* cell instance sg13cmos5l_decap_8_1249 r0 *1 0,0
Xsg13cmos5l_decap_8_1249 VPWR VGND sg13cmos5l_decap_8
* cell instance sg13cmos5l_decap_8_1250 r0 *1 0,0
Xsg13cmos5l_decap_8_1250 VPWR VGND sg13cmos5l_decap_8
* cell instance sg13cmos5l_decap_8_1251 r0 *1 0,0
Xsg13cmos5l_decap_8_1251 VPWR VGND sg13cmos5l_decap_8
* cell instance sg13cmos5l_decap_8_1252 r0 *1 0,0
Xsg13cmos5l_decap_8_1252 VPWR VGND sg13cmos5l_decap_8
* cell instance sg13cmos5l_decap_8_1253 r0 *1 0,0
Xsg13cmos5l_decap_8_1253 VPWR VGND sg13cmos5l_decap_8
* cell instance sg13cmos5l_decap_8_1254 r0 *1 0,0
Xsg13cmos5l_decap_8_1254 VPWR VGND sg13cmos5l_decap_8
* cell instance sg13cmos5l_decap_8_1255 r0 *1 0,0
Xsg13cmos5l_decap_8_1255 VPWR VGND sg13cmos5l_decap_8
* cell instance sg13cmos5l_decap_8_1256 r0 *1 0,0
Xsg13cmos5l_decap_8_1256 VPWR VGND sg13cmos5l_decap_8
* cell instance sg13cmos5l_decap_8_1257 r0 *1 0,0
Xsg13cmos5l_decap_8_1257 VPWR VGND sg13cmos5l_decap_8
* cell instance sg13cmos5l_decap_8_1258 r0 *1 0,0
Xsg13cmos5l_decap_8_1258 VPWR VGND sg13cmos5l_decap_8
* cell instance sg13cmos5l_decap_8_1259 r0 *1 0,0
Xsg13cmos5l_decap_8_1259 VPWR VGND sg13cmos5l_decap_8
* cell instance sg13cmos5l_decap_8_1260 r0 *1 0,0
Xsg13cmos5l_decap_8_1260 VPWR VGND sg13cmos5l_decap_8
* cell instance sg13cmos5l_decap_8_1261 r0 *1 0,0
Xsg13cmos5l_decap_8_1261 VPWR VGND sg13cmos5l_decap_8
* cell instance sg13cmos5l_decap_8_1262 r0 *1 0,0
Xsg13cmos5l_decap_8_1262 VPWR VGND sg13cmos5l_decap_8
* cell instance sg13cmos5l_decap_8_1263 r0 *1 0,0
Xsg13cmos5l_decap_8_1263 VPWR VGND sg13cmos5l_decap_8
* cell instance sg13cmos5l_decap_8_1264 r0 *1 0,0
Xsg13cmos5l_decap_8_1264 VPWR VGND sg13cmos5l_decap_8
* cell instance sg13cmos5l_decap_8_1265 r0 *1 0,0
Xsg13cmos5l_decap_8_1265 VPWR VGND sg13cmos5l_decap_8
* cell instance sg13cmos5l_decap_8_1266 r0 *1 0,0
Xsg13cmos5l_decap_8_1266 VPWR VGND sg13cmos5l_decap_8
* cell instance sg13cmos5l_decap_8_1267 r0 *1 0,0
Xsg13cmos5l_decap_8_1267 VPWR VGND sg13cmos5l_decap_8
* cell instance sg13cmos5l_decap_8_1268 r0 *1 0,0
Xsg13cmos5l_decap_8_1268 VPWR VGND sg13cmos5l_decap_8
* cell instance sg13cmos5l_decap_8_1269 r0 *1 0,0
Xsg13cmos5l_decap_8_1269 VPWR VGND sg13cmos5l_decap_8
* cell instance sg13cmos5l_decap_8_1270 r0 *1 0,0
Xsg13cmos5l_decap_8_1270 VPWR VGND sg13cmos5l_decap_8
* cell instance sg13cmos5l_decap_8_1271 r0 *1 0,0
Xsg13cmos5l_decap_8_1271 VPWR VGND sg13cmos5l_decap_8
* cell instance sg13cmos5l_decap_8_1272 r0 *1 0,0
Xsg13cmos5l_decap_8_1272 VPWR VGND sg13cmos5l_decap_8
* cell instance sg13cmos5l_decap_8_1273 r0 *1 0,0
Xsg13cmos5l_decap_8_1273 VPWR VGND sg13cmos5l_decap_8
* cell instance sg13cmos5l_decap_8_1274 r0 *1 0,0
Xsg13cmos5l_decap_8_1274 VPWR VGND sg13cmos5l_decap_8
* cell instance sg13cmos5l_decap_8_1275 r0 *1 0,0
Xsg13cmos5l_decap_8_1275 VPWR VGND sg13cmos5l_decap_8
* cell instance sg13cmos5l_decap_8_1276 r0 *1 0,0
Xsg13cmos5l_decap_8_1276 VPWR VGND sg13cmos5l_decap_8
* cell instance sg13cmos5l_decap_8_1277 r0 *1 0,0
Xsg13cmos5l_decap_8_1277 VPWR VGND sg13cmos5l_decap_8
* cell instance sg13cmos5l_decap_8_1278 r0 *1 0,0
Xsg13cmos5l_decap_8_1278 VPWR VGND sg13cmos5l_decap_8
* cell instance sg13cmos5l_decap_8_1279 r0 *1 0,0
Xsg13cmos5l_decap_8_1279 VPWR VGND sg13cmos5l_decap_8
* cell instance sg13cmos5l_decap_8_1280 r0 *1 0,0
Xsg13cmos5l_decap_8_1280 VPWR VGND sg13cmos5l_decap_8
* cell instance sg13cmos5l_decap_8_1281 r0 *1 0,0
Xsg13cmos5l_decap_8_1281 VPWR VGND sg13cmos5l_decap_8
* cell instance sg13cmos5l_decap_8_1282 r0 *1 0,0
Xsg13cmos5l_decap_8_1282 VPWR VGND sg13cmos5l_decap_8
* cell instance sg13cmos5l_decap_8_1283 r0 *1 0,0
Xsg13cmos5l_decap_8_1283 VPWR VGND sg13cmos5l_decap_8
* cell instance sg13cmos5l_decap_8_1284 r0 *1 0,0
Xsg13cmos5l_decap_8_1284 VPWR VGND sg13cmos5l_decap_8
* cell instance sg13cmos5l_decap_8_1285 r0 *1 0,0
Xsg13cmos5l_decap_8_1285 VPWR VGND sg13cmos5l_decap_8
* cell instance sg13cmos5l_decap_8_1286 r0 *1 0,0
Xsg13cmos5l_decap_8_1286 VPWR VGND sg13cmos5l_decap_8
* cell instance sg13cmos5l_decap_8_1287 r0 *1 0,0
Xsg13cmos5l_decap_8_1287 VPWR VGND sg13cmos5l_decap_8
* cell instance sg13cmos5l_decap_8_1288 r0 *1 0,0
Xsg13cmos5l_decap_8_1288 VPWR VGND sg13cmos5l_decap_8
* cell instance sg13cmos5l_decap_8_1289 r0 *1 0,0
Xsg13cmos5l_decap_8_1289 VPWR VGND sg13cmos5l_decap_8
* cell instance sg13cmos5l_decap_8_1290 r0 *1 0,0
Xsg13cmos5l_decap_8_1290 VPWR VGND sg13cmos5l_decap_8
* cell instance sg13cmos5l_decap_8_1291 r0 *1 0,0
Xsg13cmos5l_decap_8_1291 VPWR VGND sg13cmos5l_decap_8
* cell instance sg13cmos5l_decap_8_1292 r0 *1 0,0
Xsg13cmos5l_decap_8_1292 VPWR VGND sg13cmos5l_decap_8
* cell instance sg13cmos5l_decap_8_1293 r0 *1 0,0
Xsg13cmos5l_decap_8_1293 VPWR VGND sg13cmos5l_decap_8
* cell instance sg13cmos5l_decap_8_1294 r0 *1 0,0
Xsg13cmos5l_decap_8_1294 VPWR VGND sg13cmos5l_decap_8
* cell instance sg13cmos5l_decap_8_1295 r0 *1 0,0
Xsg13cmos5l_decap_8_1295 VPWR VGND sg13cmos5l_decap_8
* cell instance sg13cmos5l_decap_8_1296 r0 *1 0,0
Xsg13cmos5l_decap_8_1296 VPWR VGND sg13cmos5l_decap_8
* cell instance sg13cmos5l_decap_8_1297 r0 *1 0,0
Xsg13cmos5l_decap_8_1297 VPWR VGND sg13cmos5l_decap_8
* cell instance sg13cmos5l_decap_8_1298 r0 *1 0,0
Xsg13cmos5l_decap_8_1298 VPWR VGND sg13cmos5l_decap_8
* cell instance sg13cmos5l_decap_8_1299 r0 *1 0,0
Xsg13cmos5l_decap_8_1299 VPWR VGND sg13cmos5l_decap_8
* cell instance sg13cmos5l_decap_8_1300 r0 *1 0,0
Xsg13cmos5l_decap_8_1300 VPWR VGND sg13cmos5l_decap_8
* cell instance sg13cmos5l_decap_8_1301 r0 *1 0,0
Xsg13cmos5l_decap_8_1301 VPWR VGND sg13cmos5l_decap_8
* cell instance sg13cmos5l_decap_8_1302 r0 *1 0,0
Xsg13cmos5l_decap_8_1302 VPWR VGND sg13cmos5l_decap_8
* cell instance sg13cmos5l_decap_8_1303 r0 *1 0,0
Xsg13cmos5l_decap_8_1303 VPWR VGND sg13cmos5l_decap_8
* cell instance sg13cmos5l_decap_8_1304 r0 *1 0,0
Xsg13cmos5l_decap_8_1304 VPWR VGND sg13cmos5l_decap_8
* cell instance sg13cmos5l_decap_8_1305 r0 *1 0,0
Xsg13cmos5l_decap_8_1305 VPWR VGND sg13cmos5l_decap_8
* cell instance sg13cmos5l_decap_8_1306 r0 *1 0,0
Xsg13cmos5l_decap_8_1306 VPWR VGND sg13cmos5l_decap_8
* cell instance sg13cmos5l_decap_8_1307 r0 *1 0,0
Xsg13cmos5l_decap_8_1307 VPWR VGND sg13cmos5l_decap_8
* cell instance sg13cmos5l_decap_8_1308 r0 *1 0,0
Xsg13cmos5l_decap_8_1308 VPWR VGND sg13cmos5l_decap_8
* cell instance sg13cmos5l_decap_8_1309 r0 *1 0,0
Xsg13cmos5l_decap_8_1309 VPWR VGND sg13cmos5l_decap_8
* cell instance sg13cmos5l_decap_8_1310 r0 *1 0,0
Xsg13cmos5l_decap_8_1310 VPWR VGND sg13cmos5l_decap_8
* cell instance sg13cmos5l_decap_8_1311 r0 *1 0,0
Xsg13cmos5l_decap_8_1311 VPWR VGND sg13cmos5l_decap_8
* cell instance sg13cmos5l_decap_8_1312 r0 *1 0,0
Xsg13cmos5l_decap_8_1312 VPWR VGND sg13cmos5l_decap_8
* cell instance sg13cmos5l_decap_8_1313 r0 *1 0,0
Xsg13cmos5l_decap_8_1313 VPWR VGND sg13cmos5l_decap_8
* cell instance sg13cmos5l_decap_8_1314 r0 *1 0,0
Xsg13cmos5l_decap_8_1314 VPWR VGND sg13cmos5l_decap_8
* cell instance sg13cmos5l_decap_8_1315 r0 *1 0,0
Xsg13cmos5l_decap_8_1315 VPWR VGND sg13cmos5l_decap_8
* cell instance sg13cmos5l_decap_8_1316 r0 *1 0,0
Xsg13cmos5l_decap_8_1316 VPWR VGND sg13cmos5l_decap_8
* cell instance sg13cmos5l_decap_8_1317 r0 *1 0,0
Xsg13cmos5l_decap_8_1317 VPWR VGND sg13cmos5l_decap_8
* cell instance sg13cmos5l_decap_8_1318 r0 *1 0,0
Xsg13cmos5l_decap_8_1318 VPWR VGND sg13cmos5l_decap_8
* cell instance sg13cmos5l_decap_8_1319 r0 *1 0,0
Xsg13cmos5l_decap_8_1319 VPWR VGND sg13cmos5l_decap_8
* cell instance sg13cmos5l_decap_8_1320 r0 *1 0,0
Xsg13cmos5l_decap_8_1320 VPWR VGND sg13cmos5l_decap_8
* cell instance sg13cmos5l_decap_8_1321 r0 *1 0,0
Xsg13cmos5l_decap_8_1321 VPWR VGND sg13cmos5l_decap_8
* cell instance sg13cmos5l_decap_8_1322 r0 *1 0,0
Xsg13cmos5l_decap_8_1322 VPWR VGND sg13cmos5l_decap_8
* cell instance sg13cmos5l_decap_8_1323 r0 *1 0,0
Xsg13cmos5l_decap_8_1323 VPWR VGND sg13cmos5l_decap_8
* cell instance sg13cmos5l_decap_8_1324 r0 *1 0,0
Xsg13cmos5l_decap_8_1324 VPWR VGND sg13cmos5l_decap_8
* cell instance sg13cmos5l_decap_8_1325 r0 *1 0,0
Xsg13cmos5l_decap_8_1325 VPWR VGND sg13cmos5l_decap_8
* cell instance sg13cmos5l_decap_8_1326 r0 *1 0,0
Xsg13cmos5l_decap_8_1326 VPWR VGND sg13cmos5l_decap_8
* cell instance sg13cmos5l_decap_8_1327 r0 *1 0,0
Xsg13cmos5l_decap_8_1327 VPWR VGND sg13cmos5l_decap_8
* cell instance sg13cmos5l_decap_8_1328 r0 *1 0,0
Xsg13cmos5l_decap_8_1328 VPWR VGND sg13cmos5l_decap_8
* cell instance sg13cmos5l_decap_8_1329 r0 *1 0,0
Xsg13cmos5l_decap_8_1329 VPWR VGND sg13cmos5l_decap_8
* cell instance sg13cmos5l_decap_8_1330 r0 *1 0,0
Xsg13cmos5l_decap_8_1330 VPWR VGND sg13cmos5l_decap_8
* cell instance sg13cmos5l_decap_8_1331 r0 *1 0,0
Xsg13cmos5l_decap_8_1331 VPWR VGND sg13cmos5l_decap_8
* cell instance sg13cmos5l_decap_8_1332 r0 *1 0,0
Xsg13cmos5l_decap_8_1332 VPWR VGND sg13cmos5l_decap_8
* cell instance sg13cmos5l_decap_8_1333 r0 *1 0,0
Xsg13cmos5l_decap_8_1333 VPWR VGND sg13cmos5l_decap_8
* cell instance sg13cmos5l_decap_8_1334 r0 *1 0,0
Xsg13cmos5l_decap_8_1334 VPWR VGND sg13cmos5l_decap_8
* cell instance sg13cmos5l_decap_8_1335 r0 *1 0,0
Xsg13cmos5l_decap_8_1335 VPWR VGND sg13cmos5l_decap_8
* cell instance sg13cmos5l_decap_8_1336 r0 *1 0,0
Xsg13cmos5l_decap_8_1336 VPWR VGND sg13cmos5l_decap_8
* cell instance sg13cmos5l_decap_8_1337 r0 *1 0,0
Xsg13cmos5l_decap_8_1337 VPWR VGND sg13cmos5l_decap_8
* cell instance sg13cmos5l_decap_8_1338 r0 *1 0,0
Xsg13cmos5l_decap_8_1338 VPWR VGND sg13cmos5l_decap_8
* cell instance sg13cmos5l_decap_8_1339 r0 *1 0,0
Xsg13cmos5l_decap_8_1339 VPWR VGND sg13cmos5l_decap_8
* cell instance sg13cmos5l_decap_8_1340 r0 *1 0,0
Xsg13cmos5l_decap_8_1340 VPWR VGND sg13cmos5l_decap_8
* cell instance sg13cmos5l_decap_8_1341 r0 *1 0,0
Xsg13cmos5l_decap_8_1341 VPWR VGND sg13cmos5l_decap_8
* cell instance sg13cmos5l_decap_8_1342 r0 *1 0,0
Xsg13cmos5l_decap_8_1342 VPWR VGND sg13cmos5l_decap_8
* cell instance sg13cmos5l_decap_8_1343 r0 *1 0,0
Xsg13cmos5l_decap_8_1343 VPWR VGND sg13cmos5l_decap_8
* cell instance sg13cmos5l_decap_8_1344 r0 *1 0,0
Xsg13cmos5l_decap_8_1344 VPWR VGND sg13cmos5l_decap_8
* cell instance sg13cmos5l_decap_8_1345 r0 *1 0,0
Xsg13cmos5l_decap_8_1345 VPWR VGND sg13cmos5l_decap_8
* cell instance sg13cmos5l_decap_8_1346 r0 *1 0,0
Xsg13cmos5l_decap_8_1346 VPWR VGND sg13cmos5l_decap_8
* cell instance sg13cmos5l_decap_8_1347 r0 *1 0,0
Xsg13cmos5l_decap_8_1347 VPWR VGND sg13cmos5l_decap_8
* cell instance sg13cmos5l_decap_8_1348 r0 *1 0,0
Xsg13cmos5l_decap_8_1348 VPWR VGND sg13cmos5l_decap_8
* cell instance sg13cmos5l_decap_8_1349 r0 *1 0,0
Xsg13cmos5l_decap_8_1349 VPWR VGND sg13cmos5l_decap_8
* cell instance sg13cmos5l_decap_8_1350 r0 *1 0,0
Xsg13cmos5l_decap_8_1350 VPWR VGND sg13cmos5l_decap_8
* cell instance sg13cmos5l_decap_8_1351 r0 *1 0,0
Xsg13cmos5l_decap_8_1351 VPWR VGND sg13cmos5l_decap_8
* cell instance sg13cmos5l_decap_8_1352 r0 *1 0,0
Xsg13cmos5l_decap_8_1352 VPWR VGND sg13cmos5l_decap_8
* cell instance sg13cmos5l_decap_8_1353 r0 *1 0,0
Xsg13cmos5l_decap_8_1353 VPWR VGND sg13cmos5l_decap_8
* cell instance sg13cmos5l_decap_8_1354 r0 *1 0,0
Xsg13cmos5l_decap_8_1354 VPWR VGND sg13cmos5l_decap_8
* cell instance sg13cmos5l_decap_8_1355 r0 *1 0,0
Xsg13cmos5l_decap_8_1355 VPWR VGND sg13cmos5l_decap_8
* cell instance sg13cmos5l_decap_8_1356 r0 *1 0,0
Xsg13cmos5l_decap_8_1356 VPWR VGND sg13cmos5l_decap_8
* cell instance sg13cmos5l_decap_8_1357 r0 *1 0,0
Xsg13cmos5l_decap_8_1357 VPWR VGND sg13cmos5l_decap_8
* cell instance sg13cmos5l_decap_8_1358 r0 *1 0,0
Xsg13cmos5l_decap_8_1358 VPWR VGND sg13cmos5l_decap_8
* cell instance sg13cmos5l_decap_8_1359 r0 *1 0,0
Xsg13cmos5l_decap_8_1359 VPWR VGND sg13cmos5l_decap_8
* cell instance sg13cmos5l_decap_8_1360 r0 *1 0,0
Xsg13cmos5l_decap_8_1360 VPWR VGND sg13cmos5l_decap_8
* cell instance sg13cmos5l_decap_8_1361 r0 *1 0,0
Xsg13cmos5l_decap_8_1361 VPWR VGND sg13cmos5l_decap_8
* cell instance sg13cmos5l_decap_8_1362 r0 *1 0,0
Xsg13cmos5l_decap_8_1362 VPWR VGND sg13cmos5l_decap_8
* cell instance sg13cmos5l_decap_8_1363 r0 *1 0,0
Xsg13cmos5l_decap_8_1363 VPWR VGND sg13cmos5l_decap_8
* cell instance sg13cmos5l_decap_8_1364 r0 *1 0,0
Xsg13cmos5l_decap_8_1364 VPWR VGND sg13cmos5l_decap_8
* cell instance sg13cmos5l_decap_8_1365 r0 *1 0,0
Xsg13cmos5l_decap_8_1365 VPWR VGND sg13cmos5l_decap_8
* cell instance sg13cmos5l_decap_8_1366 r0 *1 0,0
Xsg13cmos5l_decap_8_1366 VPWR VGND sg13cmos5l_decap_8
* cell instance sg13cmos5l_decap_8_1367 r0 *1 0,0
Xsg13cmos5l_decap_8_1367 VPWR VGND sg13cmos5l_decap_8
* cell instance sg13cmos5l_decap_8_1368 r0 *1 0,0
Xsg13cmos5l_decap_8_1368 VPWR VGND sg13cmos5l_decap_8
* cell instance sg13cmos5l_decap_8_1369 r0 *1 0,0
Xsg13cmos5l_decap_8_1369 VPWR VGND sg13cmos5l_decap_8
* cell instance sg13cmos5l_decap_8_1370 r0 *1 0,0
Xsg13cmos5l_decap_8_1370 VPWR VGND sg13cmos5l_decap_8
* cell instance sg13cmos5l_decap_8_1371 r0 *1 0,0
Xsg13cmos5l_decap_8_1371 VPWR VGND sg13cmos5l_decap_8
* cell instance sg13cmos5l_decap_8_1372 r0 *1 0,0
Xsg13cmos5l_decap_8_1372 VPWR VGND sg13cmos5l_decap_8
* cell instance sg13cmos5l_decap_8_1373 r0 *1 0,0
Xsg13cmos5l_decap_8_1373 VPWR VGND sg13cmos5l_decap_8
* cell instance sg13cmos5l_decap_8_1374 r0 *1 0,0
Xsg13cmos5l_decap_8_1374 VPWR VGND sg13cmos5l_decap_8
* cell instance sg13cmos5l_decap_8_1375 r0 *1 0,0
Xsg13cmos5l_decap_8_1375 VPWR VGND sg13cmos5l_decap_8
* cell instance sg13cmos5l_decap_8_1376 r0 *1 0,0
Xsg13cmos5l_decap_8_1376 VPWR VGND sg13cmos5l_decap_8
* cell instance sg13cmos5l_decap_8_1377 r0 *1 0,0
Xsg13cmos5l_decap_8_1377 VPWR VGND sg13cmos5l_decap_8
* cell instance sg13cmos5l_decap_8_1378 r0 *1 0,0
Xsg13cmos5l_decap_8_1378 VPWR VGND sg13cmos5l_decap_8
* cell instance sg13cmos5l_decap_8_1379 r0 *1 0,0
Xsg13cmos5l_decap_8_1379 VPWR VGND sg13cmos5l_decap_8
* cell instance sg13cmos5l_decap_8_1380 r0 *1 0,0
Xsg13cmos5l_decap_8_1380 VPWR VGND sg13cmos5l_decap_8
* cell instance sg13cmos5l_decap_8_1381 r0 *1 0,0
Xsg13cmos5l_decap_8_1381 VPWR VGND sg13cmos5l_decap_8
* cell instance sg13cmos5l_decap_8_1382 r0 *1 0,0
Xsg13cmos5l_decap_8_1382 VPWR VGND sg13cmos5l_decap_8
* cell instance sg13cmos5l_decap_8_1383 r0 *1 0,0
Xsg13cmos5l_decap_8_1383 VPWR VGND sg13cmos5l_decap_8
* cell instance sg13cmos5l_decap_8_1384 r0 *1 0,0
Xsg13cmos5l_decap_8_1384 VPWR VGND sg13cmos5l_decap_8
* cell instance sg13cmos5l_decap_8_1385 r0 *1 0,0
Xsg13cmos5l_decap_8_1385 VPWR VGND sg13cmos5l_decap_8
* cell instance sg13cmos5l_decap_8_1386 r0 *1 0,0
Xsg13cmos5l_decap_8_1386 VPWR VGND sg13cmos5l_decap_8
* cell instance sg13cmos5l_decap_8_1387 r0 *1 0,0
Xsg13cmos5l_decap_8_1387 VPWR VGND sg13cmos5l_decap_8
* cell instance sg13cmos5l_decap_8_1388 r0 *1 0,0
Xsg13cmos5l_decap_8_1388 VPWR VGND sg13cmos5l_decap_8
* cell instance sg13cmos5l_decap_8_1389 r0 *1 0,0
Xsg13cmos5l_decap_8_1389 VPWR VGND sg13cmos5l_decap_8
* cell instance sg13cmos5l_decap_8_1390 r0 *1 0,0
Xsg13cmos5l_decap_8_1390 VPWR VGND sg13cmos5l_decap_8
* cell instance sg13cmos5l_decap_8_1391 r0 *1 0,0
Xsg13cmos5l_decap_8_1391 VPWR VGND sg13cmos5l_decap_8
* cell instance sg13cmos5l_decap_8_1392 r0 *1 0,0
Xsg13cmos5l_decap_8_1392 VPWR VGND sg13cmos5l_decap_8
* cell instance sg13cmos5l_decap_8_1393 r0 *1 0,0
Xsg13cmos5l_decap_8_1393 VPWR VGND sg13cmos5l_decap_8
* cell instance sg13cmos5l_decap_8_1394 r0 *1 0,0
Xsg13cmos5l_decap_8_1394 VPWR VGND sg13cmos5l_decap_8
* cell instance sg13cmos5l_decap_8_1395 r0 *1 0,0
Xsg13cmos5l_decap_8_1395 VPWR VGND sg13cmos5l_decap_8
* cell instance sg13cmos5l_decap_8_1396 r0 *1 0,0
Xsg13cmos5l_decap_8_1396 VPWR VGND sg13cmos5l_decap_8
* cell instance sg13cmos5l_decap_8_1397 r0 *1 0,0
Xsg13cmos5l_decap_8_1397 VPWR VGND sg13cmos5l_decap_8
* cell instance sg13cmos5l_decap_8_1398 r0 *1 0,0
Xsg13cmos5l_decap_8_1398 VPWR VGND sg13cmos5l_decap_8
* cell instance sg13cmos5l_decap_8_1399 r0 *1 0,0
Xsg13cmos5l_decap_8_1399 VPWR VGND sg13cmos5l_decap_8
* cell instance sg13cmos5l_decap_8_1400 r0 *1 0,0
Xsg13cmos5l_decap_8_1400 VPWR VGND sg13cmos5l_decap_8
* cell instance sg13cmos5l_decap_8_1401 r0 *1 0,0
Xsg13cmos5l_decap_8_1401 VPWR VGND sg13cmos5l_decap_8
* cell instance sg13cmos5l_decap_8_1402 r0 *1 0,0
Xsg13cmos5l_decap_8_1402 VPWR VGND sg13cmos5l_decap_8
* cell instance sg13cmos5l_decap_8_1403 r0 *1 0,0
Xsg13cmos5l_decap_8_1403 VPWR VGND sg13cmos5l_decap_8
* cell instance sg13cmos5l_decap_8_1404 r0 *1 0,0
Xsg13cmos5l_decap_8_1404 VPWR VGND sg13cmos5l_decap_8
* cell instance sg13cmos5l_decap_8_1405 r0 *1 0,0
Xsg13cmos5l_decap_8_1405 VPWR VGND sg13cmos5l_decap_8
* cell instance sg13cmos5l_decap_8_1406 r0 *1 0,0
Xsg13cmos5l_decap_8_1406 VPWR VGND sg13cmos5l_decap_8
* cell instance sg13cmos5l_decap_8_1407 r0 *1 0,0
Xsg13cmos5l_decap_8_1407 VPWR VGND sg13cmos5l_decap_8
* cell instance sg13cmos5l_decap_8_1408 r0 *1 0,0
Xsg13cmos5l_decap_8_1408 VPWR VGND sg13cmos5l_decap_8
* cell instance sg13cmos5l_decap_8_1409 r0 *1 0,0
Xsg13cmos5l_decap_8_1409 VPWR VGND sg13cmos5l_decap_8
* cell instance sg13cmos5l_decap_8_1410 r0 *1 0,0
Xsg13cmos5l_decap_8_1410 VPWR VGND sg13cmos5l_decap_8
* cell instance sg13cmos5l_decap_8_1411 r0 *1 0,0
Xsg13cmos5l_decap_8_1411 VPWR VGND sg13cmos5l_decap_8
* cell instance sg13cmos5l_decap_8_1412 r0 *1 0,0
Xsg13cmos5l_decap_8_1412 VPWR VGND sg13cmos5l_decap_8
* cell instance sg13cmos5l_decap_8_1413 r0 *1 0,0
Xsg13cmos5l_decap_8_1413 VPWR VGND sg13cmos5l_decap_8
* cell instance sg13cmos5l_decap_8_1414 r0 *1 0,0
Xsg13cmos5l_decap_8_1414 VPWR VGND sg13cmos5l_decap_8
* cell instance sg13cmos5l_decap_8_1415 r0 *1 0,0
Xsg13cmos5l_decap_8_1415 VPWR VGND sg13cmos5l_decap_8
* cell instance sg13cmos5l_decap_8_1416 r0 *1 0,0
Xsg13cmos5l_decap_8_1416 VPWR VGND sg13cmos5l_decap_8
* cell instance sg13cmos5l_decap_8_1417 r0 *1 0,0
Xsg13cmos5l_decap_8_1417 VPWR VGND sg13cmos5l_decap_8
* cell instance sg13cmos5l_decap_8_1418 r0 *1 0,0
Xsg13cmos5l_decap_8_1418 VPWR VGND sg13cmos5l_decap_8
* cell instance sg13cmos5l_decap_8_1419 r0 *1 0,0
Xsg13cmos5l_decap_8_1419 VPWR VGND sg13cmos5l_decap_8
* cell instance sg13cmos5l_decap_8_1420 r0 *1 0,0
Xsg13cmos5l_decap_8_1420 VPWR VGND sg13cmos5l_decap_8
* cell instance sg13cmos5l_decap_8_1421 r0 *1 0,0
Xsg13cmos5l_decap_8_1421 VPWR VGND sg13cmos5l_decap_8
* cell instance sg13cmos5l_decap_8_1422 r0 *1 0,0
Xsg13cmos5l_decap_8_1422 VPWR VGND sg13cmos5l_decap_8
* cell instance sg13cmos5l_decap_8_1423 r0 *1 0,0
Xsg13cmos5l_decap_8_1423 VPWR VGND sg13cmos5l_decap_8
* cell instance sg13cmos5l_decap_8_1424 r0 *1 0,0
Xsg13cmos5l_decap_8_1424 VPWR VGND sg13cmos5l_decap_8
* cell instance sg13cmos5l_decap_8_1425 r0 *1 0,0
Xsg13cmos5l_decap_8_1425 VPWR VGND sg13cmos5l_decap_8
* cell instance sg13cmos5l_decap_8_1426 r0 *1 0,0
Xsg13cmos5l_decap_8_1426 VPWR VGND sg13cmos5l_decap_8
* cell instance sg13cmos5l_decap_8_1427 r0 *1 0,0
Xsg13cmos5l_decap_8_1427 VPWR VGND sg13cmos5l_decap_8
* cell instance sg13cmos5l_decap_8_1428 r0 *1 0,0
Xsg13cmos5l_decap_8_1428 VPWR VGND sg13cmos5l_decap_8
* cell instance sg13cmos5l_decap_8_1429 r0 *1 0,0
Xsg13cmos5l_decap_8_1429 VPWR VGND sg13cmos5l_decap_8
* cell instance sg13cmos5l_decap_8_1430 r0 *1 0,0
Xsg13cmos5l_decap_8_1430 VPWR VGND sg13cmos5l_decap_8
* cell instance sg13cmos5l_decap_8_1431 r0 *1 0,0
Xsg13cmos5l_decap_8_1431 VPWR VGND sg13cmos5l_decap_8
* cell instance sg13cmos5l_decap_8_1432 r0 *1 0,0
Xsg13cmos5l_decap_8_1432 VPWR VGND sg13cmos5l_decap_8
* cell instance sg13cmos5l_decap_8_1433 r0 *1 0,0
Xsg13cmos5l_decap_8_1433 VPWR VGND sg13cmos5l_decap_8
* cell instance sg13cmos5l_decap_8_1434 r0 *1 0,0
Xsg13cmos5l_decap_8_1434 VPWR VGND sg13cmos5l_decap_8
* cell instance sg13cmos5l_decap_8_1435 r0 *1 0,0
Xsg13cmos5l_decap_8_1435 VPWR VGND sg13cmos5l_decap_8
* cell instance sg13cmos5l_decap_8_1436 r0 *1 0,0
Xsg13cmos5l_decap_8_1436 VPWR VGND sg13cmos5l_decap_8
* cell instance sg13cmos5l_decap_8_1437 r0 *1 0,0
Xsg13cmos5l_decap_8_1437 VPWR VGND sg13cmos5l_decap_8
* cell instance sg13cmos5l_decap_8_1438 r0 *1 0,0
Xsg13cmos5l_decap_8_1438 VPWR VGND sg13cmos5l_decap_8
* cell instance sg13cmos5l_decap_8_1439 r0 *1 0,0
Xsg13cmos5l_decap_8_1439 VPWR VGND sg13cmos5l_decap_8
* cell instance sg13cmos5l_decap_8_1440 r0 *1 0,0
Xsg13cmos5l_decap_8_1440 VPWR VGND sg13cmos5l_decap_8
* cell instance sg13cmos5l_decap_8_1441 r0 *1 0,0
Xsg13cmos5l_decap_8_1441 VPWR VGND sg13cmos5l_decap_8
* cell instance sg13cmos5l_decap_8_1442 r0 *1 0,0
Xsg13cmos5l_decap_8_1442 VPWR VGND sg13cmos5l_decap_8
* cell instance sg13cmos5l_decap_8_1443 r0 *1 0,0
Xsg13cmos5l_decap_8_1443 VPWR VGND sg13cmos5l_decap_8
* cell instance sg13cmos5l_decap_8_1444 r0 *1 0,0
Xsg13cmos5l_decap_8_1444 VPWR VGND sg13cmos5l_decap_8
* cell instance sg13cmos5l_decap_8_1445 r0 *1 0,0
Xsg13cmos5l_decap_8_1445 VPWR VGND sg13cmos5l_decap_8
* cell instance sg13cmos5l_decap_8_1446 r0 *1 0,0
Xsg13cmos5l_decap_8_1446 VPWR VGND sg13cmos5l_decap_8
* cell instance sg13cmos5l_decap_8_1447 r0 *1 0,0
Xsg13cmos5l_decap_8_1447 VPWR VGND sg13cmos5l_decap_8
* cell instance sg13cmos5l_decap_8_1448 r0 *1 0,0
Xsg13cmos5l_decap_8_1448 VPWR VGND sg13cmos5l_decap_8
* cell instance sg13cmos5l_decap_8_1449 r0 *1 0,0
Xsg13cmos5l_decap_8_1449 VPWR VGND sg13cmos5l_decap_8
* cell instance sg13cmos5l_decap_8_1450 r0 *1 0,0
Xsg13cmos5l_decap_8_1450 VPWR VGND sg13cmos5l_decap_8
* cell instance sg13cmos5l_decap_8_1451 r0 *1 0,0
Xsg13cmos5l_decap_8_1451 VPWR VGND sg13cmos5l_decap_8
* cell instance sg13cmos5l_decap_8_1452 r0 *1 0,0
Xsg13cmos5l_decap_8_1452 VPWR VGND sg13cmos5l_decap_8
* cell instance sg13cmos5l_decap_8_1453 r0 *1 0,0
Xsg13cmos5l_decap_8_1453 VPWR VGND sg13cmos5l_decap_8
* cell instance sg13cmos5l_decap_8_1454 r0 *1 0,0
Xsg13cmos5l_decap_8_1454 VPWR VGND sg13cmos5l_decap_8
* cell instance sg13cmos5l_decap_8_1455 r0 *1 0,0
Xsg13cmos5l_decap_8_1455 VPWR VGND sg13cmos5l_decap_8
* cell instance sg13cmos5l_decap_8_1456 r0 *1 0,0
Xsg13cmos5l_decap_8_1456 VPWR VGND sg13cmos5l_decap_8
* cell instance sg13cmos5l_decap_8_1457 r0 *1 0,0
Xsg13cmos5l_decap_8_1457 VPWR VGND sg13cmos5l_decap_8
* cell instance sg13cmos5l_decap_8_1458 r0 *1 0,0
Xsg13cmos5l_decap_8_1458 VPWR VGND sg13cmos5l_decap_8
* cell instance sg13cmos5l_decap_8_1459 r0 *1 0,0
Xsg13cmos5l_decap_8_1459 VPWR VGND sg13cmos5l_decap_8
* cell instance sg13cmos5l_decap_8_1460 r0 *1 0,0
Xsg13cmos5l_decap_8_1460 VPWR VGND sg13cmos5l_decap_8
* cell instance sg13cmos5l_decap_8_1461 r0 *1 0,0
Xsg13cmos5l_decap_8_1461 VPWR VGND sg13cmos5l_decap_8
* cell instance sg13cmos5l_decap_8_1462 r0 *1 0,0
Xsg13cmos5l_decap_8_1462 VPWR VGND sg13cmos5l_decap_8
* cell instance sg13cmos5l_decap_8_1463 r0 *1 0,0
Xsg13cmos5l_decap_8_1463 VPWR VGND sg13cmos5l_decap_8
* cell instance sg13cmos5l_decap_8_1464 r0 *1 0,0
Xsg13cmos5l_decap_8_1464 VPWR VGND sg13cmos5l_decap_8
* cell instance sg13cmos5l_decap_8_1465 r0 *1 0,0
Xsg13cmos5l_decap_8_1465 VPWR VGND sg13cmos5l_decap_8
* cell instance sg13cmos5l_decap_8_1466 r0 *1 0,0
Xsg13cmos5l_decap_8_1466 VPWR VGND sg13cmos5l_decap_8
* cell instance sg13cmos5l_decap_8_1467 r0 *1 0,0
Xsg13cmos5l_decap_8_1467 VPWR VGND sg13cmos5l_decap_8
* cell instance sg13cmos5l_decap_8_1468 r0 *1 0,0
Xsg13cmos5l_decap_8_1468 VPWR VGND sg13cmos5l_decap_8
* cell instance sg13cmos5l_decap_8_1469 r0 *1 0,0
Xsg13cmos5l_decap_8_1469 VPWR VGND sg13cmos5l_decap_8
* cell instance sg13cmos5l_decap_8_1470 r0 *1 0,0
Xsg13cmos5l_decap_8_1470 VPWR VGND sg13cmos5l_decap_8
* cell instance sg13cmos5l_decap_8_1471 r0 *1 0,0
Xsg13cmos5l_decap_8_1471 VPWR VGND sg13cmos5l_decap_8
* cell instance sg13cmos5l_decap_8_1472 r0 *1 0,0
Xsg13cmos5l_decap_8_1472 VPWR VGND sg13cmos5l_decap_8
* cell instance sg13cmos5l_decap_8_1473 r0 *1 0,0
Xsg13cmos5l_decap_8_1473 VPWR VGND sg13cmos5l_decap_8
* cell instance sg13cmos5l_decap_8_1474 r0 *1 0,0
Xsg13cmos5l_decap_8_1474 VPWR VGND sg13cmos5l_decap_8
* cell instance sg13cmos5l_decap_8_1475 r0 *1 0,0
Xsg13cmos5l_decap_8_1475 VPWR VGND sg13cmos5l_decap_8
* cell instance sg13cmos5l_decap_8_1476 r0 *1 0,0
Xsg13cmos5l_decap_8_1476 VPWR VGND sg13cmos5l_decap_8
* cell instance sg13cmos5l_decap_8_1477 r0 *1 0,0
Xsg13cmos5l_decap_8_1477 VPWR VGND sg13cmos5l_decap_8
* cell instance sg13cmos5l_decap_8_1478 r0 *1 0,0
Xsg13cmos5l_decap_8_1478 VPWR VGND sg13cmos5l_decap_8
* cell instance sg13cmos5l_decap_8_1479 r0 *1 0,0
Xsg13cmos5l_decap_8_1479 VPWR VGND sg13cmos5l_decap_8
* cell instance sg13cmos5l_decap_8_1480 r0 *1 0,0
Xsg13cmos5l_decap_8_1480 VPWR VGND sg13cmos5l_decap_8
* cell instance sg13cmos5l_decap_8_1481 r0 *1 0,0
Xsg13cmos5l_decap_8_1481 VPWR VGND sg13cmos5l_decap_8
* cell instance sg13cmos5l_decap_8_1482 r0 *1 0,0
Xsg13cmos5l_decap_8_1482 VPWR VGND sg13cmos5l_decap_8
* cell instance sg13cmos5l_decap_8_1483 r0 *1 0,0
Xsg13cmos5l_decap_8_1483 VPWR VGND sg13cmos5l_decap_8
* cell instance sg13cmos5l_decap_8_1484 r0 *1 0,0
Xsg13cmos5l_decap_8_1484 VPWR VGND sg13cmos5l_decap_8
* cell instance sg13cmos5l_decap_8_1485 r0 *1 0,0
Xsg13cmos5l_decap_8_1485 VPWR VGND sg13cmos5l_decap_8
* cell instance sg13cmos5l_decap_8_1486 r0 *1 0,0
Xsg13cmos5l_decap_8_1486 VPWR VGND sg13cmos5l_decap_8
* cell instance sg13cmos5l_decap_8_1487 r0 *1 0,0
Xsg13cmos5l_decap_8_1487 VPWR VGND sg13cmos5l_decap_8
* cell instance sg13cmos5l_decap_8_1488 r0 *1 0,0
Xsg13cmos5l_decap_8_1488 VPWR VGND sg13cmos5l_decap_8
* cell instance sg13cmos5l_decap_8_1489 r0 *1 0,0
Xsg13cmos5l_decap_8_1489 VPWR VGND sg13cmos5l_decap_8
* cell instance sg13cmos5l_decap_8_1490 r0 *1 0,0
Xsg13cmos5l_decap_8_1490 VPWR VGND sg13cmos5l_decap_8
* cell instance sg13cmos5l_decap_8_1491 r0 *1 0,0
Xsg13cmos5l_decap_8_1491 VPWR VGND sg13cmos5l_decap_8
* cell instance sg13cmos5l_decap_8_1492 r0 *1 0,0
Xsg13cmos5l_decap_8_1492 VPWR VGND sg13cmos5l_decap_8
* cell instance sg13cmos5l_decap_8_1493 r0 *1 0,0
Xsg13cmos5l_decap_8_1493 VPWR VGND sg13cmos5l_decap_8
* cell instance sg13cmos5l_decap_8_1494 r0 *1 0,0
Xsg13cmos5l_decap_8_1494 VPWR VGND sg13cmos5l_decap_8
* cell instance sg13cmos5l_decap_8_1495 r0 *1 0,0
Xsg13cmos5l_decap_8_1495 VPWR VGND sg13cmos5l_decap_8
* cell instance sg13cmos5l_decap_8_1496 r0 *1 0,0
Xsg13cmos5l_decap_8_1496 VPWR VGND sg13cmos5l_decap_8
* cell instance sg13cmos5l_decap_8_1497 r0 *1 0,0
Xsg13cmos5l_decap_8_1497 VPWR VGND sg13cmos5l_decap_8
* cell instance sg13cmos5l_decap_8_1498 r0 *1 0,0
Xsg13cmos5l_decap_8_1498 VPWR VGND sg13cmos5l_decap_8
* cell instance sg13cmos5l_decap_8_1499 r0 *1 0,0
Xsg13cmos5l_decap_8_1499 VPWR VGND sg13cmos5l_decap_8
* cell instance sg13cmos5l_decap_8_1500 r0 *1 0,0
Xsg13cmos5l_decap_8_1500 VPWR VGND sg13cmos5l_decap_8
* cell instance sg13cmos5l_decap_8_1501 r0 *1 0,0
Xsg13cmos5l_decap_8_1501 VPWR VGND sg13cmos5l_decap_8
* cell instance sg13cmos5l_decap_8_1502 r0 *1 0,0
Xsg13cmos5l_decap_8_1502 VPWR VGND sg13cmos5l_decap_8
* cell instance sg13cmos5l_decap_8_1503 r0 *1 0,0
Xsg13cmos5l_decap_8_1503 VPWR VGND sg13cmos5l_decap_8
* cell instance sg13cmos5l_decap_8_1504 r0 *1 0,0
Xsg13cmos5l_decap_8_1504 VPWR VGND sg13cmos5l_decap_8
* cell instance sg13cmos5l_decap_8_1505 r0 *1 0,0
Xsg13cmos5l_decap_8_1505 VPWR VGND sg13cmos5l_decap_8
* cell instance sg13cmos5l_decap_8_1506 r0 *1 0,0
Xsg13cmos5l_decap_8_1506 VPWR VGND sg13cmos5l_decap_8
* cell instance sg13cmos5l_decap_8_1507 r0 *1 0,0
Xsg13cmos5l_decap_8_1507 VPWR VGND sg13cmos5l_decap_8
* cell instance sg13cmos5l_decap_8_1508 r0 *1 0,0
Xsg13cmos5l_decap_8_1508 VPWR VGND sg13cmos5l_decap_8
* cell instance sg13cmos5l_decap_8_1509 r0 *1 0,0
Xsg13cmos5l_decap_8_1509 VPWR VGND sg13cmos5l_decap_8
* cell instance sg13cmos5l_decap_8_1510 r0 *1 0,0
Xsg13cmos5l_decap_8_1510 VPWR VGND sg13cmos5l_decap_8
* cell instance sg13cmos5l_decap_8_1511 r0 *1 0,0
Xsg13cmos5l_decap_8_1511 VPWR VGND sg13cmos5l_decap_8
* cell instance sg13cmos5l_decap_8_1512 r0 *1 0,0
Xsg13cmos5l_decap_8_1512 VPWR VGND sg13cmos5l_decap_8
* cell instance sg13cmos5l_decap_8_1513 r0 *1 0,0
Xsg13cmos5l_decap_8_1513 VPWR VGND sg13cmos5l_decap_8
* cell instance sg13cmos5l_decap_8_1514 r0 *1 0,0
Xsg13cmos5l_decap_8_1514 VPWR VGND sg13cmos5l_decap_8
* cell instance sg13cmos5l_decap_8_1515 r0 *1 0,0
Xsg13cmos5l_decap_8_1515 VPWR VGND sg13cmos5l_decap_8
* cell instance sg13cmos5l_decap_8_1516 r0 *1 0,0
Xsg13cmos5l_decap_8_1516 VPWR VGND sg13cmos5l_decap_8
* cell instance sg13cmos5l_decap_8_1517 r0 *1 0,0
Xsg13cmos5l_decap_8_1517 VPWR VGND sg13cmos5l_decap_8
* cell instance sg13cmos5l_decap_8_1518 r0 *1 0,0
Xsg13cmos5l_decap_8_1518 VPWR VGND sg13cmos5l_decap_8
* cell instance sg13cmos5l_decap_8_1519 r0 *1 0,0
Xsg13cmos5l_decap_8_1519 VPWR VGND sg13cmos5l_decap_8
* cell instance sg13cmos5l_decap_8_1520 r0 *1 0,0
Xsg13cmos5l_decap_8_1520 VPWR VGND sg13cmos5l_decap_8
* cell instance sg13cmos5l_decap_8_1521 r0 *1 0,0
Xsg13cmos5l_decap_8_1521 VPWR VGND sg13cmos5l_decap_8
* cell instance sg13cmos5l_decap_8_1522 r0 *1 0,0
Xsg13cmos5l_decap_8_1522 VPWR VGND sg13cmos5l_decap_8
* cell instance sg13cmos5l_decap_8_1523 r0 *1 0,0
Xsg13cmos5l_decap_8_1523 VPWR VGND sg13cmos5l_decap_8
* cell instance sg13cmos5l_decap_8_1524 r0 *1 0,0
Xsg13cmos5l_decap_8_1524 VPWR VGND sg13cmos5l_decap_8
* cell instance sg13cmos5l_decap_8_1525 r0 *1 0,0
Xsg13cmos5l_decap_8_1525 VPWR VGND sg13cmos5l_decap_8
* cell instance sg13cmos5l_decap_8_1526 r0 *1 0,0
Xsg13cmos5l_decap_8_1526 VPWR VGND sg13cmos5l_decap_8
* cell instance sg13cmos5l_decap_8_1527 r0 *1 0,0
Xsg13cmos5l_decap_8_1527 VPWR VGND sg13cmos5l_decap_8
* cell instance sg13cmos5l_decap_8_1528 r0 *1 0,0
Xsg13cmos5l_decap_8_1528 VPWR VGND sg13cmos5l_decap_8
* cell instance sg13cmos5l_decap_8_1529 r0 *1 0,0
Xsg13cmos5l_decap_8_1529 VPWR VGND sg13cmos5l_decap_8
* cell instance sg13cmos5l_decap_8_1530 r0 *1 0,0
Xsg13cmos5l_decap_8_1530 VPWR VGND sg13cmos5l_decap_8
* cell instance sg13cmos5l_decap_8_1531 r0 *1 0,0
Xsg13cmos5l_decap_8_1531 VPWR VGND sg13cmos5l_decap_8
* cell instance sg13cmos5l_decap_8_1532 r0 *1 0,0
Xsg13cmos5l_decap_8_1532 VPWR VGND sg13cmos5l_decap_8
* cell instance sg13cmos5l_decap_8_1533 r0 *1 0,0
Xsg13cmos5l_decap_8_1533 VPWR VGND sg13cmos5l_decap_8
* cell instance sg13cmos5l_decap_8_1534 r0 *1 0,0
Xsg13cmos5l_decap_8_1534 VPWR VGND sg13cmos5l_decap_8
* cell instance sg13cmos5l_decap_8_1535 r0 *1 0,0
Xsg13cmos5l_decap_8_1535 VPWR VGND sg13cmos5l_decap_8
* cell instance sg13cmos5l_decap_8_1536 r0 *1 0,0
Xsg13cmos5l_decap_8_1536 VPWR VGND sg13cmos5l_decap_8
* cell instance sg13cmos5l_decap_8_1537 r0 *1 0,0
Xsg13cmos5l_decap_8_1537 VPWR VGND sg13cmos5l_decap_8
* cell instance sg13cmos5l_decap_8_1538 r0 *1 0,0
Xsg13cmos5l_decap_8_1538 VPWR VGND sg13cmos5l_decap_8
* cell instance sg13cmos5l_decap_8_1539 r0 *1 0,0
Xsg13cmos5l_decap_8_1539 VPWR VGND sg13cmos5l_decap_8
* cell instance sg13cmos5l_decap_8_1540 r0 *1 0,0
Xsg13cmos5l_decap_8_1540 VPWR VGND sg13cmos5l_decap_8
* cell instance sg13cmos5l_decap_8_1541 r0 *1 0,0
Xsg13cmos5l_decap_8_1541 VPWR VGND sg13cmos5l_decap_8
* cell instance sg13cmos5l_decap_8_1542 r0 *1 0,0
Xsg13cmos5l_decap_8_1542 VPWR VGND sg13cmos5l_decap_8
* cell instance sg13cmos5l_decap_8_1543 r0 *1 0,0
Xsg13cmos5l_decap_8_1543 VPWR VGND sg13cmos5l_decap_8
* cell instance sg13cmos5l_decap_8_1544 r0 *1 0,0
Xsg13cmos5l_decap_8_1544 VPWR VGND sg13cmos5l_decap_8
* cell instance sg13cmos5l_decap_8_1545 r0 *1 0,0
Xsg13cmos5l_decap_8_1545 VPWR VGND sg13cmos5l_decap_8
* cell instance sg13cmos5l_decap_8_1546 r0 *1 0,0
Xsg13cmos5l_decap_8_1546 VPWR VGND sg13cmos5l_decap_8
* cell instance sg13cmos5l_decap_8_1547 r0 *1 0,0
Xsg13cmos5l_decap_8_1547 VPWR VGND sg13cmos5l_decap_8
* cell instance sg13cmos5l_decap_8_1548 r0 *1 0,0
Xsg13cmos5l_decap_8_1548 VPWR VGND sg13cmos5l_decap_8
* cell instance sg13cmos5l_decap_8_1549 r0 *1 0,0
Xsg13cmos5l_decap_8_1549 VPWR VGND sg13cmos5l_decap_8
* cell instance sg13cmos5l_decap_8_1550 r0 *1 0,0
Xsg13cmos5l_decap_8_1550 VPWR VGND sg13cmos5l_decap_8
* cell instance sg13cmos5l_decap_8_1551 r0 *1 0,0
Xsg13cmos5l_decap_8_1551 VPWR VGND sg13cmos5l_decap_8
* cell instance sg13cmos5l_decap_8_1552 r0 *1 0,0
Xsg13cmos5l_decap_8_1552 VPWR VGND sg13cmos5l_decap_8
* cell instance sg13cmos5l_decap_8_1553 r0 *1 0,0
Xsg13cmos5l_decap_8_1553 VPWR VGND sg13cmos5l_decap_8
* cell instance sg13cmos5l_decap_8_1554 r0 *1 0,0
Xsg13cmos5l_decap_8_1554 VPWR VGND sg13cmos5l_decap_8
* cell instance sg13cmos5l_decap_8_1555 r0 *1 0,0
Xsg13cmos5l_decap_8_1555 VPWR VGND sg13cmos5l_decap_8
* cell instance sg13cmos5l_decap_8_1556 r0 *1 0,0
Xsg13cmos5l_decap_8_1556 VPWR VGND sg13cmos5l_decap_8
* cell instance sg13cmos5l_decap_8_1557 r0 *1 0,0
Xsg13cmos5l_decap_8_1557 VPWR VGND sg13cmos5l_decap_8
* cell instance sg13cmos5l_decap_8_1558 r0 *1 0,0
Xsg13cmos5l_decap_8_1558 VPWR VGND sg13cmos5l_decap_8
* cell instance sg13cmos5l_decap_8_1559 r0 *1 0,0
Xsg13cmos5l_decap_8_1559 VPWR VGND sg13cmos5l_decap_8
* cell instance sg13cmos5l_decap_8_1560 r0 *1 0,0
Xsg13cmos5l_decap_8_1560 VPWR VGND sg13cmos5l_decap_8
* cell instance sg13cmos5l_decap_8_1561 r0 *1 0,0
Xsg13cmos5l_decap_8_1561 VPWR VGND sg13cmos5l_decap_8
* cell instance sg13cmos5l_decap_8_1562 r0 *1 0,0
Xsg13cmos5l_decap_8_1562 VPWR VGND sg13cmos5l_decap_8
* cell instance sg13cmos5l_decap_8_1563 r0 *1 0,0
Xsg13cmos5l_decap_8_1563 VPWR VGND sg13cmos5l_decap_8
* cell instance sg13cmos5l_decap_8_1564 r0 *1 0,0
Xsg13cmos5l_decap_8_1564 VPWR VGND sg13cmos5l_decap_8
* cell instance sg13cmos5l_decap_8_1565 r0 *1 0,0
Xsg13cmos5l_decap_8_1565 VPWR VGND sg13cmos5l_decap_8
* cell instance sg13cmos5l_decap_8_1566 r0 *1 0,0
Xsg13cmos5l_decap_8_1566 VPWR VGND sg13cmos5l_decap_8
* cell instance sg13cmos5l_decap_8_1567 r0 *1 0,0
Xsg13cmos5l_decap_8_1567 VPWR VGND sg13cmos5l_decap_8
* cell instance sg13cmos5l_decap_8_1568 r0 *1 0,0
Xsg13cmos5l_decap_8_1568 VPWR VGND sg13cmos5l_decap_8
* cell instance sg13cmos5l_decap_8_1569 r0 *1 0,0
Xsg13cmos5l_decap_8_1569 VPWR VGND sg13cmos5l_decap_8
* cell instance sg13cmos5l_decap_8_1570 r0 *1 0,0
Xsg13cmos5l_decap_8_1570 VPWR VGND sg13cmos5l_decap_8
* cell instance sg13cmos5l_decap_8_1571 r0 *1 0,0
Xsg13cmos5l_decap_8_1571 VPWR VGND sg13cmos5l_decap_8
* cell instance sg13cmos5l_decap_8_1572 r0 *1 0,0
Xsg13cmos5l_decap_8_1572 VPWR VGND sg13cmos5l_decap_8
* cell instance sg13cmos5l_decap_8_1573 r0 *1 0,0
Xsg13cmos5l_decap_8_1573 VPWR VGND sg13cmos5l_decap_8
* cell instance sg13cmos5l_decap_8_1574 r0 *1 0,0
Xsg13cmos5l_decap_8_1574 VPWR VGND sg13cmos5l_decap_8
* cell instance sg13cmos5l_decap_8_1575 r0 *1 0,0
Xsg13cmos5l_decap_8_1575 VPWR VGND sg13cmos5l_decap_8
* cell instance sg13cmos5l_decap_8_1576 r0 *1 0,0
Xsg13cmos5l_decap_8_1576 VPWR VGND sg13cmos5l_decap_8
* cell instance sg13cmos5l_decap_8_1577 r0 *1 0,0
Xsg13cmos5l_decap_8_1577 VPWR VGND sg13cmos5l_decap_8
* cell instance sg13cmos5l_decap_8_1578 r0 *1 0,0
Xsg13cmos5l_decap_8_1578 VPWR VGND sg13cmos5l_decap_8
* cell instance sg13cmos5l_decap_8_1579 r0 *1 0,0
Xsg13cmos5l_decap_8_1579 VPWR VGND sg13cmos5l_decap_8
* cell instance sg13cmos5l_decap_8_1580 r0 *1 0,0
Xsg13cmos5l_decap_8_1580 VPWR VGND sg13cmos5l_decap_8
* cell instance sg13cmos5l_decap_8_1581 r0 *1 0,0
Xsg13cmos5l_decap_8_1581 VPWR VGND sg13cmos5l_decap_8
* cell instance sg13cmos5l_decap_8_1582 r0 *1 0,0
Xsg13cmos5l_decap_8_1582 VPWR VGND sg13cmos5l_decap_8
* cell instance sg13cmos5l_decap_8_1583 r0 *1 0,0
Xsg13cmos5l_decap_8_1583 VPWR VGND sg13cmos5l_decap_8
* cell instance sg13cmos5l_decap_8_1584 r0 *1 0,0
Xsg13cmos5l_decap_8_1584 VPWR VGND sg13cmos5l_decap_8
* cell instance sg13cmos5l_decap_8_1585 r0 *1 0,0
Xsg13cmos5l_decap_8_1585 VPWR VGND sg13cmos5l_decap_8
* cell instance sg13cmos5l_decap_8_1586 r0 *1 0,0
Xsg13cmos5l_decap_8_1586 VPWR VGND sg13cmos5l_decap_8
* cell instance sg13cmos5l_decap_8_1587 r0 *1 0,0
Xsg13cmos5l_decap_8_1587 VPWR VGND sg13cmos5l_decap_8
* cell instance sg13cmos5l_decap_8_1588 r0 *1 0,0
Xsg13cmos5l_decap_8_1588 VPWR VGND sg13cmos5l_decap_8
* cell instance sg13cmos5l_decap_8_1589 r0 *1 0,0
Xsg13cmos5l_decap_8_1589 VPWR VGND sg13cmos5l_decap_8
* cell instance sg13cmos5l_decap_8_1590 r0 *1 0,0
Xsg13cmos5l_decap_8_1590 VPWR VGND sg13cmos5l_decap_8
* cell instance sg13cmos5l_decap_8_1591 r0 *1 0,0
Xsg13cmos5l_decap_8_1591 VPWR VGND sg13cmos5l_decap_8
* cell instance sg13cmos5l_decap_8_1592 r0 *1 0,0
Xsg13cmos5l_decap_8_1592 VPWR VGND sg13cmos5l_decap_8
* cell instance sg13cmos5l_decap_8_1593 r0 *1 0,0
Xsg13cmos5l_decap_8_1593 VPWR VGND sg13cmos5l_decap_8
* cell instance sg13cmos5l_decap_8_1594 r0 *1 0,0
Xsg13cmos5l_decap_8_1594 VPWR VGND sg13cmos5l_decap_8
* cell instance sg13cmos5l_decap_8_1595 r0 *1 0,0
Xsg13cmos5l_decap_8_1595 VPWR VGND sg13cmos5l_decap_8
* cell instance sg13cmos5l_decap_8_1596 r0 *1 0,0
Xsg13cmos5l_decap_8_1596 VPWR VGND sg13cmos5l_decap_8
* cell instance sg13cmos5l_decap_8_1597 r0 *1 0,0
Xsg13cmos5l_decap_8_1597 VPWR VGND sg13cmos5l_decap_8
* cell instance sg13cmos5l_decap_8_1598 r0 *1 0,0
Xsg13cmos5l_decap_8_1598 VPWR VGND sg13cmos5l_decap_8
* cell instance sg13cmos5l_decap_8_1599 r0 *1 0,0
Xsg13cmos5l_decap_8_1599 VPWR VGND sg13cmos5l_decap_8
* cell instance sg13cmos5l_decap_8_1600 r0 *1 0,0
Xsg13cmos5l_decap_8_1600 VPWR VGND sg13cmos5l_decap_8
* cell instance sg13cmos5l_decap_8_1601 r0 *1 0,0
Xsg13cmos5l_decap_8_1601 VPWR VGND sg13cmos5l_decap_8
* cell instance sg13cmos5l_decap_8_1602 r0 *1 0,0
Xsg13cmos5l_decap_8_1602 VPWR VGND sg13cmos5l_decap_8
* cell instance sg13cmos5l_decap_8_1603 r0 *1 0,0
Xsg13cmos5l_decap_8_1603 VPWR VGND sg13cmos5l_decap_8
* cell instance sg13cmos5l_decap_8_1604 r0 *1 0,0
Xsg13cmos5l_decap_8_1604 VPWR VGND sg13cmos5l_decap_8
* cell instance sg13cmos5l_decap_8_1605 r0 *1 0,0
Xsg13cmos5l_decap_8_1605 VPWR VGND sg13cmos5l_decap_8
* cell instance sg13cmos5l_decap_8_1606 r0 *1 0,0
Xsg13cmos5l_decap_8_1606 VPWR VGND sg13cmos5l_decap_8
* cell instance sg13cmos5l_decap_8_1607 r0 *1 0,0
Xsg13cmos5l_decap_8_1607 VPWR VGND sg13cmos5l_decap_8
* cell instance sg13cmos5l_decap_8_1608 r0 *1 0,0
Xsg13cmos5l_decap_8_1608 VPWR VGND sg13cmos5l_decap_8
* cell instance sg13cmos5l_decap_8_1609 r0 *1 0,0
Xsg13cmos5l_decap_8_1609 VPWR VGND sg13cmos5l_decap_8
* cell instance sg13cmos5l_decap_8_1610 r0 *1 0,0
Xsg13cmos5l_decap_8_1610 VPWR VGND sg13cmos5l_decap_8
* cell instance sg13cmos5l_decap_8_1611 r0 *1 0,0
Xsg13cmos5l_decap_8_1611 VPWR VGND sg13cmos5l_decap_8
* cell instance sg13cmos5l_decap_8_1612 r0 *1 0,0
Xsg13cmos5l_decap_8_1612 VPWR VGND sg13cmos5l_decap_8
* cell instance sg13cmos5l_decap_8_1613 r0 *1 0,0
Xsg13cmos5l_decap_8_1613 VPWR VGND sg13cmos5l_decap_8
* cell instance sg13cmos5l_decap_8_1614 r0 *1 0,0
Xsg13cmos5l_decap_8_1614 VPWR VGND sg13cmos5l_decap_8
* cell instance sg13cmos5l_decap_8_1615 r0 *1 0,0
Xsg13cmos5l_decap_8_1615 VPWR VGND sg13cmos5l_decap_8
* cell instance sg13cmos5l_decap_8_1616 r0 *1 0,0
Xsg13cmos5l_decap_8_1616 VPWR VGND sg13cmos5l_decap_8
* cell instance sg13cmos5l_decap_8_1617 r0 *1 0,0
Xsg13cmos5l_decap_8_1617 VPWR VGND sg13cmos5l_decap_8
* cell instance sg13cmos5l_decap_8_1618 r0 *1 0,0
Xsg13cmos5l_decap_8_1618 VPWR VGND sg13cmos5l_decap_8
* cell instance sg13cmos5l_decap_8_1619 r0 *1 0,0
Xsg13cmos5l_decap_8_1619 VPWR VGND sg13cmos5l_decap_8
* cell instance sg13cmos5l_decap_8_1620 r0 *1 0,0
Xsg13cmos5l_decap_8_1620 VPWR VGND sg13cmos5l_decap_8
* cell instance sg13cmos5l_decap_8_1621 r0 *1 0,0
Xsg13cmos5l_decap_8_1621 VPWR VGND sg13cmos5l_decap_8
* cell instance sg13cmos5l_decap_8_1622 r0 *1 0,0
Xsg13cmos5l_decap_8_1622 VPWR VGND sg13cmos5l_decap_8
* cell instance sg13cmos5l_decap_8_1623 r0 *1 0,0
Xsg13cmos5l_decap_8_1623 VPWR VGND sg13cmos5l_decap_8
* cell instance sg13cmos5l_decap_8_1624 r0 *1 0,0
Xsg13cmos5l_decap_8_1624 VPWR VGND sg13cmos5l_decap_8
* cell instance sg13cmos5l_decap_8_1625 r0 *1 0,0
Xsg13cmos5l_decap_8_1625 VPWR VGND sg13cmos5l_decap_8
* cell instance sg13cmos5l_decap_8_1626 r0 *1 0,0
Xsg13cmos5l_decap_8_1626 VPWR VGND sg13cmos5l_decap_8
* cell instance sg13cmos5l_decap_8_1627 r0 *1 0,0
Xsg13cmos5l_decap_8_1627 VPWR VGND sg13cmos5l_decap_8
* cell instance sg13cmos5l_decap_8_1628 r0 *1 0,0
Xsg13cmos5l_decap_8_1628 VPWR VGND sg13cmos5l_decap_8
* cell instance sg13cmos5l_decap_8_1629 r0 *1 0,0
Xsg13cmos5l_decap_8_1629 VPWR VGND sg13cmos5l_decap_8
* cell instance sg13cmos5l_decap_8_1630 r0 *1 0,0
Xsg13cmos5l_decap_8_1630 VPWR VGND sg13cmos5l_decap_8
* cell instance sg13cmos5l_decap_8_1631 r0 *1 0,0
Xsg13cmos5l_decap_8_1631 VPWR VGND sg13cmos5l_decap_8
* cell instance sg13cmos5l_decap_8_1632 r0 *1 0,0
Xsg13cmos5l_decap_8_1632 VPWR VGND sg13cmos5l_decap_8
* cell instance sg13cmos5l_decap_8_1633 r0 *1 0,0
Xsg13cmos5l_decap_8_1633 VPWR VGND sg13cmos5l_decap_8
* cell instance sg13cmos5l_decap_8_1634 r0 *1 0,0
Xsg13cmos5l_decap_8_1634 VPWR VGND sg13cmos5l_decap_8
* cell instance sg13cmos5l_decap_8_1635 r0 *1 0,0
Xsg13cmos5l_decap_8_1635 VPWR VGND sg13cmos5l_decap_8
* cell instance sg13cmos5l_decap_8_1636 r0 *1 0,0
Xsg13cmos5l_decap_8_1636 VPWR VGND sg13cmos5l_decap_8
* cell instance sg13cmos5l_decap_8_1637 r0 *1 0,0
Xsg13cmos5l_decap_8_1637 VPWR VGND sg13cmos5l_decap_8
* cell instance sg13cmos5l_decap_8_1638 r0 *1 0,0
Xsg13cmos5l_decap_8_1638 VPWR VGND sg13cmos5l_decap_8
* cell instance sg13cmos5l_decap_8_1639 r0 *1 0,0
Xsg13cmos5l_decap_8_1639 VPWR VGND sg13cmos5l_decap_8
* cell instance sg13cmos5l_decap_8_1640 r0 *1 0,0
Xsg13cmos5l_decap_8_1640 VPWR VGND sg13cmos5l_decap_8
* cell instance sg13cmos5l_decap_8_1641 r0 *1 0,0
Xsg13cmos5l_decap_8_1641 VPWR VGND sg13cmos5l_decap_8
* cell instance sg13cmos5l_decap_8_1642 r0 *1 0,0
Xsg13cmos5l_decap_8_1642 VPWR VGND sg13cmos5l_decap_8
* cell instance sg13cmos5l_decap_8_1643 r0 *1 0,0
Xsg13cmos5l_decap_8_1643 VPWR VGND sg13cmos5l_decap_8
* cell instance sg13cmos5l_decap_8_1644 r0 *1 0,0
Xsg13cmos5l_decap_8_1644 VPWR VGND sg13cmos5l_decap_8
* cell instance sg13cmos5l_decap_8_1645 r0 *1 0,0
Xsg13cmos5l_decap_8_1645 VPWR VGND sg13cmos5l_decap_8
* cell instance sg13cmos5l_decap_8_1646 r0 *1 0,0
Xsg13cmos5l_decap_8_1646 VPWR VGND sg13cmos5l_decap_8
* cell instance sg13cmos5l_decap_8_1647 r0 *1 0,0
Xsg13cmos5l_decap_8_1647 VPWR VGND sg13cmos5l_decap_8
* cell instance sg13cmos5l_decap_8_1648 r0 *1 0,0
Xsg13cmos5l_decap_8_1648 VPWR VGND sg13cmos5l_decap_8
* cell instance sg13cmos5l_decap_8_1649 r0 *1 0,0
Xsg13cmos5l_decap_8_1649 VPWR VGND sg13cmos5l_decap_8
* cell instance sg13cmos5l_decap_8_1650 r0 *1 0,0
Xsg13cmos5l_decap_8_1650 VPWR VGND sg13cmos5l_decap_8
* cell instance sg13cmos5l_decap_8_1651 r0 *1 0,0
Xsg13cmos5l_decap_8_1651 VPWR VGND sg13cmos5l_decap_8
* cell instance sg13cmos5l_decap_8_1652 r0 *1 0,0
Xsg13cmos5l_decap_8_1652 VPWR VGND sg13cmos5l_decap_8
* cell instance sg13cmos5l_decap_8_1653 r0 *1 0,0
Xsg13cmos5l_decap_8_1653 VPWR VGND sg13cmos5l_decap_8
* cell instance sg13cmos5l_decap_8_1654 r0 *1 0,0
Xsg13cmos5l_decap_8_1654 VPWR VGND sg13cmos5l_decap_8
* cell instance sg13cmos5l_decap_8_1655 r0 *1 0,0
Xsg13cmos5l_decap_8_1655 VPWR VGND sg13cmos5l_decap_8
* cell instance sg13cmos5l_decap_8_1656 r0 *1 0,0
Xsg13cmos5l_decap_8_1656 VPWR VGND sg13cmos5l_decap_8
* cell instance sg13cmos5l_decap_8_1657 r0 *1 0,0
Xsg13cmos5l_decap_8_1657 VPWR VGND sg13cmos5l_decap_8
* cell instance sg13cmos5l_decap_8_1658 r0 *1 0,0
Xsg13cmos5l_decap_8_1658 VPWR VGND sg13cmos5l_decap_8
* cell instance sg13cmos5l_decap_8_1659 r0 *1 0,0
Xsg13cmos5l_decap_8_1659 VPWR VGND sg13cmos5l_decap_8
* cell instance sg13cmos5l_decap_8_1660 r0 *1 0,0
Xsg13cmos5l_decap_8_1660 VPWR VGND sg13cmos5l_decap_8
* cell instance sg13cmos5l_decap_8_1661 r0 *1 0,0
Xsg13cmos5l_decap_8_1661 VPWR VGND sg13cmos5l_decap_8
* cell instance sg13cmos5l_decap_8_1662 r0 *1 0,0
Xsg13cmos5l_decap_8_1662 VPWR VGND sg13cmos5l_decap_8
* cell instance sg13cmos5l_decap_8_1663 r0 *1 0,0
Xsg13cmos5l_decap_8_1663 VPWR VGND sg13cmos5l_decap_8
* cell instance sg13cmos5l_decap_8_1664 r0 *1 0,0
Xsg13cmos5l_decap_8_1664 VPWR VGND sg13cmos5l_decap_8
* cell instance sg13cmos5l_decap_8_1665 r0 *1 0,0
Xsg13cmos5l_decap_8_1665 VPWR VGND sg13cmos5l_decap_8
* cell instance sg13cmos5l_decap_8_1666 r0 *1 0,0
Xsg13cmos5l_decap_8_1666 VPWR VGND sg13cmos5l_decap_8
* cell instance sg13cmos5l_decap_8_1667 r0 *1 0,0
Xsg13cmos5l_decap_8_1667 VPWR VGND sg13cmos5l_decap_8
* cell instance sg13cmos5l_decap_8_1668 r0 *1 0,0
Xsg13cmos5l_decap_8_1668 VPWR VGND sg13cmos5l_decap_8
* cell instance sg13cmos5l_decap_8_1669 r0 *1 0,0
Xsg13cmos5l_decap_8_1669 VPWR VGND sg13cmos5l_decap_8
* cell instance sg13cmos5l_decap_8_1670 r0 *1 0,0
Xsg13cmos5l_decap_8_1670 VPWR VGND sg13cmos5l_decap_8
* cell instance sg13cmos5l_decap_8_1671 r0 *1 0,0
Xsg13cmos5l_decap_8_1671 VPWR VGND sg13cmos5l_decap_8
* cell instance sg13cmos5l_decap_8_1672 r0 *1 0,0
Xsg13cmos5l_decap_8_1672 VPWR VGND sg13cmos5l_decap_8
* cell instance sg13cmos5l_decap_8_1673 r0 *1 0,0
Xsg13cmos5l_decap_8_1673 VPWR VGND sg13cmos5l_decap_8
* cell instance sg13cmos5l_decap_8_1674 r0 *1 0,0
Xsg13cmos5l_decap_8_1674 VPWR VGND sg13cmos5l_decap_8
* cell instance sg13cmos5l_decap_8_1675 r0 *1 0,0
Xsg13cmos5l_decap_8_1675 VPWR VGND sg13cmos5l_decap_8
* cell instance sg13cmos5l_decap_8_1676 r0 *1 0,0
Xsg13cmos5l_decap_8_1676 VPWR VGND sg13cmos5l_decap_8
* cell instance sg13cmos5l_decap_8_1677 r0 *1 0,0
Xsg13cmos5l_decap_8_1677 VPWR VGND sg13cmos5l_decap_8
* cell instance sg13cmos5l_decap_8_1678 r0 *1 0,0
Xsg13cmos5l_decap_8_1678 VPWR VGND sg13cmos5l_decap_8
* cell instance sg13cmos5l_decap_8_1679 r0 *1 0,0
Xsg13cmos5l_decap_8_1679 VPWR VGND sg13cmos5l_decap_8
* cell instance sg13cmos5l_decap_8_1680 r0 *1 0,0
Xsg13cmos5l_decap_8_1680 VPWR VGND sg13cmos5l_decap_8
* cell instance sg13cmos5l_decap_8_1681 r0 *1 0,0
Xsg13cmos5l_decap_8_1681 VPWR VGND sg13cmos5l_decap_8
* cell instance sg13cmos5l_decap_8_1682 r0 *1 0,0
Xsg13cmos5l_decap_8_1682 VPWR VGND sg13cmos5l_decap_8
* cell instance sg13cmos5l_decap_8_1683 r0 *1 0,0
Xsg13cmos5l_decap_8_1683 VPWR VGND sg13cmos5l_decap_8
* cell instance sg13cmos5l_decap_8_1684 r0 *1 0,0
Xsg13cmos5l_decap_8_1684 VPWR VGND sg13cmos5l_decap_8
* cell instance sg13cmos5l_decap_8_1685 r0 *1 0,0
Xsg13cmos5l_decap_8_1685 VPWR VGND sg13cmos5l_decap_8
* cell instance sg13cmos5l_decap_8_1686 r0 *1 0,0
Xsg13cmos5l_decap_8_1686 VPWR VGND sg13cmos5l_decap_8
* cell instance sg13cmos5l_decap_8_1687 r0 *1 0,0
Xsg13cmos5l_decap_8_1687 VPWR VGND sg13cmos5l_decap_8
* cell instance sg13cmos5l_decap_8_1688 r0 *1 0,0
Xsg13cmos5l_decap_8_1688 VPWR VGND sg13cmos5l_decap_8
* cell instance sg13cmos5l_decap_8_1689 r0 *1 0,0
Xsg13cmos5l_decap_8_1689 VPWR VGND sg13cmos5l_decap_8
* cell instance sg13cmos5l_decap_8_1690 r0 *1 0,0
Xsg13cmos5l_decap_8_1690 VPWR VGND sg13cmos5l_decap_8
* cell instance sg13cmos5l_decap_8_1691 r0 *1 0,0
Xsg13cmos5l_decap_8_1691 VPWR VGND sg13cmos5l_decap_8
* cell instance sg13cmos5l_decap_8_1692 r0 *1 0,0
Xsg13cmos5l_decap_8_1692 VPWR VGND sg13cmos5l_decap_8
* cell instance sg13cmos5l_decap_8_1693 r0 *1 0,0
Xsg13cmos5l_decap_8_1693 VPWR VGND sg13cmos5l_decap_8
* cell instance sg13cmos5l_decap_8_1694 r0 *1 0,0
Xsg13cmos5l_decap_8_1694 VPWR VGND sg13cmos5l_decap_8
* cell instance sg13cmos5l_decap_8_1695 r0 *1 0,0
Xsg13cmos5l_decap_8_1695 VPWR VGND sg13cmos5l_decap_8
* cell instance sg13cmos5l_decap_8_1696 r0 *1 0,0
Xsg13cmos5l_decap_8_1696 VPWR VGND sg13cmos5l_decap_8
* cell instance sg13cmos5l_decap_8_1697 r0 *1 0,0
Xsg13cmos5l_decap_8_1697 VPWR VGND sg13cmos5l_decap_8
* cell instance sg13cmos5l_decap_8_1698 r0 *1 0,0
Xsg13cmos5l_decap_8_1698 VPWR VGND sg13cmos5l_decap_8
* cell instance sg13cmos5l_decap_8_1699 r0 *1 0,0
Xsg13cmos5l_decap_8_1699 VPWR VGND sg13cmos5l_decap_8
* cell instance sg13cmos5l_decap_8_1700 r0 *1 0,0
Xsg13cmos5l_decap_8_1700 VPWR VGND sg13cmos5l_decap_8
* cell instance sg13cmos5l_decap_8_1701 r0 *1 0,0
Xsg13cmos5l_decap_8_1701 VPWR VGND sg13cmos5l_decap_8
* cell instance sg13cmos5l_decap_8_1702 r0 *1 0,0
Xsg13cmos5l_decap_8_1702 VPWR VGND sg13cmos5l_decap_8
* cell instance sg13cmos5l_decap_8_1703 r0 *1 0,0
Xsg13cmos5l_decap_8_1703 VPWR VGND sg13cmos5l_decap_8
* cell instance sg13cmos5l_decap_8_1704 r0 *1 0,0
Xsg13cmos5l_decap_8_1704 VPWR VGND sg13cmos5l_decap_8
* cell instance sg13cmos5l_decap_8_1705 r0 *1 0,0
Xsg13cmos5l_decap_8_1705 VPWR VGND sg13cmos5l_decap_8
* cell instance sg13cmos5l_decap_8_1706 r0 *1 0,0
Xsg13cmos5l_decap_8_1706 VPWR VGND sg13cmos5l_decap_8
* cell instance sg13cmos5l_decap_8_1707 r0 *1 0,0
Xsg13cmos5l_decap_8_1707 VPWR VGND sg13cmos5l_decap_8
* cell instance sg13cmos5l_decap_8_1708 r0 *1 0,0
Xsg13cmos5l_decap_8_1708 VPWR VGND sg13cmos5l_decap_8
* cell instance sg13cmos5l_decap_8_1709 r0 *1 0,0
Xsg13cmos5l_decap_8_1709 VPWR VGND sg13cmos5l_decap_8
* cell instance sg13cmos5l_decap_8_1710 r0 *1 0,0
Xsg13cmos5l_decap_8_1710 VPWR VGND sg13cmos5l_decap_8
* cell instance sg13cmos5l_decap_8_1711 r0 *1 0,0
Xsg13cmos5l_decap_8_1711 VPWR VGND sg13cmos5l_decap_8
* cell instance sg13cmos5l_decap_8_1712 r0 *1 0,0
Xsg13cmos5l_decap_8_1712 VPWR VGND sg13cmos5l_decap_8
* cell instance sg13cmos5l_decap_8_1713 r0 *1 0,0
Xsg13cmos5l_decap_8_1713 VPWR VGND sg13cmos5l_decap_8
* cell instance sg13cmos5l_decap_8_1714 r0 *1 0,0
Xsg13cmos5l_decap_8_1714 VPWR VGND sg13cmos5l_decap_8
* cell instance sg13cmos5l_decap_8_1715 r0 *1 0,0
Xsg13cmos5l_decap_8_1715 VPWR VGND sg13cmos5l_decap_8
* cell instance sg13cmos5l_decap_8_1716 r0 *1 0,0
Xsg13cmos5l_decap_8_1716 VPWR VGND sg13cmos5l_decap_8
* cell instance sg13cmos5l_decap_8_1717 r0 *1 0,0
Xsg13cmos5l_decap_8_1717 VPWR VGND sg13cmos5l_decap_8
* cell instance sg13cmos5l_decap_8_1718 r0 *1 0,0
Xsg13cmos5l_decap_8_1718 VPWR VGND sg13cmos5l_decap_8
* cell instance sg13cmos5l_decap_8_1719 r0 *1 0,0
Xsg13cmos5l_decap_8_1719 VPWR VGND sg13cmos5l_decap_8
* cell instance sg13cmos5l_decap_8_1720 r0 *1 0,0
Xsg13cmos5l_decap_8_1720 VPWR VGND sg13cmos5l_decap_8
* cell instance sg13cmos5l_decap_8_1721 r0 *1 0,0
Xsg13cmos5l_decap_8_1721 VPWR VGND sg13cmos5l_decap_8
* cell instance sg13cmos5l_decap_8_1722 r0 *1 0,0
Xsg13cmos5l_decap_8_1722 VPWR VGND sg13cmos5l_decap_8
* cell instance sg13cmos5l_decap_8_1723 r0 *1 0,0
Xsg13cmos5l_decap_8_1723 VPWR VGND sg13cmos5l_decap_8
* cell instance sg13cmos5l_decap_8_1724 r0 *1 0,0
Xsg13cmos5l_decap_8_1724 VPWR VGND sg13cmos5l_decap_8
* cell instance sg13cmos5l_decap_8_1725 r0 *1 0,0
Xsg13cmos5l_decap_8_1725 VPWR VGND sg13cmos5l_decap_8
* cell instance sg13cmos5l_decap_8_1726 r0 *1 0,0
Xsg13cmos5l_decap_8_1726 VPWR VGND sg13cmos5l_decap_8
* cell instance sg13cmos5l_decap_8_1727 r0 *1 0,0
Xsg13cmos5l_decap_8_1727 VPWR VGND sg13cmos5l_decap_8
* cell instance sg13cmos5l_decap_8_1728 r0 *1 0,0
Xsg13cmos5l_decap_8_1728 VPWR VGND sg13cmos5l_decap_8
* cell instance sg13cmos5l_decap_8_1729 r0 *1 0,0
Xsg13cmos5l_decap_8_1729 VPWR VGND sg13cmos5l_decap_8
* cell instance sg13cmos5l_decap_8_1730 r0 *1 0,0
Xsg13cmos5l_decap_8_1730 VPWR VGND sg13cmos5l_decap_8
* cell instance sg13cmos5l_decap_8_1731 r0 *1 0,0
Xsg13cmos5l_decap_8_1731 VPWR VGND sg13cmos5l_decap_8
* cell instance sg13cmos5l_decap_8_1732 r0 *1 0,0
Xsg13cmos5l_decap_8_1732 VPWR VGND sg13cmos5l_decap_8
* cell instance sg13cmos5l_decap_8_1733 r0 *1 0,0
Xsg13cmos5l_decap_8_1733 VPWR VGND sg13cmos5l_decap_8
* cell instance sg13cmos5l_decap_8_1734 r0 *1 0,0
Xsg13cmos5l_decap_8_1734 VPWR VGND sg13cmos5l_decap_8
* cell instance sg13cmos5l_decap_8_1735 r0 *1 0,0
Xsg13cmos5l_decap_8_1735 VPWR VGND sg13cmos5l_decap_8
* cell instance sg13cmos5l_decap_8_1736 r0 *1 0,0
Xsg13cmos5l_decap_8_1736 VPWR VGND sg13cmos5l_decap_8
* cell instance sg13cmos5l_decap_8_1737 r0 *1 0,0
Xsg13cmos5l_decap_8_1737 VPWR VGND sg13cmos5l_decap_8
* cell instance sg13cmos5l_decap_8_1738 r0 *1 0,0
Xsg13cmos5l_decap_8_1738 VPWR VGND sg13cmos5l_decap_8
* cell instance sg13cmos5l_decap_8_1739 r0 *1 0,0
Xsg13cmos5l_decap_8_1739 VPWR VGND sg13cmos5l_decap_8
* cell instance sg13cmos5l_decap_8_1740 r0 *1 0,0
Xsg13cmos5l_decap_8_1740 VPWR VGND sg13cmos5l_decap_8
* cell instance sg13cmos5l_decap_8_1741 r0 *1 0,0
Xsg13cmos5l_decap_8_1741 VPWR VGND sg13cmos5l_decap_8
* cell instance sg13cmos5l_decap_8_1742 r0 *1 0,0
Xsg13cmos5l_decap_8_1742 VPWR VGND sg13cmos5l_decap_8
* cell instance sg13cmos5l_decap_8_1743 r0 *1 0,0
Xsg13cmos5l_decap_8_1743 VPWR VGND sg13cmos5l_decap_8
* cell instance sg13cmos5l_decap_8_1744 r0 *1 0,0
Xsg13cmos5l_decap_8_1744 VPWR VGND sg13cmos5l_decap_8
* cell instance sg13cmos5l_decap_8_1745 r0 *1 0,0
Xsg13cmos5l_decap_8_1745 VPWR VGND sg13cmos5l_decap_8
* cell instance sg13cmos5l_decap_8_1746 r0 *1 0,0
Xsg13cmos5l_decap_8_1746 VPWR VGND sg13cmos5l_decap_8
* cell instance sg13cmos5l_decap_8_1747 r0 *1 0,0
Xsg13cmos5l_decap_8_1747 VPWR VGND sg13cmos5l_decap_8
* cell instance sg13cmos5l_decap_8_1748 r0 *1 0,0
Xsg13cmos5l_decap_8_1748 VPWR VGND sg13cmos5l_decap_8
* cell instance sg13cmos5l_decap_8_1749 r0 *1 0,0
Xsg13cmos5l_decap_8_1749 VPWR VGND sg13cmos5l_decap_8
* cell instance sg13cmos5l_decap_8_1750 r0 *1 0,0
Xsg13cmos5l_decap_8_1750 VPWR VGND sg13cmos5l_decap_8
* cell instance sg13cmos5l_decap_8_1751 r0 *1 0,0
Xsg13cmos5l_decap_8_1751 VPWR VGND sg13cmos5l_decap_8
* cell instance sg13cmos5l_decap_8_1752 r0 *1 0,0
Xsg13cmos5l_decap_8_1752 VPWR VGND sg13cmos5l_decap_8
* cell instance sg13cmos5l_decap_8_1753 r0 *1 0,0
Xsg13cmos5l_decap_8_1753 VPWR VGND sg13cmos5l_decap_8
* cell instance sg13cmos5l_decap_8_1754 r0 *1 0,0
Xsg13cmos5l_decap_8_1754 VPWR VGND sg13cmos5l_decap_8
* cell instance sg13cmos5l_decap_8_1755 r0 *1 0,0
Xsg13cmos5l_decap_8_1755 VPWR VGND sg13cmos5l_decap_8
* cell instance sg13cmos5l_decap_8_1756 r0 *1 0,0
Xsg13cmos5l_decap_8_1756 VPWR VGND sg13cmos5l_decap_8
* cell instance sg13cmos5l_decap_8_1757 r0 *1 0,0
Xsg13cmos5l_decap_8_1757 VPWR VGND sg13cmos5l_decap_8
* cell instance sg13cmos5l_decap_8_1758 r0 *1 0,0
Xsg13cmos5l_decap_8_1758 VPWR VGND sg13cmos5l_decap_8
* cell instance sg13cmos5l_decap_8_1759 r0 *1 0,0
Xsg13cmos5l_decap_8_1759 VPWR VGND sg13cmos5l_decap_8
* cell instance sg13cmos5l_decap_8_1760 r0 *1 0,0
Xsg13cmos5l_decap_8_1760 VPWR VGND sg13cmos5l_decap_8
* cell instance sg13cmos5l_decap_8_1761 r0 *1 0,0
Xsg13cmos5l_decap_8_1761 VPWR VGND sg13cmos5l_decap_8
* cell instance sg13cmos5l_decap_8_1762 r0 *1 0,0
Xsg13cmos5l_decap_8_1762 VPWR VGND sg13cmos5l_decap_8
* cell instance sg13cmos5l_decap_8_1763 r0 *1 0,0
Xsg13cmos5l_decap_8_1763 VPWR VGND sg13cmos5l_decap_8
* cell instance sg13cmos5l_decap_8_1764 r0 *1 0,0
Xsg13cmos5l_decap_8_1764 VPWR VGND sg13cmos5l_decap_8
* cell instance sg13cmos5l_decap_8_1765 r0 *1 0,0
Xsg13cmos5l_decap_8_1765 VPWR VGND sg13cmos5l_decap_8
* cell instance sg13cmos5l_decap_8_1766 r0 *1 0,0
Xsg13cmos5l_decap_8_1766 VPWR VGND sg13cmos5l_decap_8
* cell instance sg13cmos5l_decap_8_1767 r0 *1 0,0
Xsg13cmos5l_decap_8_1767 VPWR VGND sg13cmos5l_decap_8
* cell instance sg13cmos5l_decap_8_1768 r0 *1 0,0
Xsg13cmos5l_decap_8_1768 VPWR VGND sg13cmos5l_decap_8
* cell instance sg13cmos5l_decap_8_1769 r0 *1 0,0
Xsg13cmos5l_decap_8_1769 VPWR VGND sg13cmos5l_decap_8
* cell instance sg13cmos5l_decap_8_1770 r0 *1 0,0
Xsg13cmos5l_decap_8_1770 VPWR VGND sg13cmos5l_decap_8
* cell instance sg13cmos5l_decap_8_1771 r0 *1 0,0
Xsg13cmos5l_decap_8_1771 VPWR VGND sg13cmos5l_decap_8
* cell instance sg13cmos5l_decap_8_1772 r0 *1 0,0
Xsg13cmos5l_decap_8_1772 VPWR VGND sg13cmos5l_decap_8
* cell instance sg13cmos5l_decap_8_1773 r0 *1 0,0
Xsg13cmos5l_decap_8_1773 VPWR VGND sg13cmos5l_decap_8
* cell instance sg13cmos5l_decap_8_1774 r0 *1 0,0
Xsg13cmos5l_decap_8_1774 VPWR VGND sg13cmos5l_decap_8
* cell instance sg13cmos5l_decap_8_1775 r0 *1 0,0
Xsg13cmos5l_decap_8_1775 VPWR VGND sg13cmos5l_decap_8
* cell instance sg13cmos5l_decap_8_1776 r0 *1 0,0
Xsg13cmos5l_decap_8_1776 VPWR VGND sg13cmos5l_decap_8
* cell instance sg13cmos5l_decap_8_1777 r0 *1 0,0
Xsg13cmos5l_decap_8_1777 VPWR VGND sg13cmos5l_decap_8
* cell instance sg13cmos5l_decap_8_1778 r0 *1 0,0
Xsg13cmos5l_decap_8_1778 VPWR VGND sg13cmos5l_decap_8
* cell instance sg13cmos5l_decap_8_1779 r0 *1 0,0
Xsg13cmos5l_decap_8_1779 VPWR VGND sg13cmos5l_decap_8
* cell instance sg13cmos5l_decap_8_1780 r0 *1 0,0
Xsg13cmos5l_decap_8_1780 VPWR VGND sg13cmos5l_decap_8
* cell instance sg13cmos5l_decap_8_1781 r0 *1 0,0
Xsg13cmos5l_decap_8_1781 VPWR VGND sg13cmos5l_decap_8
* cell instance sg13cmos5l_decap_8_1782 r0 *1 0,0
Xsg13cmos5l_decap_8_1782 VPWR VGND sg13cmos5l_decap_8
* cell instance sg13cmos5l_decap_8_1783 r0 *1 0,0
Xsg13cmos5l_decap_8_1783 VPWR VGND sg13cmos5l_decap_8
* cell instance sg13cmos5l_decap_8_1784 r0 *1 0,0
Xsg13cmos5l_decap_8_1784 VPWR VGND sg13cmos5l_decap_8
* cell instance sg13cmos5l_decap_8_1785 r0 *1 0,0
Xsg13cmos5l_decap_8_1785 VPWR VGND sg13cmos5l_decap_8
* cell instance sg13cmos5l_decap_8_1786 r0 *1 0,0
Xsg13cmos5l_decap_8_1786 VPWR VGND sg13cmos5l_decap_8
* cell instance sg13cmos5l_decap_8_1787 r0 *1 0,0
Xsg13cmos5l_decap_8_1787 VPWR VGND sg13cmos5l_decap_8
* cell instance sg13cmos5l_decap_8_1788 r0 *1 0,0
Xsg13cmos5l_decap_8_1788 VPWR VGND sg13cmos5l_decap_8
* cell instance sg13cmos5l_decap_8_1789 r0 *1 0,0
Xsg13cmos5l_decap_8_1789 VPWR VGND sg13cmos5l_decap_8
* cell instance sg13cmos5l_decap_8_1790 r0 *1 0,0
Xsg13cmos5l_decap_8_1790 VPWR VGND sg13cmos5l_decap_8
* cell instance sg13cmos5l_decap_8_1791 r0 *1 0,0
Xsg13cmos5l_decap_8_1791 VPWR VGND sg13cmos5l_decap_8
* cell instance sg13cmos5l_decap_8_1792 r0 *1 0,0
Xsg13cmos5l_decap_8_1792 VPWR VGND sg13cmos5l_decap_8
* cell instance sg13cmos5l_decap_8_1793 r0 *1 0,0
Xsg13cmos5l_decap_8_1793 VPWR VGND sg13cmos5l_decap_8
* cell instance sg13cmos5l_decap_8_1794 r0 *1 0,0
Xsg13cmos5l_decap_8_1794 VPWR VGND sg13cmos5l_decap_8
* cell instance sg13cmos5l_decap_8_1795 r0 *1 0,0
Xsg13cmos5l_decap_8_1795 VPWR VGND sg13cmos5l_decap_8
* cell instance sg13cmos5l_decap_8_1796 r0 *1 0,0
Xsg13cmos5l_decap_8_1796 VPWR VGND sg13cmos5l_decap_8
* cell instance sg13cmos5l_decap_8_1797 r0 *1 0,0
Xsg13cmos5l_decap_8_1797 VPWR VGND sg13cmos5l_decap_8
* cell instance sg13cmos5l_decap_8_1798 r0 *1 0,0
Xsg13cmos5l_decap_8_1798 VPWR VGND sg13cmos5l_decap_8
* cell instance sg13cmos5l_decap_8_1799 r0 *1 0,0
Xsg13cmos5l_decap_8_1799 VPWR VGND sg13cmos5l_decap_8
* cell instance sg13cmos5l_decap_8_1800 r0 *1 0,0
Xsg13cmos5l_decap_8_1800 VPWR VGND sg13cmos5l_decap_8
* cell instance sg13cmos5l_decap_8_1801 r0 *1 0,0
Xsg13cmos5l_decap_8_1801 VPWR VGND sg13cmos5l_decap_8
* cell instance sg13cmos5l_decap_8_1802 r0 *1 0,0
Xsg13cmos5l_decap_8_1802 VPWR VGND sg13cmos5l_decap_8
* cell instance sg13cmos5l_decap_8_1803 r0 *1 0,0
Xsg13cmos5l_decap_8_1803 VPWR VGND sg13cmos5l_decap_8
* cell instance sg13cmos5l_decap_8_1804 r0 *1 0,0
Xsg13cmos5l_decap_8_1804 VPWR VGND sg13cmos5l_decap_8
* cell instance sg13cmos5l_decap_8_1805 r0 *1 0,0
Xsg13cmos5l_decap_8_1805 VPWR VGND sg13cmos5l_decap_8
* cell instance sg13cmos5l_decap_8_1806 r0 *1 0,0
Xsg13cmos5l_decap_8_1806 VPWR VGND sg13cmos5l_decap_8
* cell instance sg13cmos5l_decap_8_1807 r0 *1 0,0
Xsg13cmos5l_decap_8_1807 VPWR VGND sg13cmos5l_decap_8
* cell instance sg13cmos5l_decap_8_1808 r0 *1 0,0
Xsg13cmos5l_decap_8_1808 VPWR VGND sg13cmos5l_decap_8
* cell instance sg13cmos5l_decap_8_1809 r0 *1 0,0
Xsg13cmos5l_decap_8_1809 VPWR VGND sg13cmos5l_decap_8
* cell instance sg13cmos5l_decap_8_1810 r0 *1 0,0
Xsg13cmos5l_decap_8_1810 VPWR VGND sg13cmos5l_decap_8
* cell instance sg13cmos5l_decap_8_1811 r0 *1 0,0
Xsg13cmos5l_decap_8_1811 VPWR VGND sg13cmos5l_decap_8
* cell instance sg13cmos5l_decap_8_1812 r0 *1 0,0
Xsg13cmos5l_decap_8_1812 VPWR VGND sg13cmos5l_decap_8
* cell instance sg13cmos5l_decap_8_1813 r0 *1 0,0
Xsg13cmos5l_decap_8_1813 VPWR VGND sg13cmos5l_decap_8
* cell instance sg13cmos5l_decap_8_1814 r0 *1 0,0
Xsg13cmos5l_decap_8_1814 VPWR VGND sg13cmos5l_decap_8
* cell instance sg13cmos5l_decap_8_1815 r0 *1 0,0
Xsg13cmos5l_decap_8_1815 VPWR VGND sg13cmos5l_decap_8
* cell instance sg13cmos5l_decap_8_1816 r0 *1 0,0
Xsg13cmos5l_decap_8_1816 VPWR VGND sg13cmos5l_decap_8
* cell instance sg13cmos5l_decap_8_1817 r0 *1 0,0
Xsg13cmos5l_decap_8_1817 VPWR VGND sg13cmos5l_decap_8
* cell instance sg13cmos5l_decap_8_1818 r0 *1 0,0
Xsg13cmos5l_decap_8_1818 VPWR VGND sg13cmos5l_decap_8
* cell instance sg13cmos5l_decap_8_1819 r0 *1 0,0
Xsg13cmos5l_decap_8_1819 VPWR VGND sg13cmos5l_decap_8
* cell instance sg13cmos5l_decap_8_1820 r0 *1 0,0
Xsg13cmos5l_decap_8_1820 VPWR VGND sg13cmos5l_decap_8
* cell instance sg13cmos5l_decap_8_1821 r0 *1 0,0
Xsg13cmos5l_decap_8_1821 VPWR VGND sg13cmos5l_decap_8
* cell instance sg13cmos5l_decap_8_1822 r0 *1 0,0
Xsg13cmos5l_decap_8_1822 VPWR VGND sg13cmos5l_decap_8
* cell instance sg13cmos5l_decap_8_1823 r0 *1 0,0
Xsg13cmos5l_decap_8_1823 VPWR VGND sg13cmos5l_decap_8
* cell instance sg13cmos5l_decap_8_1824 r0 *1 0,0
Xsg13cmos5l_decap_8_1824 VPWR VGND sg13cmos5l_decap_8
* cell instance sg13cmos5l_decap_8_1825 r0 *1 0,0
Xsg13cmos5l_decap_8_1825 VPWR VGND sg13cmos5l_decap_8
* cell instance sg13cmos5l_decap_8_1826 r0 *1 0,0
Xsg13cmos5l_decap_8_1826 VPWR VGND sg13cmos5l_decap_8
* cell instance sg13cmos5l_decap_8_1827 r0 *1 0,0
Xsg13cmos5l_decap_8_1827 VPWR VGND sg13cmos5l_decap_8
* cell instance sg13cmos5l_decap_8_1828 r0 *1 0,0
Xsg13cmos5l_decap_8_1828 VPWR VGND sg13cmos5l_decap_8
* cell instance sg13cmos5l_decap_8_1829 r0 *1 0,0
Xsg13cmos5l_decap_8_1829 VPWR VGND sg13cmos5l_decap_8
* cell instance sg13cmos5l_decap_8_1830 r0 *1 0,0
Xsg13cmos5l_decap_8_1830 VPWR VGND sg13cmos5l_decap_8
* cell instance sg13cmos5l_decap_8_1831 r0 *1 0,0
Xsg13cmos5l_decap_8_1831 VPWR VGND sg13cmos5l_decap_8
* cell instance sg13cmos5l_decap_8_1832 r0 *1 0,0
Xsg13cmos5l_decap_8_1832 VPWR VGND sg13cmos5l_decap_8
* cell instance sg13cmos5l_decap_8_1833 r0 *1 0,0
Xsg13cmos5l_decap_8_1833 VPWR VGND sg13cmos5l_decap_8
* cell instance sg13cmos5l_decap_8_1834 r0 *1 0,0
Xsg13cmos5l_decap_8_1834 VPWR VGND sg13cmos5l_decap_8
* cell instance sg13cmos5l_decap_8_1835 r0 *1 0,0
Xsg13cmos5l_decap_8_1835 VPWR VGND sg13cmos5l_decap_8
* cell instance sg13cmos5l_decap_8_1836 r0 *1 0,0
Xsg13cmos5l_decap_8_1836 VPWR VGND sg13cmos5l_decap_8
* cell instance sg13cmos5l_decap_8_1837 r0 *1 0,0
Xsg13cmos5l_decap_8_1837 VPWR VGND sg13cmos5l_decap_8
* cell instance sg13cmos5l_decap_8_1838 r0 *1 0,0
Xsg13cmos5l_decap_8_1838 VPWR VGND sg13cmos5l_decap_8
* cell instance sg13cmos5l_decap_8_1839 r0 *1 0,0
Xsg13cmos5l_decap_8_1839 VPWR VGND sg13cmos5l_decap_8
* cell instance sg13cmos5l_decap_8_1840 r0 *1 0,0
Xsg13cmos5l_decap_8_1840 VPWR VGND sg13cmos5l_decap_8
* cell instance sg13cmos5l_decap_8_1841 r0 *1 0,0
Xsg13cmos5l_decap_8_1841 VPWR VGND sg13cmos5l_decap_8
* cell instance sg13cmos5l_decap_8_1842 r0 *1 0,0
Xsg13cmos5l_decap_8_1842 VPWR VGND sg13cmos5l_decap_8
* cell instance sg13cmos5l_decap_8_1843 r0 *1 0,0
Xsg13cmos5l_decap_8_1843 VPWR VGND sg13cmos5l_decap_8
* cell instance sg13cmos5l_decap_8_1844 r0 *1 0,0
Xsg13cmos5l_decap_8_1844 VPWR VGND sg13cmos5l_decap_8
* cell instance sg13cmos5l_decap_8_1845 r0 *1 0,0
Xsg13cmos5l_decap_8_1845 VPWR VGND sg13cmos5l_decap_8
* cell instance sg13cmos5l_decap_8_1846 r0 *1 0,0
Xsg13cmos5l_decap_8_1846 VPWR VGND sg13cmos5l_decap_8
* cell instance sg13cmos5l_decap_8_1847 r0 *1 0,0
Xsg13cmos5l_decap_8_1847 VPWR VGND sg13cmos5l_decap_8
* cell instance sg13cmos5l_decap_8_1848 r0 *1 0,0
Xsg13cmos5l_decap_8_1848 VPWR VGND sg13cmos5l_decap_8
* cell instance sg13cmos5l_decap_8_1849 r0 *1 0,0
Xsg13cmos5l_decap_8_1849 VPWR VGND sg13cmos5l_decap_8
* cell instance sg13cmos5l_decap_8_1850 r0 *1 0,0
Xsg13cmos5l_decap_8_1850 VPWR VGND sg13cmos5l_decap_8
* cell instance sg13cmos5l_decap_8_1851 r0 *1 0,0
Xsg13cmos5l_decap_8_1851 VPWR VGND sg13cmos5l_decap_8
* cell instance sg13cmos5l_decap_8_1852 r0 *1 0,0
Xsg13cmos5l_decap_8_1852 VPWR VGND sg13cmos5l_decap_8
* cell instance sg13cmos5l_decap_8_1853 r0 *1 0,0
Xsg13cmos5l_decap_8_1853 VPWR VGND sg13cmos5l_decap_8
* cell instance sg13cmos5l_decap_8_1854 r0 *1 0,0
Xsg13cmos5l_decap_8_1854 VPWR VGND sg13cmos5l_decap_8
* cell instance sg13cmos5l_decap_8_1855 r0 *1 0,0
Xsg13cmos5l_decap_8_1855 VPWR VGND sg13cmos5l_decap_8
* cell instance sg13cmos5l_decap_8_1856 r0 *1 0,0
Xsg13cmos5l_decap_8_1856 VPWR VGND sg13cmos5l_decap_8
* cell instance sg13cmos5l_decap_8_1857 r0 *1 0,0
Xsg13cmos5l_decap_8_1857 VPWR VGND sg13cmos5l_decap_8
* cell instance sg13cmos5l_decap_8_1858 r0 *1 0,0
Xsg13cmos5l_decap_8_1858 VPWR VGND sg13cmos5l_decap_8
* cell instance sg13cmos5l_decap_8_1859 r0 *1 0,0
Xsg13cmos5l_decap_8_1859 VPWR VGND sg13cmos5l_decap_8
* cell instance sg13cmos5l_decap_8_1860 r0 *1 0,0
Xsg13cmos5l_decap_8_1860 VPWR VGND sg13cmos5l_decap_8
* cell instance sg13cmos5l_decap_8_1861 r0 *1 0,0
Xsg13cmos5l_decap_8_1861 VPWR VGND sg13cmos5l_decap_8
* cell instance sg13cmos5l_decap_8_1862 r0 *1 0,0
Xsg13cmos5l_decap_8_1862 VPWR VGND sg13cmos5l_decap_8
* cell instance sg13cmos5l_decap_8_1863 r0 *1 0,0
Xsg13cmos5l_decap_8_1863 VPWR VGND sg13cmos5l_decap_8
* cell instance sg13cmos5l_decap_8_1864 r0 *1 0,0
Xsg13cmos5l_decap_8_1864 VPWR VGND sg13cmos5l_decap_8
* cell instance sg13cmos5l_decap_8_1865 r0 *1 0,0
Xsg13cmos5l_decap_8_1865 VPWR VGND sg13cmos5l_decap_8
* cell instance sg13cmos5l_decap_8_1866 r0 *1 0,0
Xsg13cmos5l_decap_8_1866 VPWR VGND sg13cmos5l_decap_8
* cell instance sg13cmos5l_decap_8_1867 r0 *1 0,0
Xsg13cmos5l_decap_8_1867 VPWR VGND sg13cmos5l_decap_8
* cell instance sg13cmos5l_decap_8_1868 r0 *1 0,0
Xsg13cmos5l_decap_8_1868 VPWR VGND sg13cmos5l_decap_8
* cell instance sg13cmos5l_decap_8_1869 r0 *1 0,0
Xsg13cmos5l_decap_8_1869 VPWR VGND sg13cmos5l_decap_8
* cell instance sg13cmos5l_decap_8_1870 r0 *1 0,0
Xsg13cmos5l_decap_8_1870 VPWR VGND sg13cmos5l_decap_8
* cell instance sg13cmos5l_decap_8_1871 r0 *1 0,0
Xsg13cmos5l_decap_8_1871 VPWR VGND sg13cmos5l_decap_8
* cell instance sg13cmos5l_decap_8_1872 r0 *1 0,0
Xsg13cmos5l_decap_8_1872 VPWR VGND sg13cmos5l_decap_8
* cell instance sg13cmos5l_decap_8_1873 r0 *1 0,0
Xsg13cmos5l_decap_8_1873 VPWR VGND sg13cmos5l_decap_8
* cell instance sg13cmos5l_decap_8_1874 r0 *1 0,0
Xsg13cmos5l_decap_8_1874 VPWR VGND sg13cmos5l_decap_8
* cell instance sg13cmos5l_decap_8_1875 r0 *1 0,0
Xsg13cmos5l_decap_8_1875 VPWR VGND sg13cmos5l_decap_8
* cell instance sg13cmos5l_decap_8_1876 r0 *1 0,0
Xsg13cmos5l_decap_8_1876 VPWR VGND sg13cmos5l_decap_8
* cell instance sg13cmos5l_decap_8_1877 r0 *1 0,0
Xsg13cmos5l_decap_8_1877 VPWR VGND sg13cmos5l_decap_8
* cell instance sg13cmos5l_decap_8_1878 r0 *1 0,0
Xsg13cmos5l_decap_8_1878 VPWR VGND sg13cmos5l_decap_8
* cell instance sg13cmos5l_decap_8_1879 r0 *1 0,0
Xsg13cmos5l_decap_8_1879 VPWR VGND sg13cmos5l_decap_8
* cell instance sg13cmos5l_decap_8_1880 r0 *1 0,0
Xsg13cmos5l_decap_8_1880 VPWR VGND sg13cmos5l_decap_8
* cell instance sg13cmos5l_decap_8_1881 r0 *1 0,0
Xsg13cmos5l_decap_8_1881 VPWR VGND sg13cmos5l_decap_8
* cell instance sg13cmos5l_decap_8_1882 r0 *1 0,0
Xsg13cmos5l_decap_8_1882 VPWR VGND sg13cmos5l_decap_8
* cell instance sg13cmos5l_decap_8_1883 r0 *1 0,0
Xsg13cmos5l_decap_8_1883 VPWR VGND sg13cmos5l_decap_8
* cell instance sg13cmos5l_decap_8_1884 r0 *1 0,0
Xsg13cmos5l_decap_8_1884 VPWR VGND sg13cmos5l_decap_8
* cell instance sg13cmos5l_decap_8_1885 r0 *1 0,0
Xsg13cmos5l_decap_8_1885 VPWR VGND sg13cmos5l_decap_8
* cell instance sg13cmos5l_decap_8_1886 r0 *1 0,0
Xsg13cmos5l_decap_8_1886 VPWR VGND sg13cmos5l_decap_8
* cell instance sg13cmos5l_decap_8_1887 r0 *1 0,0
Xsg13cmos5l_decap_8_1887 VPWR VGND sg13cmos5l_decap_8
* cell instance sg13cmos5l_decap_8_1888 r0 *1 0,0
Xsg13cmos5l_decap_8_1888 VPWR VGND sg13cmos5l_decap_8
* cell instance sg13cmos5l_decap_8_1889 r0 *1 0,0
Xsg13cmos5l_decap_8_1889 VPWR VGND sg13cmos5l_decap_8
* cell instance sg13cmos5l_decap_8_1890 r0 *1 0,0
Xsg13cmos5l_decap_8_1890 VPWR VGND sg13cmos5l_decap_8
* cell instance sg13cmos5l_decap_8_1891 r0 *1 0,0
Xsg13cmos5l_decap_8_1891 VPWR VGND sg13cmos5l_decap_8
* cell instance sg13cmos5l_decap_8_1892 r0 *1 0,0
Xsg13cmos5l_decap_8_1892 VPWR VGND sg13cmos5l_decap_8
* cell instance sg13cmos5l_decap_8_1893 r0 *1 0,0
Xsg13cmos5l_decap_8_1893 VPWR VGND sg13cmos5l_decap_8
* cell instance sg13cmos5l_decap_8_1894 r0 *1 0,0
Xsg13cmos5l_decap_8_1894 VPWR VGND sg13cmos5l_decap_8
* cell instance sg13cmos5l_decap_8_1895 r0 *1 0,0
Xsg13cmos5l_decap_8_1895 VPWR VGND sg13cmos5l_decap_8
* cell instance sg13cmos5l_decap_8_1896 r0 *1 0,0
Xsg13cmos5l_decap_8_1896 VPWR VGND sg13cmos5l_decap_8
* cell instance sg13cmos5l_decap_8_1897 r0 *1 0,0
Xsg13cmos5l_decap_8_1897 VPWR VGND sg13cmos5l_decap_8
* cell instance sg13cmos5l_decap_8_1898 r0 *1 0,0
Xsg13cmos5l_decap_8_1898 VPWR VGND sg13cmos5l_decap_8
* cell instance sg13cmos5l_decap_8_1899 r0 *1 0,0
Xsg13cmos5l_decap_8_1899 VPWR VGND sg13cmos5l_decap_8
* cell instance sg13cmos5l_decap_8_1900 r0 *1 0,0
Xsg13cmos5l_decap_8_1900 VPWR VGND sg13cmos5l_decap_8
* cell instance sg13cmos5l_decap_8_1901 r0 *1 0,0
Xsg13cmos5l_decap_8_1901 VPWR VGND sg13cmos5l_decap_8
* cell instance sg13cmos5l_decap_8_1902 r0 *1 0,0
Xsg13cmos5l_decap_8_1902 VPWR VGND sg13cmos5l_decap_8
* cell instance sg13cmos5l_decap_8_1903 r0 *1 0,0
Xsg13cmos5l_decap_8_1903 VPWR VGND sg13cmos5l_decap_8
* cell instance sg13cmos5l_decap_8_1904 r0 *1 0,0
Xsg13cmos5l_decap_8_1904 VPWR VGND sg13cmos5l_decap_8
* cell instance sg13cmos5l_decap_8_1905 r0 *1 0,0
Xsg13cmos5l_decap_8_1905 VPWR VGND sg13cmos5l_decap_8
* cell instance sg13cmos5l_decap_8_1906 r0 *1 0,0
Xsg13cmos5l_decap_8_1906 VPWR VGND sg13cmos5l_decap_8
* cell instance sg13cmos5l_decap_8_1907 r0 *1 0,0
Xsg13cmos5l_decap_8_1907 VPWR VGND sg13cmos5l_decap_8
* cell instance sg13cmos5l_decap_8_1908 r0 *1 0,0
Xsg13cmos5l_decap_8_1908 VPWR VGND sg13cmos5l_decap_8
* cell instance sg13cmos5l_decap_8_1909 r0 *1 0,0
Xsg13cmos5l_decap_8_1909 VPWR VGND sg13cmos5l_decap_8
* cell instance sg13cmos5l_decap_8_1910 r0 *1 0,0
Xsg13cmos5l_decap_8_1910 VPWR VGND sg13cmos5l_decap_8
* cell instance sg13cmos5l_decap_8_1911 r0 *1 0,0
Xsg13cmos5l_decap_8_1911 VPWR VGND sg13cmos5l_decap_8
* cell instance sg13cmos5l_decap_8_1912 r0 *1 0,0
Xsg13cmos5l_decap_8_1912 VPWR VGND sg13cmos5l_decap_8
* cell instance sg13cmos5l_decap_8_1913 r0 *1 0,0
Xsg13cmos5l_decap_8_1913 VPWR VGND sg13cmos5l_decap_8
* cell instance sg13cmos5l_decap_8_1914 r0 *1 0,0
Xsg13cmos5l_decap_8_1914 VPWR VGND sg13cmos5l_decap_8
* cell instance sg13cmos5l_decap_8_1915 r0 *1 0,0
Xsg13cmos5l_decap_8_1915 VPWR VGND sg13cmos5l_decap_8
* cell instance sg13cmos5l_decap_8_1916 r0 *1 0,0
Xsg13cmos5l_decap_8_1916 VPWR VGND sg13cmos5l_decap_8
* cell instance sg13cmos5l_decap_8_1917 r0 *1 0,0
Xsg13cmos5l_decap_8_1917 VPWR VGND sg13cmos5l_decap_8
* cell instance sg13cmos5l_decap_8_1918 r0 *1 0,0
Xsg13cmos5l_decap_8_1918 VPWR VGND sg13cmos5l_decap_8
* cell instance sg13cmos5l_decap_8_1919 r0 *1 0,0
Xsg13cmos5l_decap_8_1919 VPWR VGND sg13cmos5l_decap_8
* cell instance sg13cmos5l_decap_8_1920 r0 *1 0,0
Xsg13cmos5l_decap_8_1920 VPWR VGND sg13cmos5l_decap_8
* cell instance sg13cmos5l_decap_8_1921 r0 *1 0,0
Xsg13cmos5l_decap_8_1921 VPWR VGND sg13cmos5l_decap_8
* cell instance sg13cmos5l_decap_8_1922 r0 *1 0,0
Xsg13cmos5l_decap_8_1922 VPWR VGND sg13cmos5l_decap_8
* cell instance sg13cmos5l_decap_8_1923 r0 *1 0,0
Xsg13cmos5l_decap_8_1923 VPWR VGND sg13cmos5l_decap_8
* cell instance sg13cmos5l_decap_8_1924 r0 *1 0,0
Xsg13cmos5l_decap_8_1924 VPWR VGND sg13cmos5l_decap_8
* cell instance sg13cmos5l_decap_8_1925 r0 *1 0,0
Xsg13cmos5l_decap_8_1925 VPWR VGND sg13cmos5l_decap_8
* cell instance sg13cmos5l_decap_8_1926 r0 *1 0,0
Xsg13cmos5l_decap_8_1926 VPWR VGND sg13cmos5l_decap_8
* cell instance sg13cmos5l_decap_8_1927 r0 *1 0,0
Xsg13cmos5l_decap_8_1927 VPWR VGND sg13cmos5l_decap_8
* cell instance sg13cmos5l_decap_8_1928 r0 *1 0,0
Xsg13cmos5l_decap_8_1928 VPWR VGND sg13cmos5l_decap_8
* cell instance sg13cmos5l_decap_8_1929 r0 *1 0,0
Xsg13cmos5l_decap_8_1929 VPWR VGND sg13cmos5l_decap_8
* cell instance sg13cmos5l_decap_8_1930 r0 *1 0,0
Xsg13cmos5l_decap_8_1930 VPWR VGND sg13cmos5l_decap_8
* cell instance sg13cmos5l_decap_8_1931 r0 *1 0,0
Xsg13cmos5l_decap_8_1931 VPWR VGND sg13cmos5l_decap_8
* cell instance sg13cmos5l_decap_8_1932 r0 *1 0,0
Xsg13cmos5l_decap_8_1932 VPWR VGND sg13cmos5l_decap_8
* cell instance sg13cmos5l_decap_8_1933 r0 *1 0,0
Xsg13cmos5l_decap_8_1933 VPWR VGND sg13cmos5l_decap_8
* cell instance sg13cmos5l_decap_8_1934 r0 *1 0,0
Xsg13cmos5l_decap_8_1934 VPWR VGND sg13cmos5l_decap_8
* cell instance sg13cmos5l_decap_8_1935 r0 *1 0,0
Xsg13cmos5l_decap_8_1935 VPWR VGND sg13cmos5l_decap_8
* cell instance sg13cmos5l_decap_8_1936 r0 *1 0,0
Xsg13cmos5l_decap_8_1936 VPWR VGND sg13cmos5l_decap_8
* cell instance sg13cmos5l_decap_8_1937 r0 *1 0,0
Xsg13cmos5l_decap_8_1937 VPWR VGND sg13cmos5l_decap_8
* cell instance sg13cmos5l_decap_8_1938 r0 *1 0,0
Xsg13cmos5l_decap_8_1938 VPWR VGND sg13cmos5l_decap_8
* cell instance sg13cmos5l_decap_8_1939 r0 *1 0,0
Xsg13cmos5l_decap_8_1939 VPWR VGND sg13cmos5l_decap_8
* cell instance sg13cmos5l_decap_8_1940 r0 *1 0,0
Xsg13cmos5l_decap_8_1940 VPWR VGND sg13cmos5l_decap_8
* cell instance sg13cmos5l_decap_8_1941 r0 *1 0,0
Xsg13cmos5l_decap_8_1941 VPWR VGND sg13cmos5l_decap_8
* cell instance sg13cmos5l_decap_8_1942 r0 *1 0,0
Xsg13cmos5l_decap_8_1942 VPWR VGND sg13cmos5l_decap_8
* cell instance sg13cmos5l_decap_8_1943 r0 *1 0,0
Xsg13cmos5l_decap_8_1943 VPWR VGND sg13cmos5l_decap_8
* cell instance sg13cmos5l_decap_8_1944 r0 *1 0,0
Xsg13cmos5l_decap_8_1944 VPWR VGND sg13cmos5l_decap_8
* cell instance sg13cmos5l_decap_8_1945 r0 *1 0,0
Xsg13cmos5l_decap_8_1945 VPWR VGND sg13cmos5l_decap_8
* cell instance sg13cmos5l_decap_8_1946 r0 *1 0,0
Xsg13cmos5l_decap_8_1946 VPWR VGND sg13cmos5l_decap_8
* cell instance sg13cmos5l_decap_8_1947 r0 *1 0,0
Xsg13cmos5l_decap_8_1947 VPWR VGND sg13cmos5l_decap_8
* cell instance sg13cmos5l_decap_8_1948 r0 *1 0,0
Xsg13cmos5l_decap_8_1948 VPWR VGND sg13cmos5l_decap_8
* cell instance sg13cmos5l_decap_8_1949 r0 *1 0,0
Xsg13cmos5l_decap_8_1949 VPWR VGND sg13cmos5l_decap_8
* cell instance sg13cmos5l_decap_8_1950 r0 *1 0,0
Xsg13cmos5l_decap_8_1950 VPWR VGND sg13cmos5l_decap_8
* cell instance sg13cmos5l_decap_8_1951 r0 *1 0,0
Xsg13cmos5l_decap_8_1951 VPWR VGND sg13cmos5l_decap_8
* cell instance sg13cmos5l_decap_8_1952 r0 *1 0,0
Xsg13cmos5l_decap_8_1952 VPWR VGND sg13cmos5l_decap_8
* cell instance sg13cmos5l_decap_8_1953 r0 *1 0,0
Xsg13cmos5l_decap_8_1953 VPWR VGND sg13cmos5l_decap_8
* cell instance sg13cmos5l_decap_8_1954 r0 *1 0,0
Xsg13cmos5l_decap_8_1954 VPWR VGND sg13cmos5l_decap_8
* cell instance sg13cmos5l_decap_8_1955 r0 *1 0,0
Xsg13cmos5l_decap_8_1955 VPWR VGND sg13cmos5l_decap_8
* cell instance sg13cmos5l_decap_8_1956 r0 *1 0,0
Xsg13cmos5l_decap_8_1956 VPWR VGND sg13cmos5l_decap_8
* cell instance sg13cmos5l_decap_8_1957 r0 *1 0,0
Xsg13cmos5l_decap_8_1957 VPWR VGND sg13cmos5l_decap_8
* cell instance sg13cmos5l_decap_8_1958 r0 *1 0,0
Xsg13cmos5l_decap_8_1958 VPWR VGND sg13cmos5l_decap_8
* cell instance sg13cmos5l_decap_8_1959 r0 *1 0,0
Xsg13cmos5l_decap_8_1959 VPWR VGND sg13cmos5l_decap_8
* cell instance sg13cmos5l_decap_8_1960 r0 *1 0,0
Xsg13cmos5l_decap_8_1960 VPWR VGND sg13cmos5l_decap_8
* cell instance sg13cmos5l_decap_8_1961 r0 *1 0,0
Xsg13cmos5l_decap_8_1961 VPWR VGND sg13cmos5l_decap_8
* cell instance sg13cmos5l_decap_8_1962 r0 *1 0,0
Xsg13cmos5l_decap_8_1962 VPWR VGND sg13cmos5l_decap_8
* cell instance sg13cmos5l_decap_8_1963 r0 *1 0,0
Xsg13cmos5l_decap_8_1963 VPWR VGND sg13cmos5l_decap_8
* cell instance sg13cmos5l_decap_8_1964 r0 *1 0,0
Xsg13cmos5l_decap_8_1964 VPWR VGND sg13cmos5l_decap_8
* cell instance sg13cmos5l_decap_8_1965 r0 *1 0,0
Xsg13cmos5l_decap_8_1965 VPWR VGND sg13cmos5l_decap_8
* cell instance sg13cmos5l_decap_8_1966 r0 *1 0,0
Xsg13cmos5l_decap_8_1966 VPWR VGND sg13cmos5l_decap_8
* cell instance sg13cmos5l_decap_8_1967 r0 *1 0,0
Xsg13cmos5l_decap_8_1967 VPWR VGND sg13cmos5l_decap_8
* cell instance sg13cmos5l_decap_8_1968 r0 *1 0,0
Xsg13cmos5l_decap_8_1968 VPWR VGND sg13cmos5l_decap_8
* cell instance sg13cmos5l_decap_8_1969 r0 *1 0,0
Xsg13cmos5l_decap_8_1969 VPWR VGND sg13cmos5l_decap_8
* cell instance sg13cmos5l_decap_8_1970 r0 *1 0,0
Xsg13cmos5l_decap_8_1970 VPWR VGND sg13cmos5l_decap_8
* cell instance sg13cmos5l_decap_8_1971 r0 *1 0,0
Xsg13cmos5l_decap_8_1971 VPWR VGND sg13cmos5l_decap_8
* cell instance sg13cmos5l_decap_8_1972 r0 *1 0,0
Xsg13cmos5l_decap_8_1972 VPWR VGND sg13cmos5l_decap_8
* cell instance sg13cmos5l_decap_8_1973 r0 *1 0,0
Xsg13cmos5l_decap_8_1973 VPWR VGND sg13cmos5l_decap_8
* cell instance sg13cmos5l_decap_8_1974 r0 *1 0,0
Xsg13cmos5l_decap_8_1974 VPWR VGND sg13cmos5l_decap_8
* cell instance sg13cmos5l_decap_8_1975 r0 *1 0,0
Xsg13cmos5l_decap_8_1975 VPWR VGND sg13cmos5l_decap_8
* cell instance sg13cmos5l_decap_8_1976 r0 *1 0,0
Xsg13cmos5l_decap_8_1976 VPWR VGND sg13cmos5l_decap_8
* cell instance sg13cmos5l_decap_8_1977 r0 *1 0,0
Xsg13cmos5l_decap_8_1977 VPWR VGND sg13cmos5l_decap_8
* cell instance sg13cmos5l_decap_8_1978 r0 *1 0,0
Xsg13cmos5l_decap_8_1978 VPWR VGND sg13cmos5l_decap_8
* cell instance sg13cmos5l_decap_8_1979 r0 *1 0,0
Xsg13cmos5l_decap_8_1979 VPWR VGND sg13cmos5l_decap_8
* cell instance sg13cmos5l_decap_8_1980 r0 *1 0,0
Xsg13cmos5l_decap_8_1980 VPWR VGND sg13cmos5l_decap_8
* cell instance sg13cmos5l_decap_8_1981 r0 *1 0,0
Xsg13cmos5l_decap_8_1981 VPWR VGND sg13cmos5l_decap_8
* cell instance sg13cmos5l_decap_8_1982 r0 *1 0,0
Xsg13cmos5l_decap_8_1982 VPWR VGND sg13cmos5l_decap_8
* cell instance sg13cmos5l_decap_8_1983 r0 *1 0,0
Xsg13cmos5l_decap_8_1983 VPWR VGND sg13cmos5l_decap_8
* cell instance sg13cmos5l_decap_8_1984 r0 *1 0,0
Xsg13cmos5l_decap_8_1984 VPWR VGND sg13cmos5l_decap_8
* cell instance sg13cmos5l_decap_8_1985 r0 *1 0,0
Xsg13cmos5l_decap_8_1985 VPWR VGND sg13cmos5l_decap_8
* cell instance sg13cmos5l_decap_8_1986 r0 *1 0,0
Xsg13cmos5l_decap_8_1986 VPWR VGND sg13cmos5l_decap_8
* cell instance sg13cmos5l_decap_8_1987 r0 *1 0,0
Xsg13cmos5l_decap_8_1987 VPWR VGND sg13cmos5l_decap_8
* cell instance sg13cmos5l_decap_8_1988 r0 *1 0,0
Xsg13cmos5l_decap_8_1988 VPWR VGND sg13cmos5l_decap_8
* cell instance sg13cmos5l_decap_8_1989 r0 *1 0,0
Xsg13cmos5l_decap_8_1989 VPWR VGND sg13cmos5l_decap_8
* cell instance sg13cmos5l_decap_8_1990 r0 *1 0,0
Xsg13cmos5l_decap_8_1990 VPWR VGND sg13cmos5l_decap_8
* cell instance sg13cmos5l_decap_8_1991 r0 *1 0,0
Xsg13cmos5l_decap_8_1991 VPWR VGND sg13cmos5l_decap_8
* cell instance sg13cmos5l_decap_8_1992 r0 *1 0,0
Xsg13cmos5l_decap_8_1992 VPWR VGND sg13cmos5l_decap_8
* cell instance sg13cmos5l_decap_8_1993 r0 *1 0,0
Xsg13cmos5l_decap_8_1993 VPWR VGND sg13cmos5l_decap_8
* cell instance sg13cmos5l_decap_8_1994 r0 *1 0,0
Xsg13cmos5l_decap_8_1994 VPWR VGND sg13cmos5l_decap_8
* cell instance sg13cmos5l_decap_8_1995 r0 *1 0,0
Xsg13cmos5l_decap_8_1995 VPWR VGND sg13cmos5l_decap_8
* cell instance sg13cmos5l_decap_8_1996 r0 *1 0,0
Xsg13cmos5l_decap_8_1996 VPWR VGND sg13cmos5l_decap_8
* cell instance sg13cmos5l_decap_8_1997 r0 *1 0,0
Xsg13cmos5l_decap_8_1997 VPWR VGND sg13cmos5l_decap_8
* cell instance sg13cmos5l_decap_8_1998 r0 *1 0,0
Xsg13cmos5l_decap_8_1998 VPWR VGND sg13cmos5l_decap_8
* cell instance sg13cmos5l_decap_8_1999 r0 *1 0,0
Xsg13cmos5l_decap_8_1999 VPWR VGND sg13cmos5l_decap_8
* cell instance sg13cmos5l_decap_8_2000 r0 *1 0,0
Xsg13cmos5l_decap_8_2000 VPWR VGND sg13cmos5l_decap_8
* cell instance sg13cmos5l_decap_8_2001 r0 *1 0,0
Xsg13cmos5l_decap_8_2001 VPWR VGND sg13cmos5l_decap_8
* cell instance sg13cmos5l_decap_8_2002 r0 *1 0,0
Xsg13cmos5l_decap_8_2002 VPWR VGND sg13cmos5l_decap_8
* cell instance sg13cmos5l_decap_8_2003 r0 *1 0,0
Xsg13cmos5l_decap_8_2003 VPWR VGND sg13cmos5l_decap_8
* cell instance sg13cmos5l_decap_8_2004 r0 *1 0,0
Xsg13cmos5l_decap_8_2004 VPWR VGND sg13cmos5l_decap_8
* cell instance sg13cmos5l_decap_8_2005 r0 *1 0,0
Xsg13cmos5l_decap_8_2005 VPWR VGND sg13cmos5l_decap_8
* cell instance sg13cmos5l_decap_8_2006 r0 *1 0,0
Xsg13cmos5l_decap_8_2006 VPWR VGND sg13cmos5l_decap_8
* cell instance sg13cmos5l_decap_8_2007 r0 *1 0,0
Xsg13cmos5l_decap_8_2007 VPWR VGND sg13cmos5l_decap_8
* cell instance sg13cmos5l_decap_8_2008 r0 *1 0,0
Xsg13cmos5l_decap_8_2008 VPWR VGND sg13cmos5l_decap_8
* cell instance sg13cmos5l_decap_8_2009 r0 *1 0,0
Xsg13cmos5l_decap_8_2009 VPWR VGND sg13cmos5l_decap_8
* cell instance sg13cmos5l_decap_8_2010 r0 *1 0,0
Xsg13cmos5l_decap_8_2010 VPWR VGND sg13cmos5l_decap_8
* cell instance sg13cmos5l_decap_8_2011 r0 *1 0,0
Xsg13cmos5l_decap_8_2011 VPWR VGND sg13cmos5l_decap_8
* cell instance sg13cmos5l_decap_8_2012 r0 *1 0,0
Xsg13cmos5l_decap_8_2012 VPWR VGND sg13cmos5l_decap_8
* cell instance sg13cmos5l_decap_8_2013 r0 *1 0,0
Xsg13cmos5l_decap_8_2013 VPWR VGND sg13cmos5l_decap_8
* cell instance sg13cmos5l_decap_8_2014 r0 *1 0,0
Xsg13cmos5l_decap_8_2014 VPWR VGND sg13cmos5l_decap_8
* cell instance sg13cmos5l_decap_8_2015 r0 *1 0,0
Xsg13cmos5l_decap_8_2015 VPWR VGND sg13cmos5l_decap_8
* cell instance sg13cmos5l_decap_8_2016 r0 *1 0,0
Xsg13cmos5l_decap_8_2016 VPWR VGND sg13cmos5l_decap_8
* cell instance sg13cmos5l_decap_8_2017 r0 *1 0,0
Xsg13cmos5l_decap_8_2017 VPWR VGND sg13cmos5l_decap_8
* cell instance sg13cmos5l_decap_8_2018 r0 *1 0,0
Xsg13cmos5l_decap_8_2018 VPWR VGND sg13cmos5l_decap_8
* cell instance sg13cmos5l_decap_8_2019 r0 *1 0,0
Xsg13cmos5l_decap_8_2019 VPWR VGND sg13cmos5l_decap_8
* cell instance sg13cmos5l_decap_8_2020 r0 *1 0,0
Xsg13cmos5l_decap_8_2020 VPWR VGND sg13cmos5l_decap_8
* cell instance sg13cmos5l_decap_8_2021 r0 *1 0,0
Xsg13cmos5l_decap_8_2021 VPWR VGND sg13cmos5l_decap_8
* cell instance sg13cmos5l_decap_8_2022 r0 *1 0,0
Xsg13cmos5l_decap_8_2022 VPWR VGND sg13cmos5l_decap_8
* cell instance sg13cmos5l_decap_8_2023 r0 *1 0,0
Xsg13cmos5l_decap_8_2023 VPWR VGND sg13cmos5l_decap_8
* cell instance sg13cmos5l_decap_8_2024 r0 *1 0,0
Xsg13cmos5l_decap_8_2024 VPWR VGND sg13cmos5l_decap_8
* cell instance sg13cmos5l_decap_8_2025 r0 *1 0,0
Xsg13cmos5l_decap_8_2025 VPWR VGND sg13cmos5l_decap_8
* cell instance sg13cmos5l_decap_8_2026 r0 *1 0,0
Xsg13cmos5l_decap_8_2026 VPWR VGND sg13cmos5l_decap_8
* cell instance sg13cmos5l_decap_8_2027 r0 *1 0,0
Xsg13cmos5l_decap_8_2027 VPWR VGND sg13cmos5l_decap_8
* cell instance sg13cmos5l_decap_8_2028 r0 *1 0,0
Xsg13cmos5l_decap_8_2028 VPWR VGND sg13cmos5l_decap_8
* cell instance sg13cmos5l_decap_8_2029 r0 *1 0,0
Xsg13cmos5l_decap_8_2029 VPWR VGND sg13cmos5l_decap_8
* cell instance sg13cmos5l_decap_8_2030 r0 *1 0,0
Xsg13cmos5l_decap_8_2030 VPWR VGND sg13cmos5l_decap_8
* cell instance sg13cmos5l_decap_8_2031 r0 *1 0,0
Xsg13cmos5l_decap_8_2031 VPWR VGND sg13cmos5l_decap_8
* cell instance sg13cmos5l_decap_8_2032 r0 *1 0,0
Xsg13cmos5l_decap_8_2032 VPWR VGND sg13cmos5l_decap_8
* cell instance sg13cmos5l_decap_8_2033 r0 *1 0,0
Xsg13cmos5l_decap_8_2033 VPWR VGND sg13cmos5l_decap_8
* cell instance sg13cmos5l_decap_8_2034 r0 *1 0,0
Xsg13cmos5l_decap_8_2034 VPWR VGND sg13cmos5l_decap_8
* cell instance sg13cmos5l_decap_8_2035 r0 *1 0,0
Xsg13cmos5l_decap_8_2035 VPWR VGND sg13cmos5l_decap_8
* cell instance sg13cmos5l_decap_8_2036 r0 *1 0,0
Xsg13cmos5l_decap_8_2036 VPWR VGND sg13cmos5l_decap_8
* cell instance sg13cmos5l_decap_8_2037 r0 *1 0,0
Xsg13cmos5l_decap_8_2037 VPWR VGND sg13cmos5l_decap_8
* cell instance sg13cmos5l_decap_8_2038 r0 *1 0,0
Xsg13cmos5l_decap_8_2038 VPWR VGND sg13cmos5l_decap_8
* cell instance sg13cmos5l_decap_8_2039 r0 *1 0,0
Xsg13cmos5l_decap_8_2039 VPWR VGND sg13cmos5l_decap_8
* cell instance sg13cmos5l_decap_8_2040 r0 *1 0,0
Xsg13cmos5l_decap_8_2040 VPWR VGND sg13cmos5l_decap_8
* cell instance sg13cmos5l_decap_8_2041 r0 *1 0,0
Xsg13cmos5l_decap_8_2041 VPWR VGND sg13cmos5l_decap_8
* cell instance sg13cmos5l_decap_8_2042 r0 *1 0,0
Xsg13cmos5l_decap_8_2042 VPWR VGND sg13cmos5l_decap_8
* cell instance sg13cmos5l_decap_8_2043 r0 *1 0,0
Xsg13cmos5l_decap_8_2043 VPWR VGND sg13cmos5l_decap_8
* cell instance sg13cmos5l_decap_8_2044 r0 *1 0,0
Xsg13cmos5l_decap_8_2044 VPWR VGND sg13cmos5l_decap_8
* cell instance sg13cmos5l_decap_8_2045 r0 *1 0,0
Xsg13cmos5l_decap_8_2045 VPWR VGND sg13cmos5l_decap_8
* cell instance sg13cmos5l_decap_8_2046 r0 *1 0,0
Xsg13cmos5l_decap_8_2046 VPWR VGND sg13cmos5l_decap_8
* cell instance sg13cmos5l_decap_8_2047 r0 *1 0,0
Xsg13cmos5l_decap_8_2047 VPWR VGND sg13cmos5l_decap_8
* cell instance sg13cmos5l_decap_8_2048 r0 *1 0,0
Xsg13cmos5l_decap_8_2048 VPWR VGND sg13cmos5l_decap_8
* cell instance sg13cmos5l_decap_8_2049 r0 *1 0,0
Xsg13cmos5l_decap_8_2049 VPWR VGND sg13cmos5l_decap_8
* cell instance sg13cmos5l_decap_8_2050 r0 *1 0,0
Xsg13cmos5l_decap_8_2050 VPWR VGND sg13cmos5l_decap_8
* cell instance sg13cmos5l_decap_8_2051 r0 *1 0,0
Xsg13cmos5l_decap_8_2051 VPWR VGND sg13cmos5l_decap_8
* cell instance sg13cmos5l_decap_8_2052 r0 *1 0,0
Xsg13cmos5l_decap_8_2052 VPWR VGND sg13cmos5l_decap_8
* cell instance sg13cmos5l_decap_8_2053 r0 *1 0,0
Xsg13cmos5l_decap_8_2053 VPWR VGND sg13cmos5l_decap_8
* cell instance sg13cmos5l_decap_8_2054 r0 *1 0,0
Xsg13cmos5l_decap_8_2054 VPWR VGND sg13cmos5l_decap_8
* cell instance sg13cmos5l_decap_8_2055 r0 *1 0,0
Xsg13cmos5l_decap_8_2055 VPWR VGND sg13cmos5l_decap_8
* cell instance sg13cmos5l_decap_8_2056 r0 *1 0,0
Xsg13cmos5l_decap_8_2056 VPWR VGND sg13cmos5l_decap_8
* cell instance sg13cmos5l_decap_8_2057 r0 *1 0,0
Xsg13cmos5l_decap_8_2057 VPWR VGND sg13cmos5l_decap_8
* cell instance sg13cmos5l_decap_8_2058 r0 *1 0,0
Xsg13cmos5l_decap_8_2058 VPWR VGND sg13cmos5l_decap_8
* cell instance sg13cmos5l_decap_8_2059 r0 *1 0,0
Xsg13cmos5l_decap_8_2059 VPWR VGND sg13cmos5l_decap_8
* cell instance sg13cmos5l_decap_8_2060 r0 *1 0,0
Xsg13cmos5l_decap_8_2060 VPWR VGND sg13cmos5l_decap_8
* cell instance sg13cmos5l_decap_8_2061 r0 *1 0,0
Xsg13cmos5l_decap_8_2061 VPWR VGND sg13cmos5l_decap_8
* cell instance sg13cmos5l_decap_8_2062 r0 *1 0,0
Xsg13cmos5l_decap_8_2062 VPWR VGND sg13cmos5l_decap_8
* cell instance sg13cmos5l_decap_8_2063 r0 *1 0,0
Xsg13cmos5l_decap_8_2063 VPWR VGND sg13cmos5l_decap_8
* cell instance sg13cmos5l_decap_8_2064 r0 *1 0,0
Xsg13cmos5l_decap_8_2064 VPWR VGND sg13cmos5l_decap_8
* cell instance sg13cmos5l_decap_8_2065 r0 *1 0,0
Xsg13cmos5l_decap_8_2065 VPWR VGND sg13cmos5l_decap_8
* cell instance sg13cmos5l_decap_8_2066 r0 *1 0,0
Xsg13cmos5l_decap_8_2066 VPWR VGND sg13cmos5l_decap_8
* cell instance sg13cmos5l_decap_8_2067 r0 *1 0,0
Xsg13cmos5l_decap_8_2067 VPWR VGND sg13cmos5l_decap_8
* cell instance sg13cmos5l_decap_8_2068 r0 *1 0,0
Xsg13cmos5l_decap_8_2068 VPWR VGND sg13cmos5l_decap_8
* cell instance sg13cmos5l_decap_8_2069 r0 *1 0,0
Xsg13cmos5l_decap_8_2069 VPWR VGND sg13cmos5l_decap_8
* cell instance sg13cmos5l_decap_8_2070 r0 *1 0,0
Xsg13cmos5l_decap_8_2070 VPWR VGND sg13cmos5l_decap_8
* cell instance sg13cmos5l_decap_8_2071 r0 *1 0,0
Xsg13cmos5l_decap_8_2071 VPWR VGND sg13cmos5l_decap_8
* cell instance sg13cmos5l_decap_8_2072 r0 *1 0,0
Xsg13cmos5l_decap_8_2072 VPWR VGND sg13cmos5l_decap_8
* cell instance sg13cmos5l_decap_8_2073 r0 *1 0,0
Xsg13cmos5l_decap_8_2073 VPWR VGND sg13cmos5l_decap_8
* cell instance sg13cmos5l_decap_8_2074 r0 *1 0,0
Xsg13cmos5l_decap_8_2074 VPWR VGND sg13cmos5l_decap_8
* cell instance sg13cmos5l_decap_8_2075 r0 *1 0,0
Xsg13cmos5l_decap_8_2075 VPWR VGND sg13cmos5l_decap_8
* cell instance sg13cmos5l_decap_8_2076 r0 *1 0,0
Xsg13cmos5l_decap_8_2076 VPWR VGND sg13cmos5l_decap_8
* cell instance sg13cmos5l_decap_8_2077 r0 *1 0,0
Xsg13cmos5l_decap_8_2077 VPWR VGND sg13cmos5l_decap_8
* cell instance sg13cmos5l_decap_8_2078 r0 *1 0,0
Xsg13cmos5l_decap_8_2078 VPWR VGND sg13cmos5l_decap_8
* cell instance sg13cmos5l_decap_8_2079 r0 *1 0,0
Xsg13cmos5l_decap_8_2079 VPWR VGND sg13cmos5l_decap_8
* cell instance sg13cmos5l_decap_8_2080 r0 *1 0,0
Xsg13cmos5l_decap_8_2080 VPWR VGND sg13cmos5l_decap_8
* cell instance sg13cmos5l_decap_8_2081 r0 *1 0,0
Xsg13cmos5l_decap_8_2081 VPWR VGND sg13cmos5l_decap_8
* cell instance sg13cmos5l_decap_8_2082 r0 *1 0,0
Xsg13cmos5l_decap_8_2082 VPWR VGND sg13cmos5l_decap_8
* cell instance sg13cmos5l_decap_8_2083 r0 *1 0,0
Xsg13cmos5l_decap_8_2083 VPWR VGND sg13cmos5l_decap_8
* cell instance sg13cmos5l_decap_8_2084 r0 *1 0,0
Xsg13cmos5l_decap_8_2084 VPWR VGND sg13cmos5l_decap_8
* cell instance sg13cmos5l_decap_8_2085 r0 *1 0,0
Xsg13cmos5l_decap_8_2085 VPWR VGND sg13cmos5l_decap_8
* cell instance sg13cmos5l_decap_8_2086 r0 *1 0,0
Xsg13cmos5l_decap_8_2086 VPWR VGND sg13cmos5l_decap_8
* cell instance sg13cmos5l_decap_8_2087 r0 *1 0,0
Xsg13cmos5l_decap_8_2087 VPWR VGND sg13cmos5l_decap_8
* cell instance sg13cmos5l_decap_8_2088 r0 *1 0,0
Xsg13cmos5l_decap_8_2088 VPWR VGND sg13cmos5l_decap_8
* cell instance sg13cmos5l_decap_8_2089 r0 *1 0,0
Xsg13cmos5l_decap_8_2089 VPWR VGND sg13cmos5l_decap_8
* cell instance sg13cmos5l_decap_8_2090 r0 *1 0,0
Xsg13cmos5l_decap_8_2090 VPWR VGND sg13cmos5l_decap_8
* cell instance sg13cmos5l_decap_8_2091 r0 *1 0,0
Xsg13cmos5l_decap_8_2091 VPWR VGND sg13cmos5l_decap_8
* cell instance sg13cmos5l_decap_8_2092 r0 *1 0,0
Xsg13cmos5l_decap_8_2092 VPWR VGND sg13cmos5l_decap_8
* cell instance sg13cmos5l_decap_8_2093 r0 *1 0,0
Xsg13cmos5l_decap_8_2093 VPWR VGND sg13cmos5l_decap_8
* cell instance sg13cmos5l_decap_8_2094 r0 *1 0,0
Xsg13cmos5l_decap_8_2094 VPWR VGND sg13cmos5l_decap_8
* cell instance sg13cmos5l_decap_8_2095 r0 *1 0,0
Xsg13cmos5l_decap_8_2095 VPWR VGND sg13cmos5l_decap_8
* cell instance sg13cmos5l_decap_8_2096 r0 *1 0,0
Xsg13cmos5l_decap_8_2096 VPWR VGND sg13cmos5l_decap_8
* cell instance sg13cmos5l_decap_8_2097 r0 *1 0,0
Xsg13cmos5l_decap_8_2097 VPWR VGND sg13cmos5l_decap_8
* cell instance sg13cmos5l_decap_8_2098 r0 *1 0,0
Xsg13cmos5l_decap_8_2098 VPWR VGND sg13cmos5l_decap_8
* cell instance sg13cmos5l_decap_8_2099 r0 *1 0,0
Xsg13cmos5l_decap_8_2099 VPWR VGND sg13cmos5l_decap_8
* cell instance sg13cmos5l_decap_8_2100 r0 *1 0,0
Xsg13cmos5l_decap_8_2100 VPWR VGND sg13cmos5l_decap_8
* cell instance sg13cmos5l_decap_8_2101 r0 *1 0,0
Xsg13cmos5l_decap_8_2101 VPWR VGND sg13cmos5l_decap_8
* cell instance sg13cmos5l_decap_8_2102 r0 *1 0,0
Xsg13cmos5l_decap_8_2102 VPWR VGND sg13cmos5l_decap_8
* cell instance sg13cmos5l_decap_8_2103 r0 *1 0,0
Xsg13cmos5l_decap_8_2103 VPWR VGND sg13cmos5l_decap_8
* cell instance sg13cmos5l_decap_8_2104 r0 *1 0,0
Xsg13cmos5l_decap_8_2104 VPWR VGND sg13cmos5l_decap_8
* cell instance sg13cmos5l_decap_8_2105 r0 *1 0,0
Xsg13cmos5l_decap_8_2105 VPWR VGND sg13cmos5l_decap_8
* cell instance sg13cmos5l_decap_8_2106 r0 *1 0,0
Xsg13cmos5l_decap_8_2106 VPWR VGND sg13cmos5l_decap_8
* cell instance sg13cmos5l_decap_8_2107 r0 *1 0,0
Xsg13cmos5l_decap_8_2107 VPWR VGND sg13cmos5l_decap_8
* cell instance sg13cmos5l_decap_8_2108 r0 *1 0,0
Xsg13cmos5l_decap_8_2108 VPWR VGND sg13cmos5l_decap_8
* cell instance sg13cmos5l_decap_8_2109 r0 *1 0,0
Xsg13cmos5l_decap_8_2109 VPWR VGND sg13cmos5l_decap_8
* cell instance sg13cmos5l_decap_8_2110 r0 *1 0,0
Xsg13cmos5l_decap_8_2110 VPWR VGND sg13cmos5l_decap_8
* cell instance sg13cmos5l_decap_8_2111 r0 *1 0,0
Xsg13cmos5l_decap_8_2111 VPWR VGND sg13cmos5l_decap_8
* cell instance sg13cmos5l_decap_8_2112 r0 *1 0,0
Xsg13cmos5l_decap_8_2112 VPWR VGND sg13cmos5l_decap_8
* cell instance sg13cmos5l_decap_8_2113 r0 *1 0,0
Xsg13cmos5l_decap_8_2113 VPWR VGND sg13cmos5l_decap_8
* cell instance sg13cmos5l_decap_8_2114 r0 *1 0,0
Xsg13cmos5l_decap_8_2114 VPWR VGND sg13cmos5l_decap_8
* cell instance sg13cmos5l_decap_8_2115 r0 *1 0,0
Xsg13cmos5l_decap_8_2115 VPWR VGND sg13cmos5l_decap_8
* cell instance sg13cmos5l_decap_8_2116 r0 *1 0,0
Xsg13cmos5l_decap_8_2116 VPWR VGND sg13cmos5l_decap_8
* cell instance sg13cmos5l_decap_8_2117 r0 *1 0,0
Xsg13cmos5l_decap_8_2117 VPWR VGND sg13cmos5l_decap_8
* cell instance sg13cmos5l_decap_8_2118 r0 *1 0,0
Xsg13cmos5l_decap_8_2118 VPWR VGND sg13cmos5l_decap_8
* cell instance sg13cmos5l_decap_8_2119 r0 *1 0,0
Xsg13cmos5l_decap_8_2119 VPWR VGND sg13cmos5l_decap_8
* cell instance sg13cmos5l_decap_8_2120 r0 *1 0,0
Xsg13cmos5l_decap_8_2120 VPWR VGND sg13cmos5l_decap_8
* cell instance sg13cmos5l_decap_8_2121 r0 *1 0,0
Xsg13cmos5l_decap_8_2121 VPWR VGND sg13cmos5l_decap_8
* cell instance sg13cmos5l_decap_8_2122 r0 *1 0,0
Xsg13cmos5l_decap_8_2122 VPWR VGND sg13cmos5l_decap_8
* cell instance sg13cmos5l_decap_8_2123 r0 *1 0,0
Xsg13cmos5l_decap_8_2123 VPWR VGND sg13cmos5l_decap_8
* cell instance sg13cmos5l_decap_8_2124 r0 *1 0,0
Xsg13cmos5l_decap_8_2124 VPWR VGND sg13cmos5l_decap_8
* cell instance sg13cmos5l_decap_8_2125 r0 *1 0,0
Xsg13cmos5l_decap_8_2125 VPWR VGND sg13cmos5l_decap_8
* cell instance sg13cmos5l_decap_8_2126 r0 *1 0,0
Xsg13cmos5l_decap_8_2126 VPWR VGND sg13cmos5l_decap_8
* cell instance sg13cmos5l_decap_8_2127 r0 *1 0,0
Xsg13cmos5l_decap_8_2127 VPWR VGND sg13cmos5l_decap_8
* cell instance sg13cmos5l_decap_8_2128 r0 *1 0,0
Xsg13cmos5l_decap_8_2128 VPWR VGND sg13cmos5l_decap_8
* cell instance sg13cmos5l_decap_8_2129 r0 *1 0,0
Xsg13cmos5l_decap_8_2129 VPWR VGND sg13cmos5l_decap_8
* cell instance sg13cmos5l_decap_8_2130 r0 *1 0,0
Xsg13cmos5l_decap_8_2130 VPWR VGND sg13cmos5l_decap_8
* cell instance sg13cmos5l_decap_8_2131 r0 *1 0,0
Xsg13cmos5l_decap_8_2131 VPWR VGND sg13cmos5l_decap_8
* cell instance sg13cmos5l_decap_8_2132 r0 *1 0,0
Xsg13cmos5l_decap_8_2132 VPWR VGND sg13cmos5l_decap_8
* cell instance sg13cmos5l_decap_8_2133 r0 *1 0,0
Xsg13cmos5l_decap_8_2133 VPWR VGND sg13cmos5l_decap_8
* cell instance sg13cmos5l_decap_8_2134 r0 *1 0,0
Xsg13cmos5l_decap_8_2134 VPWR VGND sg13cmos5l_decap_8
* cell instance sg13cmos5l_decap_8_2135 r0 *1 0,0
Xsg13cmos5l_decap_8_2135 VPWR VGND sg13cmos5l_decap_8
* cell instance sg13cmos5l_decap_8_2136 r0 *1 0,0
Xsg13cmos5l_decap_8_2136 VPWR VGND sg13cmos5l_decap_8
* cell instance sg13cmos5l_decap_8_2137 r0 *1 0,0
Xsg13cmos5l_decap_8_2137 VPWR VGND sg13cmos5l_decap_8
* cell instance sg13cmos5l_decap_8_2138 r0 *1 0,0
Xsg13cmos5l_decap_8_2138 VPWR VGND sg13cmos5l_decap_8
* cell instance sg13cmos5l_decap_8_2139 r0 *1 0,0
Xsg13cmos5l_decap_8_2139 VPWR VGND sg13cmos5l_decap_8
* cell instance sg13cmos5l_decap_8_2140 r0 *1 0,0
Xsg13cmos5l_decap_8_2140 VPWR VGND sg13cmos5l_decap_8
* cell instance sg13cmos5l_decap_8_2141 r0 *1 0,0
Xsg13cmos5l_decap_8_2141 VPWR VGND sg13cmos5l_decap_8
* cell instance sg13cmos5l_decap_8_2142 r0 *1 0,0
Xsg13cmos5l_decap_8_2142 VPWR VGND sg13cmos5l_decap_8
* cell instance sg13cmos5l_decap_8_2143 r0 *1 0,0
Xsg13cmos5l_decap_8_2143 VPWR VGND sg13cmos5l_decap_8
* cell instance sg13cmos5l_decap_8_2144 r0 *1 0,0
Xsg13cmos5l_decap_8_2144 VPWR VGND sg13cmos5l_decap_8
* cell instance sg13cmos5l_decap_8_2145 r0 *1 0,0
Xsg13cmos5l_decap_8_2145 VPWR VGND sg13cmos5l_decap_8
* cell instance sg13cmos5l_decap_8_2146 r0 *1 0,0
Xsg13cmos5l_decap_8_2146 VPWR VGND sg13cmos5l_decap_8
* cell instance sg13cmos5l_decap_8_2147 r0 *1 0,0
Xsg13cmos5l_decap_8_2147 VPWR VGND sg13cmos5l_decap_8
* cell instance sg13cmos5l_decap_8_2148 r0 *1 0,0
Xsg13cmos5l_decap_8_2148 VPWR VGND sg13cmos5l_decap_8
* cell instance sg13cmos5l_decap_8_2149 r0 *1 0,0
Xsg13cmos5l_decap_8_2149 VPWR VGND sg13cmos5l_decap_8
* cell instance sg13cmos5l_decap_8_2150 r0 *1 0,0
Xsg13cmos5l_decap_8_2150 VPWR VGND sg13cmos5l_decap_8
* cell instance sg13cmos5l_decap_8_2151 r0 *1 0,0
Xsg13cmos5l_decap_8_2151 VPWR VGND sg13cmos5l_decap_8
* cell instance sg13cmos5l_decap_8_2152 r0 *1 0,0
Xsg13cmos5l_decap_8_2152 VPWR VGND sg13cmos5l_decap_8
* cell instance sg13cmos5l_decap_8_2153 r0 *1 0,0
Xsg13cmos5l_decap_8_2153 VPWR VGND sg13cmos5l_decap_8
* cell instance sg13cmos5l_decap_8_2154 r0 *1 0,0
Xsg13cmos5l_decap_8_2154 VPWR VGND sg13cmos5l_decap_8
* cell instance sg13cmos5l_decap_8_2155 r0 *1 0,0
Xsg13cmos5l_decap_8_2155 VPWR VGND sg13cmos5l_decap_8
* cell instance sg13cmos5l_decap_8_2156 r0 *1 0,0
Xsg13cmos5l_decap_8_2156 VPWR VGND sg13cmos5l_decap_8
* cell instance sg13cmos5l_decap_8_2157 r0 *1 0,0
Xsg13cmos5l_decap_8_2157 VPWR VGND sg13cmos5l_decap_8
* cell instance sg13cmos5l_decap_8_2158 r0 *1 0,0
Xsg13cmos5l_decap_8_2158 VPWR VGND sg13cmos5l_decap_8
* cell instance sg13cmos5l_decap_8_2159 r0 *1 0,0
Xsg13cmos5l_decap_8_2159 VPWR VGND sg13cmos5l_decap_8
* cell instance sg13cmos5l_decap_8_2160 r0 *1 0,0
Xsg13cmos5l_decap_8_2160 VPWR VGND sg13cmos5l_decap_8
* cell instance sg13cmos5l_decap_8_2161 r0 *1 0,0
Xsg13cmos5l_decap_8_2161 VPWR VGND sg13cmos5l_decap_8
* cell instance sg13cmos5l_decap_8_2162 r0 *1 0,0
Xsg13cmos5l_decap_8_2162 VPWR VGND sg13cmos5l_decap_8
* cell instance sg13cmos5l_decap_8_2163 r0 *1 0,0
Xsg13cmos5l_decap_8_2163 VPWR VGND sg13cmos5l_decap_8
* cell instance sg13cmos5l_decap_8_2164 r0 *1 0,0
Xsg13cmos5l_decap_8_2164 VPWR VGND sg13cmos5l_decap_8
* cell instance sg13cmos5l_decap_8_2165 r0 *1 0,0
Xsg13cmos5l_decap_8_2165 VPWR VGND sg13cmos5l_decap_8
* cell instance sg13cmos5l_decap_8_2166 r0 *1 0,0
Xsg13cmos5l_decap_8_2166 VPWR VGND sg13cmos5l_decap_8
* cell instance sg13cmos5l_decap_8_2167 r0 *1 0,0
Xsg13cmos5l_decap_8_2167 VPWR VGND sg13cmos5l_decap_8
* cell instance sg13cmos5l_decap_8_2168 r0 *1 0,0
Xsg13cmos5l_decap_8_2168 VPWR VGND sg13cmos5l_decap_8
* cell instance sg13cmos5l_decap_8_2169 r0 *1 0,0
Xsg13cmos5l_decap_8_2169 VPWR VGND sg13cmos5l_decap_8
* cell instance sg13cmos5l_decap_8_2170 r0 *1 0,0
Xsg13cmos5l_decap_8_2170 VPWR VGND sg13cmos5l_decap_8
* cell instance sg13cmos5l_decap_8_2171 r0 *1 0,0
Xsg13cmos5l_decap_8_2171 VPWR VGND sg13cmos5l_decap_8
* cell instance sg13cmos5l_decap_8_2172 r0 *1 0,0
Xsg13cmos5l_decap_8_2172 VPWR VGND sg13cmos5l_decap_8
* cell instance sg13cmos5l_decap_8_2173 r0 *1 0,0
Xsg13cmos5l_decap_8_2173 VPWR VGND sg13cmos5l_decap_8
* cell instance sg13cmos5l_decap_8_2174 r0 *1 0,0
Xsg13cmos5l_decap_8_2174 VPWR VGND sg13cmos5l_decap_8
* cell instance sg13cmos5l_decap_8_2175 r0 *1 0,0
Xsg13cmos5l_decap_8_2175 VPWR VGND sg13cmos5l_decap_8
* cell instance sg13cmos5l_decap_8_2176 r0 *1 0,0
Xsg13cmos5l_decap_8_2176 VPWR VGND sg13cmos5l_decap_8
* cell instance sg13cmos5l_decap_8_2177 r0 *1 0,0
Xsg13cmos5l_decap_8_2177 VPWR VGND sg13cmos5l_decap_8
* cell instance sg13cmos5l_decap_8_2178 r0 *1 0,0
Xsg13cmos5l_decap_8_2178 VPWR VGND sg13cmos5l_decap_8
* cell instance sg13cmos5l_decap_8_2179 r0 *1 0,0
Xsg13cmos5l_decap_8_2179 VPWR VGND sg13cmos5l_decap_8
* cell instance sg13cmos5l_decap_8_2180 r0 *1 0,0
Xsg13cmos5l_decap_8_2180 VPWR VGND sg13cmos5l_decap_8
* cell instance sg13cmos5l_decap_8_2181 r0 *1 0,0
Xsg13cmos5l_decap_8_2181 VPWR VGND sg13cmos5l_decap_8
* cell instance sg13cmos5l_decap_8_2182 r0 *1 0,0
Xsg13cmos5l_decap_8_2182 VPWR VGND sg13cmos5l_decap_8
* cell instance sg13cmos5l_decap_8_2183 r0 *1 0,0
Xsg13cmos5l_decap_8_2183 VPWR VGND sg13cmos5l_decap_8
* cell instance sg13cmos5l_decap_8_2184 r0 *1 0,0
Xsg13cmos5l_decap_8_2184 VPWR VGND sg13cmos5l_decap_8
* cell instance sg13cmos5l_decap_8_2185 r0 *1 0,0
Xsg13cmos5l_decap_8_2185 VPWR VGND sg13cmos5l_decap_8
* cell instance sg13cmos5l_decap_8_2186 r0 *1 0,0
Xsg13cmos5l_decap_8_2186 VPWR VGND sg13cmos5l_decap_8
* cell instance sg13cmos5l_decap_8_2187 r0 *1 0,0
Xsg13cmos5l_decap_8_2187 VPWR VGND sg13cmos5l_decap_8
* cell instance sg13cmos5l_decap_8_2188 r0 *1 0,0
Xsg13cmos5l_decap_8_2188 VPWR VGND sg13cmos5l_decap_8
* cell instance sg13cmos5l_decap_8_2189 r0 *1 0,0
Xsg13cmos5l_decap_8_2189 VPWR VGND sg13cmos5l_decap_8
* cell instance sg13cmos5l_decap_8_2190 r0 *1 0,0
Xsg13cmos5l_decap_8_2190 VPWR VGND sg13cmos5l_decap_8
* cell instance sg13cmos5l_decap_8_2191 r0 *1 0,0
Xsg13cmos5l_decap_8_2191 VPWR VGND sg13cmos5l_decap_8
* cell instance sg13cmos5l_decap_8_2192 r0 *1 0,0
Xsg13cmos5l_decap_8_2192 VPWR VGND sg13cmos5l_decap_8
* cell instance sg13cmos5l_decap_8_2193 r0 *1 0,0
Xsg13cmos5l_decap_8_2193 VPWR VGND sg13cmos5l_decap_8
* cell instance sg13cmos5l_decap_8_2194 r0 *1 0,0
Xsg13cmos5l_decap_8_2194 VPWR VGND sg13cmos5l_decap_8
* cell instance sg13cmos5l_decap_8_2195 r0 *1 0,0
Xsg13cmos5l_decap_8_2195 VPWR VGND sg13cmos5l_decap_8
* cell instance sg13cmos5l_decap_8_2196 r0 *1 0,0
Xsg13cmos5l_decap_8_2196 VPWR VGND sg13cmos5l_decap_8
* cell instance sg13cmos5l_decap_8_2197 r0 *1 0,0
Xsg13cmos5l_decap_8_2197 VPWR VGND sg13cmos5l_decap_8
* cell instance sg13cmos5l_decap_8_2198 r0 *1 0,0
Xsg13cmos5l_decap_8_2198 VPWR VGND sg13cmos5l_decap_8
* cell instance sg13cmos5l_decap_8_2199 r0 *1 0,0
Xsg13cmos5l_decap_8_2199 VPWR VGND sg13cmos5l_decap_8
* cell instance sg13cmos5l_decap_8_2200 r0 *1 0,0
Xsg13cmos5l_decap_8_2200 VPWR VGND sg13cmos5l_decap_8
* cell instance sg13cmos5l_decap_8_2201 r0 *1 0,0
Xsg13cmos5l_decap_8_2201 VPWR VGND sg13cmos5l_decap_8
* cell instance sg13cmos5l_decap_8_2202 r0 *1 0,0
Xsg13cmos5l_decap_8_2202 VPWR VGND sg13cmos5l_decap_8
* cell instance sg13cmos5l_decap_8_2203 r0 *1 0,0
Xsg13cmos5l_decap_8_2203 VPWR VGND sg13cmos5l_decap_8
* cell instance sg13cmos5l_decap_8_2204 r0 *1 0,0
Xsg13cmos5l_decap_8_2204 VPWR VGND sg13cmos5l_decap_8
* cell instance sg13cmos5l_decap_8_2205 r0 *1 0,0
Xsg13cmos5l_decap_8_2205 VPWR VGND sg13cmos5l_decap_8
* cell instance sg13cmos5l_decap_8_2206 r0 *1 0,0
Xsg13cmos5l_decap_8_2206 VPWR VGND sg13cmos5l_decap_8
* cell instance sg13cmos5l_decap_8_2207 r0 *1 0,0
Xsg13cmos5l_decap_8_2207 VPWR VGND sg13cmos5l_decap_8
* cell instance sg13cmos5l_decap_8_2208 r0 *1 0,0
Xsg13cmos5l_decap_8_2208 VPWR VGND sg13cmos5l_decap_8
* cell instance sg13cmos5l_decap_8_2209 r0 *1 0,0
Xsg13cmos5l_decap_8_2209 VPWR VGND sg13cmos5l_decap_8
* cell instance sg13cmos5l_decap_8_2210 r0 *1 0,0
Xsg13cmos5l_decap_8_2210 VPWR VGND sg13cmos5l_decap_8
* cell instance sg13cmos5l_decap_8_2211 r0 *1 0,0
Xsg13cmos5l_decap_8_2211 VPWR VGND sg13cmos5l_decap_8
* cell instance sg13cmos5l_decap_8_2212 r0 *1 0,0
Xsg13cmos5l_decap_8_2212 VPWR VGND sg13cmos5l_decap_8
* cell instance sg13cmos5l_decap_8_2213 r0 *1 0,0
Xsg13cmos5l_decap_8_2213 VPWR VGND sg13cmos5l_decap_8
* cell instance sg13cmos5l_decap_8_2214 r0 *1 0,0
Xsg13cmos5l_decap_8_2214 VPWR VGND sg13cmos5l_decap_8
* cell instance sg13cmos5l_decap_8_2215 r0 *1 0,0
Xsg13cmos5l_decap_8_2215 VPWR VGND sg13cmos5l_decap_8
* cell instance sg13cmos5l_decap_8_2216 r0 *1 0,0
Xsg13cmos5l_decap_8_2216 VPWR VGND sg13cmos5l_decap_8
* cell instance sg13cmos5l_decap_8_2217 r0 *1 0,0
Xsg13cmos5l_decap_8_2217 VPWR VGND sg13cmos5l_decap_8
* cell instance sg13cmos5l_decap_8_2218 r0 *1 0,0
Xsg13cmos5l_decap_8_2218 VPWR VGND sg13cmos5l_decap_8
* cell instance sg13cmos5l_decap_8_2219 r0 *1 0,0
Xsg13cmos5l_decap_8_2219 VPWR VGND sg13cmos5l_decap_8
* cell instance sg13cmos5l_decap_8_2220 r0 *1 0,0
Xsg13cmos5l_decap_8_2220 VPWR VGND sg13cmos5l_decap_8
* cell instance sg13cmos5l_decap_8_2221 r0 *1 0,0
Xsg13cmos5l_decap_8_2221 VPWR VGND sg13cmos5l_decap_8
* cell instance sg13cmos5l_decap_8_2222 r0 *1 0,0
Xsg13cmos5l_decap_8_2222 VPWR VGND sg13cmos5l_decap_8
* cell instance sg13cmos5l_decap_8_2223 r0 *1 0,0
Xsg13cmos5l_decap_8_2223 VPWR VGND sg13cmos5l_decap_8
* cell instance sg13cmos5l_decap_8_2224 r0 *1 0,0
Xsg13cmos5l_decap_8_2224 VPWR VGND sg13cmos5l_decap_8
* cell instance sg13cmos5l_decap_8_2225 r0 *1 0,0
Xsg13cmos5l_decap_8_2225 VPWR VGND sg13cmos5l_decap_8
* cell instance sg13cmos5l_decap_8_2226 r0 *1 0,0
Xsg13cmos5l_decap_8_2226 VPWR VGND sg13cmos5l_decap_8
* cell instance sg13cmos5l_decap_8_2227 r0 *1 0,0
Xsg13cmos5l_decap_8_2227 VPWR VGND sg13cmos5l_decap_8
* cell instance sg13cmos5l_decap_8_2228 r0 *1 0,0
Xsg13cmos5l_decap_8_2228 VPWR VGND sg13cmos5l_decap_8
* cell instance sg13cmos5l_decap_8_2229 r0 *1 0,0
Xsg13cmos5l_decap_8_2229 VPWR VGND sg13cmos5l_decap_8
* cell instance sg13cmos5l_decap_8_2230 r0 *1 0,0
Xsg13cmos5l_decap_8_2230 VPWR VGND sg13cmos5l_decap_8
* cell instance sg13cmos5l_decap_8_2231 r0 *1 0,0
Xsg13cmos5l_decap_8_2231 VPWR VGND sg13cmos5l_decap_8
* cell instance sg13cmos5l_decap_8_2232 r0 *1 0,0
Xsg13cmos5l_decap_8_2232 VPWR VGND sg13cmos5l_decap_8
* cell instance sg13cmos5l_decap_8_2233 r0 *1 0,0
Xsg13cmos5l_decap_8_2233 VPWR VGND sg13cmos5l_decap_8
* cell instance sg13cmos5l_decap_8_2234 r0 *1 0,0
Xsg13cmos5l_decap_8_2234 VPWR VGND sg13cmos5l_decap_8
* cell instance sg13cmos5l_decap_8_2235 r0 *1 0,0
Xsg13cmos5l_decap_8_2235 VPWR VGND sg13cmos5l_decap_8
* cell instance sg13cmos5l_decap_8_2236 r0 *1 0,0
Xsg13cmos5l_decap_8_2236 VPWR VGND sg13cmos5l_decap_8
* cell instance sg13cmos5l_decap_8_2237 r0 *1 0,0
Xsg13cmos5l_decap_8_2237 VPWR VGND sg13cmos5l_decap_8
* cell instance sg13cmos5l_decap_8_2238 r0 *1 0,0
Xsg13cmos5l_decap_8_2238 VPWR VGND sg13cmos5l_decap_8
* cell instance sg13cmos5l_decap_8_2239 r0 *1 0,0
Xsg13cmos5l_decap_8_2239 VPWR VGND sg13cmos5l_decap_8
* cell instance sg13cmos5l_decap_8_2240 r0 *1 0,0
Xsg13cmos5l_decap_8_2240 VPWR VGND sg13cmos5l_decap_8
* cell instance sg13cmos5l_decap_8_2241 r0 *1 0,0
Xsg13cmos5l_decap_8_2241 VPWR VGND sg13cmos5l_decap_8
* cell instance sg13cmos5l_decap_8_2242 r0 *1 0,0
Xsg13cmos5l_decap_8_2242 VPWR VGND sg13cmos5l_decap_8
* cell instance sg13cmos5l_decap_8_2243 r0 *1 0,0
Xsg13cmos5l_decap_8_2243 VPWR VGND sg13cmos5l_decap_8
* cell instance sg13cmos5l_decap_8_2244 r0 *1 0,0
Xsg13cmos5l_decap_8_2244 VPWR VGND sg13cmos5l_decap_8
* cell instance sg13cmos5l_decap_8_2245 r0 *1 0,0
Xsg13cmos5l_decap_8_2245 VPWR VGND sg13cmos5l_decap_8
* cell instance sg13cmos5l_decap_8_2246 r0 *1 0,0
Xsg13cmos5l_decap_8_2246 VPWR VGND sg13cmos5l_decap_8
* cell instance sg13cmos5l_decap_8_2247 r0 *1 0,0
Xsg13cmos5l_decap_8_2247 VPWR VGND sg13cmos5l_decap_8
* cell instance sg13cmos5l_decap_8_2248 r0 *1 0,0
Xsg13cmos5l_decap_8_2248 VPWR VGND sg13cmos5l_decap_8
* cell instance sg13cmos5l_decap_8_2249 r0 *1 0,0
Xsg13cmos5l_decap_8_2249 VPWR VGND sg13cmos5l_decap_8
* cell instance sg13cmos5l_decap_8_2250 r0 *1 0,0
Xsg13cmos5l_decap_8_2250 VPWR VGND sg13cmos5l_decap_8
* cell instance sg13cmos5l_decap_8_2251 r0 *1 0,0
Xsg13cmos5l_decap_8_2251 VPWR VGND sg13cmos5l_decap_8
* cell instance sg13cmos5l_decap_8_2252 r0 *1 0,0
Xsg13cmos5l_decap_8_2252 VPWR VGND sg13cmos5l_decap_8
* cell instance sg13cmos5l_decap_8_2253 r0 *1 0,0
Xsg13cmos5l_decap_8_2253 VPWR VGND sg13cmos5l_decap_8
* cell instance sg13cmos5l_decap_8_2254 r0 *1 0,0
Xsg13cmos5l_decap_8_2254 VPWR VGND sg13cmos5l_decap_8
* cell instance sg13cmos5l_decap_8_2255 r0 *1 0,0
Xsg13cmos5l_decap_8_2255 VPWR VGND sg13cmos5l_decap_8
* cell instance sg13cmos5l_decap_8_2256 r0 *1 0,0
Xsg13cmos5l_decap_8_2256 VPWR VGND sg13cmos5l_decap_8
* cell instance sg13cmos5l_decap_8_2257 r0 *1 0,0
Xsg13cmos5l_decap_8_2257 VPWR VGND sg13cmos5l_decap_8
* cell instance sg13cmos5l_decap_8_2258 r0 *1 0,0
Xsg13cmos5l_decap_8_2258 VPWR VGND sg13cmos5l_decap_8
* cell instance sg13cmos5l_decap_8_2259 r0 *1 0,0
Xsg13cmos5l_decap_8_2259 VPWR VGND sg13cmos5l_decap_8
* cell instance sg13cmos5l_decap_8_2260 r0 *1 0,0
Xsg13cmos5l_decap_8_2260 VPWR VGND sg13cmos5l_decap_8
* cell instance sg13cmos5l_decap_8_2261 r0 *1 0,0
Xsg13cmos5l_decap_8_2261 VPWR VGND sg13cmos5l_decap_8
* cell instance sg13cmos5l_decap_8_2262 r0 *1 0,0
Xsg13cmos5l_decap_8_2262 VPWR VGND sg13cmos5l_decap_8
* cell instance sg13cmos5l_decap_8_2263 r0 *1 0,0
Xsg13cmos5l_decap_8_2263 VPWR VGND sg13cmos5l_decap_8
* cell instance sg13cmos5l_decap_8_2264 r0 *1 0,0
Xsg13cmos5l_decap_8_2264 VPWR VGND sg13cmos5l_decap_8
* cell instance sg13cmos5l_decap_8_2265 r0 *1 0,0
Xsg13cmos5l_decap_8_2265 VPWR VGND sg13cmos5l_decap_8
* cell instance sg13cmos5l_decap_8_2266 r0 *1 0,0
Xsg13cmos5l_decap_8_2266 VPWR VGND sg13cmos5l_decap_8
* cell instance sg13cmos5l_decap_8_2267 r0 *1 0,0
Xsg13cmos5l_decap_8_2267 VPWR VGND sg13cmos5l_decap_8
* cell instance sg13cmos5l_decap_8_2268 r0 *1 0,0
Xsg13cmos5l_decap_8_2268 VPWR VGND sg13cmos5l_decap_8
* cell instance sg13cmos5l_decap_8_2269 r0 *1 0,0
Xsg13cmos5l_decap_8_2269 VPWR VGND sg13cmos5l_decap_8
* cell instance sg13cmos5l_decap_8_2270 r0 *1 0,0
Xsg13cmos5l_decap_8_2270 VPWR VGND sg13cmos5l_decap_8
* cell instance sg13cmos5l_decap_8_2271 r0 *1 0,0
Xsg13cmos5l_decap_8_2271 VPWR VGND sg13cmos5l_decap_8
* cell instance sg13cmos5l_decap_8_2272 r0 *1 0,0
Xsg13cmos5l_decap_8_2272 VPWR VGND sg13cmos5l_decap_8
* cell instance sg13cmos5l_decap_8_2273 r0 *1 0,0
Xsg13cmos5l_decap_8_2273 VPWR VGND sg13cmos5l_decap_8
* cell instance sg13cmos5l_decap_8_2274 r0 *1 0,0
Xsg13cmos5l_decap_8_2274 VPWR VGND sg13cmos5l_decap_8
* cell instance sg13cmos5l_decap_8_2275 r0 *1 0,0
Xsg13cmos5l_decap_8_2275 VPWR VGND sg13cmos5l_decap_8
* cell instance sg13cmos5l_decap_8_2276 r0 *1 0,0
Xsg13cmos5l_decap_8_2276 VPWR VGND sg13cmos5l_decap_8
* cell instance sg13cmos5l_decap_8_2277 r0 *1 0,0
Xsg13cmos5l_decap_8_2277 VPWR VGND sg13cmos5l_decap_8
* cell instance sg13cmos5l_decap_8_2278 r0 *1 0,0
Xsg13cmos5l_decap_8_2278 VPWR VGND sg13cmos5l_decap_8
* cell instance sg13cmos5l_decap_8_2279 r0 *1 0,0
Xsg13cmos5l_decap_8_2279 VPWR VGND sg13cmos5l_decap_8
* cell instance sg13cmos5l_decap_8_2280 r0 *1 0,0
Xsg13cmos5l_decap_8_2280 VPWR VGND sg13cmos5l_decap_8
* cell instance sg13cmos5l_decap_8_2281 r0 *1 0,0
Xsg13cmos5l_decap_8_2281 VPWR VGND sg13cmos5l_decap_8
* cell instance sg13cmos5l_decap_8_2282 r0 *1 0,0
Xsg13cmos5l_decap_8_2282 VPWR VGND sg13cmos5l_decap_8
* cell instance sg13cmos5l_decap_8_2283 r0 *1 0,0
Xsg13cmos5l_decap_8_2283 VPWR VGND sg13cmos5l_decap_8
* cell instance sg13cmos5l_decap_8_2284 r0 *1 0,0
Xsg13cmos5l_decap_8_2284 VPWR VGND sg13cmos5l_decap_8
* cell instance sg13cmos5l_decap_8_2285 r0 *1 0,0
Xsg13cmos5l_decap_8_2285 VPWR VGND sg13cmos5l_decap_8
* cell instance sg13cmos5l_decap_8_2286 r0 *1 0,0
Xsg13cmos5l_decap_8_2286 VPWR VGND sg13cmos5l_decap_8
* cell instance sg13cmos5l_decap_8_2287 r0 *1 0,0
Xsg13cmos5l_decap_8_2287 VPWR VGND sg13cmos5l_decap_8
* cell instance sg13cmos5l_decap_8_2288 r0 *1 0,0
Xsg13cmos5l_decap_8_2288 VPWR VGND sg13cmos5l_decap_8
* cell instance sg13cmos5l_decap_8_2289 r0 *1 0,0
Xsg13cmos5l_decap_8_2289 VPWR VGND sg13cmos5l_decap_8
* cell instance sg13cmos5l_decap_8_2290 r0 *1 0,0
Xsg13cmos5l_decap_8_2290 VPWR VGND sg13cmos5l_decap_8
* cell instance sg13cmos5l_decap_8_2291 r0 *1 0,0
Xsg13cmos5l_decap_8_2291 VPWR VGND sg13cmos5l_decap_8
* cell instance sg13cmos5l_decap_8_2292 r0 *1 0,0
Xsg13cmos5l_decap_8_2292 VPWR VGND sg13cmos5l_decap_8
* cell instance sg13cmos5l_decap_8_2293 r0 *1 0,0
Xsg13cmos5l_decap_8_2293 VPWR VGND sg13cmos5l_decap_8
* cell instance sg13cmos5l_decap_8_2294 r0 *1 0,0
Xsg13cmos5l_decap_8_2294 VPWR VGND sg13cmos5l_decap_8
* cell instance sg13cmos5l_decap_8_2295 r0 *1 0,0
Xsg13cmos5l_decap_8_2295 VPWR VGND sg13cmos5l_decap_8
* cell instance sg13cmos5l_decap_8_2296 r0 *1 0,0
Xsg13cmos5l_decap_8_2296 VPWR VGND sg13cmos5l_decap_8
* cell instance sg13cmos5l_decap_8_2297 r0 *1 0,0
Xsg13cmos5l_decap_8_2297 VPWR VGND sg13cmos5l_decap_8
* cell instance sg13cmos5l_decap_8_2298 r0 *1 0,0
Xsg13cmos5l_decap_8_2298 VPWR VGND sg13cmos5l_decap_8
* cell instance sg13cmos5l_decap_8_2299 r0 *1 0,0
Xsg13cmos5l_decap_8_2299 VPWR VGND sg13cmos5l_decap_8
* cell instance sg13cmos5l_decap_8_2300 r0 *1 0,0
Xsg13cmos5l_decap_8_2300 VPWR VGND sg13cmos5l_decap_8
* cell instance sg13cmos5l_decap_8_2301 r0 *1 0,0
Xsg13cmos5l_decap_8_2301 VPWR VGND sg13cmos5l_decap_8
* cell instance sg13cmos5l_decap_8_2302 r0 *1 0,0
Xsg13cmos5l_decap_8_2302 VPWR VGND sg13cmos5l_decap_8
* cell instance sg13cmos5l_decap_8_2303 r0 *1 0,0
Xsg13cmos5l_decap_8_2303 VPWR VGND sg13cmos5l_decap_8
* cell instance sg13cmos5l_decap_8_2304 r0 *1 0,0
Xsg13cmos5l_decap_8_2304 VPWR VGND sg13cmos5l_decap_8
* cell instance sg13cmos5l_decap_8_2305 r0 *1 0,0
Xsg13cmos5l_decap_8_2305 VPWR VGND sg13cmos5l_decap_8
* cell instance sg13cmos5l_decap_8_2306 r0 *1 0,0
Xsg13cmos5l_decap_8_2306 VPWR VGND sg13cmos5l_decap_8
* cell instance sg13cmos5l_decap_8_2307 r0 *1 0,0
Xsg13cmos5l_decap_8_2307 VPWR VGND sg13cmos5l_decap_8
* cell instance sg13cmos5l_decap_8_2308 r0 *1 0,0
Xsg13cmos5l_decap_8_2308 VPWR VGND sg13cmos5l_decap_8
* cell instance sg13cmos5l_decap_8_2309 r0 *1 0,0
Xsg13cmos5l_decap_8_2309 VPWR VGND sg13cmos5l_decap_8
* cell instance sg13cmos5l_decap_8_2310 r0 *1 0,0
Xsg13cmos5l_decap_8_2310 VPWR VGND sg13cmos5l_decap_8
* cell instance sg13cmos5l_decap_8_2311 r0 *1 0,0
Xsg13cmos5l_decap_8_2311 VPWR VGND sg13cmos5l_decap_8
* cell instance sg13cmos5l_decap_8_2312 r0 *1 0,0
Xsg13cmos5l_decap_8_2312 VPWR VGND sg13cmos5l_decap_8
* cell instance sg13cmos5l_decap_8_2313 r0 *1 0,0
Xsg13cmos5l_decap_8_2313 VPWR VGND sg13cmos5l_decap_8
* cell instance sg13cmos5l_decap_8_2314 r0 *1 0,0
Xsg13cmos5l_decap_8_2314 VPWR VGND sg13cmos5l_decap_8
* cell instance sg13cmos5l_decap_8_2315 r0 *1 0,0
Xsg13cmos5l_decap_8_2315 VPWR VGND sg13cmos5l_decap_8
* cell instance sg13cmos5l_decap_8_2316 r0 *1 0,0
Xsg13cmos5l_decap_8_2316 VPWR VGND sg13cmos5l_decap_8
* cell instance sg13cmos5l_decap_8_2317 r0 *1 0,0
Xsg13cmos5l_decap_8_2317 VPWR VGND sg13cmos5l_decap_8
* cell instance sg13cmos5l_decap_8_2318 r0 *1 0,0
Xsg13cmos5l_decap_8_2318 VPWR VGND sg13cmos5l_decap_8
* cell instance sg13cmos5l_decap_8_2319 r0 *1 0,0
Xsg13cmos5l_decap_8_2319 VPWR VGND sg13cmos5l_decap_8
* cell instance sg13cmos5l_decap_8_2320 r0 *1 0,0
Xsg13cmos5l_decap_8_2320 VPWR VGND sg13cmos5l_decap_8
* cell instance sg13cmos5l_decap_8_2321 r0 *1 0,0
Xsg13cmos5l_decap_8_2321 VPWR VGND sg13cmos5l_decap_8
* cell instance sg13cmos5l_decap_8_2322 r0 *1 0,0
Xsg13cmos5l_decap_8_2322 VPWR VGND sg13cmos5l_decap_8
* cell instance sg13cmos5l_decap_8_2323 r0 *1 0,0
Xsg13cmos5l_decap_8_2323 VPWR VGND sg13cmos5l_decap_8
* cell instance sg13cmos5l_decap_8_2324 r0 *1 0,0
Xsg13cmos5l_decap_8_2324 VPWR VGND sg13cmos5l_decap_8
* cell instance sg13cmos5l_decap_8_2325 r0 *1 0,0
Xsg13cmos5l_decap_8_2325 VPWR VGND sg13cmos5l_decap_8
* cell instance sg13cmos5l_decap_8_2326 r0 *1 0,0
Xsg13cmos5l_decap_8_2326 VPWR VGND sg13cmos5l_decap_8
* cell instance sg13cmos5l_decap_8_2327 r0 *1 0,0
Xsg13cmos5l_decap_8_2327 VPWR VGND sg13cmos5l_decap_8
* cell instance sg13cmos5l_decap_8_2328 r0 *1 0,0
Xsg13cmos5l_decap_8_2328 VPWR VGND sg13cmos5l_decap_8
* cell instance sg13cmos5l_decap_8_2329 r0 *1 0,0
Xsg13cmos5l_decap_8_2329 VPWR VGND sg13cmos5l_decap_8
* cell instance sg13cmos5l_decap_8_2330 r0 *1 0,0
Xsg13cmos5l_decap_8_2330 VPWR VGND sg13cmos5l_decap_8
* cell instance sg13cmos5l_decap_8_2331 r0 *1 0,0
Xsg13cmos5l_decap_8_2331 VPWR VGND sg13cmos5l_decap_8
* cell instance sg13cmos5l_decap_8_2332 r0 *1 0,0
Xsg13cmos5l_decap_8_2332 VPWR VGND sg13cmos5l_decap_8
* cell instance sg13cmos5l_decap_8_2333 r0 *1 0,0
Xsg13cmos5l_decap_8_2333 VPWR VGND sg13cmos5l_decap_8
* cell instance sg13cmos5l_decap_8_2334 r0 *1 0,0
Xsg13cmos5l_decap_8_2334 VPWR VGND sg13cmos5l_decap_8
* cell instance sg13cmos5l_decap_8_2335 r0 *1 0,0
Xsg13cmos5l_decap_8_2335 VPWR VGND sg13cmos5l_decap_8
* cell instance sg13cmos5l_decap_8_2336 r0 *1 0,0
Xsg13cmos5l_decap_8_2336 VPWR VGND sg13cmos5l_decap_8
* cell instance sg13cmos5l_decap_8_2337 r0 *1 0,0
Xsg13cmos5l_decap_8_2337 VPWR VGND sg13cmos5l_decap_8
* cell instance sg13cmos5l_decap_8_2338 r0 *1 0,0
Xsg13cmos5l_decap_8_2338 VPWR VGND sg13cmos5l_decap_8
* cell instance sg13cmos5l_decap_8_2339 r0 *1 0,0
Xsg13cmos5l_decap_8_2339 VPWR VGND sg13cmos5l_decap_8
* cell instance sg13cmos5l_decap_8_2340 r0 *1 0,0
Xsg13cmos5l_decap_8_2340 VPWR VGND sg13cmos5l_decap_8
* cell instance sg13cmos5l_decap_8_2341 r0 *1 0,0
Xsg13cmos5l_decap_8_2341 VPWR VGND sg13cmos5l_decap_8
* cell instance sg13cmos5l_decap_8_2342 r0 *1 0,0
Xsg13cmos5l_decap_8_2342 VPWR VGND sg13cmos5l_decap_8
* cell instance sg13cmos5l_decap_8_2343 r0 *1 0,0
Xsg13cmos5l_decap_8_2343 VPWR VGND sg13cmos5l_decap_8
* cell instance sg13cmos5l_decap_8_2344 r0 *1 0,0
Xsg13cmos5l_decap_8_2344 VPWR VGND sg13cmos5l_decap_8
* cell instance sg13cmos5l_decap_8_2345 r0 *1 0,0
Xsg13cmos5l_decap_8_2345 VPWR VGND sg13cmos5l_decap_8
* cell instance sg13cmos5l_decap_8_2346 r0 *1 0,0
Xsg13cmos5l_decap_8_2346 VPWR VGND sg13cmos5l_decap_8
* cell instance sg13cmos5l_decap_8_2347 r0 *1 0,0
Xsg13cmos5l_decap_8_2347 VPWR VGND sg13cmos5l_decap_8
* cell instance sg13cmos5l_decap_8_2348 r0 *1 0,0
Xsg13cmos5l_decap_8_2348 VPWR VGND sg13cmos5l_decap_8
* cell instance sg13cmos5l_decap_8_2349 r0 *1 0,0
Xsg13cmos5l_decap_8_2349 VPWR VGND sg13cmos5l_decap_8
* cell instance sg13cmos5l_decap_8_2350 r0 *1 0,0
Xsg13cmos5l_decap_8_2350 VPWR VGND sg13cmos5l_decap_8
* cell instance sg13cmos5l_decap_8_2351 r0 *1 0,0
Xsg13cmos5l_decap_8_2351 VPWR VGND sg13cmos5l_decap_8
* cell instance sg13cmos5l_decap_8_2352 r0 *1 0,0
Xsg13cmos5l_decap_8_2352 VPWR VGND sg13cmos5l_decap_8
* cell instance sg13cmos5l_decap_8_2353 r0 *1 0,0
Xsg13cmos5l_decap_8_2353 VPWR VGND sg13cmos5l_decap_8
* cell instance sg13cmos5l_decap_8_2354 r0 *1 0,0
Xsg13cmos5l_decap_8_2354 VPWR VGND sg13cmos5l_decap_8
* cell instance sg13cmos5l_decap_8_2355 r0 *1 0,0
Xsg13cmos5l_decap_8_2355 VPWR VGND sg13cmos5l_decap_8
* cell instance sg13cmos5l_decap_8_2356 r0 *1 0,0
Xsg13cmos5l_decap_8_2356 VPWR VGND sg13cmos5l_decap_8
* cell instance sg13cmos5l_decap_8_2357 r0 *1 0,0
Xsg13cmos5l_decap_8_2357 VPWR VGND sg13cmos5l_decap_8
* cell instance sg13cmos5l_decap_8_2358 r0 *1 0,0
Xsg13cmos5l_decap_8_2358 VPWR VGND sg13cmos5l_decap_8
* cell instance sg13cmos5l_decap_8_2359 r0 *1 0,0
Xsg13cmos5l_decap_8_2359 VPWR VGND sg13cmos5l_decap_8
* cell instance sg13cmos5l_decap_8_2360 r0 *1 0,0
Xsg13cmos5l_decap_8_2360 VPWR VGND sg13cmos5l_decap_8
* cell instance sg13cmos5l_decap_8_2361 r0 *1 0,0
Xsg13cmos5l_decap_8_2361 VPWR VGND sg13cmos5l_decap_8
* cell instance sg13cmos5l_decap_8_2362 r0 *1 0,0
Xsg13cmos5l_decap_8_2362 VPWR VGND sg13cmos5l_decap_8
* cell instance sg13cmos5l_decap_8_2363 r0 *1 0,0
Xsg13cmos5l_decap_8_2363 VPWR VGND sg13cmos5l_decap_8
* cell instance sg13cmos5l_decap_8_2364 r0 *1 0,0
Xsg13cmos5l_decap_8_2364 VPWR VGND sg13cmos5l_decap_8
* cell instance sg13cmos5l_decap_8_2365 r0 *1 0,0
Xsg13cmos5l_decap_8_2365 VPWR VGND sg13cmos5l_decap_8
* cell instance sg13cmos5l_decap_8_2366 r0 *1 0,0
Xsg13cmos5l_decap_8_2366 VPWR VGND sg13cmos5l_decap_8
* cell instance sg13cmos5l_decap_8_2367 r0 *1 0,0
Xsg13cmos5l_decap_8_2367 VPWR VGND sg13cmos5l_decap_8
* cell instance sg13cmos5l_decap_8_2368 r0 *1 0,0
Xsg13cmos5l_decap_8_2368 VPWR VGND sg13cmos5l_decap_8
* cell instance sg13cmos5l_decap_8_2369 r0 *1 0,0
Xsg13cmos5l_decap_8_2369 VPWR VGND sg13cmos5l_decap_8
* cell instance sg13cmos5l_decap_8_2370 r0 *1 0,0
Xsg13cmos5l_decap_8_2370 VPWR VGND sg13cmos5l_decap_8
* cell instance sg13cmos5l_decap_8_2371 r0 *1 0,0
Xsg13cmos5l_decap_8_2371 VPWR VGND sg13cmos5l_decap_8
* cell instance sg13cmos5l_decap_8_2372 r0 *1 0,0
Xsg13cmos5l_decap_8_2372 VPWR VGND sg13cmos5l_decap_8
* cell instance sg13cmos5l_decap_8_2373 r0 *1 0,0
Xsg13cmos5l_decap_8_2373 VPWR VGND sg13cmos5l_decap_8
* cell instance sg13cmos5l_decap_8_2374 r0 *1 0,0
Xsg13cmos5l_decap_8_2374 VPWR VGND sg13cmos5l_decap_8
* cell instance sg13cmos5l_decap_8_2375 r0 *1 0,0
Xsg13cmos5l_decap_8_2375 VPWR VGND sg13cmos5l_decap_8
* cell instance sg13cmos5l_decap_8_2376 r0 *1 0,0
Xsg13cmos5l_decap_8_2376 VPWR VGND sg13cmos5l_decap_8
* cell instance sg13cmos5l_decap_8_2377 r0 *1 0,0
Xsg13cmos5l_decap_8_2377 VPWR VGND sg13cmos5l_decap_8
* cell instance sg13cmos5l_decap_8_2378 r0 *1 0,0
Xsg13cmos5l_decap_8_2378 VPWR VGND sg13cmos5l_decap_8
* cell instance sg13cmos5l_decap_8_2379 r0 *1 0,0
Xsg13cmos5l_decap_8_2379 VPWR VGND sg13cmos5l_decap_8
* cell instance sg13cmos5l_decap_8_2380 r0 *1 0,0
Xsg13cmos5l_decap_8_2380 VPWR VGND sg13cmos5l_decap_8
* cell instance sg13cmos5l_decap_8_2381 r0 *1 0,0
Xsg13cmos5l_decap_8_2381 VPWR VGND sg13cmos5l_decap_8
* cell instance sg13cmos5l_decap_8_2382 r0 *1 0,0
Xsg13cmos5l_decap_8_2382 VPWR VGND sg13cmos5l_decap_8
* cell instance sg13cmos5l_decap_8_2383 r0 *1 0,0
Xsg13cmos5l_decap_8_2383 VPWR VGND sg13cmos5l_decap_8
* cell instance sg13cmos5l_decap_8_2384 r0 *1 0,0
Xsg13cmos5l_decap_8_2384 VPWR VGND sg13cmos5l_decap_8
* cell instance sg13cmos5l_decap_8_2385 r0 *1 0,0
Xsg13cmos5l_decap_8_2385 VPWR VGND sg13cmos5l_decap_8
* cell instance sg13cmos5l_decap_8_2386 r0 *1 0,0
Xsg13cmos5l_decap_8_2386 VPWR VGND sg13cmos5l_decap_8
* cell instance sg13cmos5l_decap_8_2387 r0 *1 0,0
Xsg13cmos5l_decap_8_2387 VPWR VGND sg13cmos5l_decap_8
* cell instance sg13cmos5l_decap_8_2388 r0 *1 0,0
Xsg13cmos5l_decap_8_2388 VPWR VGND sg13cmos5l_decap_8
* cell instance sg13cmos5l_decap_8_2389 r0 *1 0,0
Xsg13cmos5l_decap_8_2389 VPWR VGND sg13cmos5l_decap_8
* cell instance sg13cmos5l_decap_8_2390 r0 *1 0,0
Xsg13cmos5l_decap_8_2390 VPWR VGND sg13cmos5l_decap_8
* cell instance sg13cmos5l_decap_8_2391 r0 *1 0,0
Xsg13cmos5l_decap_8_2391 VPWR VGND sg13cmos5l_decap_8
* cell instance sg13cmos5l_decap_8_2392 r0 *1 0,0
Xsg13cmos5l_decap_8_2392 VPWR VGND sg13cmos5l_decap_8
* cell instance sg13cmos5l_decap_8_2393 r0 *1 0,0
Xsg13cmos5l_decap_8_2393 VPWR VGND sg13cmos5l_decap_8
* cell instance sg13cmos5l_decap_8_2394 r0 *1 0,0
Xsg13cmos5l_decap_8_2394 VPWR VGND sg13cmos5l_decap_8
* cell instance sg13cmos5l_decap_8_2395 r0 *1 0,0
Xsg13cmos5l_decap_8_2395 VPWR VGND sg13cmos5l_decap_8
* cell instance sg13cmos5l_decap_8_2396 r0 *1 0,0
Xsg13cmos5l_decap_8_2396 VPWR VGND sg13cmos5l_decap_8
* cell instance sg13cmos5l_decap_8_2397 r0 *1 0,0
Xsg13cmos5l_decap_8_2397 VPWR VGND sg13cmos5l_decap_8
* cell instance sg13cmos5l_decap_8_2398 r0 *1 0,0
Xsg13cmos5l_decap_8_2398 VPWR VGND sg13cmos5l_decap_8
* cell instance sg13cmos5l_decap_8_2399 r0 *1 0,0
Xsg13cmos5l_decap_8_2399 VPWR VGND sg13cmos5l_decap_8
* cell instance sg13cmos5l_decap_8_2400 r0 *1 0,0
Xsg13cmos5l_decap_8_2400 VPWR VGND sg13cmos5l_decap_8
* cell instance sg13cmos5l_decap_8_2401 r0 *1 0,0
Xsg13cmos5l_decap_8_2401 VPWR VGND sg13cmos5l_decap_8
* cell instance sg13cmos5l_decap_8_2402 r0 *1 0,0
Xsg13cmos5l_decap_8_2402 VPWR VGND sg13cmos5l_decap_8
* cell instance sg13cmos5l_decap_8_2403 r0 *1 0,0
Xsg13cmos5l_decap_8_2403 VPWR VGND sg13cmos5l_decap_8
* cell instance sg13cmos5l_decap_8_2404 r0 *1 0,0
Xsg13cmos5l_decap_8_2404 VPWR VGND sg13cmos5l_decap_8
* cell instance sg13cmos5l_decap_8_2405 r0 *1 0,0
Xsg13cmos5l_decap_8_2405 VPWR VGND sg13cmos5l_decap_8
* cell instance sg13cmos5l_decap_8_2406 r0 *1 0,0
Xsg13cmos5l_decap_8_2406 VPWR VGND sg13cmos5l_decap_8
* cell instance sg13cmos5l_decap_8_2407 r0 *1 0,0
Xsg13cmos5l_decap_8_2407 VPWR VGND sg13cmos5l_decap_8
* cell instance sg13cmos5l_decap_8_2408 r0 *1 0,0
Xsg13cmos5l_decap_8_2408 VPWR VGND sg13cmos5l_decap_8
* cell instance sg13cmos5l_decap_8_2409 r0 *1 0,0
Xsg13cmos5l_decap_8_2409 VPWR VGND sg13cmos5l_decap_8
* cell instance sg13cmos5l_decap_8_2410 r0 *1 0,0
Xsg13cmos5l_decap_8_2410 VPWR VGND sg13cmos5l_decap_8
* cell instance sg13cmos5l_decap_8_2411 r0 *1 0,0
Xsg13cmos5l_decap_8_2411 VPWR VGND sg13cmos5l_decap_8
* cell instance sg13cmos5l_decap_8_2412 r0 *1 0,0
Xsg13cmos5l_decap_8_2412 VPWR VGND sg13cmos5l_decap_8
* cell instance sg13cmos5l_decap_8_2413 r0 *1 0,0
Xsg13cmos5l_decap_8_2413 VPWR VGND sg13cmos5l_decap_8
* cell instance sg13cmos5l_decap_8_2414 r0 *1 0,0
Xsg13cmos5l_decap_8_2414 VPWR VGND sg13cmos5l_decap_8
* cell instance sg13cmos5l_decap_8_2415 r0 *1 0,0
Xsg13cmos5l_decap_8_2415 VPWR VGND sg13cmos5l_decap_8
* cell instance sg13cmos5l_decap_8_2416 r0 *1 0,0
Xsg13cmos5l_decap_8_2416 VPWR VGND sg13cmos5l_decap_8
* cell instance sg13cmos5l_decap_8_2417 r0 *1 0,0
Xsg13cmos5l_decap_8_2417 VPWR VGND sg13cmos5l_decap_8
* cell instance sg13cmos5l_decap_8_2418 r0 *1 0,0
Xsg13cmos5l_decap_8_2418 VPWR VGND sg13cmos5l_decap_8
* cell instance sg13cmos5l_decap_8_2419 r0 *1 0,0
Xsg13cmos5l_decap_8_2419 VPWR VGND sg13cmos5l_decap_8
* cell instance sg13cmos5l_decap_8_2420 r0 *1 0,0
Xsg13cmos5l_decap_8_2420 VPWR VGND sg13cmos5l_decap_8
* cell instance sg13cmos5l_decap_8_2421 r0 *1 0,0
Xsg13cmos5l_decap_8_2421 VPWR VGND sg13cmos5l_decap_8
* cell instance sg13cmos5l_decap_8_2422 r0 *1 0,0
Xsg13cmos5l_decap_8_2422 VPWR VGND sg13cmos5l_decap_8
* cell instance sg13cmos5l_decap_8_2423 r0 *1 0,0
Xsg13cmos5l_decap_8_2423 VPWR VGND sg13cmos5l_decap_8
* cell instance sg13cmos5l_decap_8_2424 r0 *1 0,0
Xsg13cmos5l_decap_8_2424 VPWR VGND sg13cmos5l_decap_8
* cell instance sg13cmos5l_decap_8_2425 r0 *1 0,0
Xsg13cmos5l_decap_8_2425 VPWR VGND sg13cmos5l_decap_8
* cell instance sg13cmos5l_decap_8_2426 r0 *1 0,0
Xsg13cmos5l_decap_8_2426 VPWR VGND sg13cmos5l_decap_8
* cell instance sg13cmos5l_decap_8_2427 r0 *1 0,0
Xsg13cmos5l_decap_8_2427 VPWR VGND sg13cmos5l_decap_8
* cell instance sg13cmos5l_decap_8_2428 r0 *1 0,0
Xsg13cmos5l_decap_8_2428 VPWR VGND sg13cmos5l_decap_8
* cell instance sg13cmos5l_decap_8_2429 r0 *1 0,0
Xsg13cmos5l_decap_8_2429 VPWR VGND sg13cmos5l_decap_8
* cell instance sg13cmos5l_decap_8_2430 r0 *1 0,0
Xsg13cmos5l_decap_8_2430 VPWR VGND sg13cmos5l_decap_8
* cell instance sg13cmos5l_decap_8_2431 r0 *1 0,0
Xsg13cmos5l_decap_8_2431 VPWR VGND sg13cmos5l_decap_8
* cell instance sg13cmos5l_decap_8_2432 r0 *1 0,0
Xsg13cmos5l_decap_8_2432 VPWR VGND sg13cmos5l_decap_8
* cell instance sg13cmos5l_decap_8_2433 r0 *1 0,0
Xsg13cmos5l_decap_8_2433 VPWR VGND sg13cmos5l_decap_8
* cell instance sg13cmos5l_decap_8_2434 r0 *1 0,0
Xsg13cmos5l_decap_8_2434 VPWR VGND sg13cmos5l_decap_8
* cell instance sg13cmos5l_decap_8_2435 r0 *1 0,0
Xsg13cmos5l_decap_8_2435 VPWR VGND sg13cmos5l_decap_8
* cell instance sg13cmos5l_decap_8_2436 r0 *1 0,0
Xsg13cmos5l_decap_8_2436 VPWR VGND sg13cmos5l_decap_8
* cell instance sg13cmos5l_decap_8_2437 r0 *1 0,0
Xsg13cmos5l_decap_8_2437 VPWR VGND sg13cmos5l_decap_8
* cell instance sg13cmos5l_decap_8_2438 r0 *1 0,0
Xsg13cmos5l_decap_8_2438 VPWR VGND sg13cmos5l_decap_8
* cell instance sg13cmos5l_decap_8_2439 r0 *1 0,0
Xsg13cmos5l_decap_8_2439 VPWR VGND sg13cmos5l_decap_8
* cell instance sg13cmos5l_decap_8_2440 r0 *1 0,0
Xsg13cmos5l_decap_8_2440 VPWR VGND sg13cmos5l_decap_8
* cell instance sg13cmos5l_decap_8_2441 r0 *1 0,0
Xsg13cmos5l_decap_8_2441 VPWR VGND sg13cmos5l_decap_8
* cell instance sg13cmos5l_decap_8_2442 r0 *1 0,0
Xsg13cmos5l_decap_8_2442 VPWR VGND sg13cmos5l_decap_8
* cell instance sg13cmos5l_decap_8_2443 r0 *1 0,0
Xsg13cmos5l_decap_8_2443 VPWR VGND sg13cmos5l_decap_8
* cell instance sg13cmos5l_decap_8_2444 r0 *1 0,0
Xsg13cmos5l_decap_8_2444 VPWR VGND sg13cmos5l_decap_8
* cell instance sg13cmos5l_decap_8_2445 r0 *1 0,0
Xsg13cmos5l_decap_8_2445 VPWR VGND sg13cmos5l_decap_8
* cell instance sg13cmos5l_decap_8_2446 r0 *1 0,0
Xsg13cmos5l_decap_8_2446 VPWR VGND sg13cmos5l_decap_8
* cell instance sg13cmos5l_decap_8_2447 r0 *1 0,0
Xsg13cmos5l_decap_8_2447 VPWR VGND sg13cmos5l_decap_8
* cell instance sg13cmos5l_decap_8_2448 r0 *1 0,0
Xsg13cmos5l_decap_8_2448 VPWR VGND sg13cmos5l_decap_8
* cell instance sg13cmos5l_decap_8_2449 r0 *1 0,0
Xsg13cmos5l_decap_8_2449 VPWR VGND sg13cmos5l_decap_8
* cell instance sg13cmos5l_decap_8_2450 r0 *1 0,0
Xsg13cmos5l_decap_8_2450 VPWR VGND sg13cmos5l_decap_8
* cell instance sg13cmos5l_decap_8_2451 r0 *1 0,0
Xsg13cmos5l_decap_8_2451 VPWR VGND sg13cmos5l_decap_8
* cell instance sg13cmos5l_decap_8_2452 r0 *1 0,0
Xsg13cmos5l_decap_8_2452 VPWR VGND sg13cmos5l_decap_8
* cell instance sg13cmos5l_decap_8_2453 r0 *1 0,0
Xsg13cmos5l_decap_8_2453 VPWR VGND sg13cmos5l_decap_8
* cell instance sg13cmos5l_decap_8_2454 r0 *1 0,0
Xsg13cmos5l_decap_8_2454 VPWR VGND sg13cmos5l_decap_8
* cell instance sg13cmos5l_decap_8_2455 r0 *1 0,0
Xsg13cmos5l_decap_8_2455 VPWR VGND sg13cmos5l_decap_8
* cell instance sg13cmos5l_decap_8_2456 r0 *1 0,0
Xsg13cmos5l_decap_8_2456 VPWR VGND sg13cmos5l_decap_8
* cell instance sg13cmos5l_decap_8_2457 r0 *1 0,0
Xsg13cmos5l_decap_8_2457 VPWR VGND sg13cmos5l_decap_8
* cell instance sg13cmos5l_decap_8_2458 r0 *1 0,0
Xsg13cmos5l_decap_8_2458 VPWR VGND sg13cmos5l_decap_8
* cell instance sg13cmos5l_decap_8_2459 r0 *1 0,0
Xsg13cmos5l_decap_8_2459 VPWR VGND sg13cmos5l_decap_8
* cell instance sg13cmos5l_decap_8_2460 r0 *1 0,0
Xsg13cmos5l_decap_8_2460 VPWR VGND sg13cmos5l_decap_8
* cell instance sg13cmos5l_decap_8_2461 r0 *1 0,0
Xsg13cmos5l_decap_8_2461 VPWR VGND sg13cmos5l_decap_8
* cell instance sg13cmos5l_decap_8_2462 r0 *1 0,0
Xsg13cmos5l_decap_8_2462 VPWR VGND sg13cmos5l_decap_8
* cell instance sg13cmos5l_decap_8_2463 r0 *1 0,0
Xsg13cmos5l_decap_8_2463 VPWR VGND sg13cmos5l_decap_8
* cell instance sg13cmos5l_decap_8_2464 r0 *1 0,0
Xsg13cmos5l_decap_8_2464 VPWR VGND sg13cmos5l_decap_8
* cell instance sg13cmos5l_decap_8_2465 r0 *1 0,0
Xsg13cmos5l_decap_8_2465 VPWR VGND sg13cmos5l_decap_8
* cell instance sg13cmos5l_decap_8_2466 r0 *1 0,0
Xsg13cmos5l_decap_8_2466 VPWR VGND sg13cmos5l_decap_8
* cell instance sg13cmos5l_decap_8_2467 r0 *1 0,0
Xsg13cmos5l_decap_8_2467 VPWR VGND sg13cmos5l_decap_8
* cell instance sg13cmos5l_decap_8_2468 r0 *1 0,0
Xsg13cmos5l_decap_8_2468 VPWR VGND sg13cmos5l_decap_8
* cell instance sg13cmos5l_decap_8_2469 r0 *1 0,0
Xsg13cmos5l_decap_8_2469 VPWR VGND sg13cmos5l_decap_8
* cell instance sg13cmos5l_decap_8_2470 r0 *1 0,0
Xsg13cmos5l_decap_8_2470 VPWR VGND sg13cmos5l_decap_8
* cell instance sg13cmos5l_decap_8_2471 r0 *1 0,0
Xsg13cmos5l_decap_8_2471 VPWR VGND sg13cmos5l_decap_8
* cell instance sg13cmos5l_decap_8_2472 r0 *1 0,0
Xsg13cmos5l_decap_8_2472 VPWR VGND sg13cmos5l_decap_8
* cell instance sg13cmos5l_decap_8_2473 r0 *1 0,0
Xsg13cmos5l_decap_8_2473 VPWR VGND sg13cmos5l_decap_8
* cell instance sg13cmos5l_decap_8_2474 r0 *1 0,0
Xsg13cmos5l_decap_8_2474 VPWR VGND sg13cmos5l_decap_8
* cell instance sg13cmos5l_decap_8_2475 r0 *1 0,0
Xsg13cmos5l_decap_8_2475 VPWR VGND sg13cmos5l_decap_8
* cell instance sg13cmos5l_decap_8_2476 r0 *1 0,0
Xsg13cmos5l_decap_8_2476 VPWR VGND sg13cmos5l_decap_8
* cell instance sg13cmos5l_decap_8_2477 r0 *1 0,0
Xsg13cmos5l_decap_8_2477 VPWR VGND sg13cmos5l_decap_8
* cell instance sg13cmos5l_decap_8_2478 r0 *1 0,0
Xsg13cmos5l_decap_8_2478 VPWR VGND sg13cmos5l_decap_8
* cell instance sg13cmos5l_decap_8_2479 r0 *1 0,0
Xsg13cmos5l_decap_8_2479 VPWR VGND sg13cmos5l_decap_8
* cell instance sg13cmos5l_decap_8_2480 r0 *1 0,0
Xsg13cmos5l_decap_8_2480 VPWR VGND sg13cmos5l_decap_8
* cell instance sg13cmos5l_decap_8_2481 r0 *1 0,0
Xsg13cmos5l_decap_8_2481 VPWR VGND sg13cmos5l_decap_8
* cell instance sg13cmos5l_decap_8_2482 r0 *1 0,0
Xsg13cmos5l_decap_8_2482 VPWR VGND sg13cmos5l_decap_8
* cell instance sg13cmos5l_decap_8_2483 r0 *1 0,0
Xsg13cmos5l_decap_8_2483 VPWR VGND sg13cmos5l_decap_8
* cell instance sg13cmos5l_decap_8_2484 r0 *1 0,0
Xsg13cmos5l_decap_8_2484 VPWR VGND sg13cmos5l_decap_8
* cell instance sg13cmos5l_decap_8_2485 r0 *1 0,0
Xsg13cmos5l_decap_8_2485 VPWR VGND sg13cmos5l_decap_8
* cell instance sg13cmos5l_decap_8_2486 r0 *1 0,0
Xsg13cmos5l_decap_8_2486 VPWR VGND sg13cmos5l_decap_8
* cell instance sg13cmos5l_decap_8_2487 r0 *1 0,0
Xsg13cmos5l_decap_8_2487 VPWR VGND sg13cmos5l_decap_8
* cell instance sg13cmos5l_decap_8_2488 r0 *1 0,0
Xsg13cmos5l_decap_8_2488 VPWR VGND sg13cmos5l_decap_8
* cell instance sg13cmos5l_decap_8_2489 r0 *1 0,0
Xsg13cmos5l_decap_8_2489 VPWR VGND sg13cmos5l_decap_8
* cell instance sg13cmos5l_decap_8_2490 r0 *1 0,0
Xsg13cmos5l_decap_8_2490 VPWR VGND sg13cmos5l_decap_8
* cell instance sg13cmos5l_decap_8_2491 r0 *1 0,0
Xsg13cmos5l_decap_8_2491 VPWR VGND sg13cmos5l_decap_8
* cell instance sg13cmos5l_decap_8_2492 r0 *1 0,0
Xsg13cmos5l_decap_8_2492 VPWR VGND sg13cmos5l_decap_8
* cell instance sg13cmos5l_decap_8_2493 r0 *1 0,0
Xsg13cmos5l_decap_8_2493 VPWR VGND sg13cmos5l_decap_8
* cell instance sg13cmos5l_decap_8_2494 r0 *1 0,0
Xsg13cmos5l_decap_8_2494 VPWR VGND sg13cmos5l_decap_8
* cell instance sg13cmos5l_decap_8_2495 r0 *1 0,0
Xsg13cmos5l_decap_8_2495 VPWR VGND sg13cmos5l_decap_8
* cell instance sg13cmos5l_decap_8_2496 r0 *1 0,0
Xsg13cmos5l_decap_8_2496 VPWR VGND sg13cmos5l_decap_8
* cell instance sg13cmos5l_decap_8_2497 r0 *1 0,0
Xsg13cmos5l_decap_8_2497 VPWR VGND sg13cmos5l_decap_8
* cell instance sg13cmos5l_decap_8_2498 r0 *1 0,0
Xsg13cmos5l_decap_8_2498 VPWR VGND sg13cmos5l_decap_8
* cell instance sg13cmos5l_decap_8_2499 r0 *1 0,0
Xsg13cmos5l_decap_8_2499 VPWR VGND sg13cmos5l_decap_8
* cell instance sg13cmos5l_decap_8_2500 r0 *1 0,0
Xsg13cmos5l_decap_8_2500 VPWR VGND sg13cmos5l_decap_8
* cell instance sg13cmos5l_decap_8_2501 r0 *1 0,0
Xsg13cmos5l_decap_8_2501 VPWR VGND sg13cmos5l_decap_8
* cell instance sg13cmos5l_decap_8_2502 r0 *1 0,0
Xsg13cmos5l_decap_8_2502 VPWR VGND sg13cmos5l_decap_8
* cell instance sg13cmos5l_decap_8_2503 r0 *1 0,0
Xsg13cmos5l_decap_8_2503 VPWR VGND sg13cmos5l_decap_8
* cell instance sg13cmos5l_decap_8_2504 r0 *1 0,0
Xsg13cmos5l_decap_8_2504 VPWR VGND sg13cmos5l_decap_8
* cell instance sg13cmos5l_decap_8_2505 r0 *1 0,0
Xsg13cmos5l_decap_8_2505 VPWR VGND sg13cmos5l_decap_8
* cell instance sg13cmos5l_decap_8_2506 r0 *1 0,0
Xsg13cmos5l_decap_8_2506 VPWR VGND sg13cmos5l_decap_8
* cell instance sg13cmos5l_decap_8_2507 r0 *1 0,0
Xsg13cmos5l_decap_8_2507 VPWR VGND sg13cmos5l_decap_8
* cell instance sg13cmos5l_decap_8_2508 r0 *1 0,0
Xsg13cmos5l_decap_8_2508 VPWR VGND sg13cmos5l_decap_8
* cell instance sg13cmos5l_decap_8_2509 r0 *1 0,0
Xsg13cmos5l_decap_8_2509 VPWR VGND sg13cmos5l_decap_8
* cell instance sg13cmos5l_decap_8_2510 r0 *1 0,0
Xsg13cmos5l_decap_8_2510 VPWR VGND sg13cmos5l_decap_8
* cell instance sg13cmos5l_decap_8_2511 r0 *1 0,0
Xsg13cmos5l_decap_8_2511 VPWR VGND sg13cmos5l_decap_8
* cell instance sg13cmos5l_decap_8_2512 r0 *1 0,0
Xsg13cmos5l_decap_8_2512 VPWR VGND sg13cmos5l_decap_8
* cell instance sg13cmos5l_decap_8_2513 r0 *1 0,0
Xsg13cmos5l_decap_8_2513 VPWR VGND sg13cmos5l_decap_8
* cell instance sg13cmos5l_decap_8_2514 r0 *1 0,0
Xsg13cmos5l_decap_8_2514 VPWR VGND sg13cmos5l_decap_8
* cell instance sg13cmos5l_decap_8_2515 r0 *1 0,0
Xsg13cmos5l_decap_8_2515 VPWR VGND sg13cmos5l_decap_8
* cell instance sg13cmos5l_decap_8_2516 r0 *1 0,0
Xsg13cmos5l_decap_8_2516 VPWR VGND sg13cmos5l_decap_8
* cell instance sg13cmos5l_decap_8_2517 r0 *1 0,0
Xsg13cmos5l_decap_8_2517 VPWR VGND sg13cmos5l_decap_8
* cell instance sg13cmos5l_decap_8_2518 r0 *1 0,0
Xsg13cmos5l_decap_8_2518 VPWR VGND sg13cmos5l_decap_8
* cell instance sg13cmos5l_decap_8_2519 r0 *1 0,0
Xsg13cmos5l_decap_8_2519 VPWR VGND sg13cmos5l_decap_8
* cell instance sg13cmos5l_decap_8_2520 r0 *1 0,0
Xsg13cmos5l_decap_8_2520 VPWR VGND sg13cmos5l_decap_8
* cell instance sg13cmos5l_decap_8_2521 r0 *1 0,0
Xsg13cmos5l_decap_8_2521 VPWR VGND sg13cmos5l_decap_8
* cell instance sg13cmos5l_decap_8_2522 r0 *1 0,0
Xsg13cmos5l_decap_8_2522 VPWR VGND sg13cmos5l_decap_8
* cell instance sg13cmos5l_decap_8_2523 r0 *1 0,0
Xsg13cmos5l_decap_8_2523 VPWR VGND sg13cmos5l_decap_8
* cell instance sg13cmos5l_decap_8_2524 r0 *1 0,0
Xsg13cmos5l_decap_8_2524 VPWR VGND sg13cmos5l_decap_8
* cell instance sg13cmos5l_decap_8_2525 r0 *1 0,0
Xsg13cmos5l_decap_8_2525 VPWR VGND sg13cmos5l_decap_8
* cell instance sg13cmos5l_decap_8_2526 r0 *1 0,0
Xsg13cmos5l_decap_8_2526 VPWR VGND sg13cmos5l_decap_8
* cell instance sg13cmos5l_decap_8_2527 r0 *1 0,0
Xsg13cmos5l_decap_8_2527 VPWR VGND sg13cmos5l_decap_8
* cell instance sg13cmos5l_decap_8_2528 r0 *1 0,0
Xsg13cmos5l_decap_8_2528 VPWR VGND sg13cmos5l_decap_8
* cell instance sg13cmos5l_decap_8_2529 r0 *1 0,0
Xsg13cmos5l_decap_8_2529 VPWR VGND sg13cmos5l_decap_8
* cell instance sg13cmos5l_decap_8_2530 r0 *1 0,0
Xsg13cmos5l_decap_8_2530 VPWR VGND sg13cmos5l_decap_8
* cell instance sg13cmos5l_decap_8_2531 r0 *1 0,0
Xsg13cmos5l_decap_8_2531 VPWR VGND sg13cmos5l_decap_8
* cell instance sg13cmos5l_decap_8_2532 r0 *1 0,0
Xsg13cmos5l_decap_8_2532 VPWR VGND sg13cmos5l_decap_8
* cell instance sg13cmos5l_decap_8_2533 r0 *1 0,0
Xsg13cmos5l_decap_8_2533 VPWR VGND sg13cmos5l_decap_8
* cell instance sg13cmos5l_decap_8_2534 r0 *1 0,0
Xsg13cmos5l_decap_8_2534 VPWR VGND sg13cmos5l_decap_8
* cell instance sg13cmos5l_decap_8_2535 r0 *1 0,0
Xsg13cmos5l_decap_8_2535 VPWR VGND sg13cmos5l_decap_8
* cell instance sg13cmos5l_decap_8_2536 r0 *1 0,0
Xsg13cmos5l_decap_8_2536 VPWR VGND sg13cmos5l_decap_8
* cell instance sg13cmos5l_decap_8_2537 r0 *1 0,0
Xsg13cmos5l_decap_8_2537 VPWR VGND sg13cmos5l_decap_8
* cell instance sg13cmos5l_decap_8_2538 r0 *1 0,0
Xsg13cmos5l_decap_8_2538 VPWR VGND sg13cmos5l_decap_8
* cell instance sg13cmos5l_decap_8_2539 r0 *1 0,0
Xsg13cmos5l_decap_8_2539 VPWR VGND sg13cmos5l_decap_8
* cell instance sg13cmos5l_decap_8_2540 r0 *1 0,0
Xsg13cmos5l_decap_8_2540 VPWR VGND sg13cmos5l_decap_8
* cell instance sg13cmos5l_decap_8_2541 r0 *1 0,0
Xsg13cmos5l_decap_8_2541 VPWR VGND sg13cmos5l_decap_8
* cell instance sg13cmos5l_decap_8_2542 r0 *1 0,0
Xsg13cmos5l_decap_8_2542 VPWR VGND sg13cmos5l_decap_8
* cell instance sg13cmos5l_decap_8_2543 r0 *1 0,0
Xsg13cmos5l_decap_8_2543 VPWR VGND sg13cmos5l_decap_8
* cell instance sg13cmos5l_decap_8_2544 r0 *1 0,0
Xsg13cmos5l_decap_8_2544 VPWR VGND sg13cmos5l_decap_8
* cell instance sg13cmos5l_decap_8_2545 r0 *1 0,0
Xsg13cmos5l_decap_8_2545 VPWR VGND sg13cmos5l_decap_8
* cell instance sg13cmos5l_decap_8_2546 r0 *1 0,0
Xsg13cmos5l_decap_8_2546 VPWR VGND sg13cmos5l_decap_8
* cell instance sg13cmos5l_decap_8_2547 r0 *1 0,0
Xsg13cmos5l_decap_8_2547 VPWR VGND sg13cmos5l_decap_8
* cell instance sg13cmos5l_decap_8_2548 r0 *1 0,0
Xsg13cmos5l_decap_8_2548 VPWR VGND sg13cmos5l_decap_8
* cell instance sg13cmos5l_decap_8_2549 r0 *1 0,0
Xsg13cmos5l_decap_8_2549 VPWR VGND sg13cmos5l_decap_8
* cell instance sg13cmos5l_decap_8_2550 r0 *1 0,0
Xsg13cmos5l_decap_8_2550 VPWR VGND sg13cmos5l_decap_8
* cell instance sg13cmos5l_decap_8_2551 r0 *1 0,0
Xsg13cmos5l_decap_8_2551 VPWR VGND sg13cmos5l_decap_8
* cell instance sg13cmos5l_decap_8_2552 r0 *1 0,0
Xsg13cmos5l_decap_8_2552 VPWR VGND sg13cmos5l_decap_8
* cell instance sg13cmos5l_decap_8_2553 r0 *1 0,0
Xsg13cmos5l_decap_8_2553 VPWR VGND sg13cmos5l_decap_8
* cell instance sg13cmos5l_decap_8_2554 r0 *1 0,0
Xsg13cmos5l_decap_8_2554 VPWR VGND sg13cmos5l_decap_8
* cell instance sg13cmos5l_decap_8_2555 r0 *1 0,0
Xsg13cmos5l_decap_8_2555 VPWR VGND sg13cmos5l_decap_8
* cell instance sg13cmos5l_decap_8_2556 r0 *1 0,0
Xsg13cmos5l_decap_8_2556 VPWR VGND sg13cmos5l_decap_8
* cell instance sg13cmos5l_decap_8_2557 r0 *1 0,0
Xsg13cmos5l_decap_8_2557 VPWR VGND sg13cmos5l_decap_8
* cell instance sg13cmos5l_decap_8_2558 r0 *1 0,0
Xsg13cmos5l_decap_8_2558 VPWR VGND sg13cmos5l_decap_8
* cell instance sg13cmos5l_decap_8_2559 r0 *1 0,0
Xsg13cmos5l_decap_8_2559 VPWR VGND sg13cmos5l_decap_8
* cell instance sg13cmos5l_decap_8_2560 r0 *1 0,0
Xsg13cmos5l_decap_8_2560 VPWR VGND sg13cmos5l_decap_8
* cell instance sg13cmos5l_decap_8_2561 r0 *1 0,0
Xsg13cmos5l_decap_8_2561 VPWR VGND sg13cmos5l_decap_8
* cell instance sg13cmos5l_decap_8_2562 r0 *1 0,0
Xsg13cmos5l_decap_8_2562 VPWR VGND sg13cmos5l_decap_8
* cell instance sg13cmos5l_decap_8_2563 r0 *1 0,0
Xsg13cmos5l_decap_8_2563 VPWR VGND sg13cmos5l_decap_8
* cell instance sg13cmos5l_decap_8_2564 r0 *1 0,0
Xsg13cmos5l_decap_8_2564 VPWR VGND sg13cmos5l_decap_8
* cell instance sg13cmos5l_decap_8_2565 r0 *1 0,0
Xsg13cmos5l_decap_8_2565 VPWR VGND sg13cmos5l_decap_8
* cell instance sg13cmos5l_decap_8_2566 r0 *1 0,0
Xsg13cmos5l_decap_8_2566 VPWR VGND sg13cmos5l_decap_8
* cell instance sg13cmos5l_decap_8_2567 r0 *1 0,0
Xsg13cmos5l_decap_8_2567 VPWR VGND sg13cmos5l_decap_8
* cell instance sg13cmos5l_decap_8_2568 r0 *1 0,0
Xsg13cmos5l_decap_8_2568 VPWR VGND sg13cmos5l_decap_8
* cell instance sg13cmos5l_decap_8_2569 r0 *1 0,0
Xsg13cmos5l_decap_8_2569 VPWR VGND sg13cmos5l_decap_8
* cell instance sg13cmos5l_decap_8_2570 r0 *1 0,0
Xsg13cmos5l_decap_8_2570 VPWR VGND sg13cmos5l_decap_8
* cell instance sg13cmos5l_decap_8_2571 r0 *1 0,0
Xsg13cmos5l_decap_8_2571 VPWR VGND sg13cmos5l_decap_8
* cell instance sg13cmos5l_decap_8_2572 r0 *1 0,0
Xsg13cmos5l_decap_8_2572 VPWR VGND sg13cmos5l_decap_8
* cell instance sg13cmos5l_decap_8_2573 r0 *1 0,0
Xsg13cmos5l_decap_8_2573 VPWR VGND sg13cmos5l_decap_8
* cell instance sg13cmos5l_decap_8_2574 r0 *1 0,0
Xsg13cmos5l_decap_8_2574 VPWR VGND sg13cmos5l_decap_8
* cell instance sg13cmos5l_decap_8_2575 r0 *1 0,0
Xsg13cmos5l_decap_8_2575 VPWR VGND sg13cmos5l_decap_8
* cell instance sg13cmos5l_decap_8_2576 r0 *1 0,0
Xsg13cmos5l_decap_8_2576 VPWR VGND sg13cmos5l_decap_8
* cell instance sg13cmos5l_decap_8_2577 r0 *1 0,0
Xsg13cmos5l_decap_8_2577 VPWR VGND sg13cmos5l_decap_8
* cell instance sg13cmos5l_decap_8_2578 r0 *1 0,0
Xsg13cmos5l_decap_8_2578 VPWR VGND sg13cmos5l_decap_8
* cell instance sg13cmos5l_decap_8_2579 r0 *1 0,0
Xsg13cmos5l_decap_8_2579 VPWR VGND sg13cmos5l_decap_8
* cell instance sg13cmos5l_decap_8_2580 r0 *1 0,0
Xsg13cmos5l_decap_8_2580 VPWR VGND sg13cmos5l_decap_8
* cell instance sg13cmos5l_decap_8_2581 r0 *1 0,0
Xsg13cmos5l_decap_8_2581 VPWR VGND sg13cmos5l_decap_8
* cell instance sg13cmos5l_decap_8_2582 r0 *1 0,0
Xsg13cmos5l_decap_8_2582 VPWR VGND sg13cmos5l_decap_8
* cell instance sg13cmos5l_decap_8_2583 r0 *1 0,0
Xsg13cmos5l_decap_8_2583 VPWR VGND sg13cmos5l_decap_8
* cell instance sg13cmos5l_decap_8_2584 r0 *1 0,0
Xsg13cmos5l_decap_8_2584 VPWR VGND sg13cmos5l_decap_8
* cell instance sg13cmos5l_decap_8_2585 r0 *1 0,0
Xsg13cmos5l_decap_8_2585 VPWR VGND sg13cmos5l_decap_8
* cell instance sg13cmos5l_decap_8_2586 r0 *1 0,0
Xsg13cmos5l_decap_8_2586 VPWR VGND sg13cmos5l_decap_8
* cell instance sg13cmos5l_decap_8_2587 r0 *1 0,0
Xsg13cmos5l_decap_8_2587 VPWR VGND sg13cmos5l_decap_8
* cell instance sg13cmos5l_decap_8_2588 r0 *1 0,0
Xsg13cmos5l_decap_8_2588 VPWR VGND sg13cmos5l_decap_8
* cell instance sg13cmos5l_decap_8_2589 r0 *1 0,0
Xsg13cmos5l_decap_8_2589 VPWR VGND sg13cmos5l_decap_8
* cell instance sg13cmos5l_decap_8_2590 r0 *1 0,0
Xsg13cmos5l_decap_8_2590 VPWR VGND sg13cmos5l_decap_8
* cell instance sg13cmos5l_decap_8_2591 r0 *1 0,0
Xsg13cmos5l_decap_8_2591 VPWR VGND sg13cmos5l_decap_8
* cell instance sg13cmos5l_decap_8_2592 r0 *1 0,0
Xsg13cmos5l_decap_8_2592 VPWR VGND sg13cmos5l_decap_8
* cell instance sg13cmos5l_decap_8_2593 r0 *1 0,0
Xsg13cmos5l_decap_8_2593 VPWR VGND sg13cmos5l_decap_8
* cell instance sg13cmos5l_decap_8_2594 r0 *1 0,0
Xsg13cmos5l_decap_8_2594 VPWR VGND sg13cmos5l_decap_8
* cell instance sg13cmos5l_decap_8_2595 r0 *1 0,0
Xsg13cmos5l_decap_8_2595 VPWR VGND sg13cmos5l_decap_8
* cell instance sg13cmos5l_decap_8_2596 r0 *1 0,0
Xsg13cmos5l_decap_8_2596 VPWR VGND sg13cmos5l_decap_8
* cell instance sg13cmos5l_decap_8_2597 r0 *1 0,0
Xsg13cmos5l_decap_8_2597 VPWR VGND sg13cmos5l_decap_8
* cell instance sg13cmos5l_decap_8_2598 r0 *1 0,0
Xsg13cmos5l_decap_8_2598 VPWR VGND sg13cmos5l_decap_8
* cell instance sg13cmos5l_decap_8_2599 r0 *1 0,0
Xsg13cmos5l_decap_8_2599 VPWR VGND sg13cmos5l_decap_8
* cell instance sg13cmos5l_decap_8_2600 r0 *1 0,0
Xsg13cmos5l_decap_8_2600 VPWR VGND sg13cmos5l_decap_8
* cell instance sg13cmos5l_decap_8_2601 r0 *1 0,0
Xsg13cmos5l_decap_8_2601 VPWR VGND sg13cmos5l_decap_8
* cell instance sg13cmos5l_decap_8_2602 r0 *1 0,0
Xsg13cmos5l_decap_8_2602 VPWR VGND sg13cmos5l_decap_8
* cell instance sg13cmos5l_decap_8_2603 r0 *1 0,0
Xsg13cmos5l_decap_8_2603 VPWR VGND sg13cmos5l_decap_8
* cell instance sg13cmos5l_decap_8_2604 r0 *1 0,0
Xsg13cmos5l_decap_8_2604 VPWR VGND sg13cmos5l_decap_8
* cell instance sg13cmos5l_decap_8_2605 r0 *1 0,0
Xsg13cmos5l_decap_8_2605 VPWR VGND sg13cmos5l_decap_8
* cell instance sg13cmos5l_decap_8_2606 r0 *1 0,0
Xsg13cmos5l_decap_8_2606 VPWR VGND sg13cmos5l_decap_8
* cell instance sg13cmos5l_decap_8_2607 r0 *1 0,0
Xsg13cmos5l_decap_8_2607 VPWR VGND sg13cmos5l_decap_8
* cell instance sg13cmos5l_decap_8_2608 r0 *1 0,0
Xsg13cmos5l_decap_8_2608 VPWR VGND sg13cmos5l_decap_8
* cell instance sg13cmos5l_decap_8_2609 r0 *1 0,0
Xsg13cmos5l_decap_8_2609 VPWR VGND sg13cmos5l_decap_8
* cell instance sg13cmos5l_decap_8_2610 r0 *1 0,0
Xsg13cmos5l_decap_8_2610 VPWR VGND sg13cmos5l_decap_8
* cell instance sg13cmos5l_decap_8_2611 r0 *1 0,0
Xsg13cmos5l_decap_8_2611 VPWR VGND sg13cmos5l_decap_8
* cell instance sg13cmos5l_decap_8_2612 r0 *1 0,0
Xsg13cmos5l_decap_8_2612 VPWR VGND sg13cmos5l_decap_8
* cell instance sg13cmos5l_decap_8_2613 r0 *1 0,0
Xsg13cmos5l_decap_8_2613 VPWR VGND sg13cmos5l_decap_8
* cell instance sg13cmos5l_decap_8_2614 r0 *1 0,0
Xsg13cmos5l_decap_8_2614 VPWR VGND sg13cmos5l_decap_8
* cell instance sg13cmos5l_decap_8_2615 r0 *1 0,0
Xsg13cmos5l_decap_8_2615 VPWR VGND sg13cmos5l_decap_8
* cell instance sg13cmos5l_decap_8_2616 r0 *1 0,0
Xsg13cmos5l_decap_8_2616 VPWR VGND sg13cmos5l_decap_8
* cell instance sg13cmos5l_decap_8_2617 r0 *1 0,0
Xsg13cmos5l_decap_8_2617 VPWR VGND sg13cmos5l_decap_8
* cell instance sg13cmos5l_decap_8_2618 r0 *1 0,0
Xsg13cmos5l_decap_8_2618 VPWR VGND sg13cmos5l_decap_8
* cell instance sg13cmos5l_decap_8_2619 r0 *1 0,0
Xsg13cmos5l_decap_8_2619 VPWR VGND sg13cmos5l_decap_8
* cell instance sg13cmos5l_decap_8_2620 r0 *1 0,0
Xsg13cmos5l_decap_8_2620 VPWR VGND sg13cmos5l_decap_8
* cell instance sg13cmos5l_decap_8_2621 r0 *1 0,0
Xsg13cmos5l_decap_8_2621 VPWR VGND sg13cmos5l_decap_8
* cell instance sg13cmos5l_decap_8_2622 r0 *1 0,0
Xsg13cmos5l_decap_8_2622 VPWR VGND sg13cmos5l_decap_8
* cell instance sg13cmos5l_decap_8_2623 r0 *1 0,0
Xsg13cmos5l_decap_8_2623 VPWR VGND sg13cmos5l_decap_8
* cell instance sg13cmos5l_decap_8_2624 r0 *1 0,0
Xsg13cmos5l_decap_8_2624 VPWR VGND sg13cmos5l_decap_8
* cell instance sg13cmos5l_decap_8_2625 r0 *1 0,0
Xsg13cmos5l_decap_8_2625 VPWR VGND sg13cmos5l_decap_8
* cell instance sg13cmos5l_decap_8_2626 r0 *1 0,0
Xsg13cmos5l_decap_8_2626 VPWR VGND sg13cmos5l_decap_8
* cell instance sg13cmos5l_decap_8_2627 r0 *1 0,0
Xsg13cmos5l_decap_8_2627 VPWR VGND sg13cmos5l_decap_8
* cell instance sg13cmos5l_decap_8_2628 r0 *1 0,0
Xsg13cmos5l_decap_8_2628 VPWR VGND sg13cmos5l_decap_8
* cell instance sg13cmos5l_decap_8_2629 r0 *1 0,0
Xsg13cmos5l_decap_8_2629 VPWR VGND sg13cmos5l_decap_8
* cell instance sg13cmos5l_decap_8_2630 r0 *1 0,0
Xsg13cmos5l_decap_8_2630 VPWR VGND sg13cmos5l_decap_8
* cell instance sg13cmos5l_decap_8_2631 r0 *1 0,0
Xsg13cmos5l_decap_8_2631 VPWR VGND sg13cmos5l_decap_8
* cell instance sg13cmos5l_decap_8_2632 r0 *1 0,0
Xsg13cmos5l_decap_8_2632 VPWR VGND sg13cmos5l_decap_8
* cell instance sg13cmos5l_decap_8_2633 r0 *1 0,0
Xsg13cmos5l_decap_8_2633 VPWR VGND sg13cmos5l_decap_8
* cell instance sg13cmos5l_decap_8_2634 r0 *1 0,0
Xsg13cmos5l_decap_8_2634 VPWR VGND sg13cmos5l_decap_8
* cell instance sg13cmos5l_decap_8_2635 r0 *1 0,0
Xsg13cmos5l_decap_8_2635 VPWR VGND sg13cmos5l_decap_8
* cell instance sg13cmos5l_decap_8_2636 r0 *1 0,0
Xsg13cmos5l_decap_8_2636 VPWR VGND sg13cmos5l_decap_8
* cell instance sg13cmos5l_decap_8_2637 r0 *1 0,0
Xsg13cmos5l_decap_8_2637 VPWR VGND sg13cmos5l_decap_8
* cell instance sg13cmos5l_decap_8_2638 r0 *1 0,0
Xsg13cmos5l_decap_8_2638 VPWR VGND sg13cmos5l_decap_8
* cell instance sg13cmos5l_decap_8_2639 r0 *1 0,0
Xsg13cmos5l_decap_8_2639 VPWR VGND sg13cmos5l_decap_8
* cell instance sg13cmos5l_decap_8_2640 r0 *1 0,0
Xsg13cmos5l_decap_8_2640 VPWR VGND sg13cmos5l_decap_8
* cell instance sg13cmos5l_decap_8_2641 r0 *1 0,0
Xsg13cmos5l_decap_8_2641 VPWR VGND sg13cmos5l_decap_8
* cell instance sg13cmos5l_decap_8_2642 r0 *1 0,0
Xsg13cmos5l_decap_8_2642 VPWR VGND sg13cmos5l_decap_8
* cell instance sg13cmos5l_decap_8_2643 r0 *1 0,0
Xsg13cmos5l_decap_8_2643 VPWR VGND sg13cmos5l_decap_8
* cell instance sg13cmos5l_decap_8_2644 r0 *1 0,0
Xsg13cmos5l_decap_8_2644 VPWR VGND sg13cmos5l_decap_8
* cell instance sg13cmos5l_decap_8_2645 r0 *1 0,0
Xsg13cmos5l_decap_8_2645 VPWR VGND sg13cmos5l_decap_8
* cell instance sg13cmos5l_decap_8_2646 r0 *1 0,0
Xsg13cmos5l_decap_8_2646 VPWR VGND sg13cmos5l_decap_8
* cell instance sg13cmos5l_decap_8_2647 r0 *1 0,0
Xsg13cmos5l_decap_8_2647 VPWR VGND sg13cmos5l_decap_8
* cell instance sg13cmos5l_decap_8_2648 r0 *1 0,0
Xsg13cmos5l_decap_8_2648 VPWR VGND sg13cmos5l_decap_8
* cell instance sg13cmos5l_decap_8_2649 r0 *1 0,0
Xsg13cmos5l_decap_8_2649 VPWR VGND sg13cmos5l_decap_8
* cell instance sg13cmos5l_decap_8_2650 r0 *1 0,0
Xsg13cmos5l_decap_8_2650 VPWR VGND sg13cmos5l_decap_8
* cell instance sg13cmos5l_decap_8_2651 r0 *1 0,0
Xsg13cmos5l_decap_8_2651 VPWR VGND sg13cmos5l_decap_8
* cell instance sg13cmos5l_decap_8_2652 r0 *1 0,0
Xsg13cmos5l_decap_8_2652 VPWR VGND sg13cmos5l_decap_8
* cell instance sg13cmos5l_decap_8_2653 r0 *1 0,0
Xsg13cmos5l_decap_8_2653 VPWR VGND sg13cmos5l_decap_8
* cell instance sg13cmos5l_decap_8_2654 r0 *1 0,0
Xsg13cmos5l_decap_8_2654 VPWR VGND sg13cmos5l_decap_8
* cell instance sg13cmos5l_decap_8_2655 r0 *1 0,0
Xsg13cmos5l_decap_8_2655 VPWR VGND sg13cmos5l_decap_8
* cell instance sg13cmos5l_decap_8_2656 r0 *1 0,0
Xsg13cmos5l_decap_8_2656 VPWR VGND sg13cmos5l_decap_8
* cell instance sg13cmos5l_decap_8_2657 r0 *1 0,0
Xsg13cmos5l_decap_8_2657 VPWR VGND sg13cmos5l_decap_8
* cell instance sg13cmos5l_decap_8_2658 r0 *1 0,0
Xsg13cmos5l_decap_8_2658 VPWR VGND sg13cmos5l_decap_8
* cell instance sg13cmos5l_decap_8_2659 r0 *1 0,0
Xsg13cmos5l_decap_8_2659 VPWR VGND sg13cmos5l_decap_8
* cell instance sg13cmos5l_decap_8_2660 r0 *1 0,0
Xsg13cmos5l_decap_8_2660 VPWR VGND sg13cmos5l_decap_8
* cell instance sg13cmos5l_decap_8_2661 r0 *1 0,0
Xsg13cmos5l_decap_8_2661 VPWR VGND sg13cmos5l_decap_8
* cell instance sg13cmos5l_decap_8_2662 r0 *1 0,0
Xsg13cmos5l_decap_8_2662 VPWR VGND sg13cmos5l_decap_8
* cell instance sg13cmos5l_decap_8_2663 r0 *1 0,0
Xsg13cmos5l_decap_8_2663 VPWR VGND sg13cmos5l_decap_8
* cell instance sg13cmos5l_decap_8_2664 r0 *1 0,0
Xsg13cmos5l_decap_8_2664 VPWR VGND sg13cmos5l_decap_8
* cell instance sg13cmos5l_decap_8_2665 r0 *1 0,0
Xsg13cmos5l_decap_8_2665 VPWR VGND sg13cmos5l_decap_8
* cell instance sg13cmos5l_decap_8_2666 r0 *1 0,0
Xsg13cmos5l_decap_8_2666 VPWR VGND sg13cmos5l_decap_8
* cell instance sg13cmos5l_decap_8_2667 r0 *1 0,0
Xsg13cmos5l_decap_8_2667 VPWR VGND sg13cmos5l_decap_8
* cell instance sg13cmos5l_decap_8_2668 r0 *1 0,0
Xsg13cmos5l_decap_8_2668 VPWR VGND sg13cmos5l_decap_8
* cell instance sg13cmos5l_decap_8_2669 r0 *1 0,0
Xsg13cmos5l_decap_8_2669 VPWR VGND sg13cmos5l_decap_8
* cell instance sg13cmos5l_decap_8_2670 r0 *1 0,0
Xsg13cmos5l_decap_8_2670 VPWR VGND sg13cmos5l_decap_8
* cell instance sg13cmos5l_decap_8_2671 r0 *1 0,0
Xsg13cmos5l_decap_8_2671 VPWR VGND sg13cmos5l_decap_8
* cell instance sg13cmos5l_decap_8_2672 r0 *1 0,0
Xsg13cmos5l_decap_8_2672 VPWR VGND sg13cmos5l_decap_8
* cell instance sg13cmos5l_decap_8_2673 r0 *1 0,0
Xsg13cmos5l_decap_8_2673 VPWR VGND sg13cmos5l_decap_8
* cell instance sg13cmos5l_decap_8_2674 r0 *1 0,0
Xsg13cmos5l_decap_8_2674 VPWR VGND sg13cmos5l_decap_8
* cell instance sg13cmos5l_decap_8_2675 r0 *1 0,0
Xsg13cmos5l_decap_8_2675 VPWR VGND sg13cmos5l_decap_8
* cell instance sg13cmos5l_decap_8_2676 r0 *1 0,0
Xsg13cmos5l_decap_8_2676 VPWR VGND sg13cmos5l_decap_8
* cell instance sg13cmos5l_decap_8_2677 r0 *1 0,0
Xsg13cmos5l_decap_8_2677 VPWR VGND sg13cmos5l_decap_8
* cell instance sg13cmos5l_decap_8_2678 r0 *1 0,0
Xsg13cmos5l_decap_8_2678 VPWR VGND sg13cmos5l_decap_8
* cell instance sg13cmos5l_decap_8_2679 r0 *1 0,0
Xsg13cmos5l_decap_8_2679 VPWR VGND sg13cmos5l_decap_8
* cell instance sg13cmos5l_decap_8_2680 r0 *1 0,0
Xsg13cmos5l_decap_8_2680 VPWR VGND sg13cmos5l_decap_8
* cell instance sg13cmos5l_decap_8_2681 r0 *1 0,0
Xsg13cmos5l_decap_8_2681 VPWR VGND sg13cmos5l_decap_8
* cell instance sg13cmos5l_decap_8_2682 r0 *1 0,0
Xsg13cmos5l_decap_8_2682 VPWR VGND sg13cmos5l_decap_8
* cell instance sg13cmos5l_decap_8_2683 r0 *1 0,0
Xsg13cmos5l_decap_8_2683 VPWR VGND sg13cmos5l_decap_8
* cell instance sg13cmos5l_decap_8_2684 r0 *1 0,0
Xsg13cmos5l_decap_8_2684 VPWR VGND sg13cmos5l_decap_8
* cell instance sg13cmos5l_decap_8_2685 r0 *1 0,0
Xsg13cmos5l_decap_8_2685 VPWR VGND sg13cmos5l_decap_8
* cell instance sg13cmos5l_decap_8_2686 r0 *1 0,0
Xsg13cmos5l_decap_8_2686 VPWR VGND sg13cmos5l_decap_8
* cell instance sg13cmos5l_decap_8_2687 r0 *1 0,0
Xsg13cmos5l_decap_8_2687 VPWR VGND sg13cmos5l_decap_8
* cell instance sg13cmos5l_decap_8_2688 r0 *1 0,0
Xsg13cmos5l_decap_8_2688 VPWR VGND sg13cmos5l_decap_8
* cell instance sg13cmos5l_decap_8_2689 r0 *1 0,0
Xsg13cmos5l_decap_8_2689 VPWR VGND sg13cmos5l_decap_8
* cell instance sg13cmos5l_decap_8_2690 r0 *1 0,0
Xsg13cmos5l_decap_8_2690 VPWR VGND sg13cmos5l_decap_8
* cell instance sg13cmos5l_decap_8_2691 r0 *1 0,0
Xsg13cmos5l_decap_8_2691 VPWR VGND sg13cmos5l_decap_8
* cell instance sg13cmos5l_decap_8_2692 r0 *1 0,0
Xsg13cmos5l_decap_8_2692 VPWR VGND sg13cmos5l_decap_8
* cell instance sg13cmos5l_decap_8_2693 r0 *1 0,0
Xsg13cmos5l_decap_8_2693 VPWR VGND sg13cmos5l_decap_8
* cell instance sg13cmos5l_decap_8_2694 r0 *1 0,0
Xsg13cmos5l_decap_8_2694 VPWR VGND sg13cmos5l_decap_8
* cell instance sg13cmos5l_decap_8_2695 r0 *1 0,0
Xsg13cmos5l_decap_8_2695 VPWR VGND sg13cmos5l_decap_8
* cell instance sg13cmos5l_decap_8_2696 r0 *1 0,0
Xsg13cmos5l_decap_8_2696 VPWR VGND sg13cmos5l_decap_8
* cell instance sg13cmos5l_decap_8_2697 r0 *1 0,0
Xsg13cmos5l_decap_8_2697 VPWR VGND sg13cmos5l_decap_8
* cell instance sg13cmos5l_decap_8_2698 r0 *1 0,0
Xsg13cmos5l_decap_8_2698 VPWR VGND sg13cmos5l_decap_8
* cell instance sg13cmos5l_decap_8_2699 r0 *1 0,0
Xsg13cmos5l_decap_8_2699 VPWR VGND sg13cmos5l_decap_8
* cell instance sg13cmos5l_decap_8_2700 r0 *1 0,0
Xsg13cmos5l_decap_8_2700 VPWR VGND sg13cmos5l_decap_8
* cell instance sg13cmos5l_decap_8_2701 r0 *1 0,0
Xsg13cmos5l_decap_8_2701 VPWR VGND sg13cmos5l_decap_8
* cell instance sg13cmos5l_decap_8_2702 r0 *1 0,0
Xsg13cmos5l_decap_8_2702 VPWR VGND sg13cmos5l_decap_8
* cell instance sg13cmos5l_decap_8_2703 r0 *1 0,0
Xsg13cmos5l_decap_8_2703 VPWR VGND sg13cmos5l_decap_8
* cell instance sg13cmos5l_decap_8_2704 r0 *1 0,0
Xsg13cmos5l_decap_8_2704 VPWR VGND sg13cmos5l_decap_8
* cell instance sg13cmos5l_decap_8_2705 r0 *1 0,0
Xsg13cmos5l_decap_8_2705 VPWR VGND sg13cmos5l_decap_8
* cell instance sg13cmos5l_decap_8_2706 r0 *1 0,0
Xsg13cmos5l_decap_8_2706 VPWR VGND sg13cmos5l_decap_8
* cell instance sg13cmos5l_decap_8_2707 r0 *1 0,0
Xsg13cmos5l_decap_8_2707 VPWR VGND sg13cmos5l_decap_8
* cell instance sg13cmos5l_decap_8_2708 r0 *1 0,0
Xsg13cmos5l_decap_8_2708 VPWR VGND sg13cmos5l_decap_8
* cell instance sg13cmos5l_decap_8_2709 r0 *1 0,0
Xsg13cmos5l_decap_8_2709 VPWR VGND sg13cmos5l_decap_8
* cell instance sg13cmos5l_decap_8_2710 r0 *1 0,0
Xsg13cmos5l_decap_8_2710 VPWR VGND sg13cmos5l_decap_8
* cell instance sg13cmos5l_decap_8_2711 r0 *1 0,0
Xsg13cmos5l_decap_8_2711 VPWR VGND sg13cmos5l_decap_8
* cell instance sg13cmos5l_decap_8_2712 r0 *1 0,0
Xsg13cmos5l_decap_8_2712 VPWR VGND sg13cmos5l_decap_8
* cell instance sg13cmos5l_decap_8_2713 r0 *1 0,0
Xsg13cmos5l_decap_8_2713 VPWR VGND sg13cmos5l_decap_8
* cell instance sg13cmos5l_decap_8_2714 r0 *1 0,0
Xsg13cmos5l_decap_8_2714 VPWR VGND sg13cmos5l_decap_8
* cell instance sg13cmos5l_decap_8_2715 r0 *1 0,0
Xsg13cmos5l_decap_8_2715 VPWR VGND sg13cmos5l_decap_8
* cell instance sg13cmos5l_decap_8_2716 r0 *1 0,0
Xsg13cmos5l_decap_8_2716 VPWR VGND sg13cmos5l_decap_8
* cell instance sg13cmos5l_decap_8_2717 r0 *1 0,0
Xsg13cmos5l_decap_8_2717 VPWR VGND sg13cmos5l_decap_8
* cell instance sg13cmos5l_decap_8_2718 r0 *1 0,0
Xsg13cmos5l_decap_8_2718 VPWR VGND sg13cmos5l_decap_8
* cell instance sg13cmos5l_decap_8_2719 r0 *1 0,0
Xsg13cmos5l_decap_8_2719 VPWR VGND sg13cmos5l_decap_8
* cell instance sg13cmos5l_decap_8_2720 r0 *1 0,0
Xsg13cmos5l_decap_8_2720 VPWR VGND sg13cmos5l_decap_8
* cell instance sg13cmos5l_decap_8_2721 r0 *1 0,0
Xsg13cmos5l_decap_8_2721 VPWR VGND sg13cmos5l_decap_8
* cell instance sg13cmos5l_decap_8_2722 r0 *1 0,0
Xsg13cmos5l_decap_8_2722 VPWR VGND sg13cmos5l_decap_8
* cell instance sg13cmos5l_decap_8_2723 r0 *1 0,0
Xsg13cmos5l_decap_8_2723 VPWR VGND sg13cmos5l_decap_8
* cell instance sg13cmos5l_decap_8_2724 r0 *1 0,0
Xsg13cmos5l_decap_8_2724 VPWR VGND sg13cmos5l_decap_8
* cell instance sg13cmos5l_decap_8_2725 r0 *1 0,0
Xsg13cmos5l_decap_8_2725 VPWR VGND sg13cmos5l_decap_8
* cell instance sg13cmos5l_decap_8_2726 r0 *1 0,0
Xsg13cmos5l_decap_8_2726 VPWR VGND sg13cmos5l_decap_8
* cell instance sg13cmos5l_decap_8_2727 r0 *1 0,0
Xsg13cmos5l_decap_8_2727 VPWR VGND sg13cmos5l_decap_8
* cell instance sg13cmos5l_decap_8_2728 r0 *1 0,0
Xsg13cmos5l_decap_8_2728 VPWR VGND sg13cmos5l_decap_8
* cell instance sg13cmos5l_decap_8_2729 r0 *1 0,0
Xsg13cmos5l_decap_8_2729 VPWR VGND sg13cmos5l_decap_8
* cell instance sg13cmos5l_decap_8_2730 r0 *1 0,0
Xsg13cmos5l_decap_8_2730 VPWR VGND sg13cmos5l_decap_8
* cell instance sg13cmos5l_decap_8_2731 r0 *1 0,0
Xsg13cmos5l_decap_8_2731 VPWR VGND sg13cmos5l_decap_8
* cell instance sg13cmos5l_decap_8_2732 r0 *1 0,0
Xsg13cmos5l_decap_8_2732 VPWR VGND sg13cmos5l_decap_8
* cell instance sg13cmos5l_decap_8_2733 r0 *1 0,0
Xsg13cmos5l_decap_8_2733 VPWR VGND sg13cmos5l_decap_8
* cell instance sg13cmos5l_decap_8_2734 r0 *1 0,0
Xsg13cmos5l_decap_8_2734 VPWR VGND sg13cmos5l_decap_8
* cell instance sg13cmos5l_decap_8_2735 r0 *1 0,0
Xsg13cmos5l_decap_8_2735 VPWR VGND sg13cmos5l_decap_8
* cell instance sg13cmos5l_decap_8_2736 r0 *1 0,0
Xsg13cmos5l_decap_8_2736 VPWR VGND sg13cmos5l_decap_8
* cell instance sg13cmos5l_decap_8_2737 r0 *1 0,0
Xsg13cmos5l_decap_8_2737 VPWR VGND sg13cmos5l_decap_8
* cell instance sg13cmos5l_decap_8_2738 r0 *1 0,0
Xsg13cmos5l_decap_8_2738 VPWR VGND sg13cmos5l_decap_8
* cell instance sg13cmos5l_decap_8_2739 r0 *1 0,0
Xsg13cmos5l_decap_8_2739 VPWR VGND sg13cmos5l_decap_8
* cell instance sg13cmos5l_decap_8_2740 r0 *1 0,0
Xsg13cmos5l_decap_8_2740 VPWR VGND sg13cmos5l_decap_8
* cell instance sg13cmos5l_decap_8_2741 r0 *1 0,0
Xsg13cmos5l_decap_8_2741 VPWR VGND sg13cmos5l_decap_8
* cell instance sg13cmos5l_decap_8_2742 r0 *1 0,0
Xsg13cmos5l_decap_8_2742 VPWR VGND sg13cmos5l_decap_8
* cell instance sg13cmos5l_decap_8_2743 r0 *1 0,0
Xsg13cmos5l_decap_8_2743 VPWR VGND sg13cmos5l_decap_8
* cell instance sg13cmos5l_decap_8_2744 r0 *1 0,0
Xsg13cmos5l_decap_8_2744 VPWR VGND sg13cmos5l_decap_8
* cell instance sg13cmos5l_decap_8_2745 r0 *1 0,0
Xsg13cmos5l_decap_8_2745 VPWR VGND sg13cmos5l_decap_8
* cell instance sg13cmos5l_decap_8_2746 r0 *1 0,0
Xsg13cmos5l_decap_8_2746 VPWR VGND sg13cmos5l_decap_8
* cell instance sg13cmos5l_decap_8_2747 r0 *1 0,0
Xsg13cmos5l_decap_8_2747 VPWR VGND sg13cmos5l_decap_8
* cell instance sg13cmos5l_decap_8_2748 r0 *1 0,0
Xsg13cmos5l_decap_8_2748 VPWR VGND sg13cmos5l_decap_8
* cell instance sg13cmos5l_decap_8_2749 r0 *1 0,0
Xsg13cmos5l_decap_8_2749 VPWR VGND sg13cmos5l_decap_8
* cell instance sg13cmos5l_decap_8_2750 r0 *1 0,0
Xsg13cmos5l_decap_8_2750 VPWR VGND sg13cmos5l_decap_8
* cell instance sg13cmos5l_decap_8_2751 r0 *1 0,0
Xsg13cmos5l_decap_8_2751 VPWR VGND sg13cmos5l_decap_8
* cell instance sg13cmos5l_decap_8_2752 r0 *1 0,0
Xsg13cmos5l_decap_8_2752 VPWR VGND sg13cmos5l_decap_8
* cell instance sg13cmos5l_decap_8_2753 r0 *1 0,0
Xsg13cmos5l_decap_8_2753 VPWR VGND sg13cmos5l_decap_8
* cell instance sg13cmos5l_decap_8_2754 r0 *1 0,0
Xsg13cmos5l_decap_8_2754 VPWR VGND sg13cmos5l_decap_8
* cell instance sg13cmos5l_decap_8_2755 r0 *1 0,0
Xsg13cmos5l_decap_8_2755 VPWR VGND sg13cmos5l_decap_8
* cell instance sg13cmos5l_decap_8_2756 r0 *1 0,0
Xsg13cmos5l_decap_8_2756 VPWR VGND sg13cmos5l_decap_8
* cell instance sg13cmos5l_decap_8_2757 r0 *1 0,0
Xsg13cmos5l_decap_8_2757 VPWR VGND sg13cmos5l_decap_8
* cell instance sg13cmos5l_decap_8_2758 r0 *1 0,0
Xsg13cmos5l_decap_8_2758 VPWR VGND sg13cmos5l_decap_8
* cell instance sg13cmos5l_decap_8_2759 r0 *1 0,0
Xsg13cmos5l_decap_8_2759 VPWR VGND sg13cmos5l_decap_8
* cell instance sg13cmos5l_decap_8_2760 r0 *1 0,0
Xsg13cmos5l_decap_8_2760 VPWR VGND sg13cmos5l_decap_8
* cell instance sg13cmos5l_decap_8_2761 r0 *1 0,0
Xsg13cmos5l_decap_8_2761 VPWR VGND sg13cmos5l_decap_8
* cell instance sg13cmos5l_decap_8_2762 r0 *1 0,0
Xsg13cmos5l_decap_8_2762 VPWR VGND sg13cmos5l_decap_8
* cell instance sg13cmos5l_decap_8_2763 r0 *1 0,0
Xsg13cmos5l_decap_8_2763 VPWR VGND sg13cmos5l_decap_8
* cell instance sg13cmos5l_decap_8_2764 r0 *1 0,0
Xsg13cmos5l_decap_8_2764 VPWR VGND sg13cmos5l_decap_8
* cell instance sg13cmos5l_decap_8_2765 r0 *1 0,0
Xsg13cmos5l_decap_8_2765 VPWR VGND sg13cmos5l_decap_8
* cell instance sg13cmos5l_decap_8_2766 r0 *1 0,0
Xsg13cmos5l_decap_8_2766 VPWR VGND sg13cmos5l_decap_8
* cell instance sg13cmos5l_decap_8_2767 r0 *1 0,0
Xsg13cmos5l_decap_8_2767 VPWR VGND sg13cmos5l_decap_8
* cell instance sg13cmos5l_decap_8_2768 r0 *1 0,0
Xsg13cmos5l_decap_8_2768 VPWR VGND sg13cmos5l_decap_8
* cell instance sg13cmos5l_decap_8_2769 r0 *1 0,0
Xsg13cmos5l_decap_8_2769 VPWR VGND sg13cmos5l_decap_8
* cell instance sg13cmos5l_decap_8_2770 r0 *1 0,0
Xsg13cmos5l_decap_8_2770 VPWR VGND sg13cmos5l_decap_8
* cell instance sg13cmos5l_decap_8_2771 r0 *1 0,0
Xsg13cmos5l_decap_8_2771 VPWR VGND sg13cmos5l_decap_8
* cell instance sg13cmos5l_decap_8_2772 r0 *1 0,0
Xsg13cmos5l_decap_8_2772 VPWR VGND sg13cmos5l_decap_8
* cell instance sg13cmos5l_decap_8_2773 r0 *1 0,0
Xsg13cmos5l_decap_8_2773 VPWR VGND sg13cmos5l_decap_8
* cell instance sg13cmos5l_decap_8_2774 r0 *1 0,0
Xsg13cmos5l_decap_8_2774 VPWR VGND sg13cmos5l_decap_8
* cell instance sg13cmos5l_decap_8_2775 r0 *1 0,0
Xsg13cmos5l_decap_8_2775 VPWR VGND sg13cmos5l_decap_8
* cell instance sg13cmos5l_decap_8_2776 r0 *1 0,0
Xsg13cmos5l_decap_8_2776 VPWR VGND sg13cmos5l_decap_8
* cell instance sg13cmos5l_decap_8_2777 r0 *1 0,0
Xsg13cmos5l_decap_8_2777 VPWR VGND sg13cmos5l_decap_8
* cell instance sg13cmos5l_decap_8_2778 r0 *1 0,0
Xsg13cmos5l_decap_8_2778 VPWR VGND sg13cmos5l_decap_8
* cell instance sg13cmos5l_decap_8_2779 r0 *1 0,0
Xsg13cmos5l_decap_8_2779 VPWR VGND sg13cmos5l_decap_8
* cell instance sg13cmos5l_decap_8_2780 r0 *1 0,0
Xsg13cmos5l_decap_8_2780 VPWR VGND sg13cmos5l_decap_8
* cell instance sg13cmos5l_decap_8_2781 r0 *1 0,0
Xsg13cmos5l_decap_8_2781 VPWR VGND sg13cmos5l_decap_8
* cell instance sg13cmos5l_decap_8_2782 r0 *1 0,0
Xsg13cmos5l_decap_8_2782 VPWR VGND sg13cmos5l_decap_8
* cell instance sg13cmos5l_decap_8_2783 r0 *1 0,0
Xsg13cmos5l_decap_8_2783 VPWR VGND sg13cmos5l_decap_8
* cell instance sg13cmos5l_decap_8_2784 r0 *1 0,0
Xsg13cmos5l_decap_8_2784 VPWR VGND sg13cmos5l_decap_8
* cell instance sg13cmos5l_decap_8_2785 r0 *1 0,0
Xsg13cmos5l_decap_8_2785 VPWR VGND sg13cmos5l_decap_8
* cell instance sg13cmos5l_decap_8_2786 r0 *1 0,0
Xsg13cmos5l_decap_8_2786 VPWR VGND sg13cmos5l_decap_8
* cell instance sg13cmos5l_decap_8_2787 r0 *1 0,0
Xsg13cmos5l_decap_8_2787 VPWR VGND sg13cmos5l_decap_8
* cell instance sg13cmos5l_decap_8_2788 r0 *1 0,0
Xsg13cmos5l_decap_8_2788 VPWR VGND sg13cmos5l_decap_8
* cell instance sg13cmos5l_decap_8_2789 r0 *1 0,0
Xsg13cmos5l_decap_8_2789 VPWR VGND sg13cmos5l_decap_8
* cell instance sg13cmos5l_decap_8_2790 r0 *1 0,0
Xsg13cmos5l_decap_8_2790 VPWR VGND sg13cmos5l_decap_8
* cell instance sg13cmos5l_decap_8_2791 r0 *1 0,0
Xsg13cmos5l_decap_8_2791 VPWR VGND sg13cmos5l_decap_8
* cell instance sg13cmos5l_decap_8_2792 r0 *1 0,0
Xsg13cmos5l_decap_8_2792 VPWR VGND sg13cmos5l_decap_8
* cell instance sg13cmos5l_decap_8_2793 r0 *1 0,0
Xsg13cmos5l_decap_8_2793 VPWR VGND sg13cmos5l_decap_8
* cell instance sg13cmos5l_decap_8_2794 r0 *1 0,0
Xsg13cmos5l_decap_8_2794 VPWR VGND sg13cmos5l_decap_8
* cell instance sg13cmos5l_decap_8_2795 r0 *1 0,0
Xsg13cmos5l_decap_8_2795 VPWR VGND sg13cmos5l_decap_8
* cell instance sg13cmos5l_decap_8_2796 r0 *1 0,0
Xsg13cmos5l_decap_8_2796 VPWR VGND sg13cmos5l_decap_8
* cell instance sg13cmos5l_decap_8_2797 r0 *1 0,0
Xsg13cmos5l_decap_8_2797 VPWR VGND sg13cmos5l_decap_8
* cell instance sg13cmos5l_decap_8_2798 r0 *1 0,0
Xsg13cmos5l_decap_8_2798 VPWR VGND sg13cmos5l_decap_8
* cell instance sg13cmos5l_decap_8_2799 r0 *1 0,0
Xsg13cmos5l_decap_8_2799 VPWR VGND sg13cmos5l_decap_8
* cell instance sg13cmos5l_decap_8_2800 r0 *1 0,0
Xsg13cmos5l_decap_8_2800 VPWR VGND sg13cmos5l_decap_8
* cell instance sg13cmos5l_decap_8_2801 r0 *1 0,0
Xsg13cmos5l_decap_8_2801 VPWR VGND sg13cmos5l_decap_8
* cell instance sg13cmos5l_decap_8_2802 r0 *1 0,0
Xsg13cmos5l_decap_8_2802 VPWR VGND sg13cmos5l_decap_8
* cell instance sg13cmos5l_decap_8_2803 r0 *1 0,0
Xsg13cmos5l_decap_8_2803 VPWR VGND sg13cmos5l_decap_8
* cell instance sg13cmos5l_decap_8_2804 r0 *1 0,0
Xsg13cmos5l_decap_8_2804 VPWR VGND sg13cmos5l_decap_8
* cell instance sg13cmos5l_decap_8_2805 r0 *1 0,0
Xsg13cmos5l_decap_8_2805 VPWR VGND sg13cmos5l_decap_8
* cell instance sg13cmos5l_decap_8_2806 r0 *1 0,0
Xsg13cmos5l_decap_8_2806 VPWR VGND sg13cmos5l_decap_8
* cell instance sg13cmos5l_decap_8_2807 r0 *1 0,0
Xsg13cmos5l_decap_8_2807 VPWR VGND sg13cmos5l_decap_8
* cell instance sg13cmos5l_decap_8_2808 r0 *1 0,0
Xsg13cmos5l_decap_8_2808 VPWR VGND sg13cmos5l_decap_8
* cell instance sg13cmos5l_decap_8_2809 r0 *1 0,0
Xsg13cmos5l_decap_8_2809 VPWR VGND sg13cmos5l_decap_8
* cell instance sg13cmos5l_decap_8_2810 r0 *1 0,0
Xsg13cmos5l_decap_8_2810 VPWR VGND sg13cmos5l_decap_8
* cell instance sg13cmos5l_decap_8_2811 r0 *1 0,0
Xsg13cmos5l_decap_8_2811 VPWR VGND sg13cmos5l_decap_8
* cell instance sg13cmos5l_decap_8_2812 r0 *1 0,0
Xsg13cmos5l_decap_8_2812 VPWR VGND sg13cmos5l_decap_8
* cell instance sg13cmos5l_decap_8_2813 r0 *1 0,0
Xsg13cmos5l_decap_8_2813 VPWR VGND sg13cmos5l_decap_8
* cell instance sg13cmos5l_decap_8_2814 r0 *1 0,0
Xsg13cmos5l_decap_8_2814 VPWR VGND sg13cmos5l_decap_8
* cell instance sg13cmos5l_decap_8_2815 r0 *1 0,0
Xsg13cmos5l_decap_8_2815 VPWR VGND sg13cmos5l_decap_8
* cell instance sg13cmos5l_decap_8_2816 r0 *1 0,0
Xsg13cmos5l_decap_8_2816 VPWR VGND sg13cmos5l_decap_8
* cell instance sg13cmos5l_decap_8_2817 r0 *1 0,0
Xsg13cmos5l_decap_8_2817 VPWR VGND sg13cmos5l_decap_8
* cell instance sg13cmos5l_decap_8_2818 r0 *1 0,0
Xsg13cmos5l_decap_8_2818 VPWR VGND sg13cmos5l_decap_8
* cell instance sg13cmos5l_decap_8_2819 r0 *1 0,0
Xsg13cmos5l_decap_8_2819 VPWR VGND sg13cmos5l_decap_8
* cell instance sg13cmos5l_decap_8_2820 r0 *1 0,0
Xsg13cmos5l_decap_8_2820 VPWR VGND sg13cmos5l_decap_8
* cell instance sg13cmos5l_decap_8_2821 r0 *1 0,0
Xsg13cmos5l_decap_8_2821 VPWR VGND sg13cmos5l_decap_8
* cell instance sg13cmos5l_decap_8_2822 r0 *1 0,0
Xsg13cmos5l_decap_8_2822 VPWR VGND sg13cmos5l_decap_8
* cell instance sg13cmos5l_decap_8_2823 r0 *1 0,0
Xsg13cmos5l_decap_8_2823 VPWR VGND sg13cmos5l_decap_8
* cell instance sg13cmos5l_decap_8_2824 r0 *1 0,0
Xsg13cmos5l_decap_8_2824 VPWR VGND sg13cmos5l_decap_8
* cell instance sg13cmos5l_decap_8_2825 r0 *1 0,0
Xsg13cmos5l_decap_8_2825 VPWR VGND sg13cmos5l_decap_8
* cell instance sg13cmos5l_decap_8_2826 r0 *1 0,0
Xsg13cmos5l_decap_8_2826 VPWR VGND sg13cmos5l_decap_8
* cell instance sg13cmos5l_decap_8_2827 r0 *1 0,0
Xsg13cmos5l_decap_8_2827 VPWR VGND sg13cmos5l_decap_8
* cell instance sg13cmos5l_decap_8_2828 r0 *1 0,0
Xsg13cmos5l_decap_8_2828 VPWR VGND sg13cmos5l_decap_8
* cell instance sg13cmos5l_decap_8_2829 r0 *1 0,0
Xsg13cmos5l_decap_8_2829 VPWR VGND sg13cmos5l_decap_8
* cell instance sg13cmos5l_decap_8_2830 r0 *1 0,0
Xsg13cmos5l_decap_8_2830 VPWR VGND sg13cmos5l_decap_8
* cell instance sg13cmos5l_decap_8_2831 r0 *1 0,0
Xsg13cmos5l_decap_8_2831 VPWR VGND sg13cmos5l_decap_8
* cell instance sg13cmos5l_decap_8_2832 r0 *1 0,0
Xsg13cmos5l_decap_8_2832 VPWR VGND sg13cmos5l_decap_8
* cell instance sg13cmos5l_decap_8_2833 r0 *1 0,0
Xsg13cmos5l_decap_8_2833 VPWR VGND sg13cmos5l_decap_8
* cell instance sg13cmos5l_decap_8_2834 r0 *1 0,0
Xsg13cmos5l_decap_8_2834 VPWR VGND sg13cmos5l_decap_8
* cell instance sg13cmos5l_decap_8_2835 r0 *1 0,0
Xsg13cmos5l_decap_8_2835 VPWR VGND sg13cmos5l_decap_8
* cell instance sg13cmos5l_decap_8_2836 r0 *1 0,0
Xsg13cmos5l_decap_8_2836 VPWR VGND sg13cmos5l_decap_8
* cell instance sg13cmos5l_decap_8_2837 r0 *1 0,0
Xsg13cmos5l_decap_8_2837 VPWR VGND sg13cmos5l_decap_8
* cell instance sg13cmos5l_decap_8_2838 r0 *1 0,0
Xsg13cmos5l_decap_8_2838 VPWR VGND sg13cmos5l_decap_8
* cell instance sg13cmos5l_decap_8_2839 r0 *1 0,0
Xsg13cmos5l_decap_8_2839 VPWR VGND sg13cmos5l_decap_8
* cell instance sg13cmos5l_decap_8_2840 r0 *1 0,0
Xsg13cmos5l_decap_8_2840 VPWR VGND sg13cmos5l_decap_8
* cell instance sg13cmos5l_decap_8_2841 r0 *1 0,0
Xsg13cmos5l_decap_8_2841 VPWR VGND sg13cmos5l_decap_8
* cell instance sg13cmos5l_decap_8_2842 r0 *1 0,0
Xsg13cmos5l_decap_8_2842 VPWR VGND sg13cmos5l_decap_8
* cell instance sg13cmos5l_decap_8_2843 r0 *1 0,0
Xsg13cmos5l_decap_8_2843 VPWR VGND sg13cmos5l_decap_8
* cell instance sg13cmos5l_decap_8_2844 r0 *1 0,0
Xsg13cmos5l_decap_8_2844 VPWR VGND sg13cmos5l_decap_8
* cell instance sg13cmos5l_decap_8_2845 r0 *1 0,0
Xsg13cmos5l_decap_8_2845 VPWR VGND sg13cmos5l_decap_8
* cell instance sg13cmos5l_decap_8_2846 r0 *1 0,0
Xsg13cmos5l_decap_8_2846 VPWR VGND sg13cmos5l_decap_8
* cell instance sg13cmos5l_decap_8_2847 r0 *1 0,0
Xsg13cmos5l_decap_8_2847 VPWR VGND sg13cmos5l_decap_8
* cell instance sg13cmos5l_decap_8_2848 r0 *1 0,0
Xsg13cmos5l_decap_8_2848 VPWR VGND sg13cmos5l_decap_8
* cell instance sg13cmos5l_decap_8_2849 r0 *1 0,0
Xsg13cmos5l_decap_8_2849 VPWR VGND sg13cmos5l_decap_8
* cell instance sg13cmos5l_decap_8_2850 r0 *1 0,0
Xsg13cmos5l_decap_8_2850 VPWR VGND sg13cmos5l_decap_8
* cell instance sg13cmos5l_decap_8_2851 r0 *1 0,0
Xsg13cmos5l_decap_8_2851 VPWR VGND sg13cmos5l_decap_8
* cell instance sg13cmos5l_decap_8_2852 r0 *1 0,0
Xsg13cmos5l_decap_8_2852 VPWR VGND sg13cmos5l_decap_8
* cell instance sg13cmos5l_decap_8_2853 r0 *1 0,0
Xsg13cmos5l_decap_8_2853 VPWR VGND sg13cmos5l_decap_8
* cell instance sg13cmos5l_decap_8_2854 r0 *1 0,0
Xsg13cmos5l_decap_8_2854 VPWR VGND sg13cmos5l_decap_8
* cell instance sg13cmos5l_decap_8_2855 r0 *1 0,0
Xsg13cmos5l_decap_8_2855 VPWR VGND sg13cmos5l_decap_8
* cell instance sg13cmos5l_decap_8_2856 r0 *1 0,0
Xsg13cmos5l_decap_8_2856 VPWR VGND sg13cmos5l_decap_8
* cell instance sg13cmos5l_decap_8_2857 r0 *1 0,0
Xsg13cmos5l_decap_8_2857 VPWR VGND sg13cmos5l_decap_8
* cell instance sg13cmos5l_decap_8_2858 r0 *1 0,0
Xsg13cmos5l_decap_8_2858 VPWR VGND sg13cmos5l_decap_8
* cell instance sg13cmos5l_decap_8_2859 r0 *1 0,0
Xsg13cmos5l_decap_8_2859 VPWR VGND sg13cmos5l_decap_8
* cell instance sg13cmos5l_decap_8_2860 r0 *1 0,0
Xsg13cmos5l_decap_8_2860 VPWR VGND sg13cmos5l_decap_8
* cell instance sg13cmos5l_decap_8_2861 r0 *1 0,0
Xsg13cmos5l_decap_8_2861 VPWR VGND sg13cmos5l_decap_8
* cell instance sg13cmos5l_decap_8_2862 r0 *1 0,0
Xsg13cmos5l_decap_8_2862 VPWR VGND sg13cmos5l_decap_8
* cell instance sg13cmos5l_decap_8_2863 r0 *1 0,0
Xsg13cmos5l_decap_8_2863 VPWR VGND sg13cmos5l_decap_8
* cell instance sg13cmos5l_decap_8_2864 r0 *1 0,0
Xsg13cmos5l_decap_8_2864 VPWR VGND sg13cmos5l_decap_8
* cell instance sg13cmos5l_decap_8_2865 r0 *1 0,0
Xsg13cmos5l_decap_8_2865 VPWR VGND sg13cmos5l_decap_8
* cell instance sg13cmos5l_decap_8_2866 r0 *1 0,0
Xsg13cmos5l_decap_8_2866 VPWR VGND sg13cmos5l_decap_8
* cell instance sg13cmos5l_decap_8_2867 r0 *1 0,0
Xsg13cmos5l_decap_8_2867 VPWR VGND sg13cmos5l_decap_8
* cell instance sg13cmos5l_decap_8_2868 r0 *1 0,0
Xsg13cmos5l_decap_8_2868 VPWR VGND sg13cmos5l_decap_8
* cell instance sg13cmos5l_decap_8_2869 r0 *1 0,0
Xsg13cmos5l_decap_8_2869 VPWR VGND sg13cmos5l_decap_8
* cell instance sg13cmos5l_decap_8_2870 r0 *1 0,0
Xsg13cmos5l_decap_8_2870 VPWR VGND sg13cmos5l_decap_8
* cell instance sg13cmos5l_decap_8_2871 r0 *1 0,0
Xsg13cmos5l_decap_8_2871 VPWR VGND sg13cmos5l_decap_8
* cell instance sg13cmos5l_decap_8_2872 r0 *1 0,0
Xsg13cmos5l_decap_8_2872 VPWR VGND sg13cmos5l_decap_8
* cell instance sg13cmos5l_decap_8_2873 r0 *1 0,0
Xsg13cmos5l_decap_8_2873 VPWR VGND sg13cmos5l_decap_8
* cell instance sg13cmos5l_decap_8_2874 r0 *1 0,0
Xsg13cmos5l_decap_8_2874 VPWR VGND sg13cmos5l_decap_8
* cell instance sg13cmos5l_decap_8_2875 r0 *1 0,0
Xsg13cmos5l_decap_8_2875 VPWR VGND sg13cmos5l_decap_8
* cell instance sg13cmos5l_decap_8_2876 r0 *1 0,0
Xsg13cmos5l_decap_8_2876 VPWR VGND sg13cmos5l_decap_8
* cell instance sg13cmos5l_decap_8_2877 r0 *1 0,0
Xsg13cmos5l_decap_8_2877 VPWR VGND sg13cmos5l_decap_8
* cell instance sg13cmos5l_decap_8_2878 r0 *1 0,0
Xsg13cmos5l_decap_8_2878 VPWR VGND sg13cmos5l_decap_8
* cell instance sg13cmos5l_decap_8_2879 r0 *1 0,0
Xsg13cmos5l_decap_8_2879 VPWR VGND sg13cmos5l_decap_8
* cell instance sg13cmos5l_decap_8_2880 r0 *1 0,0
Xsg13cmos5l_decap_8_2880 VPWR VGND sg13cmos5l_decap_8
* cell instance sg13cmos5l_decap_8_2881 r0 *1 0,0
Xsg13cmos5l_decap_8_2881 VPWR VGND sg13cmos5l_decap_8
* cell instance sg13cmos5l_decap_8_2882 r0 *1 0,0
Xsg13cmos5l_decap_8_2882 VPWR VGND sg13cmos5l_decap_8
* cell instance sg13cmos5l_decap_8_2883 r0 *1 0,0
Xsg13cmos5l_decap_8_2883 VPWR VGND sg13cmos5l_decap_8
* cell instance sg13cmos5l_decap_8_2884 r0 *1 0,0
Xsg13cmos5l_decap_8_2884 VPWR VGND sg13cmos5l_decap_8
* cell instance sg13cmos5l_decap_8_2885 r0 *1 0,0
Xsg13cmos5l_decap_8_2885 VPWR VGND sg13cmos5l_decap_8
* cell instance sg13cmos5l_decap_8_2886 r0 *1 0,0
Xsg13cmos5l_decap_8_2886 VPWR VGND sg13cmos5l_decap_8
* cell instance sg13cmos5l_decap_8_2887 r0 *1 0,0
Xsg13cmos5l_decap_8_2887 VPWR VGND sg13cmos5l_decap_8
* cell instance sg13cmos5l_decap_8_2888 r0 *1 0,0
Xsg13cmos5l_decap_8_2888 VPWR VGND sg13cmos5l_decap_8
* cell instance sg13cmos5l_decap_8_2889 r0 *1 0,0
Xsg13cmos5l_decap_8_2889 VPWR VGND sg13cmos5l_decap_8
* cell instance sg13cmos5l_decap_8_2890 r0 *1 0,0
Xsg13cmos5l_decap_8_2890 VPWR VGND sg13cmos5l_decap_8
* cell instance sg13cmos5l_decap_8_2891 r0 *1 0,0
Xsg13cmos5l_decap_8_2891 VPWR VGND sg13cmos5l_decap_8
* cell instance sg13cmos5l_decap_8_2892 r0 *1 0,0
Xsg13cmos5l_decap_8_2892 VPWR VGND sg13cmos5l_decap_8
* cell instance sg13cmos5l_decap_8_2893 r0 *1 0,0
Xsg13cmos5l_decap_8_2893 VPWR VGND sg13cmos5l_decap_8
* cell instance sg13cmos5l_decap_8_2894 r0 *1 0,0
Xsg13cmos5l_decap_8_2894 VPWR VGND sg13cmos5l_decap_8
* cell instance sg13cmos5l_decap_8_2895 r0 *1 0,0
Xsg13cmos5l_decap_8_2895 VPWR VGND sg13cmos5l_decap_8
* cell instance sg13cmos5l_decap_8_2896 r0 *1 0,0
Xsg13cmos5l_decap_8_2896 VPWR VGND sg13cmos5l_decap_8
* cell instance sg13cmos5l_decap_8_2897 r0 *1 0,0
Xsg13cmos5l_decap_8_2897 VPWR VGND sg13cmos5l_decap_8
* cell instance sg13cmos5l_decap_8_2898 r0 *1 0,0
Xsg13cmos5l_decap_8_2898 VPWR VGND sg13cmos5l_decap_8
* cell instance sg13cmos5l_decap_8_2899 r0 *1 0,0
Xsg13cmos5l_decap_8_2899 VPWR VGND sg13cmos5l_decap_8
* cell instance sg13cmos5l_decap_8_2900 r0 *1 0,0
Xsg13cmos5l_decap_8_2900 VPWR VGND sg13cmos5l_decap_8
* cell instance sg13cmos5l_decap_8_2901 r0 *1 0,0
Xsg13cmos5l_decap_8_2901 VPWR VGND sg13cmos5l_decap_8
* cell instance sg13cmos5l_decap_8_2902 r0 *1 0,0
Xsg13cmos5l_decap_8_2902 VPWR VGND sg13cmos5l_decap_8
* cell instance sg13cmos5l_decap_8_2903 r0 *1 0,0
Xsg13cmos5l_decap_8_2903 VPWR VGND sg13cmos5l_decap_8
* cell instance sg13cmos5l_decap_8_2904 r0 *1 0,0
Xsg13cmos5l_decap_8_2904 VPWR VGND sg13cmos5l_decap_8
* cell instance sg13cmos5l_decap_8_2905 r0 *1 0,0
Xsg13cmos5l_decap_8_2905 VPWR VGND sg13cmos5l_decap_8
* cell instance sg13cmos5l_decap_8_2906 r0 *1 0,0
Xsg13cmos5l_decap_8_2906 VPWR VGND sg13cmos5l_decap_8
* cell instance sg13cmos5l_decap_8_2907 r0 *1 0,0
Xsg13cmos5l_decap_8_2907 VPWR VGND sg13cmos5l_decap_8
* cell instance sg13cmos5l_decap_8_2908 r0 *1 0,0
Xsg13cmos5l_decap_8_2908 VPWR VGND sg13cmos5l_decap_8
* cell instance sg13cmos5l_decap_8_2909 r0 *1 0,0
Xsg13cmos5l_decap_8_2909 VPWR VGND sg13cmos5l_decap_8
* cell instance sg13cmos5l_decap_8_2910 r0 *1 0,0
Xsg13cmos5l_decap_8_2910 VPWR VGND sg13cmos5l_decap_8
* cell instance sg13cmos5l_decap_8_2911 r0 *1 0,0
Xsg13cmos5l_decap_8_2911 VPWR VGND sg13cmos5l_decap_8
* cell instance sg13cmos5l_decap_8_2912 r0 *1 0,0
Xsg13cmos5l_decap_8_2912 VPWR VGND sg13cmos5l_decap_8
* cell instance sg13cmos5l_decap_8_2913 r0 *1 0,0
Xsg13cmos5l_decap_8_2913 VPWR VGND sg13cmos5l_decap_8
* cell instance sg13cmos5l_decap_8_2914 r0 *1 0,0
Xsg13cmos5l_decap_8_2914 VPWR VGND sg13cmos5l_decap_8
* cell instance sg13cmos5l_decap_8_2915 r0 *1 0,0
Xsg13cmos5l_decap_8_2915 VPWR VGND sg13cmos5l_decap_8
* cell instance sg13cmos5l_decap_8_2916 r0 *1 0,0
Xsg13cmos5l_decap_8_2916 VPWR VGND sg13cmos5l_decap_8
* cell instance sg13cmos5l_decap_8_2917 r0 *1 0,0
Xsg13cmos5l_decap_8_2917 VPWR VGND sg13cmos5l_decap_8
* cell instance sg13cmos5l_decap_8_2918 r0 *1 0,0
Xsg13cmos5l_decap_8_2918 VPWR VGND sg13cmos5l_decap_8
* cell instance sg13cmos5l_decap_8_2919 r0 *1 0,0
Xsg13cmos5l_decap_8_2919 VPWR VGND sg13cmos5l_decap_8
* cell instance sg13cmos5l_decap_8_2920 r0 *1 0,0
Xsg13cmos5l_decap_8_2920 VPWR VGND sg13cmos5l_decap_8
* cell instance sg13cmos5l_decap_8_2921 r0 *1 0,0
Xsg13cmos5l_decap_8_2921 VPWR VGND sg13cmos5l_decap_8
* cell instance sg13cmos5l_decap_8_2922 r0 *1 0,0
Xsg13cmos5l_decap_8_2922 VPWR VGND sg13cmos5l_decap_8
* cell instance sg13cmos5l_decap_8_2923 r0 *1 0,0
Xsg13cmos5l_decap_8_2923 VPWR VGND sg13cmos5l_decap_8
* cell instance sg13cmos5l_decap_8_2924 r0 *1 0,0
Xsg13cmos5l_decap_8_2924 VPWR VGND sg13cmos5l_decap_8
* cell instance sg13cmos5l_decap_8_2925 r0 *1 0,0
Xsg13cmos5l_decap_8_2925 VPWR VGND sg13cmos5l_decap_8
* cell instance sg13cmos5l_decap_8_2926 r0 *1 0,0
Xsg13cmos5l_decap_8_2926 VPWR VGND sg13cmos5l_decap_8
* cell instance sg13cmos5l_decap_8_2927 r0 *1 0,0
Xsg13cmos5l_decap_8_2927 VPWR VGND sg13cmos5l_decap_8
* cell instance sg13cmos5l_decap_8_2928 r0 *1 0,0
Xsg13cmos5l_decap_8_2928 VPWR VGND sg13cmos5l_decap_8
* cell instance sg13cmos5l_decap_8_2929 r0 *1 0,0
Xsg13cmos5l_decap_8_2929 VPWR VGND sg13cmos5l_decap_8
* cell instance sg13cmos5l_decap_8_2930 r0 *1 0,0
Xsg13cmos5l_decap_8_2930 VPWR VGND sg13cmos5l_decap_8
* cell instance sg13cmos5l_decap_8_2931 r0 *1 0,0
Xsg13cmos5l_decap_8_2931 VPWR VGND sg13cmos5l_decap_8
* cell instance sg13cmos5l_decap_8_2932 r0 *1 0,0
Xsg13cmos5l_decap_8_2932 VPWR VGND sg13cmos5l_decap_8
* cell instance sg13cmos5l_decap_8_2933 r0 *1 0,0
Xsg13cmos5l_decap_8_2933 VPWR VGND sg13cmos5l_decap_8
* cell instance sg13cmos5l_decap_8_2934 r0 *1 0,0
Xsg13cmos5l_decap_8_2934 VPWR VGND sg13cmos5l_decap_8
* cell instance sg13cmos5l_decap_8_2935 r0 *1 0,0
Xsg13cmos5l_decap_8_2935 VPWR VGND sg13cmos5l_decap_8
* cell instance sg13cmos5l_decap_8_2936 r0 *1 0,0
Xsg13cmos5l_decap_8_2936 VPWR VGND sg13cmos5l_decap_8
* cell instance sg13cmos5l_decap_8_2937 r0 *1 0,0
Xsg13cmos5l_decap_8_2937 VPWR VGND sg13cmos5l_decap_8
* cell instance sg13cmos5l_decap_8_2938 r0 *1 0,0
Xsg13cmos5l_decap_8_2938 VPWR VGND sg13cmos5l_decap_8
* cell instance sg13cmos5l_decap_8_2939 r0 *1 0,0
Xsg13cmos5l_decap_8_2939 VPWR VGND sg13cmos5l_decap_8
* cell instance sg13cmos5l_decap_8_2940 r0 *1 0,0
Xsg13cmos5l_decap_8_2940 VPWR VGND sg13cmos5l_decap_8
* cell instance sg13cmos5l_decap_8_2941 r0 *1 0,0
Xsg13cmos5l_decap_8_2941 VPWR VGND sg13cmos5l_decap_8
* cell instance sg13cmos5l_decap_8_2942 r0 *1 0,0
Xsg13cmos5l_decap_8_2942 VPWR VGND sg13cmos5l_decap_8
* cell instance sg13cmos5l_decap_8_2943 r0 *1 0,0
Xsg13cmos5l_decap_8_2943 VPWR VGND sg13cmos5l_decap_8
* cell instance sg13cmos5l_decap_8_2944 r0 *1 0,0
Xsg13cmos5l_decap_8_2944 VPWR VGND sg13cmos5l_decap_8
* cell instance sg13cmos5l_decap_8_2945 r0 *1 0,0
Xsg13cmos5l_decap_8_2945 VPWR VGND sg13cmos5l_decap_8
* cell instance sg13cmos5l_decap_8_2946 r0 *1 0,0
Xsg13cmos5l_decap_8_2946 VPWR VGND sg13cmos5l_decap_8
* cell instance sg13cmos5l_decap_8_2947 r0 *1 0,0
Xsg13cmos5l_decap_8_2947 VPWR VGND sg13cmos5l_decap_8
* cell instance sg13cmos5l_decap_8_2948 r0 *1 0,0
Xsg13cmos5l_decap_8_2948 VPWR VGND sg13cmos5l_decap_8
* cell instance sg13cmos5l_decap_8_2949 r0 *1 0,0
Xsg13cmos5l_decap_8_2949 VPWR VGND sg13cmos5l_decap_8
* cell instance sg13cmos5l_decap_8_2950 r0 *1 0,0
Xsg13cmos5l_decap_8_2950 VPWR VGND sg13cmos5l_decap_8
* cell instance sg13cmos5l_decap_8_2951 r0 *1 0,0
Xsg13cmos5l_decap_8_2951 VPWR VGND sg13cmos5l_decap_8
* cell instance sg13cmos5l_decap_8_2952 r0 *1 0,0
Xsg13cmos5l_decap_8_2952 VPWR VGND sg13cmos5l_decap_8
* cell instance sg13cmos5l_decap_8_2953 r0 *1 0,0
Xsg13cmos5l_decap_8_2953 VPWR VGND sg13cmos5l_decap_8
* cell instance sg13cmos5l_decap_8_2954 r0 *1 0,0
Xsg13cmos5l_decap_8_2954 VPWR VGND sg13cmos5l_decap_8
* cell instance sg13cmos5l_decap_8_2955 r0 *1 0,0
Xsg13cmos5l_decap_8_2955 VPWR VGND sg13cmos5l_decap_8
* cell instance sg13cmos5l_decap_8_2956 r0 *1 0,0
Xsg13cmos5l_decap_8_2956 VPWR VGND sg13cmos5l_decap_8
* cell instance sg13cmos5l_decap_8_2957 r0 *1 0,0
Xsg13cmos5l_decap_8_2957 VPWR VGND sg13cmos5l_decap_8
* cell instance sg13cmos5l_decap_8_2958 r0 *1 0,0
Xsg13cmos5l_decap_8_2958 VPWR VGND sg13cmos5l_decap_8
* cell instance sg13cmos5l_decap_8_2959 r0 *1 0,0
Xsg13cmos5l_decap_8_2959 VPWR VGND sg13cmos5l_decap_8
* cell instance sg13cmos5l_decap_8_2960 r0 *1 0,0
Xsg13cmos5l_decap_8_2960 VPWR VGND sg13cmos5l_decap_8
* cell instance sg13cmos5l_decap_8_2961 r0 *1 0,0
Xsg13cmos5l_decap_8_2961 VPWR VGND sg13cmos5l_decap_8
* cell instance sg13cmos5l_decap_8_2962 r0 *1 0,0
Xsg13cmos5l_decap_8_2962 VPWR VGND sg13cmos5l_decap_8
* cell instance sg13cmos5l_decap_8_2963 r0 *1 0,0
Xsg13cmos5l_decap_8_2963 VPWR VGND sg13cmos5l_decap_8
* cell instance sg13cmos5l_decap_8_2964 r0 *1 0,0
Xsg13cmos5l_decap_8_2964 VPWR VGND sg13cmos5l_decap_8
* cell instance sg13cmos5l_decap_8_2965 r0 *1 0,0
Xsg13cmos5l_decap_8_2965 VPWR VGND sg13cmos5l_decap_8
* cell instance sg13cmos5l_decap_8_2966 r0 *1 0,0
Xsg13cmos5l_decap_8_2966 VPWR VGND sg13cmos5l_decap_8
* cell instance sg13cmos5l_decap_8_2967 r0 *1 0,0
Xsg13cmos5l_decap_8_2967 VPWR VGND sg13cmos5l_decap_8
* cell instance sg13cmos5l_decap_8_2968 r0 *1 0,0
Xsg13cmos5l_decap_8_2968 VPWR VGND sg13cmos5l_decap_8
* cell instance sg13cmos5l_decap_8_2969 r0 *1 0,0
Xsg13cmos5l_decap_8_2969 VPWR VGND sg13cmos5l_decap_8
* cell instance sg13cmos5l_decap_8_2970 r0 *1 0,0
Xsg13cmos5l_decap_8_2970 VPWR VGND sg13cmos5l_decap_8
* cell instance sg13cmos5l_decap_8_2971 r0 *1 0,0
Xsg13cmos5l_decap_8_2971 VPWR VGND sg13cmos5l_decap_8
* cell instance sg13cmos5l_decap_8_2972 r0 *1 0,0
Xsg13cmos5l_decap_8_2972 VPWR VGND sg13cmos5l_decap_8
* cell instance sg13cmos5l_decap_8_2973 r0 *1 0,0
Xsg13cmos5l_decap_8_2973 VPWR VGND sg13cmos5l_decap_8
* cell instance sg13cmos5l_decap_8_2974 r0 *1 0,0
Xsg13cmos5l_decap_8_2974 VPWR VGND sg13cmos5l_decap_8
* cell instance sg13cmos5l_decap_8_2975 r0 *1 0,0
Xsg13cmos5l_decap_8_2975 VPWR VGND sg13cmos5l_decap_8
* cell instance sg13cmos5l_decap_8_2976 r0 *1 0,0
Xsg13cmos5l_decap_8_2976 VPWR VGND sg13cmos5l_decap_8
* cell instance sg13cmos5l_decap_8_2977 r0 *1 0,0
Xsg13cmos5l_decap_8_2977 VPWR VGND sg13cmos5l_decap_8
* cell instance sg13cmos5l_decap_8_2978 r0 *1 0,0
Xsg13cmos5l_decap_8_2978 VPWR VGND sg13cmos5l_decap_8
* cell instance sg13cmos5l_decap_8_2979 r0 *1 0,0
Xsg13cmos5l_decap_8_2979 VPWR VGND sg13cmos5l_decap_8
* cell instance sg13cmos5l_decap_8_2980 r0 *1 0,0
Xsg13cmos5l_decap_8_2980 VPWR VGND sg13cmos5l_decap_8
* cell instance sg13cmos5l_decap_8_2981 r0 *1 0,0
Xsg13cmos5l_decap_8_2981 VPWR VGND sg13cmos5l_decap_8
* cell instance sg13cmos5l_decap_8_2982 r0 *1 0,0
Xsg13cmos5l_decap_8_2982 VPWR VGND sg13cmos5l_decap_8
* cell instance sg13cmos5l_decap_8_2983 r0 *1 0,0
Xsg13cmos5l_decap_8_2983 VPWR VGND sg13cmos5l_decap_8
* cell instance sg13cmos5l_decap_8_2984 r0 *1 0,0
Xsg13cmos5l_decap_8_2984 VPWR VGND sg13cmos5l_decap_8
* cell instance sg13cmos5l_decap_8_2985 r0 *1 0,0
Xsg13cmos5l_decap_8_2985 VPWR VGND sg13cmos5l_decap_8
* cell instance sg13cmos5l_decap_8_2986 r0 *1 0,0
Xsg13cmos5l_decap_8_2986 VPWR VGND sg13cmos5l_decap_8
* cell instance sg13cmos5l_decap_8_2987 r0 *1 0,0
Xsg13cmos5l_decap_8_2987 VPWR VGND sg13cmos5l_decap_8
* cell instance sg13cmos5l_decap_8_2988 r0 *1 0,0
Xsg13cmos5l_decap_8_2988 VPWR VGND sg13cmos5l_decap_8
* cell instance sg13cmos5l_decap_8_2989 r0 *1 0,0
Xsg13cmos5l_decap_8_2989 VPWR VGND sg13cmos5l_decap_8
* cell instance sg13cmos5l_decap_8_2990 r0 *1 0,0
Xsg13cmos5l_decap_8_2990 VPWR VGND sg13cmos5l_decap_8
* cell instance sg13cmos5l_decap_8_2991 r0 *1 0,0
Xsg13cmos5l_decap_8_2991 VPWR VGND sg13cmos5l_decap_8
* cell instance sg13cmos5l_decap_8_2992 r0 *1 0,0
Xsg13cmos5l_decap_8_2992 VPWR VGND sg13cmos5l_decap_8
* cell instance sg13cmos5l_decap_8_2993 r0 *1 0,0
Xsg13cmos5l_decap_8_2993 VPWR VGND sg13cmos5l_decap_8
* cell instance sg13cmos5l_decap_8_2994 r0 *1 0,0
Xsg13cmos5l_decap_8_2994 VPWR VGND sg13cmos5l_decap_8
* cell instance sg13cmos5l_decap_8_2995 r0 *1 0,0
Xsg13cmos5l_decap_8_2995 VPWR VGND sg13cmos5l_decap_8
* cell instance sg13cmos5l_decap_8_2996 r0 *1 0,0
Xsg13cmos5l_decap_8_2996 VPWR VGND sg13cmos5l_decap_8
* cell instance sg13cmos5l_decap_8_2997 r0 *1 0,0
Xsg13cmos5l_decap_8_2997 VPWR VGND sg13cmos5l_decap_8
* cell instance sg13cmos5l_decap_8_2998 r0 *1 0,0
Xsg13cmos5l_decap_8_2998 VPWR VGND sg13cmos5l_decap_8
* cell instance sg13cmos5l_decap_8_2999 r0 *1 0,0
Xsg13cmos5l_decap_8_2999 VPWR VGND sg13cmos5l_decap_8
* cell instance sg13cmos5l_decap_8_3000 r0 *1 0,0
Xsg13cmos5l_decap_8_3000 VPWR VGND sg13cmos5l_decap_8
* cell instance sg13cmos5l_decap_8_3001 r0 *1 0,0
Xsg13cmos5l_decap_8_3001 VPWR VGND sg13cmos5l_decap_8
* cell instance sg13cmos5l_decap_8_3002 r0 *1 0,0
Xsg13cmos5l_decap_8_3002 VPWR VGND sg13cmos5l_decap_8
* cell instance sg13cmos5l_decap_8_3003 r0 *1 0,0
Xsg13cmos5l_decap_8_3003 VPWR VGND sg13cmos5l_decap_8
* cell instance sg13cmos5l_decap_8_3004 r0 *1 0,0
Xsg13cmos5l_decap_8_3004 VPWR VGND sg13cmos5l_decap_8
* cell instance sg13cmos5l_decap_8_3005 r0 *1 0,0
Xsg13cmos5l_decap_8_3005 VPWR VGND sg13cmos5l_decap_8
* cell instance sg13cmos5l_decap_8_3006 r0 *1 0,0
Xsg13cmos5l_decap_8_3006 VPWR VGND sg13cmos5l_decap_8
* cell instance sg13cmos5l_decap_8_3007 r0 *1 0,0
Xsg13cmos5l_decap_8_3007 VPWR VGND sg13cmos5l_decap_8
* cell instance sg13cmos5l_decap_8_3008 r0 *1 0,0
Xsg13cmos5l_decap_8_3008 VPWR VGND sg13cmos5l_decap_8
* cell instance sg13cmos5l_decap_8_3009 r0 *1 0,0
Xsg13cmos5l_decap_8_3009 VPWR VGND sg13cmos5l_decap_8
* cell instance sg13cmos5l_decap_8_3010 r0 *1 0,0
Xsg13cmos5l_decap_8_3010 VPWR VGND sg13cmos5l_decap_8
* cell instance sg13cmos5l_decap_8_3011 r0 *1 0,0
Xsg13cmos5l_decap_8_3011 VPWR VGND sg13cmos5l_decap_8
* cell instance sg13cmos5l_decap_8_3012 r0 *1 0,0
Xsg13cmos5l_decap_8_3012 VPWR VGND sg13cmos5l_decap_8
* cell instance sg13cmos5l_decap_8_3013 r0 *1 0,0
Xsg13cmos5l_decap_8_3013 VPWR VGND sg13cmos5l_decap_8
* cell instance sg13cmos5l_decap_8_3014 r0 *1 0,0
Xsg13cmos5l_decap_8_3014 VPWR VGND sg13cmos5l_decap_8
* cell instance sg13cmos5l_decap_8_3015 r0 *1 0,0
Xsg13cmos5l_decap_8_3015 VPWR VGND sg13cmos5l_decap_8
* cell instance sg13cmos5l_decap_8_3016 r0 *1 0,0
Xsg13cmos5l_decap_8_3016 VPWR VGND sg13cmos5l_decap_8
* cell instance sg13cmos5l_decap_8_3017 r0 *1 0,0
Xsg13cmos5l_decap_8_3017 VPWR VGND sg13cmos5l_decap_8
* cell instance sg13cmos5l_decap_8_3018 r0 *1 0,0
Xsg13cmos5l_decap_8_3018 VPWR VGND sg13cmos5l_decap_8
* cell instance sg13cmos5l_decap_8_3019 r0 *1 0,0
Xsg13cmos5l_decap_8_3019 VPWR VGND sg13cmos5l_decap_8
* cell instance sg13cmos5l_decap_8_3020 r0 *1 0,0
Xsg13cmos5l_decap_8_3020 VPWR VGND sg13cmos5l_decap_8
* cell instance sg13cmos5l_decap_8_3021 r0 *1 0,0
Xsg13cmos5l_decap_8_3021 VPWR VGND sg13cmos5l_decap_8
* cell instance sg13cmos5l_decap_8_3022 r0 *1 0,0
Xsg13cmos5l_decap_8_3022 VPWR VGND sg13cmos5l_decap_8
* cell instance sg13cmos5l_decap_8_3023 r0 *1 0,0
Xsg13cmos5l_decap_8_3023 VPWR VGND sg13cmos5l_decap_8
* cell instance sg13cmos5l_decap_8_3024 r0 *1 0,0
Xsg13cmos5l_decap_8_3024 VPWR VGND sg13cmos5l_decap_8
* cell instance sg13cmos5l_decap_8_3025 r0 *1 0,0
Xsg13cmos5l_decap_8_3025 VPWR VGND sg13cmos5l_decap_8
* cell instance sg13cmos5l_decap_8_3026 r0 *1 0,0
Xsg13cmos5l_decap_8_3026 VPWR VGND sg13cmos5l_decap_8
* cell instance sg13cmos5l_decap_8_3027 r0 *1 0,0
Xsg13cmos5l_decap_8_3027 VPWR VGND sg13cmos5l_decap_8
* cell instance sg13cmos5l_decap_8_3028 r0 *1 0,0
Xsg13cmos5l_decap_8_3028 VPWR VGND sg13cmos5l_decap_8
* cell instance sg13cmos5l_decap_8_3029 r0 *1 0,0
Xsg13cmos5l_decap_8_3029 VPWR VGND sg13cmos5l_decap_8
* cell instance sg13cmos5l_decap_8_3030 r0 *1 0,0
Xsg13cmos5l_decap_8_3030 VPWR VGND sg13cmos5l_decap_8
* cell instance sg13cmos5l_decap_8_3031 r0 *1 0,0
Xsg13cmos5l_decap_8_3031 VPWR VGND sg13cmos5l_decap_8
* cell instance sg13cmos5l_decap_8_3032 r0 *1 0,0
Xsg13cmos5l_decap_8_3032 VPWR VGND sg13cmos5l_decap_8
* cell instance sg13cmos5l_decap_8_3033 r0 *1 0,0
Xsg13cmos5l_decap_8_3033 VPWR VGND sg13cmos5l_decap_8
* cell instance sg13cmos5l_decap_8_3034 r0 *1 0,0
Xsg13cmos5l_decap_8_3034 VPWR VGND sg13cmos5l_decap_8
* cell instance sg13cmos5l_decap_8_3035 r0 *1 0,0
Xsg13cmos5l_decap_8_3035 VPWR VGND sg13cmos5l_decap_8
* cell instance sg13cmos5l_decap_8_3036 r0 *1 0,0
Xsg13cmos5l_decap_8_3036 VPWR VGND sg13cmos5l_decap_8
* cell instance sg13cmos5l_decap_8_3037 r0 *1 0,0
Xsg13cmos5l_decap_8_3037 VPWR VGND sg13cmos5l_decap_8
* cell instance sg13cmos5l_decap_8_3038 r0 *1 0,0
Xsg13cmos5l_decap_8_3038 VPWR VGND sg13cmos5l_decap_8
* cell instance sg13cmos5l_decap_8_3039 r0 *1 0,0
Xsg13cmos5l_decap_8_3039 VPWR VGND sg13cmos5l_decap_8
* cell instance sg13cmos5l_decap_8_3040 r0 *1 0,0
Xsg13cmos5l_decap_8_3040 VPWR VGND sg13cmos5l_decap_8
* cell instance sg13cmos5l_decap_8_3041 r0 *1 0,0
Xsg13cmos5l_decap_8_3041 VPWR VGND sg13cmos5l_decap_8
* cell instance sg13cmos5l_decap_8_3042 r0 *1 0,0
Xsg13cmos5l_decap_8_3042 VPWR VGND sg13cmos5l_decap_8
* cell instance sg13cmos5l_decap_8_3043 r0 *1 0,0
Xsg13cmos5l_decap_8_3043 VPWR VGND sg13cmos5l_decap_8
* cell instance sg13cmos5l_decap_8_3044 r0 *1 0,0
Xsg13cmos5l_decap_8_3044 VPWR VGND sg13cmos5l_decap_8
* cell instance sg13cmos5l_decap_8_3045 r0 *1 0,0
Xsg13cmos5l_decap_8_3045 VPWR VGND sg13cmos5l_decap_8
* cell instance sg13cmos5l_decap_8_3046 r0 *1 0,0
Xsg13cmos5l_decap_8_3046 VPWR VGND sg13cmos5l_decap_8
* cell instance sg13cmos5l_decap_8_3047 r0 *1 0,0
Xsg13cmos5l_decap_8_3047 VPWR VGND sg13cmos5l_decap_8
* cell instance sg13cmos5l_decap_8_3048 r0 *1 0,0
Xsg13cmos5l_decap_8_3048 VPWR VGND sg13cmos5l_decap_8
* cell instance sg13cmos5l_decap_8_3049 r0 *1 0,0
Xsg13cmos5l_decap_8_3049 VPWR VGND sg13cmos5l_decap_8
* cell instance sg13cmos5l_decap_8_3050 r0 *1 0,0
Xsg13cmos5l_decap_8_3050 VPWR VGND sg13cmos5l_decap_8
* cell instance sg13cmos5l_decap_8_3051 r0 *1 0,0
Xsg13cmos5l_decap_8_3051 VPWR VGND sg13cmos5l_decap_8
* cell instance sg13cmos5l_decap_8_3052 r0 *1 0,0
Xsg13cmos5l_decap_8_3052 VPWR VGND sg13cmos5l_decap_8
* cell instance sg13cmos5l_decap_8_3053 r0 *1 0,0
Xsg13cmos5l_decap_8_3053 VPWR VGND sg13cmos5l_decap_8
* cell instance sg13cmos5l_decap_8_3054 r0 *1 0,0
Xsg13cmos5l_decap_8_3054 VPWR VGND sg13cmos5l_decap_8
* cell instance sg13cmos5l_decap_8_3055 r0 *1 0,0
Xsg13cmos5l_decap_8_3055 VPWR VGND sg13cmos5l_decap_8
* cell instance sg13cmos5l_decap_8_3056 r0 *1 0,0
Xsg13cmos5l_decap_8_3056 VPWR VGND sg13cmos5l_decap_8
* cell instance sg13cmos5l_decap_8_3057 r0 *1 0,0
Xsg13cmos5l_decap_8_3057 VPWR VGND sg13cmos5l_decap_8
* cell instance sg13cmos5l_decap_8_3058 r0 *1 0,0
Xsg13cmos5l_decap_8_3058 VPWR VGND sg13cmos5l_decap_8
* cell instance sg13cmos5l_decap_8_3059 r0 *1 0,0
Xsg13cmos5l_decap_8_3059 VPWR VGND sg13cmos5l_decap_8
* cell instance sg13cmos5l_decap_8_3060 r0 *1 0,0
Xsg13cmos5l_decap_8_3060 VPWR VGND sg13cmos5l_decap_8
* cell instance sg13cmos5l_decap_8_3061 r0 *1 0,0
Xsg13cmos5l_decap_8_3061 VPWR VGND sg13cmos5l_decap_8
* cell instance sg13cmos5l_decap_8_3062 r0 *1 0,0
Xsg13cmos5l_decap_8_3062 VPWR VGND sg13cmos5l_decap_8
* cell instance sg13cmos5l_decap_8_3063 r0 *1 0,0
Xsg13cmos5l_decap_8_3063 VPWR VGND sg13cmos5l_decap_8
* cell instance sg13cmos5l_decap_8_3064 r0 *1 0,0
Xsg13cmos5l_decap_8_3064 VPWR VGND sg13cmos5l_decap_8
* cell instance sg13cmos5l_decap_8_3065 r0 *1 0,0
Xsg13cmos5l_decap_8_3065 VPWR VGND sg13cmos5l_decap_8
* cell instance sg13cmos5l_decap_8_3066 r0 *1 0,0
Xsg13cmos5l_decap_8_3066 VPWR VGND sg13cmos5l_decap_8
* cell instance sg13cmos5l_decap_8_3067 r0 *1 0,0
Xsg13cmos5l_decap_8_3067 VPWR VGND sg13cmos5l_decap_8
* cell instance sg13cmos5l_decap_8_3068 r0 *1 0,0
Xsg13cmos5l_decap_8_3068 VPWR VGND sg13cmos5l_decap_8
* cell instance sg13cmos5l_decap_8_3069 r0 *1 0,0
Xsg13cmos5l_decap_8_3069 VPWR VGND sg13cmos5l_decap_8
* cell instance sg13cmos5l_decap_8_3070 r0 *1 0,0
Xsg13cmos5l_decap_8_3070 VPWR VGND sg13cmos5l_decap_8
* cell instance sg13cmos5l_decap_8_3071 r0 *1 0,0
Xsg13cmos5l_decap_8_3071 VPWR VGND sg13cmos5l_decap_8
* cell instance sg13cmos5l_decap_8_3072 r0 *1 0,0
Xsg13cmos5l_decap_8_3072 VPWR VGND sg13cmos5l_decap_8
* cell instance sg13cmos5l_decap_8_3073 r0 *1 0,0
Xsg13cmos5l_decap_8_3073 VPWR VGND sg13cmos5l_decap_8
* cell instance sg13cmos5l_decap_8_3074 r0 *1 0,0
Xsg13cmos5l_decap_8_3074 VPWR VGND sg13cmos5l_decap_8
* cell instance sg13cmos5l_decap_8_3075 r0 *1 0,0
Xsg13cmos5l_decap_8_3075 VPWR VGND sg13cmos5l_decap_8
* cell instance sg13cmos5l_decap_8_3076 r0 *1 0,0
Xsg13cmos5l_decap_8_3076 VPWR VGND sg13cmos5l_decap_8
* cell instance sg13cmos5l_decap_8_3077 r0 *1 0,0
Xsg13cmos5l_decap_8_3077 VPWR VGND sg13cmos5l_decap_8
* cell instance sg13cmos5l_decap_8_3078 r0 *1 0,0
Xsg13cmos5l_decap_8_3078 VPWR VGND sg13cmos5l_decap_8
* cell instance sg13cmos5l_decap_8_3079 r0 *1 0,0
Xsg13cmos5l_decap_8_3079 VPWR VGND sg13cmos5l_decap_8
* cell instance sg13cmos5l_decap_8_3080 r0 *1 0,0
Xsg13cmos5l_decap_8_3080 VPWR VGND sg13cmos5l_decap_8
* cell instance sg13cmos5l_decap_8_3081 r0 *1 0,0
Xsg13cmos5l_decap_8_3081 VPWR VGND sg13cmos5l_decap_8
* cell instance sg13cmos5l_decap_8_3082 r0 *1 0,0
Xsg13cmos5l_decap_8_3082 VPWR VGND sg13cmos5l_decap_8
* cell instance sg13cmos5l_decap_8_3083 r0 *1 0,0
Xsg13cmos5l_decap_8_3083 VPWR VGND sg13cmos5l_decap_8
* cell instance sg13cmos5l_decap_8_3084 r0 *1 0,0
Xsg13cmos5l_decap_8_3084 VPWR VGND sg13cmos5l_decap_8
* cell instance sg13cmos5l_decap_8_3085 r0 *1 0,0
Xsg13cmos5l_decap_8_3085 VPWR VGND sg13cmos5l_decap_8
* cell instance sg13cmos5l_decap_8_3086 r0 *1 0,0
Xsg13cmos5l_decap_8_3086 VPWR VGND sg13cmos5l_decap_8
* cell instance sg13cmos5l_decap_8_3087 r0 *1 0,0
Xsg13cmos5l_decap_8_3087 VPWR VGND sg13cmos5l_decap_8
* cell instance sg13cmos5l_decap_8_3088 r0 *1 0,0
Xsg13cmos5l_decap_8_3088 VPWR VGND sg13cmos5l_decap_8
* cell instance sg13cmos5l_decap_8_3089 r0 *1 0,0
Xsg13cmos5l_decap_8_3089 VPWR VGND sg13cmos5l_decap_8
* cell instance sg13cmos5l_decap_8_3090 r0 *1 0,0
Xsg13cmos5l_decap_8_3090 VPWR VGND sg13cmos5l_decap_8
* cell instance sg13cmos5l_decap_8_3091 r0 *1 0,0
Xsg13cmos5l_decap_8_3091 VPWR VGND sg13cmos5l_decap_8
* cell instance sg13cmos5l_decap_8_3092 r0 *1 0,0
Xsg13cmos5l_decap_8_3092 VPWR VGND sg13cmos5l_decap_8
* cell instance sg13cmos5l_decap_8_3093 r0 *1 0,0
Xsg13cmos5l_decap_8_3093 VPWR VGND sg13cmos5l_decap_8
* cell instance sg13cmos5l_decap_8_3094 r0 *1 0,0
Xsg13cmos5l_decap_8_3094 VPWR VGND sg13cmos5l_decap_8
* cell instance sg13cmos5l_decap_8_3095 r0 *1 0,0
Xsg13cmos5l_decap_8_3095 VPWR VGND sg13cmos5l_decap_8
* cell instance sg13cmos5l_decap_8_3096 r0 *1 0,0
Xsg13cmos5l_decap_8_3096 VPWR VGND sg13cmos5l_decap_8
* cell instance sg13cmos5l_decap_8_3097 r0 *1 0,0
Xsg13cmos5l_decap_8_3097 VPWR VGND sg13cmos5l_decap_8
* cell instance sg13cmos5l_decap_8_3098 r0 *1 0,0
Xsg13cmos5l_decap_8_3098 VPWR VGND sg13cmos5l_decap_8
* cell instance sg13cmos5l_decap_8_3099 r0 *1 0,0
Xsg13cmos5l_decap_8_3099 VPWR VGND sg13cmos5l_decap_8
* cell instance sg13cmos5l_decap_8_3100 r0 *1 0,0
Xsg13cmos5l_decap_8_3100 VPWR VGND sg13cmos5l_decap_8
* cell instance sg13cmos5l_decap_8_3101 r0 *1 0,0
Xsg13cmos5l_decap_8_3101 VPWR VGND sg13cmos5l_decap_8
* cell instance sg13cmos5l_decap_8_3102 r0 *1 0,0
Xsg13cmos5l_decap_8_3102 VPWR VGND sg13cmos5l_decap_8
* cell instance sg13cmos5l_decap_8_3103 r0 *1 0,0
Xsg13cmos5l_decap_8_3103 VPWR VGND sg13cmos5l_decap_8
* cell instance sg13cmos5l_decap_8_3104 r0 *1 0,0
Xsg13cmos5l_decap_8_3104 VPWR VGND sg13cmos5l_decap_8
* cell instance sg13cmos5l_decap_8_3105 r0 *1 0,0
Xsg13cmos5l_decap_8_3105 VPWR VGND sg13cmos5l_decap_8
* cell instance sg13cmos5l_decap_8_3106 r0 *1 0,0
Xsg13cmos5l_decap_8_3106 VPWR VGND sg13cmos5l_decap_8
* cell instance sg13cmos5l_decap_8_3107 r0 *1 0,0
Xsg13cmos5l_decap_8_3107 VPWR VGND sg13cmos5l_decap_8
* cell instance sg13cmos5l_decap_8_3108 r0 *1 0,0
Xsg13cmos5l_decap_8_3108 VPWR VGND sg13cmos5l_decap_8
* cell instance sg13cmos5l_decap_8_3109 r0 *1 0,0
Xsg13cmos5l_decap_8_3109 VPWR VGND sg13cmos5l_decap_8
* cell instance sg13cmos5l_decap_8_3110 r0 *1 0,0
Xsg13cmos5l_decap_8_3110 VPWR VGND sg13cmos5l_decap_8
* cell instance sg13cmos5l_decap_8_3111 r0 *1 0,0
Xsg13cmos5l_decap_8_3111 VPWR VGND sg13cmos5l_decap_8
* cell instance sg13cmos5l_decap_8_3112 r0 *1 0,0
Xsg13cmos5l_decap_8_3112 VPWR VGND sg13cmos5l_decap_8
* cell instance sg13cmos5l_decap_8_3113 r0 *1 0,0
Xsg13cmos5l_decap_8_3113 VPWR VGND sg13cmos5l_decap_8
* cell instance sg13cmos5l_decap_8_3114 r0 *1 0,0
Xsg13cmos5l_decap_8_3114 VPWR VGND sg13cmos5l_decap_8
* cell instance sg13cmos5l_decap_8_3115 r0 *1 0,0
Xsg13cmos5l_decap_8_3115 VPWR VGND sg13cmos5l_decap_8
* cell instance sg13cmos5l_decap_8_3116 r0 *1 0,0
Xsg13cmos5l_decap_8_3116 VPWR VGND sg13cmos5l_decap_8
* cell instance sg13cmos5l_decap_8_3117 r0 *1 0,0
Xsg13cmos5l_decap_8_3117 VPWR VGND sg13cmos5l_decap_8
* cell instance sg13cmos5l_decap_8_3118 r0 *1 0,0
Xsg13cmos5l_decap_8_3118 VPWR VGND sg13cmos5l_decap_8
* cell instance sg13cmos5l_decap_8_3119 r0 *1 0,0
Xsg13cmos5l_decap_8_3119 VPWR VGND sg13cmos5l_decap_8
* cell instance sg13cmos5l_decap_8_3120 r0 *1 0,0
Xsg13cmos5l_decap_8_3120 VPWR VGND sg13cmos5l_decap_8
* cell instance sg13cmos5l_decap_8_3121 r0 *1 0,0
Xsg13cmos5l_decap_8_3121 VPWR VGND sg13cmos5l_decap_8
* cell instance sg13cmos5l_decap_8_3122 r0 *1 0,0
Xsg13cmos5l_decap_8_3122 VPWR VGND sg13cmos5l_decap_8
* cell instance sg13cmos5l_decap_8_3123 r0 *1 0,0
Xsg13cmos5l_decap_8_3123 VPWR VGND sg13cmos5l_decap_8
* cell instance sg13cmos5l_decap_8_3124 r0 *1 0,0
Xsg13cmos5l_decap_8_3124 VPWR VGND sg13cmos5l_decap_8
* cell instance sg13cmos5l_decap_8_3125 r0 *1 0,0
Xsg13cmos5l_decap_8_3125 VPWR VGND sg13cmos5l_decap_8
* cell instance sg13cmos5l_decap_8_3126 r0 *1 0,0
Xsg13cmos5l_decap_8_3126 VPWR VGND sg13cmos5l_decap_8
* cell instance sg13cmos5l_decap_8_3127 r0 *1 0,0
Xsg13cmos5l_decap_8_3127 VPWR VGND sg13cmos5l_decap_8
* cell instance sg13cmos5l_decap_8_3128 r0 *1 0,0
Xsg13cmos5l_decap_8_3128 VPWR VGND sg13cmos5l_decap_8
* cell instance sg13cmos5l_decap_8_3129 r0 *1 0,0
Xsg13cmos5l_decap_8_3129 VPWR VGND sg13cmos5l_decap_8
* cell instance sg13cmos5l_decap_8_3130 r0 *1 0,0
Xsg13cmos5l_decap_8_3130 VPWR VGND sg13cmos5l_decap_8
* cell instance sg13cmos5l_decap_8_3131 r0 *1 0,0
Xsg13cmos5l_decap_8_3131 VPWR VGND sg13cmos5l_decap_8
* cell instance sg13cmos5l_decap_8_3132 r0 *1 0,0
Xsg13cmos5l_decap_8_3132 VPWR VGND sg13cmos5l_decap_8
* cell instance sg13cmos5l_decap_8_3133 r0 *1 0,0
Xsg13cmos5l_decap_8_3133 VPWR VGND sg13cmos5l_decap_8
* cell instance sg13cmos5l_decap_8_3134 r0 *1 0,0
Xsg13cmos5l_decap_8_3134 VPWR VGND sg13cmos5l_decap_8
* cell instance sg13cmos5l_decap_8_3135 r0 *1 0,0
Xsg13cmos5l_decap_8_3135 VPWR VGND sg13cmos5l_decap_8
* cell instance sg13cmos5l_decap_8_3136 r0 *1 0,0
Xsg13cmos5l_decap_8_3136 VPWR VGND sg13cmos5l_decap_8
* cell instance sg13cmos5l_decap_8_3137 r0 *1 0,0
Xsg13cmos5l_decap_8_3137 VPWR VGND sg13cmos5l_decap_8
* cell instance sg13cmos5l_decap_8_3138 r0 *1 0,0
Xsg13cmos5l_decap_8_3138 VPWR VGND sg13cmos5l_decap_8
* cell instance sg13cmos5l_decap_8_3139 r0 *1 0,0
Xsg13cmos5l_decap_8_3139 VPWR VGND sg13cmos5l_decap_8
* cell instance sg13cmos5l_decap_8_3140 r0 *1 0,0
Xsg13cmos5l_decap_8_3140 VPWR VGND sg13cmos5l_decap_8
* cell instance sg13cmos5l_decap_8_3141 r0 *1 0,0
Xsg13cmos5l_decap_8_3141 VPWR VGND sg13cmos5l_decap_8
* cell instance sg13cmos5l_decap_8_3142 r0 *1 0,0
Xsg13cmos5l_decap_8_3142 VPWR VGND sg13cmos5l_decap_8
* cell instance sg13cmos5l_decap_8_3143 r0 *1 0,0
Xsg13cmos5l_decap_8_3143 VPWR VGND sg13cmos5l_decap_8
* cell instance sg13cmos5l_decap_8_3144 r0 *1 0,0
Xsg13cmos5l_decap_8_3144 VPWR VGND sg13cmos5l_decap_8
* cell instance sg13cmos5l_decap_8_3145 r0 *1 0,0
Xsg13cmos5l_decap_8_3145 VPWR VGND sg13cmos5l_decap_8
* cell instance sg13cmos5l_decap_8_3146 r0 *1 0,0
Xsg13cmos5l_decap_8_3146 VPWR VGND sg13cmos5l_decap_8
* cell instance sg13cmos5l_decap_8_3147 r0 *1 0,0
Xsg13cmos5l_decap_8_3147 VPWR VGND sg13cmos5l_decap_8
* cell instance sg13cmos5l_decap_8_3148 r0 *1 0,0
Xsg13cmos5l_decap_8_3148 VPWR VGND sg13cmos5l_decap_8
* cell instance sg13cmos5l_decap_8_3149 r0 *1 0,0
Xsg13cmos5l_decap_8_3149 VPWR VGND sg13cmos5l_decap_8
* cell instance sg13cmos5l_decap_8_3150 r0 *1 0,0
Xsg13cmos5l_decap_8_3150 VPWR VGND sg13cmos5l_decap_8
* cell instance sg13cmos5l_decap_8_3151 r0 *1 0,0
Xsg13cmos5l_decap_8_3151 VPWR VGND sg13cmos5l_decap_8
* cell instance sg13cmos5l_decap_8_3152 r0 *1 0,0
Xsg13cmos5l_decap_8_3152 VPWR VGND sg13cmos5l_decap_8
* cell instance sg13cmos5l_decap_8_3153 r0 *1 0,0
Xsg13cmos5l_decap_8_3153 VPWR VGND sg13cmos5l_decap_8
* cell instance sg13cmos5l_decap_8_3154 r0 *1 0,0
Xsg13cmos5l_decap_8_3154 VPWR VGND sg13cmos5l_decap_8
* cell instance sg13cmos5l_decap_8_3155 r0 *1 0,0
Xsg13cmos5l_decap_8_3155 VPWR VGND sg13cmos5l_decap_8
* cell instance sg13cmos5l_decap_8_3156 r0 *1 0,0
Xsg13cmos5l_decap_8_3156 VPWR VGND sg13cmos5l_decap_8
* cell instance sg13cmos5l_decap_8_3157 r0 *1 0,0
Xsg13cmos5l_decap_8_3157 VPWR VGND sg13cmos5l_decap_8
* cell instance sg13cmos5l_decap_8_3158 r0 *1 0,0
Xsg13cmos5l_decap_8_3158 VPWR VGND sg13cmos5l_decap_8
* cell instance sg13cmos5l_decap_8_3159 r0 *1 0,0
Xsg13cmos5l_decap_8_3159 VPWR VGND sg13cmos5l_decap_8
* cell instance sg13cmos5l_decap_8_3160 r0 *1 0,0
Xsg13cmos5l_decap_8_3160 VPWR VGND sg13cmos5l_decap_8
* cell instance sg13cmos5l_decap_8_3161 r0 *1 0,0
Xsg13cmos5l_decap_8_3161 VPWR VGND sg13cmos5l_decap_8
* cell instance sg13cmos5l_decap_8_3162 r0 *1 0,0
Xsg13cmos5l_decap_8_3162 VPWR VGND sg13cmos5l_decap_8
* cell instance sg13cmos5l_decap_8_3163 r0 *1 0,0
Xsg13cmos5l_decap_8_3163 VPWR VGND sg13cmos5l_decap_8
* cell instance sg13cmos5l_decap_8_3164 r0 *1 0,0
Xsg13cmos5l_decap_8_3164 VPWR VGND sg13cmos5l_decap_8
* cell instance sg13cmos5l_decap_8_3165 r0 *1 0,0
Xsg13cmos5l_decap_8_3165 VPWR VGND sg13cmos5l_decap_8
* cell instance sg13cmos5l_decap_8_3166 r0 *1 0,0
Xsg13cmos5l_decap_8_3166 VPWR VGND sg13cmos5l_decap_8
* cell instance sg13cmos5l_decap_8_3167 r0 *1 0,0
Xsg13cmos5l_decap_8_3167 VPWR VGND sg13cmos5l_decap_8
* cell instance sg13cmos5l_decap_8_3168 r0 *1 0,0
Xsg13cmos5l_decap_8_3168 VPWR VGND sg13cmos5l_decap_8
* cell instance sg13cmos5l_decap_8_3169 r0 *1 0,0
Xsg13cmos5l_decap_8_3169 VPWR VGND sg13cmos5l_decap_8
* cell instance sg13cmos5l_decap_8_3170 r0 *1 0,0
Xsg13cmos5l_decap_8_3170 VPWR VGND sg13cmos5l_decap_8
* cell instance sg13cmos5l_decap_8_3171 r0 *1 0,0
Xsg13cmos5l_decap_8_3171 VPWR VGND sg13cmos5l_decap_8
* cell instance sg13cmos5l_decap_8_3172 r0 *1 0,0
Xsg13cmos5l_decap_8_3172 VPWR VGND sg13cmos5l_decap_8
* cell instance sg13cmos5l_decap_8_3173 r0 *1 0,0
Xsg13cmos5l_decap_8_3173 VPWR VGND sg13cmos5l_decap_8
* cell instance sg13cmos5l_decap_8_3174 r0 *1 0,0
Xsg13cmos5l_decap_8_3174 VPWR VGND sg13cmos5l_decap_8
* cell instance sg13cmos5l_decap_8_3175 r0 *1 0,0
Xsg13cmos5l_decap_8_3175 VPWR VGND sg13cmos5l_decap_8
* cell instance sg13cmos5l_decap_8_3176 r0 *1 0,0
Xsg13cmos5l_decap_8_3176 VPWR VGND sg13cmos5l_decap_8
* cell instance sg13cmos5l_decap_8_3177 r0 *1 0,0
Xsg13cmos5l_decap_8_3177 VPWR VGND sg13cmos5l_decap_8
* cell instance sg13cmos5l_decap_8_3178 r0 *1 0,0
Xsg13cmos5l_decap_8_3178 VPWR VGND sg13cmos5l_decap_8
* cell instance sg13cmos5l_decap_8_3179 r0 *1 0,0
Xsg13cmos5l_decap_8_3179 VPWR VGND sg13cmos5l_decap_8
* cell instance sg13cmos5l_decap_8_3180 r0 *1 0,0
Xsg13cmos5l_decap_8_3180 VPWR VGND sg13cmos5l_decap_8
* cell instance sg13cmos5l_decap_8_3181 r0 *1 0,0
Xsg13cmos5l_decap_8_3181 VPWR VGND sg13cmos5l_decap_8
* cell instance sg13cmos5l_decap_8_3182 r0 *1 0,0
Xsg13cmos5l_decap_8_3182 VPWR VGND sg13cmos5l_decap_8
* cell instance sg13cmos5l_decap_8_3183 r0 *1 0,0
Xsg13cmos5l_decap_8_3183 VPWR VGND sg13cmos5l_decap_8
* cell instance sg13cmos5l_decap_8_3184 r0 *1 0,0
Xsg13cmos5l_decap_8_3184 VPWR VGND sg13cmos5l_decap_8
* cell instance sg13cmos5l_decap_8_3185 r0 *1 0,0
Xsg13cmos5l_decap_8_3185 VPWR VGND sg13cmos5l_decap_8
* cell instance sg13cmos5l_decap_8_3186 r0 *1 0,0
Xsg13cmos5l_decap_8_3186 VPWR VGND sg13cmos5l_decap_8
* cell instance sg13cmos5l_decap_8_3187 r0 *1 0,0
Xsg13cmos5l_decap_8_3187 VPWR VGND sg13cmos5l_decap_8
* cell instance sg13cmos5l_decap_8_3188 r0 *1 0,0
Xsg13cmos5l_decap_8_3188 VPWR VGND sg13cmos5l_decap_8
* cell instance sg13cmos5l_decap_8_3189 r0 *1 0,0
Xsg13cmos5l_decap_8_3189 VPWR VGND sg13cmos5l_decap_8
* cell instance sg13cmos5l_decap_8_3190 r0 *1 0,0
Xsg13cmos5l_decap_8_3190 VPWR VGND sg13cmos5l_decap_8
* cell instance sg13cmos5l_decap_8_3191 r0 *1 0,0
Xsg13cmos5l_decap_8_3191 VPWR VGND sg13cmos5l_decap_8
* cell instance sg13cmos5l_decap_8_3192 r0 *1 0,0
Xsg13cmos5l_decap_8_3192 VPWR VGND sg13cmos5l_decap_8
* cell instance sg13cmos5l_decap_8_3193 r0 *1 0,0
Xsg13cmos5l_decap_8_3193 VPWR VGND sg13cmos5l_decap_8
* cell instance sg13cmos5l_decap_8_3194 r0 *1 0,0
Xsg13cmos5l_decap_8_3194 VPWR VGND sg13cmos5l_decap_8
* cell instance sg13cmos5l_decap_8_3195 r0 *1 0,0
Xsg13cmos5l_decap_8_3195 VPWR VGND sg13cmos5l_decap_8
* cell instance sg13cmos5l_decap_8_3196 r0 *1 0,0
Xsg13cmos5l_decap_8_3196 VPWR VGND sg13cmos5l_decap_8
* cell instance sg13cmos5l_decap_8_3197 r0 *1 0,0
Xsg13cmos5l_decap_8_3197 VPWR VGND sg13cmos5l_decap_8
* cell instance sg13cmos5l_decap_8_3198 r0 *1 0,0
Xsg13cmos5l_decap_8_3198 VPWR VGND sg13cmos5l_decap_8
* cell instance sg13cmos5l_decap_8_3199 r0 *1 0,0
Xsg13cmos5l_decap_8_3199 VPWR VGND sg13cmos5l_decap_8
* cell instance sg13cmos5l_decap_8_3200 r0 *1 0,0
Xsg13cmos5l_decap_8_3200 VPWR VGND sg13cmos5l_decap_8
* cell instance sg13cmos5l_decap_8_3201 r0 *1 0,0
Xsg13cmos5l_decap_8_3201 VPWR VGND sg13cmos5l_decap_8
* cell instance sg13cmos5l_decap_8_3202 r0 *1 0,0
Xsg13cmos5l_decap_8_3202 VPWR VGND sg13cmos5l_decap_8
* cell instance sg13cmos5l_decap_8_3203 r0 *1 0,0
Xsg13cmos5l_decap_8_3203 VPWR VGND sg13cmos5l_decap_8
* cell instance sg13cmos5l_decap_8_3204 r0 *1 0,0
Xsg13cmos5l_decap_8_3204 VPWR VGND sg13cmos5l_decap_8
* cell instance sg13cmos5l_decap_8_3205 r0 *1 0,0
Xsg13cmos5l_decap_8_3205 VPWR VGND sg13cmos5l_decap_8
* cell instance sg13cmos5l_decap_8_3206 r0 *1 0,0
Xsg13cmos5l_decap_8_3206 VPWR VGND sg13cmos5l_decap_8
* cell instance sg13cmos5l_decap_8_3207 r0 *1 0,0
Xsg13cmos5l_decap_8_3207 VPWR VGND sg13cmos5l_decap_8
* cell instance sg13cmos5l_decap_8_3208 r0 *1 0,0
Xsg13cmos5l_decap_8_3208 VPWR VGND sg13cmos5l_decap_8
* cell instance sg13cmos5l_decap_8_3209 r0 *1 0,0
Xsg13cmos5l_decap_8_3209 VPWR VGND sg13cmos5l_decap_8
* cell instance sg13cmos5l_decap_8_3210 r0 *1 0,0
Xsg13cmos5l_decap_8_3210 VPWR VGND sg13cmos5l_decap_8
* cell instance sg13cmos5l_decap_8_3211 r0 *1 0,0
Xsg13cmos5l_decap_8_3211 VPWR VGND sg13cmos5l_decap_8
* cell instance sg13cmos5l_decap_8_3212 r0 *1 0,0
Xsg13cmos5l_decap_8_3212 VPWR VGND sg13cmos5l_decap_8
* cell instance sg13cmos5l_decap_8_3213 r0 *1 0,0
Xsg13cmos5l_decap_8_3213 VPWR VGND sg13cmos5l_decap_8
* cell instance sg13cmos5l_decap_8_3214 r0 *1 0,0
Xsg13cmos5l_decap_8_3214 VPWR VGND sg13cmos5l_decap_8
* cell instance sg13cmos5l_decap_8_3215 r0 *1 0,0
Xsg13cmos5l_decap_8_3215 VPWR VGND sg13cmos5l_decap_8
* cell instance sg13cmos5l_decap_8_3216 r0 *1 0,0
Xsg13cmos5l_decap_8_3216 VPWR VGND sg13cmos5l_decap_8
* cell instance sg13cmos5l_decap_8_3217 r0 *1 0,0
Xsg13cmos5l_decap_8_3217 VPWR VGND sg13cmos5l_decap_8
* cell instance sg13cmos5l_decap_8_3218 r0 *1 0,0
Xsg13cmos5l_decap_8_3218 VPWR VGND sg13cmos5l_decap_8
* cell instance sg13cmos5l_decap_8_3219 r0 *1 0,0
Xsg13cmos5l_decap_8_3219 VPWR VGND sg13cmos5l_decap_8
* cell instance sg13cmos5l_decap_8_3220 r0 *1 0,0
Xsg13cmos5l_decap_8_3220 VPWR VGND sg13cmos5l_decap_8
* cell instance sg13cmos5l_decap_8_3221 r0 *1 0,0
Xsg13cmos5l_decap_8_3221 VPWR VGND sg13cmos5l_decap_8
* cell instance sg13cmos5l_decap_8_3222 r0 *1 0,0
Xsg13cmos5l_decap_8_3222 VPWR VGND sg13cmos5l_decap_8
* cell instance sg13cmos5l_decap_8_3223 r0 *1 0,0
Xsg13cmos5l_decap_8_3223 VPWR VGND sg13cmos5l_decap_8
* cell instance sg13cmos5l_decap_8_3224 r0 *1 0,0
Xsg13cmos5l_decap_8_3224 VPWR VGND sg13cmos5l_decap_8
* cell instance sg13cmos5l_decap_8_3225 r0 *1 0,0
Xsg13cmos5l_decap_8_3225 VPWR VGND sg13cmos5l_decap_8
* cell instance sg13cmos5l_decap_8_3226 r0 *1 0,0
Xsg13cmos5l_decap_8_3226 VPWR VGND sg13cmos5l_decap_8
* cell instance sg13cmos5l_decap_8_3227 r0 *1 0,0
Xsg13cmos5l_decap_8_3227 VPWR VGND sg13cmos5l_decap_8
* cell instance sg13cmos5l_decap_8_3228 r0 *1 0,0
Xsg13cmos5l_decap_8_3228 VPWR VGND sg13cmos5l_decap_8
* cell instance sg13cmos5l_decap_8_3229 r0 *1 0,0
Xsg13cmos5l_decap_8_3229 VPWR VGND sg13cmos5l_decap_8
* cell instance sg13cmos5l_decap_8_3230 r0 *1 0,0
Xsg13cmos5l_decap_8_3230 VPWR VGND sg13cmos5l_decap_8
* cell instance sg13cmos5l_decap_8_3231 r0 *1 0,0
Xsg13cmos5l_decap_8_3231 VPWR VGND sg13cmos5l_decap_8
* cell instance sg13cmos5l_decap_8_3232 r0 *1 0,0
Xsg13cmos5l_decap_8_3232 VPWR VGND sg13cmos5l_decap_8
* cell instance sg13cmos5l_decap_8_3233 r0 *1 0,0
Xsg13cmos5l_decap_8_3233 VPWR VGND sg13cmos5l_decap_8
* cell instance sg13cmos5l_decap_8_3234 r0 *1 0,0
Xsg13cmos5l_decap_8_3234 VPWR VGND sg13cmos5l_decap_8
* cell instance sg13cmos5l_decap_8_3235 r0 *1 0,0
Xsg13cmos5l_decap_8_3235 VPWR VGND sg13cmos5l_decap_8
* cell instance sg13cmos5l_decap_8_3236 r0 *1 0,0
Xsg13cmos5l_decap_8_3236 VPWR VGND sg13cmos5l_decap_8
* cell instance sg13cmos5l_decap_8_3237 r0 *1 0,0
Xsg13cmos5l_decap_8_3237 VPWR VGND sg13cmos5l_decap_8
* cell instance sg13cmos5l_decap_8_3238 r0 *1 0,0
Xsg13cmos5l_decap_8_3238 VPWR VGND sg13cmos5l_decap_8
* cell instance sg13cmos5l_decap_8_3239 r0 *1 0,0
Xsg13cmos5l_decap_8_3239 VPWR VGND sg13cmos5l_decap_8
* cell instance sg13cmos5l_decap_8_3240 r0 *1 0,0
Xsg13cmos5l_decap_8_3240 VPWR VGND sg13cmos5l_decap_8
* cell instance sg13cmos5l_decap_8_3241 r0 *1 0,0
Xsg13cmos5l_decap_8_3241 VPWR VGND sg13cmos5l_decap_8
* cell instance sg13cmos5l_decap_8_3242 r0 *1 0,0
Xsg13cmos5l_decap_8_3242 VPWR VGND sg13cmos5l_decap_8
* cell instance sg13cmos5l_decap_8_3243 r0 *1 0,0
Xsg13cmos5l_decap_8_3243 VPWR VGND sg13cmos5l_decap_8
* cell instance sg13cmos5l_decap_8_3244 r0 *1 0,0
Xsg13cmos5l_decap_8_3244 VPWR VGND sg13cmos5l_decap_8
* cell instance sg13cmos5l_decap_8_3245 r0 *1 0,0
Xsg13cmos5l_decap_8_3245 VPWR VGND sg13cmos5l_decap_8
* cell instance sg13cmos5l_decap_8_3246 r0 *1 0,0
Xsg13cmos5l_decap_8_3246 VPWR VGND sg13cmos5l_decap_8
* cell instance sg13cmos5l_decap_8_3247 r0 *1 0,0
Xsg13cmos5l_decap_8_3247 VPWR VGND sg13cmos5l_decap_8
* cell instance sg13cmos5l_decap_8_3248 r0 *1 0,0
Xsg13cmos5l_decap_8_3248 VPWR VGND sg13cmos5l_decap_8
* cell instance sg13cmos5l_decap_8_3249 r0 *1 0,0
Xsg13cmos5l_decap_8_3249 VPWR VGND sg13cmos5l_decap_8
* cell instance sg13cmos5l_decap_8_3250 r0 *1 0,0
Xsg13cmos5l_decap_8_3250 VPWR VGND sg13cmos5l_decap_8
* cell instance sg13cmos5l_decap_8_3251 r0 *1 0,0
Xsg13cmos5l_decap_8_3251 VPWR VGND sg13cmos5l_decap_8
* cell instance sg13cmos5l_decap_8_3252 r0 *1 0,0
Xsg13cmos5l_decap_8_3252 VPWR VGND sg13cmos5l_decap_8
* cell instance sg13cmos5l_decap_8_3253 r0 *1 0,0
Xsg13cmos5l_decap_8_3253 VPWR VGND sg13cmos5l_decap_8
* cell instance sg13cmos5l_decap_8_3254 r0 *1 0,0
Xsg13cmos5l_decap_8_3254 VPWR VGND sg13cmos5l_decap_8
* cell instance sg13cmos5l_decap_8_3255 r0 *1 0,0
Xsg13cmos5l_decap_8_3255 VPWR VGND sg13cmos5l_decap_8
* cell instance sg13cmos5l_decap_8_3256 r0 *1 0,0
Xsg13cmos5l_decap_8_3256 VPWR VGND sg13cmos5l_decap_8
* cell instance sg13cmos5l_decap_8_3257 r0 *1 0,0
Xsg13cmos5l_decap_8_3257 VPWR VGND sg13cmos5l_decap_8
* cell instance sg13cmos5l_decap_8_3258 r0 *1 0,0
Xsg13cmos5l_decap_8_3258 VPWR VGND sg13cmos5l_decap_8
* cell instance sg13cmos5l_decap_8_3259 r0 *1 0,0
Xsg13cmos5l_decap_8_3259 VPWR VGND sg13cmos5l_decap_8
* cell instance sg13cmos5l_decap_8_3260 r0 *1 0,0
Xsg13cmos5l_decap_8_3260 VPWR VGND sg13cmos5l_decap_8
* cell instance sg13cmos5l_decap_8_3261 r0 *1 0,0
Xsg13cmos5l_decap_8_3261 VPWR VGND sg13cmos5l_decap_8
* cell instance sg13cmos5l_decap_8_3262 r0 *1 0,0
Xsg13cmos5l_decap_8_3262 VPWR VGND sg13cmos5l_decap_8
* cell instance sg13cmos5l_decap_8_3263 r0 *1 0,0
Xsg13cmos5l_decap_8_3263 VPWR VGND sg13cmos5l_decap_8
* cell instance sg13cmos5l_decap_8_3264 r0 *1 0,0
Xsg13cmos5l_decap_8_3264 VPWR VGND sg13cmos5l_decap_8
* cell instance sg13cmos5l_decap_8_3265 r0 *1 0,0
Xsg13cmos5l_decap_8_3265 VPWR VGND sg13cmos5l_decap_8
* cell instance sg13cmos5l_decap_8_3266 r0 *1 0,0
Xsg13cmos5l_decap_8_3266 VPWR VGND sg13cmos5l_decap_8
* cell instance sg13cmos5l_decap_8_3267 r0 *1 0,0
Xsg13cmos5l_decap_8_3267 VPWR VGND sg13cmos5l_decap_8
* cell instance sg13cmos5l_decap_8_3268 r0 *1 0,0
Xsg13cmos5l_decap_8_3268 VPWR VGND sg13cmos5l_decap_8
* cell instance sg13cmos5l_decap_8_3269 r0 *1 0,0
Xsg13cmos5l_decap_8_3269 VPWR VGND sg13cmos5l_decap_8
* cell instance sg13cmos5l_decap_8_3270 r0 *1 0,0
Xsg13cmos5l_decap_8_3270 VPWR VGND sg13cmos5l_decap_8
* cell instance sg13cmos5l_decap_8_3271 r0 *1 0,0
Xsg13cmos5l_decap_8_3271 VPWR VGND sg13cmos5l_decap_8
* cell instance sg13cmos5l_decap_8_3272 r0 *1 0,0
Xsg13cmos5l_decap_8_3272 VPWR VGND sg13cmos5l_decap_8
* cell instance sg13cmos5l_decap_8_3273 r0 *1 0,0
Xsg13cmos5l_decap_8_3273 VPWR VGND sg13cmos5l_decap_8
* cell instance sg13cmos5l_decap_8_3274 r0 *1 0,0
Xsg13cmos5l_decap_8_3274 VPWR VGND sg13cmos5l_decap_8
* cell instance sg13cmos5l_decap_8_3275 r0 *1 0,0
Xsg13cmos5l_decap_8_3275 VPWR VGND sg13cmos5l_decap_8
* cell instance sg13cmos5l_decap_8_3276 r0 *1 0,0
Xsg13cmos5l_decap_8_3276 VPWR VGND sg13cmos5l_decap_8
* cell instance sg13cmos5l_decap_8_3277 r0 *1 0,0
Xsg13cmos5l_decap_8_3277 VPWR VGND sg13cmos5l_decap_8
* cell instance sg13cmos5l_decap_8_3278 r0 *1 0,0
Xsg13cmos5l_decap_8_3278 VPWR VGND sg13cmos5l_decap_8
* cell instance sg13cmos5l_decap_8_3279 r0 *1 0,0
Xsg13cmos5l_decap_8_3279 VPWR VGND sg13cmos5l_decap_8
* cell instance sg13cmos5l_decap_8_3280 r0 *1 0,0
Xsg13cmos5l_decap_8_3280 VPWR VGND sg13cmos5l_decap_8
* cell instance sg13cmos5l_decap_8_3281 r0 *1 0,0
Xsg13cmos5l_decap_8_3281 VPWR VGND sg13cmos5l_decap_8
* cell instance sg13cmos5l_decap_8_3282 r0 *1 0,0
Xsg13cmos5l_decap_8_3282 VPWR VGND sg13cmos5l_decap_8
* cell instance sg13cmos5l_decap_8_3283 r0 *1 0,0
Xsg13cmos5l_decap_8_3283 VPWR VGND sg13cmos5l_decap_8
* cell instance sg13cmos5l_decap_8_3284 r0 *1 0,0
Xsg13cmos5l_decap_8_3284 VPWR VGND sg13cmos5l_decap_8
* cell instance sg13cmos5l_decap_8_3285 r0 *1 0,0
Xsg13cmos5l_decap_8_3285 VPWR VGND sg13cmos5l_decap_8
* cell instance sg13cmos5l_decap_8_3286 r0 *1 0,0
Xsg13cmos5l_decap_8_3286 VPWR VGND sg13cmos5l_decap_8
* cell instance sg13cmos5l_decap_8_3287 r0 *1 0,0
Xsg13cmos5l_decap_8_3287 VPWR VGND sg13cmos5l_decap_8
* cell instance sg13cmos5l_decap_8_3288 r0 *1 0,0
Xsg13cmos5l_decap_8_3288 VPWR VGND sg13cmos5l_decap_8
* cell instance sg13cmos5l_decap_8_3289 r0 *1 0,0
Xsg13cmos5l_decap_8_3289 VPWR VGND sg13cmos5l_decap_8
* cell instance sg13cmos5l_decap_8_3290 r0 *1 0,0
Xsg13cmos5l_decap_8_3290 VPWR VGND sg13cmos5l_decap_8
* cell instance sg13cmos5l_decap_8_3291 r0 *1 0,0
Xsg13cmos5l_decap_8_3291 VPWR VGND sg13cmos5l_decap_8
* cell instance sg13cmos5l_decap_8_3292 r0 *1 0,0
Xsg13cmos5l_decap_8_3292 VPWR VGND sg13cmos5l_decap_8
* cell instance sg13cmos5l_decap_8_3293 r0 *1 0,0
Xsg13cmos5l_decap_8_3293 VPWR VGND sg13cmos5l_decap_8
* cell instance sg13cmos5l_decap_8_3294 r0 *1 0,0
Xsg13cmos5l_decap_8_3294 VPWR VGND sg13cmos5l_decap_8
* cell instance sg13cmos5l_decap_8_3295 r0 *1 0,0
Xsg13cmos5l_decap_8_3295 VPWR VGND sg13cmos5l_decap_8
* cell instance sg13cmos5l_decap_8_3296 r0 *1 0,0
Xsg13cmos5l_decap_8_3296 VPWR VGND sg13cmos5l_decap_8
* cell instance sg13cmos5l_decap_8_3297 r0 *1 0,0
Xsg13cmos5l_decap_8_3297 VPWR VGND sg13cmos5l_decap_8
* cell instance sg13cmos5l_decap_8_3298 r0 *1 0,0
Xsg13cmos5l_decap_8_3298 VPWR VGND sg13cmos5l_decap_8
* cell instance sg13cmos5l_decap_8_3299 r0 *1 0,0
Xsg13cmos5l_decap_8_3299 VPWR VGND sg13cmos5l_decap_8
* cell instance sg13cmos5l_decap_8_3300 r0 *1 0,0
Xsg13cmos5l_decap_8_3300 VPWR VGND sg13cmos5l_decap_8
* cell instance sg13cmos5l_decap_8_3301 r0 *1 0,0
Xsg13cmos5l_decap_8_3301 VPWR VGND sg13cmos5l_decap_8
* cell instance sg13cmos5l_decap_8_3302 r0 *1 0,0
Xsg13cmos5l_decap_8_3302 VPWR VGND sg13cmos5l_decap_8
* cell instance sg13cmos5l_decap_8_3303 r0 *1 0,0
Xsg13cmos5l_decap_8_3303 VPWR VGND sg13cmos5l_decap_8
* cell instance sg13cmos5l_decap_8_3304 r0 *1 0,0
Xsg13cmos5l_decap_8_3304 VPWR VGND sg13cmos5l_decap_8
* cell instance sg13cmos5l_decap_8_3305 r0 *1 0,0
Xsg13cmos5l_decap_8_3305 VPWR VGND sg13cmos5l_decap_8
* cell instance sg13cmos5l_decap_8_3306 r0 *1 0,0
Xsg13cmos5l_decap_8_3306 VPWR VGND sg13cmos5l_decap_8
* cell instance sg13cmos5l_decap_8_3307 r0 *1 0,0
Xsg13cmos5l_decap_8_3307 VPWR VGND sg13cmos5l_decap_8
* cell instance sg13cmos5l_decap_8_3308 r0 *1 0,0
Xsg13cmos5l_decap_8_3308 VPWR VGND sg13cmos5l_decap_8
* cell instance sg13cmos5l_decap_8_3309 r0 *1 0,0
Xsg13cmos5l_decap_8_3309 VPWR VGND sg13cmos5l_decap_8
* cell instance sg13cmos5l_decap_8_3310 r0 *1 0,0
Xsg13cmos5l_decap_8_3310 VPWR VGND sg13cmos5l_decap_8
* cell instance sg13cmos5l_decap_8_3311 r0 *1 0,0
Xsg13cmos5l_decap_8_3311 VPWR VGND sg13cmos5l_decap_8
* cell instance sg13cmos5l_decap_8_3312 r0 *1 0,0
Xsg13cmos5l_decap_8_3312 VPWR VGND sg13cmos5l_decap_8
* cell instance sg13cmos5l_decap_8_3313 r0 *1 0,0
Xsg13cmos5l_decap_8_3313 VPWR VGND sg13cmos5l_decap_8
* cell instance sg13cmos5l_decap_8_3314 r0 *1 0,0
Xsg13cmos5l_decap_8_3314 VPWR VGND sg13cmos5l_decap_8
* cell instance sg13cmos5l_decap_8_3315 r0 *1 0,0
Xsg13cmos5l_decap_8_3315 VPWR VGND sg13cmos5l_decap_8
* cell instance sg13cmos5l_decap_8_3316 r0 *1 0,0
Xsg13cmos5l_decap_8_3316 VPWR VGND sg13cmos5l_decap_8
* cell instance sg13cmos5l_decap_8_3317 r0 *1 0,0
Xsg13cmos5l_decap_8_3317 VPWR VGND sg13cmos5l_decap_8
* cell instance sg13cmos5l_decap_8_3318 r0 *1 0,0
Xsg13cmos5l_decap_8_3318 VPWR VGND sg13cmos5l_decap_8
* cell instance sg13cmos5l_decap_8_3319 r0 *1 0,0
Xsg13cmos5l_decap_8_3319 VPWR VGND sg13cmos5l_decap_8
* cell instance sg13cmos5l_decap_8_3320 r0 *1 0,0
Xsg13cmos5l_decap_8_3320 VPWR VGND sg13cmos5l_decap_8
* cell instance sg13cmos5l_decap_8_3321 r0 *1 0,0
Xsg13cmos5l_decap_8_3321 VPWR VGND sg13cmos5l_decap_8
* cell instance sg13cmos5l_decap_8_3322 r0 *1 0,0
Xsg13cmos5l_decap_8_3322 VPWR VGND sg13cmos5l_decap_8
* cell instance sg13cmos5l_decap_8_3323 r0 *1 0,0
Xsg13cmos5l_decap_8_3323 VPWR VGND sg13cmos5l_decap_8
* cell instance sg13cmos5l_decap_8_3324 r0 *1 0,0
Xsg13cmos5l_decap_8_3324 VPWR VGND sg13cmos5l_decap_8
* cell instance sg13cmos5l_decap_8_3325 r0 *1 0,0
Xsg13cmos5l_decap_8_3325 VPWR VGND sg13cmos5l_decap_8
* cell instance sg13cmos5l_decap_8_3326 r0 *1 0,0
Xsg13cmos5l_decap_8_3326 VPWR VGND sg13cmos5l_decap_8
* cell instance sg13cmos5l_decap_8_3327 r0 *1 0,0
Xsg13cmos5l_decap_8_3327 VPWR VGND sg13cmos5l_decap_8
* cell instance sg13cmos5l_decap_8_3328 r0 *1 0,0
Xsg13cmos5l_decap_8_3328 VPWR VGND sg13cmos5l_decap_8
* cell instance sg13cmos5l_decap_8_3329 r0 *1 0,0
Xsg13cmos5l_decap_8_3329 VPWR VGND sg13cmos5l_decap_8
* cell instance sg13cmos5l_decap_8_3330 r0 *1 0,0
Xsg13cmos5l_decap_8_3330 VPWR VGND sg13cmos5l_decap_8
* cell instance sg13cmos5l_decap_8_3331 r0 *1 0,0
Xsg13cmos5l_decap_8_3331 VPWR VGND sg13cmos5l_decap_8
* cell instance sg13cmos5l_decap_8_3332 r0 *1 0,0
Xsg13cmos5l_decap_8_3332 VPWR VGND sg13cmos5l_decap_8
* cell instance sg13cmos5l_decap_8_3333 r0 *1 0,0
Xsg13cmos5l_decap_8_3333 VPWR VGND sg13cmos5l_decap_8
* cell instance sg13cmos5l_decap_8_3334 r0 *1 0,0
Xsg13cmos5l_decap_8_3334 VPWR VGND sg13cmos5l_decap_8
* cell instance sg13cmos5l_decap_8_3335 r0 *1 0,0
Xsg13cmos5l_decap_8_3335 VPWR VGND sg13cmos5l_decap_8
* cell instance sg13cmos5l_decap_8_3336 r0 *1 0,0
Xsg13cmos5l_decap_8_3336 VPWR VGND sg13cmos5l_decap_8
* cell instance sg13cmos5l_decap_8_3337 r0 *1 0,0
Xsg13cmos5l_decap_8_3337 VPWR VGND sg13cmos5l_decap_8
* cell instance sg13cmos5l_decap_8_3338 r0 *1 0,0
Xsg13cmos5l_decap_8_3338 VPWR VGND sg13cmos5l_decap_8
* cell instance sg13cmos5l_decap_8_3339 r0 *1 0,0
Xsg13cmos5l_decap_8_3339 VPWR VGND sg13cmos5l_decap_8
* cell instance sg13cmos5l_decap_8_3340 r0 *1 0,0
Xsg13cmos5l_decap_8_3340 VPWR VGND sg13cmos5l_decap_8
* cell instance sg13cmos5l_decap_8_3341 r0 *1 0,0
Xsg13cmos5l_decap_8_3341 VPWR VGND sg13cmos5l_decap_8
* cell instance sg13cmos5l_decap_8_3342 r0 *1 0,0
Xsg13cmos5l_decap_8_3342 VPWR VGND sg13cmos5l_decap_8
* cell instance sg13cmos5l_decap_8_3343 r0 *1 0,0
Xsg13cmos5l_decap_8_3343 VPWR VGND sg13cmos5l_decap_8
* cell instance sg13cmos5l_decap_8_3344 r0 *1 0,0
Xsg13cmos5l_decap_8_3344 VPWR VGND sg13cmos5l_decap_8
* cell instance sg13cmos5l_decap_8_3345 r0 *1 0,0
Xsg13cmos5l_decap_8_3345 VPWR VGND sg13cmos5l_decap_8
* cell instance sg13cmos5l_decap_8_3346 r0 *1 0,0
Xsg13cmos5l_decap_8_3346 VPWR VGND sg13cmos5l_decap_8
* cell instance sg13cmos5l_decap_8_3347 r0 *1 0,0
Xsg13cmos5l_decap_8_3347 VPWR VGND sg13cmos5l_decap_8
* cell instance sg13cmos5l_decap_8_3348 r0 *1 0,0
Xsg13cmos5l_decap_8_3348 VPWR VGND sg13cmos5l_decap_8
* cell instance sg13cmos5l_decap_8_3349 r0 *1 0,0
Xsg13cmos5l_decap_8_3349 VPWR VGND sg13cmos5l_decap_8
* cell instance sg13cmos5l_decap_8_3350 r0 *1 0,0
Xsg13cmos5l_decap_8_3350 VPWR VGND sg13cmos5l_decap_8
* cell instance sg13cmos5l_decap_8_3351 r0 *1 0,0
Xsg13cmos5l_decap_8_3351 VPWR VGND sg13cmos5l_decap_8
* cell instance sg13cmos5l_decap_8_3352 r0 *1 0,0
Xsg13cmos5l_decap_8_3352 VPWR VGND sg13cmos5l_decap_8
* cell instance sg13cmos5l_decap_8_3353 r0 *1 0,0
Xsg13cmos5l_decap_8_3353 VPWR VGND sg13cmos5l_decap_8
* cell instance sg13cmos5l_decap_8_3354 r0 *1 0,0
Xsg13cmos5l_decap_8_3354 VPWR VGND sg13cmos5l_decap_8
* cell instance sg13cmos5l_decap_8_3355 r0 *1 0,0
Xsg13cmos5l_decap_8_3355 VPWR VGND sg13cmos5l_decap_8
* cell instance sg13cmos5l_decap_8_3356 r0 *1 0,0
Xsg13cmos5l_decap_8_3356 VPWR VGND sg13cmos5l_decap_8
* cell instance sg13cmos5l_decap_8_3357 r0 *1 0,0
Xsg13cmos5l_decap_8_3357 VPWR VGND sg13cmos5l_decap_8
* cell instance sg13cmos5l_decap_8_3358 r0 *1 0,0
Xsg13cmos5l_decap_8_3358 VPWR VGND sg13cmos5l_decap_8
* cell instance sg13cmos5l_decap_8_3359 r0 *1 0,0
Xsg13cmos5l_decap_8_3359 VPWR VGND sg13cmos5l_decap_8
* cell instance sg13cmos5l_decap_8_3360 r0 *1 0,0
Xsg13cmos5l_decap_8_3360 VPWR VGND sg13cmos5l_decap_8
* cell instance sg13cmos5l_decap_8_3361 r0 *1 0,0
Xsg13cmos5l_decap_8_3361 VPWR VGND sg13cmos5l_decap_8
* cell instance sg13cmos5l_decap_8_3362 r0 *1 0,0
Xsg13cmos5l_decap_8_3362 VPWR VGND sg13cmos5l_decap_8
* cell instance sg13cmos5l_decap_8_3363 r0 *1 0,0
Xsg13cmos5l_decap_8_3363 VPWR VGND sg13cmos5l_decap_8
* cell instance sg13cmos5l_decap_8_3364 r0 *1 0,0
Xsg13cmos5l_decap_8_3364 VPWR VGND sg13cmos5l_decap_8
* cell instance sg13cmos5l_decap_8_3365 r0 *1 0,0
Xsg13cmos5l_decap_8_3365 VPWR VGND sg13cmos5l_decap_8
* cell instance sg13cmos5l_decap_8_3366 r0 *1 0,0
Xsg13cmos5l_decap_8_3366 VPWR VGND sg13cmos5l_decap_8
* cell instance sg13cmos5l_decap_8_3367 r0 *1 0,0
Xsg13cmos5l_decap_8_3367 VPWR VGND sg13cmos5l_decap_8
* cell instance sg13cmos5l_decap_8_3368 r0 *1 0,0
Xsg13cmos5l_decap_8_3368 VPWR VGND sg13cmos5l_decap_8
* cell instance sg13cmos5l_decap_8_3369 r0 *1 0,0
Xsg13cmos5l_decap_8_3369 VPWR VGND sg13cmos5l_decap_8
* cell instance sg13cmos5l_decap_8_3370 r0 *1 0,0
Xsg13cmos5l_decap_8_3370 VPWR VGND sg13cmos5l_decap_8
* cell instance sg13cmos5l_decap_8_3371 r0 *1 0,0
Xsg13cmos5l_decap_8_3371 VPWR VGND sg13cmos5l_decap_8
* cell instance sg13cmos5l_decap_8_3372 r0 *1 0,0
Xsg13cmos5l_decap_8_3372 VPWR VGND sg13cmos5l_decap_8
* cell instance sg13cmos5l_decap_8_3373 r0 *1 0,0
Xsg13cmos5l_decap_8_3373 VPWR VGND sg13cmos5l_decap_8
* cell instance sg13cmos5l_decap_8_3374 r0 *1 0,0
Xsg13cmos5l_decap_8_3374 VPWR VGND sg13cmos5l_decap_8
* cell instance sg13cmos5l_decap_8_3375 r0 *1 0,0
Xsg13cmos5l_decap_8_3375 VPWR VGND sg13cmos5l_decap_8
* cell instance sg13cmos5l_decap_8_3376 r0 *1 0,0
Xsg13cmos5l_decap_8_3376 VPWR VGND sg13cmos5l_decap_8
* cell instance sg13cmos5l_decap_8_3377 r0 *1 0,0
Xsg13cmos5l_decap_8_3377 VPWR VGND sg13cmos5l_decap_8
* cell instance sg13cmos5l_decap_8_3378 r0 *1 0,0
Xsg13cmos5l_decap_8_3378 VPWR VGND sg13cmos5l_decap_8
* cell instance sg13cmos5l_decap_8_3379 r0 *1 0,0
Xsg13cmos5l_decap_8_3379 VPWR VGND sg13cmos5l_decap_8
* cell instance sg13cmos5l_decap_8_3380 r0 *1 0,0
Xsg13cmos5l_decap_8_3380 VPWR VGND sg13cmos5l_decap_8
* cell instance sg13cmos5l_decap_8_3381 r0 *1 0,0
Xsg13cmos5l_decap_8_3381 VPWR VGND sg13cmos5l_decap_8
* cell instance sg13cmos5l_decap_8_3382 r0 *1 0,0
Xsg13cmos5l_decap_8_3382 VPWR VGND sg13cmos5l_decap_8
* cell instance sg13cmos5l_decap_8_3383 r0 *1 0,0
Xsg13cmos5l_decap_8_3383 VPWR VGND sg13cmos5l_decap_8
* cell instance sg13cmos5l_decap_8_3384 r0 *1 0,0
Xsg13cmos5l_decap_8_3384 VPWR VGND sg13cmos5l_decap_8
* cell instance sg13cmos5l_decap_8_3385 r0 *1 0,0
Xsg13cmos5l_decap_8_3385 VPWR VGND sg13cmos5l_decap_8
* cell instance sg13cmos5l_decap_8_3386 r0 *1 0,0
Xsg13cmos5l_decap_8_3386 VPWR VGND sg13cmos5l_decap_8
* cell instance sg13cmos5l_decap_8_3387 r0 *1 0,0
Xsg13cmos5l_decap_8_3387 VPWR VGND sg13cmos5l_decap_8
* cell instance sg13cmos5l_decap_8_3388 r0 *1 0,0
Xsg13cmos5l_decap_8_3388 VPWR VGND sg13cmos5l_decap_8
* cell instance sg13cmos5l_decap_8_3389 r0 *1 0,0
Xsg13cmos5l_decap_8_3389 VPWR VGND sg13cmos5l_decap_8
* cell instance sg13cmos5l_decap_8_3390 r0 *1 0,0
Xsg13cmos5l_decap_8_3390 VPWR VGND sg13cmos5l_decap_8
* cell instance sg13cmos5l_decap_8_3391 r0 *1 0,0
Xsg13cmos5l_decap_8_3391 VPWR VGND sg13cmos5l_decap_8
* cell instance sg13cmos5l_decap_8_3392 r0 *1 0,0
Xsg13cmos5l_decap_8_3392 VPWR VGND sg13cmos5l_decap_8
* cell instance sg13cmos5l_decap_8_3393 r0 *1 0,0
Xsg13cmos5l_decap_8_3393 VPWR VGND sg13cmos5l_decap_8
* cell instance sg13cmos5l_decap_8_3394 r0 *1 0,0
Xsg13cmos5l_decap_8_3394 VPWR VGND sg13cmos5l_decap_8
* cell instance sg13cmos5l_decap_8_3395 r0 *1 0,0
Xsg13cmos5l_decap_8_3395 VPWR VGND sg13cmos5l_decap_8
* cell instance sg13cmos5l_decap_8_3396 r0 *1 0,0
Xsg13cmos5l_decap_8_3396 VPWR VGND sg13cmos5l_decap_8
* cell instance sg13cmos5l_decap_8_3397 r0 *1 0,0
Xsg13cmos5l_decap_8_3397 VPWR VGND sg13cmos5l_decap_8
* cell instance sg13cmos5l_decap_8_3398 r0 *1 0,0
Xsg13cmos5l_decap_8_3398 VPWR VGND sg13cmos5l_decap_8
* cell instance sg13cmos5l_decap_8_3399 r0 *1 0,0
Xsg13cmos5l_decap_8_3399 VPWR VGND sg13cmos5l_decap_8
* cell instance sg13cmos5l_decap_8_3400 r0 *1 0,0
Xsg13cmos5l_decap_8_3400 VPWR VGND sg13cmos5l_decap_8
* cell instance sg13cmos5l_decap_8_3401 r0 *1 0,0
Xsg13cmos5l_decap_8_3401 VPWR VGND sg13cmos5l_decap_8
* cell instance sg13cmos5l_decap_8_3402 r0 *1 0,0
Xsg13cmos5l_decap_8_3402 VPWR VGND sg13cmos5l_decap_8
* cell instance sg13cmos5l_decap_8_3403 r0 *1 0,0
Xsg13cmos5l_decap_8_3403 VPWR VGND sg13cmos5l_decap_8
* cell instance sg13cmos5l_decap_8_3404 r0 *1 0,0
Xsg13cmos5l_decap_8_3404 VPWR VGND sg13cmos5l_decap_8
* cell instance sg13cmos5l_decap_8_3405 r0 *1 0,0
Xsg13cmos5l_decap_8_3405 VPWR VGND sg13cmos5l_decap_8
* cell instance sg13cmos5l_decap_8_3406 r0 *1 0,0
Xsg13cmos5l_decap_8_3406 VPWR VGND sg13cmos5l_decap_8
* cell instance sg13cmos5l_decap_8_3407 r0 *1 0,0
Xsg13cmos5l_decap_8_3407 VPWR VGND sg13cmos5l_decap_8
* cell instance sg13cmos5l_decap_8_3408 r0 *1 0,0
Xsg13cmos5l_decap_8_3408 VPWR VGND sg13cmos5l_decap_8
* cell instance sg13cmos5l_decap_8_3409 r0 *1 0,0
Xsg13cmos5l_decap_8_3409 VPWR VGND sg13cmos5l_decap_8
* cell instance sg13cmos5l_decap_8_3410 r0 *1 0,0
Xsg13cmos5l_decap_8_3410 VPWR VGND sg13cmos5l_decap_8
* cell instance sg13cmos5l_decap_8_3411 r0 *1 0,0
Xsg13cmos5l_decap_8_3411 VPWR VGND sg13cmos5l_decap_8
* cell instance sg13cmos5l_decap_8_3412 r0 *1 0,0
Xsg13cmos5l_decap_8_3412 VPWR VGND sg13cmos5l_decap_8
* cell instance sg13cmos5l_decap_8_3413 r0 *1 0,0
Xsg13cmos5l_decap_8_3413 VPWR VGND sg13cmos5l_decap_8
* cell instance sg13cmos5l_decap_8_3414 r0 *1 0,0
Xsg13cmos5l_decap_8_3414 VPWR VGND sg13cmos5l_decap_8
* cell instance sg13cmos5l_decap_8_3415 r0 *1 0,0
Xsg13cmos5l_decap_8_3415 VPWR VGND sg13cmos5l_decap_8
* cell instance sg13cmos5l_decap_8_3416 r0 *1 0,0
Xsg13cmos5l_decap_8_3416 VPWR VGND sg13cmos5l_decap_8
* cell instance sg13cmos5l_decap_8_3417 r0 *1 0,0
Xsg13cmos5l_decap_8_3417 VPWR VGND sg13cmos5l_decap_8
* cell instance sg13cmos5l_decap_8_3418 r0 *1 0,0
Xsg13cmos5l_decap_8_3418 VPWR VGND sg13cmos5l_decap_8
* cell instance sg13cmos5l_decap_8_3419 r0 *1 0,0
Xsg13cmos5l_decap_8_3419 VPWR VGND sg13cmos5l_decap_8
* cell instance sg13cmos5l_decap_8_3420 r0 *1 0,0
Xsg13cmos5l_decap_8_3420 VPWR VGND sg13cmos5l_decap_8
* cell instance sg13cmos5l_decap_8_3421 r0 *1 0,0
Xsg13cmos5l_decap_8_3421 VPWR VGND sg13cmos5l_decap_8
* cell instance sg13cmos5l_decap_8_3422 r0 *1 0,0
Xsg13cmos5l_decap_8_3422 VPWR VGND sg13cmos5l_decap_8
* cell instance sg13cmos5l_decap_8_3423 r0 *1 0,0
Xsg13cmos5l_decap_8_3423 VPWR VGND sg13cmos5l_decap_8
* cell instance sg13cmos5l_decap_8_3424 r0 *1 0,0
Xsg13cmos5l_decap_8_3424 VPWR VGND sg13cmos5l_decap_8
* cell instance sg13cmos5l_decap_8_3425 r0 *1 0,0
Xsg13cmos5l_decap_8_3425 VPWR VGND sg13cmos5l_decap_8
* cell instance sg13cmos5l_decap_8_3426 r0 *1 0,0
Xsg13cmos5l_decap_8_3426 VPWR VGND sg13cmos5l_decap_8
* cell instance sg13cmos5l_decap_8_3427 r0 *1 0,0
Xsg13cmos5l_decap_8_3427 VPWR VGND sg13cmos5l_decap_8
* cell instance sg13cmos5l_decap_8_3428 r0 *1 0,0
Xsg13cmos5l_decap_8_3428 VPWR VGND sg13cmos5l_decap_8
* cell instance sg13cmos5l_decap_8_3429 r0 *1 0,0
Xsg13cmos5l_decap_8_3429 VPWR VGND sg13cmos5l_decap_8
* cell instance sg13cmos5l_decap_8_3430 r0 *1 0,0
Xsg13cmos5l_decap_8_3430 VPWR VGND sg13cmos5l_decap_8
* cell instance sg13cmos5l_decap_8_3431 r0 *1 0,0
Xsg13cmos5l_decap_8_3431 VPWR VGND sg13cmos5l_decap_8
* cell instance sg13cmos5l_decap_8_3432 r0 *1 0,0
Xsg13cmos5l_decap_8_3432 VPWR VGND sg13cmos5l_decap_8
* cell instance sg13cmos5l_decap_8_3433 r0 *1 0,0
Xsg13cmos5l_decap_8_3433 VPWR VGND sg13cmos5l_decap_8
* cell instance sg13cmos5l_decap_8_3434 r0 *1 0,0
Xsg13cmos5l_decap_8_3434 VPWR VGND sg13cmos5l_decap_8
* cell instance sg13cmos5l_decap_8_3435 r0 *1 0,0
Xsg13cmos5l_decap_8_3435 VPWR VGND sg13cmos5l_decap_8
* cell instance sg13cmos5l_decap_8_3436 r0 *1 0,0
Xsg13cmos5l_decap_8_3436 VPWR VGND sg13cmos5l_decap_8
* cell instance sg13cmos5l_decap_8_3437 r0 *1 0,0
Xsg13cmos5l_decap_8_3437 VPWR VGND sg13cmos5l_decap_8
* cell instance sg13cmos5l_decap_8_3438 r0 *1 0,0
Xsg13cmos5l_decap_8_3438 VPWR VGND sg13cmos5l_decap_8
* cell instance sg13cmos5l_decap_8_3439 r0 *1 0,0
Xsg13cmos5l_decap_8_3439 VPWR VGND sg13cmos5l_decap_8
* cell instance sg13cmos5l_decap_8_3440 r0 *1 0,0
Xsg13cmos5l_decap_8_3440 VPWR VGND sg13cmos5l_decap_8
* cell instance sg13cmos5l_decap_8_3441 r0 *1 0,0
Xsg13cmos5l_decap_8_3441 VPWR VGND sg13cmos5l_decap_8
* cell instance sg13cmos5l_decap_8_3442 r0 *1 0,0
Xsg13cmos5l_decap_8_3442 VPWR VGND sg13cmos5l_decap_8
* cell instance sg13cmos5l_decap_8_3443 r0 *1 0,0
Xsg13cmos5l_decap_8_3443 VPWR VGND sg13cmos5l_decap_8
* cell instance sg13cmos5l_decap_8_3444 r0 *1 0,0
Xsg13cmos5l_decap_8_3444 VPWR VGND sg13cmos5l_decap_8
* cell instance sg13cmos5l_decap_8_3445 r0 *1 0,0
Xsg13cmos5l_decap_8_3445 VPWR VGND sg13cmos5l_decap_8
* cell instance sg13cmos5l_decap_8_3446 r0 *1 0,0
Xsg13cmos5l_decap_8_3446 VPWR VGND sg13cmos5l_decap_8
* cell instance sg13cmos5l_decap_8_3447 r0 *1 0,0
Xsg13cmos5l_decap_8_3447 VPWR VGND sg13cmos5l_decap_8
* cell instance sg13cmos5l_decap_8_3448 r0 *1 0,0
Xsg13cmos5l_decap_8_3448 VPWR VGND sg13cmos5l_decap_8
* cell instance sg13cmos5l_decap_8_3449 r0 *1 0,0
Xsg13cmos5l_decap_8_3449 VPWR VGND sg13cmos5l_decap_8
* cell instance sg13cmos5l_decap_8_3450 r0 *1 0,0
Xsg13cmos5l_decap_8_3450 VPWR VGND sg13cmos5l_decap_8
* cell instance sg13cmos5l_decap_8_3451 r0 *1 0,0
Xsg13cmos5l_decap_8_3451 VPWR VGND sg13cmos5l_decap_8
* cell instance sg13cmos5l_decap_8_3452 r0 *1 0,0
Xsg13cmos5l_decap_8_3452 VPWR VGND sg13cmos5l_decap_8
* cell instance sg13cmos5l_decap_8_3453 r0 *1 0,0
Xsg13cmos5l_decap_8_3453 VPWR VGND sg13cmos5l_decap_8
* cell instance sg13cmos5l_decap_8_3454 r0 *1 0,0
Xsg13cmos5l_decap_8_3454 VPWR VGND sg13cmos5l_decap_8
* cell instance sg13cmos5l_decap_8_3455 r0 *1 0,0
Xsg13cmos5l_decap_8_3455 VPWR VGND sg13cmos5l_decap_8
* cell instance sg13cmos5l_decap_8_3456 r0 *1 0,0
Xsg13cmos5l_decap_8_3456 VPWR VGND sg13cmos5l_decap_8
* cell instance sg13cmos5l_decap_8_3457 r0 *1 0,0
Xsg13cmos5l_decap_8_3457 VPWR VGND sg13cmos5l_decap_8
* cell instance sg13cmos5l_decap_8_3458 r0 *1 0,0
Xsg13cmos5l_decap_8_3458 VPWR VGND sg13cmos5l_decap_8
* cell instance sg13cmos5l_decap_8_3459 r0 *1 0,0
Xsg13cmos5l_decap_8_3459 VPWR VGND sg13cmos5l_decap_8
* cell instance sg13cmos5l_decap_8_3460 r0 *1 0,0
Xsg13cmos5l_decap_8_3460 VPWR VGND sg13cmos5l_decap_8
* cell instance sg13cmos5l_decap_8_3461 r0 *1 0,0
Xsg13cmos5l_decap_8_3461 VPWR VGND sg13cmos5l_decap_8
* cell instance sg13cmos5l_decap_8_3462 r0 *1 0,0
Xsg13cmos5l_decap_8_3462 VPWR VGND sg13cmos5l_decap_8
* cell instance sg13cmos5l_decap_8_3463 r0 *1 0,0
Xsg13cmos5l_decap_8_3463 VPWR VGND sg13cmos5l_decap_8
* cell instance sg13cmos5l_decap_8_3464 r0 *1 0,0
Xsg13cmos5l_decap_8_3464 VPWR VGND sg13cmos5l_decap_8
* cell instance sg13cmos5l_decap_8_3465 r0 *1 0,0
Xsg13cmos5l_decap_8_3465 VPWR VGND sg13cmos5l_decap_8
* cell instance sg13cmos5l_decap_8_3466 r0 *1 0,0
Xsg13cmos5l_decap_8_3466 VPWR VGND sg13cmos5l_decap_8
* cell instance sg13cmos5l_decap_8_3467 r0 *1 0,0
Xsg13cmos5l_decap_8_3467 VPWR VGND sg13cmos5l_decap_8
* cell instance sg13cmos5l_decap_8_3468 r0 *1 0,0
Xsg13cmos5l_decap_8_3468 VPWR VGND sg13cmos5l_decap_8
* cell instance sg13cmos5l_decap_8_3469 r0 *1 0,0
Xsg13cmos5l_decap_8_3469 VPWR VGND sg13cmos5l_decap_8
* cell instance sg13cmos5l_decap_8_3470 r0 *1 0,0
Xsg13cmos5l_decap_8_3470 VPWR VGND sg13cmos5l_decap_8
* cell instance sg13cmos5l_decap_8_3471 r0 *1 0,0
Xsg13cmos5l_decap_8_3471 VPWR VGND sg13cmos5l_decap_8
* cell instance sg13cmos5l_decap_8_3472 r0 *1 0,0
Xsg13cmos5l_decap_8_3472 VPWR VGND sg13cmos5l_decap_8
* cell instance sg13cmos5l_decap_8_3473 r0 *1 0,0
Xsg13cmos5l_decap_8_3473 VPWR VGND sg13cmos5l_decap_8
* cell instance sg13cmos5l_decap_8_3474 r0 *1 0,0
Xsg13cmos5l_decap_8_3474 VPWR VGND sg13cmos5l_decap_8
* cell instance sg13cmos5l_decap_8_3475 r0 *1 0,0
Xsg13cmos5l_decap_8_3475 VPWR VGND sg13cmos5l_decap_8
* cell instance sg13cmos5l_decap_8_3476 r0 *1 0,0
Xsg13cmos5l_decap_8_3476 VPWR VGND sg13cmos5l_decap_8
* cell instance sg13cmos5l_decap_8_3477 r0 *1 0,0
Xsg13cmos5l_decap_8_3477 VPWR VGND sg13cmos5l_decap_8
* cell instance sg13cmos5l_decap_8_3478 r0 *1 0,0
Xsg13cmos5l_decap_8_3478 VPWR VGND sg13cmos5l_decap_8
* cell instance sg13cmos5l_decap_8_3479 r0 *1 0,0
Xsg13cmos5l_decap_8_3479 VPWR VGND sg13cmos5l_decap_8
* cell instance sg13cmos5l_decap_8_3480 r0 *1 0,0
Xsg13cmos5l_decap_8_3480 VPWR VGND sg13cmos5l_decap_8
* cell instance sg13cmos5l_decap_8_3481 r0 *1 0,0
Xsg13cmos5l_decap_8_3481 VPWR VGND sg13cmos5l_decap_8
* cell instance sg13cmos5l_decap_8_3482 r0 *1 0,0
Xsg13cmos5l_decap_8_3482 VPWR VGND sg13cmos5l_decap_8
* cell instance sg13cmos5l_decap_8_3483 r0 *1 0,0
Xsg13cmos5l_decap_8_3483 VPWR VGND sg13cmos5l_decap_8
* cell instance sg13cmos5l_decap_8_3484 r0 *1 0,0
Xsg13cmos5l_decap_8_3484 VPWR VGND sg13cmos5l_decap_8
* cell instance sg13cmos5l_decap_8_3485 r0 *1 0,0
Xsg13cmos5l_decap_8_3485 VPWR VGND sg13cmos5l_decap_8
* cell instance sg13cmos5l_decap_8_3486 r0 *1 0,0
Xsg13cmos5l_decap_8_3486 VPWR VGND sg13cmos5l_decap_8
* cell instance sg13cmos5l_decap_8_3487 r0 *1 0,0
Xsg13cmos5l_decap_8_3487 VPWR VGND sg13cmos5l_decap_8
* cell instance sg13cmos5l_decap_8_3488 r0 *1 0,0
Xsg13cmos5l_decap_8_3488 VPWR VGND sg13cmos5l_decap_8
* cell instance sg13cmos5l_decap_8_3489 r0 *1 0,0
Xsg13cmos5l_decap_8_3489 VPWR VGND sg13cmos5l_decap_8
* cell instance sg13cmos5l_decap_8_3490 r0 *1 0,0
Xsg13cmos5l_decap_8_3490 VPWR VGND sg13cmos5l_decap_8
* cell instance sg13cmos5l_decap_8_3491 r0 *1 0,0
Xsg13cmos5l_decap_8_3491 VPWR VGND sg13cmos5l_decap_8
* cell instance sg13cmos5l_decap_8_3492 r0 *1 0,0
Xsg13cmos5l_decap_8_3492 VPWR VGND sg13cmos5l_decap_8
* cell instance sg13cmos5l_decap_8_3493 r0 *1 0,0
Xsg13cmos5l_decap_8_3493 VPWR VGND sg13cmos5l_decap_8
* cell instance sg13cmos5l_decap_8_3494 r0 *1 0,0
Xsg13cmos5l_decap_8_3494 VPWR VGND sg13cmos5l_decap_8
* cell instance sg13cmos5l_decap_8_3495 r0 *1 0,0
Xsg13cmos5l_decap_8_3495 VPWR VGND sg13cmos5l_decap_8
* cell instance sg13cmos5l_decap_8_3496 r0 *1 0,0
Xsg13cmos5l_decap_8_3496 VPWR VGND sg13cmos5l_decap_8
* cell instance sg13cmos5l_decap_8_3497 r0 *1 0,0
Xsg13cmos5l_decap_8_3497 VPWR VGND sg13cmos5l_decap_8
* cell instance sg13cmos5l_decap_8_3498 r0 *1 0,0
Xsg13cmos5l_decap_8_3498 VPWR VGND sg13cmos5l_decap_8
* cell instance sg13cmos5l_decap_8_3499 r0 *1 0,0
Xsg13cmos5l_decap_8_3499 VPWR VGND sg13cmos5l_decap_8
* cell instance sg13cmos5l_decap_8_3500 r0 *1 0,0
Xsg13cmos5l_decap_8_3500 VPWR VGND sg13cmos5l_decap_8
* cell instance sg13cmos5l_decap_8_3501 r0 *1 0,0
Xsg13cmos5l_decap_8_3501 VPWR VGND sg13cmos5l_decap_8
* cell instance sg13cmos5l_decap_8_3502 r0 *1 0,0
Xsg13cmos5l_decap_8_3502 VPWR VGND sg13cmos5l_decap_8
* cell instance sg13cmos5l_decap_8_3503 r0 *1 0,0
Xsg13cmos5l_decap_8_3503 VPWR VGND sg13cmos5l_decap_8
* cell instance sg13cmos5l_decap_8_3504 r0 *1 0,0
Xsg13cmos5l_decap_8_3504 VPWR VGND sg13cmos5l_decap_8
* cell instance sg13cmos5l_decap_8_3505 r0 *1 0,0
Xsg13cmos5l_decap_8_3505 VPWR VGND sg13cmos5l_decap_8
* cell instance sg13cmos5l_decap_8_3506 r0 *1 0,0
Xsg13cmos5l_decap_8_3506 VPWR VGND sg13cmos5l_decap_8
* cell instance sg13cmos5l_decap_8_3507 r0 *1 0,0
Xsg13cmos5l_decap_8_3507 VPWR VGND sg13cmos5l_decap_8
* cell instance sg13cmos5l_decap_8_3508 r0 *1 0,0
Xsg13cmos5l_decap_8_3508 VPWR VGND sg13cmos5l_decap_8
* cell instance sg13cmos5l_decap_8_3509 r0 *1 0,0
Xsg13cmos5l_decap_8_3509 VPWR VGND sg13cmos5l_decap_8
* cell instance sg13cmos5l_decap_8_3510 r0 *1 0,0
Xsg13cmos5l_decap_8_3510 VPWR VGND sg13cmos5l_decap_8
* cell instance sg13cmos5l_decap_8_3511 r0 *1 0,0
Xsg13cmos5l_decap_8_3511 VPWR VGND sg13cmos5l_decap_8
* cell instance sg13cmos5l_decap_8_3512 r0 *1 0,0
Xsg13cmos5l_decap_8_3512 VPWR VGND sg13cmos5l_decap_8
* cell instance sg13cmos5l_decap_8_3513 r0 *1 0,0
Xsg13cmos5l_decap_8_3513 VPWR VGND sg13cmos5l_decap_8
* cell instance sg13cmos5l_decap_8_3514 r0 *1 0,0
Xsg13cmos5l_decap_8_3514 VPWR VGND sg13cmos5l_decap_8
* cell instance sg13cmos5l_decap_8_3515 r0 *1 0,0
Xsg13cmos5l_decap_8_3515 VPWR VGND sg13cmos5l_decap_8
* cell instance sg13cmos5l_decap_8_3516 r0 *1 0,0
Xsg13cmos5l_decap_8_3516 VPWR VGND sg13cmos5l_decap_8
* cell instance sg13cmos5l_decap_8_3517 r0 *1 0,0
Xsg13cmos5l_decap_8_3517 VPWR VGND sg13cmos5l_decap_8
* cell instance sg13cmos5l_decap_8_3518 r0 *1 0,0
Xsg13cmos5l_decap_8_3518 VPWR VGND sg13cmos5l_decap_8
* cell instance sg13cmos5l_decap_8_3519 r0 *1 0,0
Xsg13cmos5l_decap_8_3519 VPWR VGND sg13cmos5l_decap_8
* cell instance sg13cmos5l_decap_8_3520 r0 *1 0,0
Xsg13cmos5l_decap_8_3520 VPWR VGND sg13cmos5l_decap_8
* cell instance sg13cmos5l_decap_8_3521 r0 *1 0,0
Xsg13cmos5l_decap_8_3521 VPWR VGND sg13cmos5l_decap_8
* cell instance sg13cmos5l_decap_8_3522 r0 *1 0,0
Xsg13cmos5l_decap_8_3522 VPWR VGND sg13cmos5l_decap_8
* cell instance sg13cmos5l_decap_8_3523 r0 *1 0,0
Xsg13cmos5l_decap_8_3523 VPWR VGND sg13cmos5l_decap_8
* cell instance sg13cmos5l_decap_8_3524 r0 *1 0,0
Xsg13cmos5l_decap_8_3524 VPWR VGND sg13cmos5l_decap_8
* cell instance sg13cmos5l_decap_8_3525 r0 *1 0,0
Xsg13cmos5l_decap_8_3525 VPWR VGND sg13cmos5l_decap_8
* cell instance sg13cmos5l_decap_8_3526 r0 *1 0,0
Xsg13cmos5l_decap_8_3526 VPWR VGND sg13cmos5l_decap_8
* cell instance sg13cmos5l_decap_8_3527 r0 *1 0,0
Xsg13cmos5l_decap_8_3527 VPWR VGND sg13cmos5l_decap_8
* cell instance sg13cmos5l_decap_8_3528 r0 *1 0,0
Xsg13cmos5l_decap_8_3528 VPWR VGND sg13cmos5l_decap_8
* cell instance sg13cmos5l_decap_8_3529 r0 *1 0,0
Xsg13cmos5l_decap_8_3529 VPWR VGND sg13cmos5l_decap_8
* cell instance sg13cmos5l_decap_8_3530 r0 *1 0,0
Xsg13cmos5l_decap_8_3530 VPWR VGND sg13cmos5l_decap_8
* cell instance sg13cmos5l_decap_8_3531 r0 *1 0,0
Xsg13cmos5l_decap_8_3531 VPWR VGND sg13cmos5l_decap_8
* cell instance sg13cmos5l_decap_8_3532 r0 *1 0,0
Xsg13cmos5l_decap_8_3532 VPWR VGND sg13cmos5l_decap_8
* cell instance sg13cmos5l_decap_8_3533 r0 *1 0,0
Xsg13cmos5l_decap_8_3533 VPWR VGND sg13cmos5l_decap_8
* cell instance sg13cmos5l_decap_8_3534 r0 *1 0,0
Xsg13cmos5l_decap_8_3534 VPWR VGND sg13cmos5l_decap_8
* cell instance sg13cmos5l_decap_8_3535 r0 *1 0,0
Xsg13cmos5l_decap_8_3535 VPWR VGND sg13cmos5l_decap_8
* cell instance sg13cmos5l_decap_8_3536 r0 *1 0,0
Xsg13cmos5l_decap_8_3536 VPWR VGND sg13cmos5l_decap_8
* cell instance sg13cmos5l_decap_8_3537 r0 *1 0,0
Xsg13cmos5l_decap_8_3537 VPWR VGND sg13cmos5l_decap_8
* cell instance sg13cmos5l_decap_8_3538 r0 *1 0,0
Xsg13cmos5l_decap_8_3538 VPWR VGND sg13cmos5l_decap_8
* cell instance sg13cmos5l_decap_8_3539 r0 *1 0,0
Xsg13cmos5l_decap_8_3539 VPWR VGND sg13cmos5l_decap_8
* cell instance sg13cmos5l_decap_8_3540 r0 *1 0,0
Xsg13cmos5l_decap_8_3540 VPWR VGND sg13cmos5l_decap_8
* cell instance sg13cmos5l_decap_8_3541 r0 *1 0,0
Xsg13cmos5l_decap_8_3541 VPWR VGND sg13cmos5l_decap_8
* cell instance sg13cmos5l_decap_8_3542 r0 *1 0,0
Xsg13cmos5l_decap_8_3542 VPWR VGND sg13cmos5l_decap_8
* cell instance sg13cmos5l_decap_8_3543 r0 *1 0,0
Xsg13cmos5l_decap_8_3543 VPWR VGND sg13cmos5l_decap_8
* cell instance sg13cmos5l_decap_8_3544 r0 *1 0,0
Xsg13cmos5l_decap_8_3544 VPWR VGND sg13cmos5l_decap_8
* cell instance sg13cmos5l_decap_8_3545 r0 *1 0,0
Xsg13cmos5l_decap_8_3545 VPWR VGND sg13cmos5l_decap_8
* cell instance sg13cmos5l_decap_8_3546 r0 *1 0,0
Xsg13cmos5l_decap_8_3546 VPWR VGND sg13cmos5l_decap_8
* cell instance sg13cmos5l_decap_8_3547 r0 *1 0,0
Xsg13cmos5l_decap_8_3547 VPWR VGND sg13cmos5l_decap_8
* cell instance sg13cmos5l_decap_8_3548 r0 *1 0,0
Xsg13cmos5l_decap_8_3548 VPWR VGND sg13cmos5l_decap_8
* cell instance sg13cmos5l_decap_8_3549 r0 *1 0,0
Xsg13cmos5l_decap_8_3549 VPWR VGND sg13cmos5l_decap_8
* cell instance sg13cmos5l_decap_8_3550 r0 *1 0,0
Xsg13cmos5l_decap_8_3550 VPWR VGND sg13cmos5l_decap_8
* cell instance sg13cmos5l_decap_8_3551 r0 *1 0,0
Xsg13cmos5l_decap_8_3551 VPWR VGND sg13cmos5l_decap_8
* cell instance sg13cmos5l_decap_8_3552 r0 *1 0,0
Xsg13cmos5l_decap_8_3552 VPWR VGND sg13cmos5l_decap_8
* cell instance sg13cmos5l_decap_8_3553 r0 *1 0,0
Xsg13cmos5l_decap_8_3553 VPWR VGND sg13cmos5l_decap_8
* cell instance sg13cmos5l_decap_8_3554 r0 *1 0,0
Xsg13cmos5l_decap_8_3554 VPWR VGND sg13cmos5l_decap_8
* cell instance sg13cmos5l_decap_8_3555 r0 *1 0,0
Xsg13cmos5l_decap_8_3555 VPWR VGND sg13cmos5l_decap_8
* cell instance sg13cmos5l_decap_8_3556 r0 *1 0,0
Xsg13cmos5l_decap_8_3556 VPWR VGND sg13cmos5l_decap_8
* cell instance sg13cmos5l_decap_8_3557 r0 *1 0,0
Xsg13cmos5l_decap_8_3557 VPWR VGND sg13cmos5l_decap_8
* cell instance sg13cmos5l_decap_8_3558 r0 *1 0,0
Xsg13cmos5l_decap_8_3558 VPWR VGND sg13cmos5l_decap_8
* cell instance sg13cmos5l_decap_8_3559 r0 *1 0,0
Xsg13cmos5l_decap_8_3559 VPWR VGND sg13cmos5l_decap_8
* cell instance sg13cmos5l_decap_8_3560 r0 *1 0,0
Xsg13cmos5l_decap_8_3560 VPWR VGND sg13cmos5l_decap_8
* cell instance sg13cmos5l_decap_8_3561 r0 *1 0,0
Xsg13cmos5l_decap_8_3561 VPWR VGND sg13cmos5l_decap_8
* cell instance sg13cmos5l_decap_8_3562 r0 *1 0,0
Xsg13cmos5l_decap_8_3562 VPWR VGND sg13cmos5l_decap_8
* cell instance sg13cmos5l_decap_8_3563 r0 *1 0,0
Xsg13cmos5l_decap_8_3563 VPWR VGND sg13cmos5l_decap_8
* cell instance sg13cmos5l_decap_8_3564 r0 *1 0,0
Xsg13cmos5l_decap_8_3564 VPWR VGND sg13cmos5l_decap_8
* cell instance sg13cmos5l_decap_8_3565 r0 *1 0,0
Xsg13cmos5l_decap_8_3565 VPWR VGND sg13cmos5l_decap_8
* cell instance sg13cmos5l_decap_8_3566 r0 *1 0,0
Xsg13cmos5l_decap_8_3566 VPWR VGND sg13cmos5l_decap_8
* cell instance sg13cmos5l_decap_8_3567 r0 *1 0,0
Xsg13cmos5l_decap_8_3567 VPWR VGND sg13cmos5l_decap_8
* cell instance sg13cmos5l_decap_8_3568 r0 *1 0,0
Xsg13cmos5l_decap_8_3568 VPWR VGND sg13cmos5l_decap_8
* cell instance sg13cmos5l_decap_8_3569 r0 *1 0,0
Xsg13cmos5l_decap_8_3569 VPWR VGND sg13cmos5l_decap_8
* cell instance sg13cmos5l_decap_8_3570 r0 *1 0,0
Xsg13cmos5l_decap_8_3570 VPWR VGND sg13cmos5l_decap_8
* cell instance sg13cmos5l_decap_8_3571 r0 *1 0,0
Xsg13cmos5l_decap_8_3571 VPWR VGND sg13cmos5l_decap_8
* cell instance sg13cmos5l_decap_8_3572 r0 *1 0,0
Xsg13cmos5l_decap_8_3572 VPWR VGND sg13cmos5l_decap_8
* cell instance sg13cmos5l_decap_8_3573 r0 *1 0,0
Xsg13cmos5l_decap_8_3573 VPWR VGND sg13cmos5l_decap_8
* cell instance sg13cmos5l_decap_8_3574 r0 *1 0,0
Xsg13cmos5l_decap_8_3574 VPWR VGND sg13cmos5l_decap_8
* cell instance sg13cmos5l_decap_8_3575 r0 *1 0,0
Xsg13cmos5l_decap_8_3575 VPWR VGND sg13cmos5l_decap_8
* cell instance sg13cmos5l_decap_8_3576 r0 *1 0,0
Xsg13cmos5l_decap_8_3576 VPWR VGND sg13cmos5l_decap_8
* cell instance sg13cmos5l_decap_8_3577 r0 *1 0,0
Xsg13cmos5l_decap_8_3577 VPWR VGND sg13cmos5l_decap_8
* cell instance sg13cmos5l_decap_8_3578 r0 *1 0,0
Xsg13cmos5l_decap_8_3578 VPWR VGND sg13cmos5l_decap_8
* cell instance sg13cmos5l_decap_8_3579 r0 *1 0,0
Xsg13cmos5l_decap_8_3579 VPWR VGND sg13cmos5l_decap_8
* cell instance sg13cmos5l_decap_8_3580 r0 *1 0,0
Xsg13cmos5l_decap_8_3580 VPWR VGND sg13cmos5l_decap_8
* cell instance sg13cmos5l_decap_8_3581 r0 *1 0,0
Xsg13cmos5l_decap_8_3581 VPWR VGND sg13cmos5l_decap_8
* cell instance sg13cmos5l_decap_8_3582 r0 *1 0,0
Xsg13cmos5l_decap_8_3582 VPWR VGND sg13cmos5l_decap_8
* cell instance sg13cmos5l_decap_8_3583 r0 *1 0,0
Xsg13cmos5l_decap_8_3583 VPWR VGND sg13cmos5l_decap_8
* cell instance sg13cmos5l_decap_8_3584 r0 *1 0,0
Xsg13cmos5l_decap_8_3584 VPWR VGND sg13cmos5l_decap_8
* cell instance sg13cmos5l_decap_8_3585 r0 *1 0,0
Xsg13cmos5l_decap_8_3585 VPWR VGND sg13cmos5l_decap_8
* cell instance sg13cmos5l_decap_8_3586 r0 *1 0,0
Xsg13cmos5l_decap_8_3586 VPWR VGND sg13cmos5l_decap_8
* cell instance sg13cmos5l_decap_8_3587 r0 *1 0,0
Xsg13cmos5l_decap_8_3587 VPWR VGND sg13cmos5l_decap_8
* cell instance sg13cmos5l_decap_8_3588 r0 *1 0,0
Xsg13cmos5l_decap_8_3588 VPWR VGND sg13cmos5l_decap_8
* cell instance sg13cmos5l_decap_8_3589 r0 *1 0,0
Xsg13cmos5l_decap_8_3589 VPWR VGND sg13cmos5l_decap_8
* cell instance sg13cmos5l_decap_8_3590 r0 *1 0,0
Xsg13cmos5l_decap_8_3590 VPWR VGND sg13cmos5l_decap_8
* cell instance sg13cmos5l_decap_8_3591 r0 *1 0,0
Xsg13cmos5l_decap_8_3591 VPWR VGND sg13cmos5l_decap_8
* cell instance sg13cmos5l_decap_8_3592 r0 *1 0,0
Xsg13cmos5l_decap_8_3592 VPWR VGND sg13cmos5l_decap_8
* cell instance sg13cmos5l_decap_8_3593 r0 *1 0,0
Xsg13cmos5l_decap_8_3593 VPWR VGND sg13cmos5l_decap_8
* cell instance sg13cmos5l_decap_8_3594 r0 *1 0,0
Xsg13cmos5l_decap_8_3594 VPWR VGND sg13cmos5l_decap_8
* cell instance sg13cmos5l_decap_8_3595 r0 *1 0,0
Xsg13cmos5l_decap_8_3595 VPWR VGND sg13cmos5l_decap_8
* cell instance sg13cmos5l_decap_8_3596 r0 *1 0,0
Xsg13cmos5l_decap_8_3596 VPWR VGND sg13cmos5l_decap_8
* cell instance sg13cmos5l_decap_8_3597 r0 *1 0,0
Xsg13cmos5l_decap_8_3597 VPWR VGND sg13cmos5l_decap_8
* cell instance sg13cmos5l_decap_8_3598 r0 *1 0,0
Xsg13cmos5l_decap_8_3598 VPWR VGND sg13cmos5l_decap_8
* cell instance sg13cmos5l_decap_8_3599 r0 *1 0,0
Xsg13cmos5l_decap_8_3599 VPWR VGND sg13cmos5l_decap_8
* cell instance sg13cmos5l_decap_8_3600 r0 *1 0,0
Xsg13cmos5l_decap_8_3600 VPWR VGND sg13cmos5l_decap_8
* cell instance sg13cmos5l_decap_8_3601 r0 *1 0,0
Xsg13cmos5l_decap_8_3601 VPWR VGND sg13cmos5l_decap_8
* cell instance sg13cmos5l_decap_8_3602 r0 *1 0,0
Xsg13cmos5l_decap_8_3602 VPWR VGND sg13cmos5l_decap_8
* cell instance sg13cmos5l_decap_8_3603 r0 *1 0,0
Xsg13cmos5l_decap_8_3603 VPWR VGND sg13cmos5l_decap_8
* cell instance sg13cmos5l_decap_8_3604 r0 *1 0,0
Xsg13cmos5l_decap_8_3604 VPWR VGND sg13cmos5l_decap_8
* cell instance sg13cmos5l_decap_8_3605 r0 *1 0,0
Xsg13cmos5l_decap_8_3605 VPWR VGND sg13cmos5l_decap_8
* cell instance sg13cmos5l_decap_8_3606 r0 *1 0,0
Xsg13cmos5l_decap_8_3606 VPWR VGND sg13cmos5l_decap_8
* cell instance sg13cmos5l_decap_8_3607 r0 *1 0,0
Xsg13cmos5l_decap_8_3607 VPWR VGND sg13cmos5l_decap_8
* cell instance sg13cmos5l_decap_8_3608 r0 *1 0,0
Xsg13cmos5l_decap_8_3608 VPWR VGND sg13cmos5l_decap_8
* cell instance sg13cmos5l_decap_8_3609 r0 *1 0,0
Xsg13cmos5l_decap_8_3609 VPWR VGND sg13cmos5l_decap_8
* cell instance sg13cmos5l_decap_8_3610 r0 *1 0,0
Xsg13cmos5l_decap_8_3610 VPWR VGND sg13cmos5l_decap_8
* cell instance sg13cmos5l_decap_8_3611 r0 *1 0,0
Xsg13cmos5l_decap_8_3611 VPWR VGND sg13cmos5l_decap_8
* cell instance sg13cmos5l_decap_8_3612 r0 *1 0,0
Xsg13cmos5l_decap_8_3612 VPWR VGND sg13cmos5l_decap_8
* cell instance sg13cmos5l_decap_8_3613 r0 *1 0,0
Xsg13cmos5l_decap_8_3613 VPWR VGND sg13cmos5l_decap_8
* cell instance sg13cmos5l_decap_8_3614 r0 *1 0,0
Xsg13cmos5l_decap_8_3614 VPWR VGND sg13cmos5l_decap_8
* cell instance sg13cmos5l_decap_8_3615 r0 *1 0,0
Xsg13cmos5l_decap_8_3615 VPWR VGND sg13cmos5l_decap_8
* cell instance sg13cmos5l_decap_8_3616 r0 *1 0,0
Xsg13cmos5l_decap_8_3616 VPWR VGND sg13cmos5l_decap_8
* cell instance sg13cmos5l_decap_8_3617 r0 *1 0,0
Xsg13cmos5l_decap_8_3617 VPWR VGND sg13cmos5l_decap_8
* cell instance sg13cmos5l_decap_8_3618 r0 *1 0,0
Xsg13cmos5l_decap_8_3618 VPWR VGND sg13cmos5l_decap_8
* cell instance sg13cmos5l_decap_8_3619 r0 *1 0,0
Xsg13cmos5l_decap_8_3619 VPWR VGND sg13cmos5l_decap_8
* cell instance sg13cmos5l_decap_8_3620 r0 *1 0,0
Xsg13cmos5l_decap_8_3620 VPWR VGND sg13cmos5l_decap_8
* cell instance sg13cmos5l_decap_8_3621 r0 *1 0,0
Xsg13cmos5l_decap_8_3621 VPWR VGND sg13cmos5l_decap_8
* cell instance sg13cmos5l_decap_8_3622 r0 *1 0,0
Xsg13cmos5l_decap_8_3622 VPWR VGND sg13cmos5l_decap_8
* cell instance sg13cmos5l_decap_8_3623 r0 *1 0,0
Xsg13cmos5l_decap_8_3623 VPWR VGND sg13cmos5l_decap_8
* cell instance sg13cmos5l_decap_8_3624 r0 *1 0,0
Xsg13cmos5l_decap_8_3624 VPWR VGND sg13cmos5l_decap_8
* cell instance sg13cmos5l_decap_8_3625 r0 *1 0,0
Xsg13cmos5l_decap_8_3625 VPWR VGND sg13cmos5l_decap_8
* cell instance sg13cmos5l_decap_8_3626 r0 *1 0,0
Xsg13cmos5l_decap_8_3626 VPWR VGND sg13cmos5l_decap_8
* cell instance sg13cmos5l_decap_8_3627 r0 *1 0,0
Xsg13cmos5l_decap_8_3627 VPWR VGND sg13cmos5l_decap_8
* cell instance sg13cmos5l_decap_8_3628 r0 *1 0,0
Xsg13cmos5l_decap_8_3628 VPWR VGND sg13cmos5l_decap_8
* cell instance sg13cmos5l_decap_8_3629 r0 *1 0,0
Xsg13cmos5l_decap_8_3629 VPWR VGND sg13cmos5l_decap_8
* cell instance sg13cmos5l_decap_8_3630 r0 *1 0,0
Xsg13cmos5l_decap_8_3630 VPWR VGND sg13cmos5l_decap_8
* cell instance sg13cmos5l_decap_8_3631 r0 *1 0,0
Xsg13cmos5l_decap_8_3631 VPWR VGND sg13cmos5l_decap_8
* cell instance sg13cmos5l_decap_8_3632 r0 *1 0,0
Xsg13cmos5l_decap_8_3632 VPWR VGND sg13cmos5l_decap_8
* cell instance sg13cmos5l_decap_8_3633 r0 *1 0,0
Xsg13cmos5l_decap_8_3633 VPWR VGND sg13cmos5l_decap_8
* cell instance sg13cmos5l_decap_8_3634 r0 *1 0,0
Xsg13cmos5l_decap_8_3634 VPWR VGND sg13cmos5l_decap_8
* cell instance sg13cmos5l_decap_8_3635 r0 *1 0,0
Xsg13cmos5l_decap_8_3635 VPWR VGND sg13cmos5l_decap_8
* cell instance sg13cmos5l_decap_8_3636 r0 *1 0,0
Xsg13cmos5l_decap_8_3636 VPWR VGND sg13cmos5l_decap_8
* cell instance sg13cmos5l_decap_8_3637 r0 *1 0,0
Xsg13cmos5l_decap_8_3637 VPWR VGND sg13cmos5l_decap_8
* cell instance sg13cmos5l_decap_8_3638 r0 *1 0,0
Xsg13cmos5l_decap_8_3638 VPWR VGND sg13cmos5l_decap_8
* cell instance sg13cmos5l_decap_8_3639 r0 *1 0,0
Xsg13cmos5l_decap_8_3639 VPWR VGND sg13cmos5l_decap_8
* cell instance sg13cmos5l_decap_8_3640 r0 *1 0,0
Xsg13cmos5l_decap_8_3640 VPWR VGND sg13cmos5l_decap_8
* cell instance sg13cmos5l_decap_8_3641 r0 *1 0,0
Xsg13cmos5l_decap_8_3641 VPWR VGND sg13cmos5l_decap_8
* cell instance sg13cmos5l_decap_8_3642 r0 *1 0,0
Xsg13cmos5l_decap_8_3642 VPWR VGND sg13cmos5l_decap_8
* cell instance sg13cmos5l_decap_8_3643 r0 *1 0,0
Xsg13cmos5l_decap_8_3643 VPWR VGND sg13cmos5l_decap_8
* cell instance sg13cmos5l_decap_8_3644 r0 *1 0,0
Xsg13cmos5l_decap_8_3644 VPWR VGND sg13cmos5l_decap_8
* cell instance sg13cmos5l_decap_8_3645 r0 *1 0,0
Xsg13cmos5l_decap_8_3645 VPWR VGND sg13cmos5l_decap_8
* cell instance sg13cmos5l_decap_8_3646 r0 *1 0,0
Xsg13cmos5l_decap_8_3646 VPWR VGND sg13cmos5l_decap_8
* cell instance sg13cmos5l_decap_8_3647 r0 *1 0,0
Xsg13cmos5l_decap_8_3647 VPWR VGND sg13cmos5l_decap_8
* cell instance sg13cmos5l_decap_8_3648 r0 *1 0,0
Xsg13cmos5l_decap_8_3648 VPWR VGND sg13cmos5l_decap_8
* cell instance sg13cmos5l_decap_8_3649 r0 *1 0,0
Xsg13cmos5l_decap_8_3649 VPWR VGND sg13cmos5l_decap_8
* cell instance sg13cmos5l_decap_8_3650 r0 *1 0,0
Xsg13cmos5l_decap_8_3650 VPWR VGND sg13cmos5l_decap_8
* cell instance sg13cmos5l_decap_8_3651 r0 *1 0,0
Xsg13cmos5l_decap_8_3651 VPWR VGND sg13cmos5l_decap_8
* cell instance sg13cmos5l_decap_8_3652 r0 *1 0,0
Xsg13cmos5l_decap_8_3652 VPWR VGND sg13cmos5l_decap_8
* cell instance sg13cmos5l_decap_8_3653 r0 *1 0,0
Xsg13cmos5l_decap_8_3653 VPWR VGND sg13cmos5l_decap_8
* cell instance sg13cmos5l_decap_8_3654 r0 *1 0,0
Xsg13cmos5l_decap_8_3654 VPWR VGND sg13cmos5l_decap_8
* cell instance sg13cmos5l_decap_8_3655 r0 *1 0,0
Xsg13cmos5l_decap_8_3655 VPWR VGND sg13cmos5l_decap_8
* cell instance sg13cmos5l_decap_8_3656 r0 *1 0,0
Xsg13cmos5l_decap_8_3656 VPWR VGND sg13cmos5l_decap_8
* cell instance sg13cmos5l_decap_8_3657 r0 *1 0,0
Xsg13cmos5l_decap_8_3657 VPWR VGND sg13cmos5l_decap_8
* cell instance sg13cmos5l_decap_8_3658 r0 *1 0,0
Xsg13cmos5l_decap_8_3658 VPWR VGND sg13cmos5l_decap_8
* cell instance sg13cmos5l_decap_8_3659 r0 *1 0,0
Xsg13cmos5l_decap_8_3659 VPWR VGND sg13cmos5l_decap_8
* cell instance sg13cmos5l_decap_8_3660 r0 *1 0,0
Xsg13cmos5l_decap_8_3660 VPWR VGND sg13cmos5l_decap_8
* cell instance sg13cmos5l_decap_8_3661 r0 *1 0,0
Xsg13cmos5l_decap_8_3661 VPWR VGND sg13cmos5l_decap_8
* cell instance sg13cmos5l_decap_8_3662 r0 *1 0,0
Xsg13cmos5l_decap_8_3662 VPWR VGND sg13cmos5l_decap_8
* cell instance sg13cmos5l_decap_8_3663 r0 *1 0,0
Xsg13cmos5l_decap_8_3663 VPWR VGND sg13cmos5l_decap_8
* cell instance sg13cmos5l_decap_8_3664 r0 *1 0,0
Xsg13cmos5l_decap_8_3664 VPWR VGND sg13cmos5l_decap_8
* cell instance sg13cmos5l_decap_8_3665 r0 *1 0,0
Xsg13cmos5l_decap_8_3665 VPWR VGND sg13cmos5l_decap_8
* cell instance sg13cmos5l_decap_8_3666 r0 *1 0,0
Xsg13cmos5l_decap_8_3666 VPWR VGND sg13cmos5l_decap_8
* cell instance sg13cmos5l_decap_8_3667 r0 *1 0,0
Xsg13cmos5l_decap_8_3667 VPWR VGND sg13cmos5l_decap_8
* cell instance sg13cmos5l_decap_8_3668 r0 *1 0,0
Xsg13cmos5l_decap_8_3668 VPWR VGND sg13cmos5l_decap_8
* cell instance sg13cmos5l_decap_8_3669 r0 *1 0,0
Xsg13cmos5l_decap_8_3669 VPWR VGND sg13cmos5l_decap_8
* cell instance sg13cmos5l_decap_8_3670 r0 *1 0,0
Xsg13cmos5l_decap_8_3670 VPWR VGND sg13cmos5l_decap_8
* cell instance sg13cmos5l_decap_8_3671 r0 *1 0,0
Xsg13cmos5l_decap_8_3671 VPWR VGND sg13cmos5l_decap_8
* cell instance sg13cmos5l_decap_8_3672 r0 *1 0,0
Xsg13cmos5l_decap_8_3672 VPWR VGND sg13cmos5l_decap_8
* cell instance sg13cmos5l_decap_8_3673 r0 *1 0,0
Xsg13cmos5l_decap_8_3673 VPWR VGND sg13cmos5l_decap_8
* cell instance sg13cmos5l_decap_8_3674 r0 *1 0,0
Xsg13cmos5l_decap_8_3674 VPWR VGND sg13cmos5l_decap_8
* cell instance sg13cmos5l_decap_8_3675 r0 *1 0,0
Xsg13cmos5l_decap_8_3675 VPWR VGND sg13cmos5l_decap_8
* cell instance sg13cmos5l_decap_8_3676 r0 *1 0,0
Xsg13cmos5l_decap_8_3676 VPWR VGND sg13cmos5l_decap_8
* cell instance sg13cmos5l_decap_8_3677 r0 *1 0,0
Xsg13cmos5l_decap_8_3677 VPWR VGND sg13cmos5l_decap_8
* cell instance sg13cmos5l_decap_8_3678 r0 *1 0,0
Xsg13cmos5l_decap_8_3678 VPWR VGND sg13cmos5l_decap_8
* cell instance sg13cmos5l_decap_8_3679 r0 *1 0,0
Xsg13cmos5l_decap_8_3679 VPWR VGND sg13cmos5l_decap_8
* cell instance sg13cmos5l_decap_8_3680 r0 *1 0,0
Xsg13cmos5l_decap_8_3680 VPWR VGND sg13cmos5l_decap_8
* cell instance sg13cmos5l_decap_8_3681 r0 *1 0,0
Xsg13cmos5l_decap_8_3681 VPWR VGND sg13cmos5l_decap_8
* cell instance sg13cmos5l_decap_8_3682 r0 *1 0,0
Xsg13cmos5l_decap_8_3682 VPWR VGND sg13cmos5l_decap_8
* cell instance sg13cmos5l_decap_8_3683 r0 *1 0,0
Xsg13cmos5l_decap_8_3683 VPWR VGND sg13cmos5l_decap_8
* cell instance sg13cmos5l_decap_8_3684 r0 *1 0,0
Xsg13cmos5l_decap_8_3684 VPWR VGND sg13cmos5l_decap_8
* cell instance sg13cmos5l_decap_8_3685 r0 *1 0,0
Xsg13cmos5l_decap_8_3685 VPWR VGND sg13cmos5l_decap_8
* cell instance sg13cmos5l_decap_8_3686 r0 *1 0,0
Xsg13cmos5l_decap_8_3686 VPWR VGND sg13cmos5l_decap_8
* cell instance sg13cmos5l_decap_8_3687 r0 *1 0,0
Xsg13cmos5l_decap_8_3687 VPWR VGND sg13cmos5l_decap_8
* cell instance sg13cmos5l_decap_8_3688 r0 *1 0,0
Xsg13cmos5l_decap_8_3688 VPWR VGND sg13cmos5l_decap_8
* cell instance sg13cmos5l_decap_8_3689 r0 *1 0,0
Xsg13cmos5l_decap_8_3689 VPWR VGND sg13cmos5l_decap_8
* cell instance sg13cmos5l_decap_8_3690 r0 *1 0,0
Xsg13cmos5l_decap_8_3690 VPWR VGND sg13cmos5l_decap_8
* cell instance sg13cmos5l_decap_8_3691 r0 *1 0,0
Xsg13cmos5l_decap_8_3691 VPWR VGND sg13cmos5l_decap_8
* cell instance sg13cmos5l_decap_8_3692 r0 *1 0,0
Xsg13cmos5l_decap_8_3692 VPWR VGND sg13cmos5l_decap_8
* cell instance sg13cmos5l_decap_8_3693 r0 *1 0,0
Xsg13cmos5l_decap_8_3693 VPWR VGND sg13cmos5l_decap_8
* cell instance sg13cmos5l_decap_8_3694 r0 *1 0,0
Xsg13cmos5l_decap_8_3694 VPWR VGND sg13cmos5l_decap_8
* cell instance sg13cmos5l_decap_8_3695 r0 *1 0,0
Xsg13cmos5l_decap_8_3695 VPWR VGND sg13cmos5l_decap_8
* cell instance sg13cmos5l_decap_8_3696 r0 *1 0,0
Xsg13cmos5l_decap_8_3696 VPWR VGND sg13cmos5l_decap_8
* cell instance sg13cmos5l_decap_8_3697 r0 *1 0,0
Xsg13cmos5l_decap_8_3697 VPWR VGND sg13cmos5l_decap_8
* cell instance sg13cmos5l_decap_8_3698 r0 *1 0,0
Xsg13cmos5l_decap_8_3698 VPWR VGND sg13cmos5l_decap_8
* cell instance sg13cmos5l_decap_8_3699 r0 *1 0,0
Xsg13cmos5l_decap_8_3699 VPWR VGND sg13cmos5l_decap_8
* cell instance sg13cmos5l_decap_8_3700 r0 *1 0,0
Xsg13cmos5l_decap_8_3700 VPWR VGND sg13cmos5l_decap_8
* cell instance sg13cmos5l_decap_8_3701 r0 *1 0,0
Xsg13cmos5l_decap_8_3701 VPWR VGND sg13cmos5l_decap_8
* cell instance sg13cmos5l_decap_8_3702 r0 *1 0,0
Xsg13cmos5l_decap_8_3702 VPWR VGND sg13cmos5l_decap_8
* cell instance sg13cmos5l_decap_8_3703 r0 *1 0,0
Xsg13cmos5l_decap_8_3703 VPWR VGND sg13cmos5l_decap_8
* cell instance sg13cmos5l_decap_8_3704 r0 *1 0,0
Xsg13cmos5l_decap_8_3704 VPWR VGND sg13cmos5l_decap_8
* cell instance sg13cmos5l_decap_8_3705 r0 *1 0,0
Xsg13cmos5l_decap_8_3705 VPWR VGND sg13cmos5l_decap_8
* cell instance sg13cmos5l_decap_8_3706 r0 *1 0,0
Xsg13cmos5l_decap_8_3706 VPWR VGND sg13cmos5l_decap_8
* cell instance sg13cmos5l_decap_8_3707 r0 *1 0,0
Xsg13cmos5l_decap_8_3707 VPWR VGND sg13cmos5l_decap_8
* cell instance sg13cmos5l_decap_8_3708 r0 *1 0,0
Xsg13cmos5l_decap_8_3708 VPWR VGND sg13cmos5l_decap_8
* cell instance sg13cmos5l_decap_8_3709 r0 *1 0,0
Xsg13cmos5l_decap_8_3709 VPWR VGND sg13cmos5l_decap_8
* cell instance sg13cmos5l_decap_8_3710 r0 *1 0,0
Xsg13cmos5l_decap_8_3710 VPWR VGND sg13cmos5l_decap_8
* cell instance sg13cmos5l_decap_8_3711 r0 *1 0,0
Xsg13cmos5l_decap_8_3711 VPWR VGND sg13cmos5l_decap_8
* cell instance sg13cmos5l_decap_8_3712 r0 *1 0,0
Xsg13cmos5l_decap_8_3712 VPWR VGND sg13cmos5l_decap_8
* cell instance sg13cmos5l_decap_8_3713 r0 *1 0,0
Xsg13cmos5l_decap_8_3713 VPWR VGND sg13cmos5l_decap_8
* cell instance sg13cmos5l_decap_8_3714 r0 *1 0,0
Xsg13cmos5l_decap_8_3714 VPWR VGND sg13cmos5l_decap_8
* cell instance sg13cmos5l_decap_8_3715 r0 *1 0,0
Xsg13cmos5l_decap_8_3715 VPWR VGND sg13cmos5l_decap_8
* cell instance sg13cmos5l_decap_8_3716 r0 *1 0,0
Xsg13cmos5l_decap_8_3716 VPWR VGND sg13cmos5l_decap_8
* cell instance sg13cmos5l_decap_8_3717 r0 *1 0,0
Xsg13cmos5l_decap_8_3717 VPWR VGND sg13cmos5l_decap_8
* cell instance sg13cmos5l_decap_8_3718 r0 *1 0,0
Xsg13cmos5l_decap_8_3718 VPWR VGND sg13cmos5l_decap_8
* cell instance sg13cmos5l_decap_8_3719 r0 *1 0,0
Xsg13cmos5l_decap_8_3719 VPWR VGND sg13cmos5l_decap_8
* cell instance sg13cmos5l_decap_8_3720 r0 *1 0,0
Xsg13cmos5l_decap_8_3720 VPWR VGND sg13cmos5l_decap_8
* cell instance sg13cmos5l_decap_8_3721 r0 *1 0,0
Xsg13cmos5l_decap_8_3721 VPWR VGND sg13cmos5l_decap_8
* cell instance sg13cmos5l_decap_8_3722 r0 *1 0,0
Xsg13cmos5l_decap_8_3722 VPWR VGND sg13cmos5l_decap_8
* cell instance sg13cmos5l_decap_8_3723 r0 *1 0,0
Xsg13cmos5l_decap_8_3723 VPWR VGND sg13cmos5l_decap_8
* cell instance sg13cmos5l_decap_8_3724 r0 *1 0,0
Xsg13cmos5l_decap_8_3724 VPWR VGND sg13cmos5l_decap_8
* cell instance sg13cmos5l_decap_8_3725 r0 *1 0,0
Xsg13cmos5l_decap_8_3725 VPWR VGND sg13cmos5l_decap_8
* cell instance sg13cmos5l_decap_8_3726 r0 *1 0,0
Xsg13cmos5l_decap_8_3726 VPWR VGND sg13cmos5l_decap_8
* cell instance sg13cmos5l_decap_8_3727 r0 *1 0,0
Xsg13cmos5l_decap_8_3727 VPWR VGND sg13cmos5l_decap_8
* cell instance sg13cmos5l_decap_8_3728 r0 *1 0,0
Xsg13cmos5l_decap_8_3728 VPWR VGND sg13cmos5l_decap_8
* cell instance sg13cmos5l_decap_8_3729 r0 *1 0,0
Xsg13cmos5l_decap_8_3729 VPWR VGND sg13cmos5l_decap_8
* cell instance sg13cmos5l_decap_8_3730 r0 *1 0,0
Xsg13cmos5l_decap_8_3730 VPWR VGND sg13cmos5l_decap_8
* cell instance sg13cmos5l_decap_8_3731 r0 *1 0,0
Xsg13cmos5l_decap_8_3731 VPWR VGND sg13cmos5l_decap_8
* cell instance sg13cmos5l_decap_8_3732 r0 *1 0,0
Xsg13cmos5l_decap_8_3732 VPWR VGND sg13cmos5l_decap_8
* cell instance sg13cmos5l_decap_8_3733 r0 *1 0,0
Xsg13cmos5l_decap_8_3733 VPWR VGND sg13cmos5l_decap_8
* cell instance sg13cmos5l_decap_8_3734 r0 *1 0,0
Xsg13cmos5l_decap_8_3734 VPWR VGND sg13cmos5l_decap_8
* cell instance sg13cmos5l_decap_8_3735 r0 *1 0,0
Xsg13cmos5l_decap_8_3735 VPWR VGND sg13cmos5l_decap_8
* cell instance sg13cmos5l_decap_8_3736 r0 *1 0,0
Xsg13cmos5l_decap_8_3736 VPWR VGND sg13cmos5l_decap_8
* cell instance sg13cmos5l_decap_8_3737 r0 *1 0,0
Xsg13cmos5l_decap_8_3737 VPWR VGND sg13cmos5l_decap_8
* cell instance sg13cmos5l_decap_8_3738 r0 *1 0,0
Xsg13cmos5l_decap_8_3738 VPWR VGND sg13cmos5l_decap_8
* cell instance sg13cmos5l_decap_8_3739 r0 *1 0,0
Xsg13cmos5l_decap_8_3739 VPWR VGND sg13cmos5l_decap_8
* cell instance sg13cmos5l_decap_8_3740 r0 *1 0,0
Xsg13cmos5l_decap_8_3740 VPWR VGND sg13cmos5l_decap_8
* cell instance sg13cmos5l_decap_8_3741 r0 *1 0,0
Xsg13cmos5l_decap_8_3741 VPWR VGND sg13cmos5l_decap_8
* cell instance sg13cmos5l_decap_8_3742 r0 *1 0,0
Xsg13cmos5l_decap_8_3742 VPWR VGND sg13cmos5l_decap_8
* cell instance sg13cmos5l_decap_8_3743 r0 *1 0,0
Xsg13cmos5l_decap_8_3743 VPWR VGND sg13cmos5l_decap_8
* cell instance sg13cmos5l_decap_8_3744 r0 *1 0,0
Xsg13cmos5l_decap_8_3744 VPWR VGND sg13cmos5l_decap_8
* cell instance sg13cmos5l_decap_8_3745 r0 *1 0,0
Xsg13cmos5l_decap_8_3745 VPWR VGND sg13cmos5l_decap_8
* cell instance sg13cmos5l_decap_8_3746 r0 *1 0,0
Xsg13cmos5l_decap_8_3746 VPWR VGND sg13cmos5l_decap_8
* cell instance sg13cmos5l_decap_8_3747 r0 *1 0,0
Xsg13cmos5l_decap_8_3747 VPWR VGND sg13cmos5l_decap_8
* cell instance sg13cmos5l_decap_8_3748 r0 *1 0,0
Xsg13cmos5l_decap_8_3748 VPWR VGND sg13cmos5l_decap_8
* cell instance sg13cmos5l_decap_8_3749 r0 *1 0,0
Xsg13cmos5l_decap_8_3749 VPWR VGND sg13cmos5l_decap_8
* cell instance sg13cmos5l_decap_8_3750 r0 *1 0,0
Xsg13cmos5l_decap_8_3750 VPWR VGND sg13cmos5l_decap_8
* cell instance sg13cmos5l_decap_8_3751 r0 *1 0,0
Xsg13cmos5l_decap_8_3751 VPWR VGND sg13cmos5l_decap_8
* cell instance sg13cmos5l_decap_8_3752 r0 *1 0,0
Xsg13cmos5l_decap_8_3752 VPWR VGND sg13cmos5l_decap_8
* cell instance sg13cmos5l_decap_8_3753 r0 *1 0,0
Xsg13cmos5l_decap_8_3753 VPWR VGND sg13cmos5l_decap_8
* cell instance sg13cmos5l_decap_8_3754 r0 *1 0,0
Xsg13cmos5l_decap_8_3754 VPWR VGND sg13cmos5l_decap_8
* cell instance sg13cmos5l_decap_8_3755 r0 *1 0,0
Xsg13cmos5l_decap_8_3755 VPWR VGND sg13cmos5l_decap_8
* cell instance sg13cmos5l_decap_8_3756 r0 *1 0,0
Xsg13cmos5l_decap_8_3756 VPWR VGND sg13cmos5l_decap_8
* cell instance sg13cmos5l_decap_8_3757 r0 *1 0,0
Xsg13cmos5l_decap_8_3757 VPWR VGND sg13cmos5l_decap_8
* cell instance sg13cmos5l_decap_8_3758 r0 *1 0,0
Xsg13cmos5l_decap_8_3758 VPWR VGND sg13cmos5l_decap_8
* cell instance sg13cmos5l_decap_8_3759 r0 *1 0,0
Xsg13cmos5l_decap_8_3759 VPWR VGND sg13cmos5l_decap_8
* cell instance sg13cmos5l_decap_8_3760 r0 *1 0,0
Xsg13cmos5l_decap_8_3760 VPWR VGND sg13cmos5l_decap_8
* cell instance sg13cmos5l_decap_8_3761 r0 *1 0,0
Xsg13cmos5l_decap_8_3761 VPWR VGND sg13cmos5l_decap_8
* cell instance sg13cmos5l_decap_8_3762 r0 *1 0,0
Xsg13cmos5l_decap_8_3762 VPWR VGND sg13cmos5l_decap_8
* cell instance sg13cmos5l_decap_8_3763 r0 *1 0,0
Xsg13cmos5l_decap_8_3763 VPWR VGND sg13cmos5l_decap_8
* cell instance sg13cmos5l_decap_8_3764 r0 *1 0,0
Xsg13cmos5l_decap_8_3764 VPWR VGND sg13cmos5l_decap_8
* cell instance sg13cmos5l_decap_8_3765 r0 *1 0,0
Xsg13cmos5l_decap_8_3765 VPWR VGND sg13cmos5l_decap_8
* cell instance sg13cmos5l_decap_8_3766 r0 *1 0,0
Xsg13cmos5l_decap_8_3766 VPWR VGND sg13cmos5l_decap_8
* cell instance sg13cmos5l_decap_8_3767 r0 *1 0,0
Xsg13cmos5l_decap_8_3767 VPWR VGND sg13cmos5l_decap_8
* cell instance sg13cmos5l_decap_8_3768 r0 *1 0,0
Xsg13cmos5l_decap_8_3768 VPWR VGND sg13cmos5l_decap_8
* cell instance sg13cmos5l_decap_8_3769 r0 *1 0,0
Xsg13cmos5l_decap_8_3769 VPWR VGND sg13cmos5l_decap_8
* cell instance sg13cmos5l_decap_8_3770 r0 *1 0,0
Xsg13cmos5l_decap_8_3770 VPWR VGND sg13cmos5l_decap_8
* cell instance sg13cmos5l_decap_8_3771 r0 *1 0,0
Xsg13cmos5l_decap_8_3771 VPWR VGND sg13cmos5l_decap_8
* cell instance sg13cmos5l_decap_8_3772 r0 *1 0,0
Xsg13cmos5l_decap_8_3772 VPWR VGND sg13cmos5l_decap_8
* cell instance sg13cmos5l_decap_8_3773 r0 *1 0,0
Xsg13cmos5l_decap_8_3773 VPWR VGND sg13cmos5l_decap_8
* cell instance sg13cmos5l_decap_8_3774 r0 *1 0,0
Xsg13cmos5l_decap_8_3774 VPWR VGND sg13cmos5l_decap_8
* cell instance sg13cmos5l_decap_8_3775 r0 *1 0,0
Xsg13cmos5l_decap_8_3775 VPWR VGND sg13cmos5l_decap_8
* cell instance sg13cmos5l_decap_8_3776 r0 *1 0,0
Xsg13cmos5l_decap_8_3776 VPWR VGND sg13cmos5l_decap_8
* cell instance sg13cmos5l_decap_8_3777 r0 *1 0,0
Xsg13cmos5l_decap_8_3777 VPWR VGND sg13cmos5l_decap_8
* cell instance sg13cmos5l_decap_8_3778 r0 *1 0,0
Xsg13cmos5l_decap_8_3778 VPWR VGND sg13cmos5l_decap_8
* cell instance sg13cmos5l_decap_8_3779 r0 *1 0,0
Xsg13cmos5l_decap_8_3779 VPWR VGND sg13cmos5l_decap_8
* cell instance sg13cmos5l_decap_8_3780 r0 *1 0,0
Xsg13cmos5l_decap_8_3780 VPWR VGND sg13cmos5l_decap_8
* cell instance sg13cmos5l_decap_8_3781 r0 *1 0,0
Xsg13cmos5l_decap_8_3781 VPWR VGND sg13cmos5l_decap_8
* cell instance sg13cmos5l_decap_8_3782 r0 *1 0,0
Xsg13cmos5l_decap_8_3782 VPWR VGND sg13cmos5l_decap_8
* cell instance sg13cmos5l_decap_8_3783 r0 *1 0,0
Xsg13cmos5l_decap_8_3783 VPWR VGND sg13cmos5l_decap_8
* cell instance sg13cmos5l_decap_8_3784 r0 *1 0,0
Xsg13cmos5l_decap_8_3784 VPWR VGND sg13cmos5l_decap_8
* cell instance sg13cmos5l_decap_8_3785 r0 *1 0,0
Xsg13cmos5l_decap_8_3785 VPWR VGND sg13cmos5l_decap_8
* cell instance sg13cmos5l_decap_8_3786 r0 *1 0,0
Xsg13cmos5l_decap_8_3786 VPWR VGND sg13cmos5l_decap_8
* cell instance sg13cmos5l_decap_8_3787 r0 *1 0,0
Xsg13cmos5l_decap_8_3787 VPWR VGND sg13cmos5l_decap_8
* cell instance sg13cmos5l_decap_8_3788 r0 *1 0,0
Xsg13cmos5l_decap_8_3788 VPWR VGND sg13cmos5l_decap_8
* cell instance sg13cmos5l_decap_8_3789 r0 *1 0,0
Xsg13cmos5l_decap_8_3789 VPWR VGND sg13cmos5l_decap_8
* cell instance sg13cmos5l_decap_8_3790 r0 *1 0,0
Xsg13cmos5l_decap_8_3790 VPWR VGND sg13cmos5l_decap_8
* cell instance sg13cmos5l_decap_8_3791 r0 *1 0,0
Xsg13cmos5l_decap_8_3791 VPWR VGND sg13cmos5l_decap_8
* cell instance sg13cmos5l_decap_8_3792 r0 *1 0,0
Xsg13cmos5l_decap_8_3792 VPWR VGND sg13cmos5l_decap_8
* cell instance sg13cmos5l_decap_8_3793 r0 *1 0,0
Xsg13cmos5l_decap_8_3793 VPWR VGND sg13cmos5l_decap_8
* cell instance sg13cmos5l_decap_8_3794 r0 *1 0,0
Xsg13cmos5l_decap_8_3794 VPWR VGND sg13cmos5l_decap_8
* cell instance sg13cmos5l_decap_8_3795 r0 *1 0,0
Xsg13cmos5l_decap_8_3795 VPWR VGND sg13cmos5l_decap_8
* cell instance sg13cmos5l_decap_8_3796 r0 *1 0,0
Xsg13cmos5l_decap_8_3796 VPWR VGND sg13cmos5l_decap_8
* cell instance sg13cmos5l_decap_8_3797 r0 *1 0,0
Xsg13cmos5l_decap_8_3797 VPWR VGND sg13cmos5l_decap_8
* cell instance sg13cmos5l_decap_8_3798 r0 *1 0,0
Xsg13cmos5l_decap_8_3798 VPWR VGND sg13cmos5l_decap_8
* cell instance sg13cmos5l_decap_8_3799 r0 *1 0,0
Xsg13cmos5l_decap_8_3799 VPWR VGND sg13cmos5l_decap_8
* cell instance sg13cmos5l_decap_8_3800 r0 *1 0,0
Xsg13cmos5l_decap_8_3800 VPWR VGND sg13cmos5l_decap_8
* cell instance sg13cmos5l_decap_8_3801 r0 *1 0,0
Xsg13cmos5l_decap_8_3801 VPWR VGND sg13cmos5l_decap_8
* cell instance sg13cmos5l_decap_8_3802 r0 *1 0,0
Xsg13cmos5l_decap_8_3802 VPWR VGND sg13cmos5l_decap_8
* cell instance sg13cmos5l_decap_8_3803 r0 *1 0,0
Xsg13cmos5l_decap_8_3803 VPWR VGND sg13cmos5l_decap_8
* cell instance sg13cmos5l_decap_8_3804 r0 *1 0,0
Xsg13cmos5l_decap_8_3804 VPWR VGND sg13cmos5l_decap_8
* cell instance sg13cmos5l_decap_8_3805 r0 *1 0,0
Xsg13cmos5l_decap_8_3805 VPWR VGND sg13cmos5l_decap_8
* cell instance sg13cmos5l_decap_8_3806 r0 *1 0,0
Xsg13cmos5l_decap_8_3806 VPWR VGND sg13cmos5l_decap_8
* cell instance sg13cmos5l_decap_8_3807 r0 *1 0,0
Xsg13cmos5l_decap_8_3807 VPWR VGND sg13cmos5l_decap_8
* cell instance sg13cmos5l_decap_8_3808 r0 *1 0,0
Xsg13cmos5l_decap_8_3808 VPWR VGND sg13cmos5l_decap_8
* cell instance sg13cmos5l_decap_8_3809 r0 *1 0,0
Xsg13cmos5l_decap_8_3809 VPWR VGND sg13cmos5l_decap_8
* cell instance sg13cmos5l_decap_8_3810 r0 *1 0,0
Xsg13cmos5l_decap_8_3810 VPWR VGND sg13cmos5l_decap_8
* cell instance sg13cmos5l_decap_8_3811 r0 *1 0,0
Xsg13cmos5l_decap_8_3811 VPWR VGND sg13cmos5l_decap_8
* cell instance sg13cmos5l_decap_8_3812 r0 *1 0,0
Xsg13cmos5l_decap_8_3812 VPWR VGND sg13cmos5l_decap_8
* cell instance sg13cmos5l_decap_8_3813 r0 *1 0,0
Xsg13cmos5l_decap_8_3813 VPWR VGND sg13cmos5l_decap_8
* cell instance sg13cmos5l_decap_8_3814 r0 *1 0,0
Xsg13cmos5l_decap_8_3814 VPWR VGND sg13cmos5l_decap_8
* cell instance sg13cmos5l_decap_8_3815 r0 *1 0,0
Xsg13cmos5l_decap_8_3815 VPWR VGND sg13cmos5l_decap_8
* cell instance sg13cmos5l_decap_8_3816 r0 *1 0,0
Xsg13cmos5l_decap_8_3816 VPWR VGND sg13cmos5l_decap_8
* cell instance sg13cmos5l_decap_8_3817 r0 *1 0,0
Xsg13cmos5l_decap_8_3817 VPWR VGND sg13cmos5l_decap_8
* cell instance sg13cmos5l_decap_8_3818 r0 *1 0,0
Xsg13cmos5l_decap_8_3818 VPWR VGND sg13cmos5l_decap_8
* cell instance sg13cmos5l_decap_8_3819 r0 *1 0,0
Xsg13cmos5l_decap_8_3819 VPWR VGND sg13cmos5l_decap_8
* cell instance sg13cmos5l_decap_8_3820 r0 *1 0,0
Xsg13cmos5l_decap_8_3820 VPWR VGND sg13cmos5l_decap_8
* cell instance sg13cmos5l_decap_8_3821 r0 *1 0,0
Xsg13cmos5l_decap_8_3821 VPWR VGND sg13cmos5l_decap_8
* cell instance sg13cmos5l_decap_8_3822 r0 *1 0,0
Xsg13cmos5l_decap_8_3822 VPWR VGND sg13cmos5l_decap_8
* cell instance sg13cmos5l_decap_8_3823 r0 *1 0,0
Xsg13cmos5l_decap_8_3823 VPWR VGND sg13cmos5l_decap_8
* cell instance sg13cmos5l_decap_8_3824 r0 *1 0,0
Xsg13cmos5l_decap_8_3824 VPWR VGND sg13cmos5l_decap_8
* cell instance sg13cmos5l_decap_8_3825 r0 *1 0,0
Xsg13cmos5l_decap_8_3825 VPWR VGND sg13cmos5l_decap_8
* cell instance sg13cmos5l_decap_8_3826 r0 *1 0,0
Xsg13cmos5l_decap_8_3826 VPWR VGND sg13cmos5l_decap_8
* cell instance sg13cmos5l_decap_8_3827 r0 *1 0,0
Xsg13cmos5l_decap_8_3827 VPWR VGND sg13cmos5l_decap_8
* cell instance sg13cmos5l_decap_8_3828 r0 *1 0,0
Xsg13cmos5l_decap_8_3828 VPWR VGND sg13cmos5l_decap_8
* cell instance sg13cmos5l_decap_8_3829 r0 *1 0,0
Xsg13cmos5l_decap_8_3829 VPWR VGND sg13cmos5l_decap_8
* cell instance sg13cmos5l_decap_8_3830 r0 *1 0,0
Xsg13cmos5l_decap_8_3830 VPWR VGND sg13cmos5l_decap_8
* cell instance sg13cmos5l_decap_8_3831 r0 *1 0,0
Xsg13cmos5l_decap_8_3831 VPWR VGND sg13cmos5l_decap_8
* cell instance sg13cmos5l_decap_8_3832 r0 *1 0,0
Xsg13cmos5l_decap_8_3832 VPWR VGND sg13cmos5l_decap_8
* cell instance sg13cmos5l_decap_8_3833 r0 *1 0,0
Xsg13cmos5l_decap_8_3833 VPWR VGND sg13cmos5l_decap_8
* cell instance sg13cmos5l_decap_8_3834 r0 *1 0,0
Xsg13cmos5l_decap_8_3834 VPWR VGND sg13cmos5l_decap_8
* cell instance sg13cmos5l_decap_8_3835 r0 *1 0,0
Xsg13cmos5l_decap_8_3835 VPWR VGND sg13cmos5l_decap_8
* cell instance sg13cmos5l_decap_8_3836 r0 *1 0,0
Xsg13cmos5l_decap_8_3836 VPWR VGND sg13cmos5l_decap_8
* cell instance sg13cmos5l_decap_8_3837 r0 *1 0,0
Xsg13cmos5l_decap_8_3837 VPWR VGND sg13cmos5l_decap_8
* cell instance sg13cmos5l_decap_8_3838 r0 *1 0,0
Xsg13cmos5l_decap_8_3838 VPWR VGND sg13cmos5l_decap_8
* cell instance sg13cmos5l_decap_8_3839 r0 *1 0,0
Xsg13cmos5l_decap_8_3839 VPWR VGND sg13cmos5l_decap_8
* cell instance sg13cmos5l_decap_8_3840 r0 *1 0,0
Xsg13cmos5l_decap_8_3840 VPWR VGND sg13cmos5l_decap_8
* cell instance sg13cmos5l_decap_8_3841 r0 *1 0,0
Xsg13cmos5l_decap_8_3841 VPWR VGND sg13cmos5l_decap_8
* cell instance sg13cmos5l_decap_8_3842 r0 *1 0,0
Xsg13cmos5l_decap_8_3842 VPWR VGND sg13cmos5l_decap_8
* cell instance sg13cmos5l_decap_8_3843 r0 *1 0,0
Xsg13cmos5l_decap_8_3843 VPWR VGND sg13cmos5l_decap_8
* cell instance sg13cmos5l_decap_8_3844 r0 *1 0,0
Xsg13cmos5l_decap_8_3844 VPWR VGND sg13cmos5l_decap_8
* cell instance sg13cmos5l_decap_8_3845 r0 *1 0,0
Xsg13cmos5l_decap_8_3845 VPWR VGND sg13cmos5l_decap_8
* cell instance sg13cmos5l_decap_8_3846 r0 *1 0,0
Xsg13cmos5l_decap_8_3846 VPWR VGND sg13cmos5l_decap_8
* cell instance sg13cmos5l_decap_8_3847 r0 *1 0,0
Xsg13cmos5l_decap_8_3847 VPWR VGND sg13cmos5l_decap_8
* cell instance sg13cmos5l_decap_8_3848 r0 *1 0,0
Xsg13cmos5l_decap_8_3848 VPWR VGND sg13cmos5l_decap_8
* cell instance sg13cmos5l_decap_8_3849 r0 *1 0,0
Xsg13cmos5l_decap_8_3849 VPWR VGND sg13cmos5l_decap_8
* cell instance sg13cmos5l_decap_8_3850 r0 *1 0,0
Xsg13cmos5l_decap_8_3850 VPWR VGND sg13cmos5l_decap_8
* cell instance sg13cmos5l_decap_8_3851 r0 *1 0,0
Xsg13cmos5l_decap_8_3851 VPWR VGND sg13cmos5l_decap_8
* cell instance sg13cmos5l_decap_8_3852 r0 *1 0,0
Xsg13cmos5l_decap_8_3852 VPWR VGND sg13cmos5l_decap_8
* cell instance sg13cmos5l_decap_8_3853 r0 *1 0,0
Xsg13cmos5l_decap_8_3853 VPWR VGND sg13cmos5l_decap_8
* cell instance sg13cmos5l_decap_8_3854 r0 *1 0,0
Xsg13cmos5l_decap_8_3854 VPWR VGND sg13cmos5l_decap_8
* cell instance sg13cmos5l_decap_8_3855 r0 *1 0,0
Xsg13cmos5l_decap_8_3855 VPWR VGND sg13cmos5l_decap_8
* cell instance sg13cmos5l_decap_8_3856 r0 *1 0,0
Xsg13cmos5l_decap_8_3856 VPWR VGND sg13cmos5l_decap_8
* cell instance sg13cmos5l_decap_8_3857 r0 *1 0,0
Xsg13cmos5l_decap_8_3857 VPWR VGND sg13cmos5l_decap_8
* cell instance sg13cmos5l_decap_8_3858 r0 *1 0,0
Xsg13cmos5l_decap_8_3858 VPWR VGND sg13cmos5l_decap_8
* cell instance sg13cmos5l_decap_8_3859 r0 *1 0,0
Xsg13cmos5l_decap_8_3859 VPWR VGND sg13cmos5l_decap_8
* cell instance sg13cmos5l_decap_8_3860 r0 *1 0,0
Xsg13cmos5l_decap_8_3860 VPWR VGND sg13cmos5l_decap_8
* cell instance sg13cmos5l_decap_8_3861 r0 *1 0,0
Xsg13cmos5l_decap_8_3861 VPWR VGND sg13cmos5l_decap_8
* cell instance sg13cmos5l_decap_8_3862 r0 *1 0,0
Xsg13cmos5l_decap_8_3862 VPWR VGND sg13cmos5l_decap_8
* cell instance sg13cmos5l_decap_8_3863 r0 *1 0,0
Xsg13cmos5l_decap_8_3863 VPWR VGND sg13cmos5l_decap_8
* cell instance sg13cmos5l_decap_8_3864 r0 *1 0,0
Xsg13cmos5l_decap_8_3864 VPWR VGND sg13cmos5l_decap_8
* cell instance sg13cmos5l_decap_8_3865 r0 *1 0,0
Xsg13cmos5l_decap_8_3865 VPWR VGND sg13cmos5l_decap_8
* cell instance sg13cmos5l_decap_8_3866 r0 *1 0,0
Xsg13cmos5l_decap_8_3866 VPWR VGND sg13cmos5l_decap_8
* cell instance sg13cmos5l_decap_8_3867 r0 *1 0,0
Xsg13cmos5l_decap_8_3867 VPWR VGND sg13cmos5l_decap_8
* cell instance sg13cmos5l_decap_8_3868 r0 *1 0,0
Xsg13cmos5l_decap_8_3868 VPWR VGND sg13cmos5l_decap_8
* cell instance sg13cmos5l_decap_8_3869 r0 *1 0,0
Xsg13cmos5l_decap_8_3869 VPWR VGND sg13cmos5l_decap_8
* cell instance sg13cmos5l_decap_8_3870 r0 *1 0,0
Xsg13cmos5l_decap_8_3870 VPWR VGND sg13cmos5l_decap_8
* cell instance sg13cmos5l_decap_8_3871 r0 *1 0,0
Xsg13cmos5l_decap_8_3871 VPWR VGND sg13cmos5l_decap_8
* cell instance sg13cmos5l_decap_8_3872 r0 *1 0,0
Xsg13cmos5l_decap_8_3872 VPWR VGND sg13cmos5l_decap_8
* cell instance sg13cmos5l_decap_8_3873 r0 *1 0,0
Xsg13cmos5l_decap_8_3873 VPWR VGND sg13cmos5l_decap_8
* cell instance sg13cmos5l_decap_8_3874 r0 *1 0,0
Xsg13cmos5l_decap_8_3874 VPWR VGND sg13cmos5l_decap_8
* cell instance sg13cmos5l_decap_8_3875 r0 *1 0,0
Xsg13cmos5l_decap_8_3875 VPWR VGND sg13cmos5l_decap_8
* cell instance sg13cmos5l_decap_8_3876 r0 *1 0,0
Xsg13cmos5l_decap_8_3876 VPWR VGND sg13cmos5l_decap_8
* cell instance sg13cmos5l_decap_8_3877 r0 *1 0,0
Xsg13cmos5l_decap_8_3877 VPWR VGND sg13cmos5l_decap_8
* cell instance sg13cmos5l_decap_8_3878 r0 *1 0,0
Xsg13cmos5l_decap_8_3878 VPWR VGND sg13cmos5l_decap_8
* cell instance sg13cmos5l_decap_8_3879 r0 *1 0,0
Xsg13cmos5l_decap_8_3879 VPWR VGND sg13cmos5l_decap_8
* cell instance sg13cmos5l_decap_8_3880 r0 *1 0,0
Xsg13cmos5l_decap_8_3880 VPWR VGND sg13cmos5l_decap_8
* cell instance sg13cmos5l_decap_8_3881 r0 *1 0,0
Xsg13cmos5l_decap_8_3881 VPWR VGND sg13cmos5l_decap_8
* cell instance sg13cmos5l_decap_8_3882 r0 *1 0,0
Xsg13cmos5l_decap_8_3882 VPWR VGND sg13cmos5l_decap_8
* cell instance sg13cmos5l_decap_8_3883 r0 *1 0,0
Xsg13cmos5l_decap_8_3883 VPWR VGND sg13cmos5l_decap_8
* cell instance sg13cmos5l_decap_8_3884 r0 *1 0,0
Xsg13cmos5l_decap_8_3884 VPWR VGND sg13cmos5l_decap_8
* cell instance sg13cmos5l_decap_8_3885 r0 *1 0,0
Xsg13cmos5l_decap_8_3885 VPWR VGND sg13cmos5l_decap_8
* cell instance sg13cmos5l_decap_8_3886 r0 *1 0,0
Xsg13cmos5l_decap_8_3886 VPWR VGND sg13cmos5l_decap_8
* cell instance sg13cmos5l_decap_8_3887 r0 *1 0,0
Xsg13cmos5l_decap_8_3887 VPWR VGND sg13cmos5l_decap_8
* cell instance sg13cmos5l_decap_8_3888 r0 *1 0,0
Xsg13cmos5l_decap_8_3888 VPWR VGND sg13cmos5l_decap_8
* cell instance sg13cmos5l_decap_8_3889 r0 *1 0,0
Xsg13cmos5l_decap_8_3889 VPWR VGND sg13cmos5l_decap_8
* cell instance sg13cmos5l_decap_8_3890 r0 *1 0,0
Xsg13cmos5l_decap_8_3890 VPWR VGND sg13cmos5l_decap_8
* cell instance sg13cmos5l_decap_8_3891 r0 *1 0,0
Xsg13cmos5l_decap_8_3891 VPWR VGND sg13cmos5l_decap_8
* cell instance sg13cmos5l_decap_8_3892 r0 *1 0,0
Xsg13cmos5l_decap_8_3892 VPWR VGND sg13cmos5l_decap_8
* cell instance sg13cmos5l_decap_8_3893 r0 *1 0,0
Xsg13cmos5l_decap_8_3893 VPWR VGND sg13cmos5l_decap_8
* cell instance sg13cmos5l_decap_8_3894 r0 *1 0,0
Xsg13cmos5l_decap_8_3894 VPWR VGND sg13cmos5l_decap_8
* cell instance sg13cmos5l_decap_8_3895 r0 *1 0,0
Xsg13cmos5l_decap_8_3895 VPWR VGND sg13cmos5l_decap_8
* cell instance sg13cmos5l_decap_8_3896 r0 *1 0,0
Xsg13cmos5l_decap_8_3896 VPWR VGND sg13cmos5l_decap_8
* cell instance sg13cmos5l_decap_8_3897 r0 *1 0,0
Xsg13cmos5l_decap_8_3897 VPWR VGND sg13cmos5l_decap_8
* cell instance sg13cmos5l_decap_8_3898 r0 *1 0,0
Xsg13cmos5l_decap_8_3898 VPWR VGND sg13cmos5l_decap_8
* cell instance sg13cmos5l_decap_8_3899 r0 *1 0,0
Xsg13cmos5l_decap_8_3899 VPWR VGND sg13cmos5l_decap_8
* cell instance sg13cmos5l_decap_8_3900 r0 *1 0,0
Xsg13cmos5l_decap_8_3900 VPWR VGND sg13cmos5l_decap_8
* cell instance sg13cmos5l_decap_8_3901 r0 *1 0,0
Xsg13cmos5l_decap_8_3901 VPWR VGND sg13cmos5l_decap_8
* cell instance sg13cmos5l_decap_8_3902 r0 *1 0,0
Xsg13cmos5l_decap_8_3902 VPWR VGND sg13cmos5l_decap_8
* cell instance sg13cmos5l_decap_8_3903 r0 *1 0,0
Xsg13cmos5l_decap_8_3903 VPWR VGND sg13cmos5l_decap_8
* cell instance sg13cmos5l_decap_8_3904 r0 *1 0,0
Xsg13cmos5l_decap_8_3904 VPWR VGND sg13cmos5l_decap_8
* cell instance sg13cmos5l_decap_8_3905 r0 *1 0,0
Xsg13cmos5l_decap_8_3905 VPWR VGND sg13cmos5l_decap_8
* cell instance sg13cmos5l_decap_8_3906 r0 *1 0,0
Xsg13cmos5l_decap_8_3906 VPWR VGND sg13cmos5l_decap_8
* cell instance sg13cmos5l_decap_8_3907 r0 *1 0,0
Xsg13cmos5l_decap_8_3907 VPWR VGND sg13cmos5l_decap_8
* cell instance sg13cmos5l_decap_8_3908 r0 *1 0,0
Xsg13cmos5l_decap_8_3908 VPWR VGND sg13cmos5l_decap_8
* cell instance sg13cmos5l_decap_8_3909 r0 *1 0,0
Xsg13cmos5l_decap_8_3909 VPWR VGND sg13cmos5l_decap_8
* cell instance sg13cmos5l_decap_8_3910 r0 *1 0,0
Xsg13cmos5l_decap_8_3910 VPWR VGND sg13cmos5l_decap_8
* cell instance sg13cmos5l_decap_8_3911 r0 *1 0,0
Xsg13cmos5l_decap_8_3911 VPWR VGND sg13cmos5l_decap_8
* cell instance sg13cmos5l_decap_8_3912 r0 *1 0,0
Xsg13cmos5l_decap_8_3912 VPWR VGND sg13cmos5l_decap_8
* cell instance sg13cmos5l_decap_8_3913 r0 *1 0,0
Xsg13cmos5l_decap_8_3913 VPWR VGND sg13cmos5l_decap_8
* cell instance sg13cmos5l_decap_8_3914 r0 *1 0,0
Xsg13cmos5l_decap_8_3914 VPWR VGND sg13cmos5l_decap_8
* cell instance sg13cmos5l_decap_8_3915 r0 *1 0,0
Xsg13cmos5l_decap_8_3915 VPWR VGND sg13cmos5l_decap_8
* cell instance sg13cmos5l_decap_8_3916 r0 *1 0,0
Xsg13cmos5l_decap_8_3916 VPWR VGND sg13cmos5l_decap_8
* cell instance sg13cmos5l_decap_8_3917 r0 *1 0,0
Xsg13cmos5l_decap_8_3917 VPWR VGND sg13cmos5l_decap_8
* cell instance sg13cmos5l_decap_8_3918 r0 *1 0,0
Xsg13cmos5l_decap_8_3918 VPWR VGND sg13cmos5l_decap_8
* cell instance sg13cmos5l_decap_8_3919 r0 *1 0,0
Xsg13cmos5l_decap_8_3919 VPWR VGND sg13cmos5l_decap_8
* cell instance sg13cmos5l_decap_8_3920 r0 *1 0,0
Xsg13cmos5l_decap_8_3920 VPWR VGND sg13cmos5l_decap_8
* cell instance sg13cmos5l_decap_8_3921 r0 *1 0,0
Xsg13cmos5l_decap_8_3921 VPWR VGND sg13cmos5l_decap_8
* cell instance sg13cmos5l_decap_8_3922 r0 *1 0,0
Xsg13cmos5l_decap_8_3922 VPWR VGND sg13cmos5l_decap_8
* cell instance sg13cmos5l_decap_8_3923 r0 *1 0,0
Xsg13cmos5l_decap_8_3923 VPWR VGND sg13cmos5l_decap_8
* cell instance sg13cmos5l_decap_8_3924 r0 *1 0,0
Xsg13cmos5l_decap_8_3924 VPWR VGND sg13cmos5l_decap_8
* cell instance sg13cmos5l_decap_8_3925 r0 *1 0,0
Xsg13cmos5l_decap_8_3925 VPWR VGND sg13cmos5l_decap_8
* cell instance sg13cmos5l_decap_8_3926 r0 *1 0,0
Xsg13cmos5l_decap_8_3926 VPWR VGND sg13cmos5l_decap_8
* cell instance sg13cmos5l_decap_8_3927 r0 *1 0,0
Xsg13cmos5l_decap_8_3927 VPWR VGND sg13cmos5l_decap_8
* cell instance sg13cmos5l_decap_8_3928 r0 *1 0,0
Xsg13cmos5l_decap_8_3928 VPWR VGND sg13cmos5l_decap_8
* cell instance sg13cmos5l_decap_8_3929 r0 *1 0,0
Xsg13cmos5l_decap_8_3929 VPWR VGND sg13cmos5l_decap_8
* cell instance sg13cmos5l_decap_8_3930 r0 *1 0,0
Xsg13cmos5l_decap_8_3930 VPWR VGND sg13cmos5l_decap_8
* cell instance sg13cmos5l_decap_8_3931 r0 *1 0,0
Xsg13cmos5l_decap_8_3931 VPWR VGND sg13cmos5l_decap_8
* cell instance sg13cmos5l_decap_8_3932 r0 *1 0,0
Xsg13cmos5l_decap_8_3932 VPWR VGND sg13cmos5l_decap_8
* cell instance sg13cmos5l_decap_8_3933 r0 *1 0,0
Xsg13cmos5l_decap_8_3933 VPWR VGND sg13cmos5l_decap_8
* cell instance sg13cmos5l_decap_8_3934 r0 *1 0,0
Xsg13cmos5l_decap_8_3934 VPWR VGND sg13cmos5l_decap_8
* cell instance sg13cmos5l_decap_8_3935 r0 *1 0,0
Xsg13cmos5l_decap_8_3935 VPWR VGND sg13cmos5l_decap_8
* cell instance sg13cmos5l_decap_8_3936 r0 *1 0,0
Xsg13cmos5l_decap_8_3936 VPWR VGND sg13cmos5l_decap_8
* cell instance sg13cmos5l_decap_8_3937 r0 *1 0,0
Xsg13cmos5l_decap_8_3937 VPWR VGND sg13cmos5l_decap_8
* cell instance sg13cmos5l_decap_8_3938 r0 *1 0,0
Xsg13cmos5l_decap_8_3938 VPWR VGND sg13cmos5l_decap_8
* cell instance sg13cmos5l_decap_8_3939 r0 *1 0,0
Xsg13cmos5l_decap_8_3939 VPWR VGND sg13cmos5l_decap_8
* cell instance sg13cmos5l_decap_8_3940 r0 *1 0,0
Xsg13cmos5l_decap_8_3940 VPWR VGND sg13cmos5l_decap_8
* cell instance sg13cmos5l_decap_8_3941 r0 *1 0,0
Xsg13cmos5l_decap_8_3941 VPWR VGND sg13cmos5l_decap_8
* cell instance sg13cmos5l_decap_8_3942 r0 *1 0,0
Xsg13cmos5l_decap_8_3942 VPWR VGND sg13cmos5l_decap_8
* cell instance sg13cmos5l_decap_8_3943 r0 *1 0,0
Xsg13cmos5l_decap_8_3943 VPWR VGND sg13cmos5l_decap_8
* cell instance sg13cmos5l_decap_8_3944 r0 *1 0,0
Xsg13cmos5l_decap_8_3944 VPWR VGND sg13cmos5l_decap_8
* cell instance sg13cmos5l_decap_8_3945 r0 *1 0,0
Xsg13cmos5l_decap_8_3945 VPWR VGND sg13cmos5l_decap_8
* cell instance sg13cmos5l_decap_8_3946 r0 *1 0,0
Xsg13cmos5l_decap_8_3946 VPWR VGND sg13cmos5l_decap_8
* cell instance sg13cmos5l_decap_8_3947 r0 *1 0,0
Xsg13cmos5l_decap_8_3947 VPWR VGND sg13cmos5l_decap_8
* cell instance sg13cmos5l_decap_8_3948 r0 *1 0,0
Xsg13cmos5l_decap_8_3948 VPWR VGND sg13cmos5l_decap_8
* cell instance sg13cmos5l_decap_8_3949 r0 *1 0,0
Xsg13cmos5l_decap_8_3949 VPWR VGND sg13cmos5l_decap_8
* cell instance sg13cmos5l_decap_8_3950 r0 *1 0,0
Xsg13cmos5l_decap_8_3950 VPWR VGND sg13cmos5l_decap_8
* cell instance sg13cmos5l_decap_8_3951 r0 *1 0,0
Xsg13cmos5l_decap_8_3951 VPWR VGND sg13cmos5l_decap_8
* cell instance sg13cmos5l_decap_8_3952 r0 *1 0,0
Xsg13cmos5l_decap_8_3952 VPWR VGND sg13cmos5l_decap_8
* cell instance sg13cmos5l_decap_8_3953 r0 *1 0,0
Xsg13cmos5l_decap_8_3953 VPWR VGND sg13cmos5l_decap_8
* cell instance sg13cmos5l_decap_8_3954 r0 *1 0,0
Xsg13cmos5l_decap_8_3954 VPWR VGND sg13cmos5l_decap_8
* cell instance sg13cmos5l_decap_8_3955 r0 *1 0,0
Xsg13cmos5l_decap_8_3955 VPWR VGND sg13cmos5l_decap_8
* cell instance sg13cmos5l_decap_8_3956 r0 *1 0,0
Xsg13cmos5l_decap_8_3956 VPWR VGND sg13cmos5l_decap_8
* cell instance sg13cmos5l_decap_8_3957 r0 *1 0,0
Xsg13cmos5l_decap_8_3957 VPWR VGND sg13cmos5l_decap_8
* cell instance sg13cmos5l_decap_8_3958 r0 *1 0,0
Xsg13cmos5l_decap_8_3958 VPWR VGND sg13cmos5l_decap_8
* cell instance sg13cmos5l_decap_8_3959 r0 *1 0,0
Xsg13cmos5l_decap_8_3959 VPWR VGND sg13cmos5l_decap_8
* cell instance sg13cmos5l_decap_8_3960 r0 *1 0,0
Xsg13cmos5l_decap_8_3960 VPWR VGND sg13cmos5l_decap_8
* cell instance sg13cmos5l_decap_8_3961 r0 *1 0,0
Xsg13cmos5l_decap_8_3961 VPWR VGND sg13cmos5l_decap_8
* cell instance sg13cmos5l_decap_8_3962 r0 *1 0,0
Xsg13cmos5l_decap_8_3962 VPWR VGND sg13cmos5l_decap_8
* cell instance sg13cmos5l_decap_8_3963 r0 *1 0,0
Xsg13cmos5l_decap_8_3963 VPWR VGND sg13cmos5l_decap_8
* cell instance sg13cmos5l_decap_8_3964 r0 *1 0,0
Xsg13cmos5l_decap_8_3964 VPWR VGND sg13cmos5l_decap_8
* cell instance sg13cmos5l_decap_8_3965 r0 *1 0,0
Xsg13cmos5l_decap_8_3965 VPWR VGND sg13cmos5l_decap_8
* cell instance sg13cmos5l_decap_8_3966 r0 *1 0,0
Xsg13cmos5l_decap_8_3966 VPWR VGND sg13cmos5l_decap_8
* cell instance sg13cmos5l_decap_8_3967 r0 *1 0,0
Xsg13cmos5l_decap_8_3967 VPWR VGND sg13cmos5l_decap_8
* cell instance sg13cmos5l_decap_8_3968 r0 *1 0,0
Xsg13cmos5l_decap_8_3968 VPWR VGND sg13cmos5l_decap_8
* cell instance sg13cmos5l_decap_8_3969 r0 *1 0,0
Xsg13cmos5l_decap_8_3969 VPWR VGND sg13cmos5l_decap_8
* cell instance sg13cmos5l_decap_8_3970 r0 *1 0,0
Xsg13cmos5l_decap_8_3970 VPWR VGND sg13cmos5l_decap_8
* cell instance sg13cmos5l_decap_8_3971 r0 *1 0,0
Xsg13cmos5l_decap_8_3971 VPWR VGND sg13cmos5l_decap_8
* cell instance sg13cmos5l_decap_8_3972 r0 *1 0,0
Xsg13cmos5l_decap_8_3972 VPWR VGND sg13cmos5l_decap_8
* cell instance sg13cmos5l_decap_8_3973 r0 *1 0,0
Xsg13cmos5l_decap_8_3973 VPWR VGND sg13cmos5l_decap_8
* cell instance sg13cmos5l_decap_8_3974 r0 *1 0,0
Xsg13cmos5l_decap_8_3974 VPWR VGND sg13cmos5l_decap_8
* cell instance sg13cmos5l_decap_8_3975 r0 *1 0,0
Xsg13cmos5l_decap_8_3975 VPWR VGND sg13cmos5l_decap_8
* cell instance sg13cmos5l_decap_8_3976 r0 *1 0,0
Xsg13cmos5l_decap_8_3976 VPWR VGND sg13cmos5l_decap_8
* cell instance sg13cmos5l_decap_8_3977 r0 *1 0,0
Xsg13cmos5l_decap_8_3977 VPWR VGND sg13cmos5l_decap_8
* cell instance sg13cmos5l_decap_8_3978 r0 *1 0,0
Xsg13cmos5l_decap_8_3978 VPWR VGND sg13cmos5l_decap_8
* cell instance sg13cmos5l_decap_8_3979 r0 *1 0,0
Xsg13cmos5l_decap_8_3979 VPWR VGND sg13cmos5l_decap_8
* cell instance sg13cmos5l_decap_8_3980 r0 *1 0,0
Xsg13cmos5l_decap_8_3980 VPWR VGND sg13cmos5l_decap_8
* cell instance sg13cmos5l_decap_8_3981 r0 *1 0,0
Xsg13cmos5l_decap_8_3981 VPWR VGND sg13cmos5l_decap_8
* cell instance sg13cmos5l_decap_8_3982 r0 *1 0,0
Xsg13cmos5l_decap_8_3982 VPWR VGND sg13cmos5l_decap_8
* cell instance sg13cmos5l_decap_8_3983 r0 *1 0,0
Xsg13cmos5l_decap_8_3983 VPWR VGND sg13cmos5l_decap_8
* cell instance sg13cmos5l_decap_8_3984 r0 *1 0,0
Xsg13cmos5l_decap_8_3984 VPWR VGND sg13cmos5l_decap_8
* cell instance sg13cmos5l_decap_8_3985 r0 *1 0,0
Xsg13cmos5l_decap_8_3985 VPWR VGND sg13cmos5l_decap_8
* cell instance sg13cmos5l_decap_8_3986 r0 *1 0,0
Xsg13cmos5l_decap_8_3986 VPWR VGND sg13cmos5l_decap_8
* cell instance sg13cmos5l_decap_8_3987 r0 *1 0,0
Xsg13cmos5l_decap_8_3987 VPWR VGND sg13cmos5l_decap_8
* cell instance sg13cmos5l_decap_8_3988 r0 *1 0,0
Xsg13cmos5l_decap_8_3988 VPWR VGND sg13cmos5l_decap_8
* cell instance sg13cmos5l_decap_8_3989 r0 *1 0,0
Xsg13cmos5l_decap_8_3989 VPWR VGND sg13cmos5l_decap_8
* cell instance sg13cmos5l_decap_8_3990 r0 *1 0,0
Xsg13cmos5l_decap_8_3990 VPWR VGND sg13cmos5l_decap_8
* cell instance sg13cmos5l_decap_8_3991 r0 *1 0,0
Xsg13cmos5l_decap_8_3991 VPWR VGND sg13cmos5l_decap_8
* cell instance sg13cmos5l_decap_8_3992 r0 *1 0,0
Xsg13cmos5l_decap_8_3992 VPWR VGND sg13cmos5l_decap_8
* cell instance sg13cmos5l_decap_8_3993 r0 *1 0,0
Xsg13cmos5l_decap_8_3993 VPWR VGND sg13cmos5l_decap_8
* cell instance sg13cmos5l_decap_8_3994 r0 *1 0,0
Xsg13cmos5l_decap_8_3994 VPWR VGND sg13cmos5l_decap_8
* cell instance sg13cmos5l_decap_8_3995 r0 *1 0,0
Xsg13cmos5l_decap_8_3995 VPWR VGND sg13cmos5l_decap_8
* cell instance sg13cmos5l_decap_8_3996 r0 *1 0,0
Xsg13cmos5l_decap_8_3996 VPWR VGND sg13cmos5l_decap_8
* cell instance sg13cmos5l_decap_8_3997 r0 *1 0,0
Xsg13cmos5l_decap_8_3997 VPWR VGND sg13cmos5l_decap_8
* cell instance sg13cmos5l_decap_8_3998 r0 *1 0,0
Xsg13cmos5l_decap_8_3998 VPWR VGND sg13cmos5l_decap_8
* cell instance sg13cmos5l_decap_8_3999 r0 *1 0,0
Xsg13cmos5l_decap_8_3999 VPWR VGND sg13cmos5l_decap_8
* cell instance sg13cmos5l_decap_8_4000 r0 *1 0,0
Xsg13cmos5l_decap_8_4000 VPWR VGND sg13cmos5l_decap_8
* cell instance sg13cmos5l_decap_8_4001 r0 *1 0,0
Xsg13cmos5l_decap_8_4001 VPWR VGND sg13cmos5l_decap_8
* cell instance sg13cmos5l_decap_8_4002 r0 *1 0,0
Xsg13cmos5l_decap_8_4002 VPWR VGND sg13cmos5l_decap_8
* cell instance sg13cmos5l_decap_8_4003 r0 *1 0,0
Xsg13cmos5l_decap_8_4003 VPWR VGND sg13cmos5l_decap_8
* cell instance sg13cmos5l_decap_8_4004 r0 *1 0,0
Xsg13cmos5l_decap_8_4004 VPWR VGND sg13cmos5l_decap_8
* cell instance sg13cmos5l_decap_8_4005 r0 *1 0,0
Xsg13cmos5l_decap_8_4005 VPWR VGND sg13cmos5l_decap_8
* cell instance sg13cmos5l_decap_8_4006 r0 *1 0,0
Xsg13cmos5l_decap_8_4006 VPWR VGND sg13cmos5l_decap_8
* cell instance sg13cmos5l_decap_8_4007 r0 *1 0,0
Xsg13cmos5l_decap_8_4007 VPWR VGND sg13cmos5l_decap_8
* cell instance sg13cmos5l_decap_8_4008 r0 *1 0,0
Xsg13cmos5l_decap_8_4008 VPWR VGND sg13cmos5l_decap_8
* cell instance sg13cmos5l_decap_8_4009 r0 *1 0,0
Xsg13cmos5l_decap_8_4009 VPWR VGND sg13cmos5l_decap_8
* cell instance sg13cmos5l_decap_8_4010 r0 *1 0,0
Xsg13cmos5l_decap_8_4010 VPWR VGND sg13cmos5l_decap_8
* cell instance sg13cmos5l_decap_8_4011 r0 *1 0,0
Xsg13cmos5l_decap_8_4011 VPWR VGND sg13cmos5l_decap_8
* cell instance sg13cmos5l_decap_8_4012 r0 *1 0,0
Xsg13cmos5l_decap_8_4012 VPWR VGND sg13cmos5l_decap_8
* cell instance sg13cmos5l_decap_8_4013 r0 *1 0,0
Xsg13cmos5l_decap_8_4013 VPWR VGND sg13cmos5l_decap_8
* cell instance sg13cmos5l_decap_8_4014 r0 *1 0,0
Xsg13cmos5l_decap_8_4014 VPWR VGND sg13cmos5l_decap_8
* cell instance sg13cmos5l_decap_8_4015 r0 *1 0,0
Xsg13cmos5l_decap_8_4015 VPWR VGND sg13cmos5l_decap_8
* cell instance sg13cmos5l_decap_8_4016 r0 *1 0,0
Xsg13cmos5l_decap_8_4016 VPWR VGND sg13cmos5l_decap_8
* cell instance sg13cmos5l_decap_8_4017 r0 *1 0,0
Xsg13cmos5l_decap_8_4017 VPWR VGND sg13cmos5l_decap_8
* cell instance sg13cmos5l_decap_8_4018 r0 *1 0,0
Xsg13cmos5l_decap_8_4018 VPWR VGND sg13cmos5l_decap_8
* cell instance sg13cmos5l_decap_8_4019 r0 *1 0,0
Xsg13cmos5l_decap_8_4019 VPWR VGND sg13cmos5l_decap_8
* cell instance sg13cmos5l_decap_8_4020 r0 *1 0,0
Xsg13cmos5l_decap_8_4020 VPWR VGND sg13cmos5l_decap_8
* cell instance sg13cmos5l_decap_8_4021 r0 *1 0,0
Xsg13cmos5l_decap_8_4021 VPWR VGND sg13cmos5l_decap_8
* cell instance sg13cmos5l_decap_8_4022 r0 *1 0,0
Xsg13cmos5l_decap_8_4022 VPWR VGND sg13cmos5l_decap_8
* cell instance sg13cmos5l_decap_8_4023 r0 *1 0,0
Xsg13cmos5l_decap_8_4023 VPWR VGND sg13cmos5l_decap_8
* cell instance sg13cmos5l_decap_8_4024 r0 *1 0,0
Xsg13cmos5l_decap_8_4024 VPWR VGND sg13cmos5l_decap_8
* cell instance sg13cmos5l_decap_8_4025 r0 *1 0,0
Xsg13cmos5l_decap_8_4025 VPWR VGND sg13cmos5l_decap_8
* cell instance sg13cmos5l_decap_8_4026 r0 *1 0,0
Xsg13cmos5l_decap_8_4026 VPWR VGND sg13cmos5l_decap_8
* cell instance sg13cmos5l_decap_8_4027 r0 *1 0,0
Xsg13cmos5l_decap_8_4027 VPWR VGND sg13cmos5l_decap_8
* cell instance sg13cmos5l_decap_8_4028 r0 *1 0,0
Xsg13cmos5l_decap_8_4028 VPWR VGND sg13cmos5l_decap_8
* cell instance sg13cmos5l_decap_8_4029 r0 *1 0,0
Xsg13cmos5l_decap_8_4029 VPWR VGND sg13cmos5l_decap_8
* cell instance sg13cmos5l_decap_8_4030 r0 *1 0,0
Xsg13cmos5l_decap_8_4030 VPWR VGND sg13cmos5l_decap_8
* cell instance sg13cmos5l_decap_8_4031 r0 *1 0,0
Xsg13cmos5l_decap_8_4031 VPWR VGND sg13cmos5l_decap_8
* cell instance sg13cmos5l_decap_8_4032 r0 *1 0,0
Xsg13cmos5l_decap_8_4032 VPWR VGND sg13cmos5l_decap_8
* cell instance sg13cmos5l_decap_8_4033 r0 *1 0,0
Xsg13cmos5l_decap_8_4033 VPWR VGND sg13cmos5l_decap_8
* cell instance sg13cmos5l_decap_8_4034 r0 *1 0,0
Xsg13cmos5l_decap_8_4034 VPWR VGND sg13cmos5l_decap_8
* cell instance sg13cmos5l_decap_8_4035 r0 *1 0,0
Xsg13cmos5l_decap_8_4035 VPWR VGND sg13cmos5l_decap_8
* cell instance sg13cmos5l_decap_8_4036 r0 *1 0,0
Xsg13cmos5l_decap_8_4036 VPWR VGND sg13cmos5l_decap_8
* cell instance sg13cmos5l_decap_8_4037 r0 *1 0,0
Xsg13cmos5l_decap_8_4037 VPWR VGND sg13cmos5l_decap_8
* cell instance sg13cmos5l_decap_8_4038 r0 *1 0,0
Xsg13cmos5l_decap_8_4038 VPWR VGND sg13cmos5l_decap_8
* cell instance sg13cmos5l_decap_8_4039 r0 *1 0,0
Xsg13cmos5l_decap_8_4039 VPWR VGND sg13cmos5l_decap_8
* cell instance sg13cmos5l_decap_8_4040 r0 *1 0,0
Xsg13cmos5l_decap_8_4040 VPWR VGND sg13cmos5l_decap_8
* cell instance sg13cmos5l_decap_8_4041 r0 *1 0,0
Xsg13cmos5l_decap_8_4041 VPWR VGND sg13cmos5l_decap_8
* cell instance sg13cmos5l_decap_8_4042 r0 *1 0,0
Xsg13cmos5l_decap_8_4042 VPWR VGND sg13cmos5l_decap_8
* cell instance sg13cmos5l_decap_8_4043 r0 *1 0,0
Xsg13cmos5l_decap_8_4043 VPWR VGND sg13cmos5l_decap_8
* cell instance sg13cmos5l_dfrbpq_1_0 r0 *1 0,0
Xsg13cmos5l_dfrbpq_1_0 \$5177 \$5080 \$5092 \$4323 VPWR VGND sg13cmos5l_dfrbpq_1
* cell instance sg13cmos5l_dfrbpq_1_1 r0 *1 0,0
Xsg13cmos5l_dfrbpq_1_1 \$5177 \$5482 \$5548 \$4323 VPWR VGND sg13cmos5l_dfrbpq_1
* cell instance sg13cmos5l_dfrbpq_1_2 r0 *1 0,0
Xsg13cmos5l_dfrbpq_1_2 \$6235 \$5863 \$6178 \$6233 VPWR VGND sg13cmos5l_dfrbpq_1
* cell instance sg13cmos5l_dfrbpq_1_3 r0 *1 0,0
Xsg13cmos5l_dfrbpq_1_3 \$6235 \$6495 \$6697 \$6233 VPWR VGND sg13cmos5l_dfrbpq_1
* cell instance sg13cmos5l_dfrbpq_1_4 r0 *1 0,0
Xsg13cmos5l_dfrbpq_1_4 \$7250 \$7259 \$6562 \$6233 VPWR VGND sg13cmos5l_dfrbpq_1
* cell instance sg13cmos5l_dfrbpq_1_5 r0 *1 0,0
Xsg13cmos5l_dfrbpq_1_5 \$7250 \$7612 \$7529 \$7576 VPWR VGND sg13cmos5l_dfrbpq_1
* cell instance sg13cmos5l_dfrbpq_1_6 r0 *1 0,0
Xsg13cmos5l_dfrbpq_1_6 \$2585 \$2577 \$2591 \$2135 VPWR VGND sg13cmos5l_dfrbpq_1
* cell instance sg13cmos5l_dfrbpq_1_7 r0 *1 0,0
Xsg13cmos5l_dfrbpq_1_7 \$2585 \$1993 \$2142 \$2135 VPWR VGND sg13cmos5l_dfrbpq_1
* cell instance sg13cmos5l_dfrbpq_1_8 r0 *1 0,0
Xsg13cmos5l_dfrbpq_1_8 \$3018 \$3010 \$3022 \$2135 VPWR VGND sg13cmos5l_dfrbpq_1
* cell instance sg13cmos5l_dfrbpq_1_9 r0 *1 0,0
Xsg13cmos5l_dfrbpq_1_9 \$7250 \$7315 \$7254 \$7576 VPWR VGND sg13cmos5l_dfrbpq_1
* cell instance sg13cmos5l_dfrbpq_1_10 r0 *1 0,0
Xsg13cmos5l_dfrbpq_1_10 \$7621 \$9350 \$9502 \$7576 VPWR VGND
+ sg13cmos5l_dfrbpq_1
* cell instance sg13cmos5l_dfrbpq_1_11 r0 *1 0,0
Xsg13cmos5l_dfrbpq_1_11 \$2585 \$2721 \$2731 \$2135 VPWR VGND
+ sg13cmos5l_dfrbpq_1
* cell instance sg13cmos5l_dfrbpq_1_12 r0 *1 0,0
Xsg13cmos5l_dfrbpq_1_12 \$6235 \$6426 \$6365 \$6233 VPWR VGND
+ sg13cmos5l_dfrbpq_1
* cell instance sg13cmos5l_dfrbpq_1_13 r0 *1 0,0
Xsg13cmos5l_dfrbpq_1_13 \$7621 \$12941 \$7584 \$10278 VPWR VGND
+ sg13cmos5l_dfrbpq_1
* cell instance sg13cmos5l_dfrbpq_1_14 r0 *1 0,0
Xsg13cmos5l_dfrbpq_1_14 \$5177 \$5636 \$5602 \$4323 VPWR VGND
+ sg13cmos5l_dfrbpq_1
* cell instance sg13cmos5l_dfrbpq_1_15 r0 *1 0,0
Xsg13cmos5l_dfrbpq_1_15 \$2277 \$2282 \$2270 \$2135 VPWR VGND
+ sg13cmos5l_dfrbpq_1
* cell instance sg13cmos5l_dfrbpq_1_16 r0 *1 0,0
Xsg13cmos5l_dfrbpq_1_16 \$7621 \$10250 \$10172 \$10278 VPWR VGND
+ sg13cmos5l_dfrbpq_1
* cell instance sg13cmos5l_dfrbpq_1_17 r0 *1 0,0
Xsg13cmos5l_dfrbpq_1_17 \$7621 \$7533 \$7262 \$7576 VPWR VGND
+ sg13cmos5l_dfrbpq_1
* cell instance sg13cmos5l_dfrbpq_1_18 r0 *1 0,0
Xsg13cmos5l_dfrbpq_1_18 \$7330 \$11896 uio_out[6] \$10278 VPWR VGND
+ sg13cmos5l_dfrbpq_1
* cell instance sg13cmos5l_dfrbpq_1_19 r0 *1 0,0
Xsg13cmos5l_dfrbpq_1_19 \$7250 \$7885 \$7651 \$7576 VPWR VGND
+ sg13cmos5l_dfrbpq_1
* cell instance sg13cmos5l_dfrbpq_1_20 r0 *1 0,0
Xsg13cmos5l_dfrbpq_1_20 \$8180 \$14177 uio_out[7] \$11312 VPWR VGND
+ sg13cmos5l_dfrbpq_1
* cell instance sg13cmos5l_dfrbpq_1_21 r0 *1 0,0
Xsg13cmos5l_dfrbpq_1_21 \$5177 \$5173 \$5161 \$4323 VPWR VGND
+ sg13cmos5l_dfrbpq_1
* cell instance sg13cmos5l_dfrbpq_1_22 r0 *1 0,0
Xsg13cmos5l_dfrbpq_1_22 \$2277 \$4575 \$4733 \$4323 VPWR VGND
+ sg13cmos5l_dfrbpq_1
* cell instance sg13cmos5l_dfrbpq_1_23 r0 *1 0,0
Xsg13cmos5l_dfrbpq_1_23 \$2277 \$3315 \$2732 \$3314 VPWR VGND
+ sg13cmos5l_dfrbpq_1
* cell instance sg13cmos5l_dfrbpq_1_24 r0 *1 0,0
Xsg13cmos5l_dfrbpq_1_24 \$2277 \$4324 \$4311 \$4323 VPWR VGND
+ sg13cmos5l_dfrbpq_1
* cell instance sg13cmos5l_dfrbpq_1_25 r0 *1 0,0
Xsg13cmos5l_dfrbpq_1_25 \$7328 \$11311 \$10873 \$10278 VPWR VGND
+ sg13cmos5l_dfrbpq_1
* cell instance sg13cmos5l_dfrbpq_1_26 r0 *1 0,0
Xsg13cmos5l_dfrbpq_1_26 \$2277 \$4114 \$4126 \$3314 VPWR VGND
+ sg13cmos5l_dfrbpq_1
* cell instance sg13cmos5l_dfrbpq_1_27 r0 *1 0,0
Xsg13cmos5l_dfrbpq_1_27 \$8180 \$15158 uio_out[2] \$11312 VPWR VGND
+ sg13cmos5l_dfrbpq_1
* cell instance sg13cmos5l_dfrbpq_1_28 r0 *1 0,0
Xsg13cmos5l_dfrbpq_1_28 \$944 \$2005 \$1831 \$2135 VPWR VGND sg13cmos5l_dfrbpq_1
* cell instance sg13cmos5l_dfrbpq_1_29 r0 *1 0,0
Xsg13cmos5l_dfrbpq_1_29 \$7328 \$8754 \$7801 \$7576 VPWR VGND
+ sg13cmos5l_dfrbpq_1
* cell instance sg13cmos5l_dfrbpq_1_30 r0 *1 0,0
Xsg13cmos5l_dfrbpq_1_30 \$5177 \$5605 \$5308 \$3314 VPWR VGND
+ sg13cmos5l_dfrbpq_1
* cell instance sg13cmos5l_dfrbpq_1_31 r0 *1 0,0
Xsg13cmos5l_dfrbpq_1_31 \$5177 \$4747 \$4759 \$3587 VPWR VGND
+ sg13cmos5l_dfrbpq_1
* cell instance sg13cmos5l_dfrbpq_1_32 r0 *1 0,0
Xsg13cmos5l_dfrbpq_1_32 \$7250 \$7541 \$7255 \$6233 VPWR VGND
+ sg13cmos5l_dfrbpq_1
* cell instance sg13cmos5l_dfrbpq_1_33 r0 *1 0,0
Xsg13cmos5l_dfrbpq_1_33 \$7328 \$8283 \$5116 \$7576 VPWR VGND
+ sg13cmos5l_dfrbpq_1
* cell instance sg13cmos5l_dfrbpq_1_34 r0 *1 0,0
Xsg13cmos5l_dfrbpq_1_34 \$7621 \$13079 \$7332 \$10278 VPWR VGND
+ sg13cmos5l_dfrbpq_1
* cell instance sg13cmos5l_dfrbpq_1_35 r0 *1 0,0
Xsg13cmos5l_dfrbpq_1_35 \$7328 \$10696 uio_out[4] \$11312 VPWR VGND
+ sg13cmos5l_dfrbpq_1
* cell instance sg13cmos5l_dfrbpq_1_36 r0 *1 0,0
Xsg13cmos5l_dfrbpq_1_36 \$7621 \$12347 uio_out[3] \$10278 VPWR VGND
+ sg13cmos5l_dfrbpq_1
* cell instance sg13cmos5l_dfrbpq_1_37 r0 *1 0,0
Xsg13cmos5l_dfrbpq_1_37 \$8180 \$13670 \$14184 \$11312 VPWR VGND
+ sg13cmos5l_dfrbpq_1
* cell instance sg13cmos5l_dfrbpq_1_38 r0 *1 0,0
Xsg13cmos5l_dfrbpq_1_38 \$7328 \$9786 \$9363 \$10278 VPWR VGND
+ sg13cmos5l_dfrbpq_1
* cell instance sg13cmos5l_dfrbpq_1_39 r0 *1 0,0
Xsg13cmos5l_dfrbpq_1_39 \$3018 \$3557 \$3569 \$3314 VPWR VGND
+ sg13cmos5l_dfrbpq_1
* cell instance sg13cmos5l_dfrbpq_1_40 r0 *1 0,0
Xsg13cmos5l_dfrbpq_1_40 \$3895 \$3888 \$3899 \$3314 VPWR VGND
+ sg13cmos5l_dfrbpq_1
* cell instance sg13cmos5l_dfrbpq_1_41 r0 *1 0,0
Xsg13cmos5l_dfrbpq_1_41 \$3895 \$5108 \$5190 \$4323 VPWR VGND
+ sg13cmos5l_dfrbpq_1
* cell instance sg13cmos5l_dfrbpq_1_42 r0 *1 0,0
Xsg13cmos5l_dfrbpq_1_42 \$3895 \$3715 \$4342 \$3314 VPWR VGND
+ sg13cmos5l_dfrbpq_1
* cell instance sg13cmos5l_dfrbpq_1_43 r0 *1 0,0
Xsg13cmos5l_dfrbpq_1_43 \$3018 \$2874 \$3039 \$2135 VPWR VGND
+ sg13cmos5l_dfrbpq_1
* cell instance sg13cmos5l_dfrbpq_1_44 r0 *1 0,0
Xsg13cmos5l_dfrbpq_1_44 \$6235 \$7543 \$7014 \$7576 VPWR VGND
+ sg13cmos5l_dfrbpq_1
* cell instance sg13cmos5l_dfrbpq_1_45 r0 *1 0,0
Xsg13cmos5l_dfrbpq_1_45 \$3895 \$4760 \$5117 \$4323 VPWR VGND
+ sg13cmos5l_dfrbpq_1
* cell instance sg13cmos5l_dfrbpq_1_46 r0 *1 0,0
Xsg13cmos5l_dfrbpq_1_46 \$7335 \$12645 \$7586 \$10278 VPWR VGND
+ sg13cmos5l_dfrbpq_1
* cell instance sg13cmos5l_dfrbpq_1_47 r0 *1 0,0
Xsg13cmos5l_dfrbpq_1_47 \$6235 \$6708 \$6713 \$5861 VPWR VGND
+ sg13cmos5l_dfrbpq_1
* cell instance sg13cmos5l_dfrbpq_1_48 r0 *1 0,0
Xsg13cmos5l_dfrbpq_1_48 \$8180 \$10177 \$10716 \$10031 VPWR VGND
+ sg13cmos5l_dfrbpq_1
* cell instance sg13cmos5l_dfrbpq_1_49 r0 *1 0,0
Xsg13cmos5l_dfrbpq_1_49 \$7328 \$8760 \$7888 \$5861 VPWR VGND
+ sg13cmos5l_dfrbpq_1
* cell instance sg13cmos5l_dfrbpq_1_50 r0 *1 0,0
Xsg13cmos5l_dfrbpq_1_50 \$5340 \$5195 \$5233 \$1179 VPWR VGND
+ sg13cmos5l_dfrbpq_1
* cell instance sg13cmos5l_dfrbpq_1_51 r0 *1 0,0
Xsg13cmos5l_dfrbpq_1_51 \$5340 \$6373 \$6204 \$5861 VPWR VGND
+ sg13cmos5l_dfrbpq_1
* cell instance sg13cmos5l_dfrbpq_1_52 r0 *1 0,0
Xsg13cmos5l_dfrbpq_1_52 \$2277 \$3187 \$2598 \$3314 VPWR VGND
+ sg13cmos5l_dfrbpq_1
* cell instance sg13cmos5l_dfrbpq_1_53 r0 *1 0,0
Xsg13cmos5l_dfrbpq_1_53 \$7330 \$15142 \$15592 \$11312 VPWR VGND
+ sg13cmos5l_dfrbpq_1
* cell instance sg13cmos5l_dfrbpq_1_54 r0 *1 0,0
Xsg13cmos5l_dfrbpq_1_54 \$3895 \$4134 \$3912 \$3587 VPWR VGND
+ sg13cmos5l_dfrbpq_1
* cell instance sg13cmos5l_dfrbpq_1_55 r0 *1 0,0
Xsg13cmos5l_dfrbpq_1_55 \$3018 \$2880 \$2743 \$1179 VPWR VGND
+ sg13cmos5l_dfrbpq_1
* cell instance sg13cmos5l_dfrbpq_1_56 r0 *1 0,0
Xsg13cmos5l_dfrbpq_1_56 \$7335 \$14847 \$14704 \$15863 VPWR VGND
+ sg13cmos5l_dfrbpq_1
* cell instance sg13cmos5l_dfrbpq_1_57 r0 *1 0,0
Xsg13cmos5l_dfrbpq_1_57 \$7335 \$16594 uio_out[5] \$15863 VPWR VGND
+ sg13cmos5l_dfrbpq_1
* cell instance sg13cmos5l_dfrbpq_1_58 r0 *1 0,0
Xsg13cmos5l_dfrbpq_1_58 \$8180 \$9961 \$9794 \$10031 VPWR VGND
+ sg13cmos5l_dfrbpq_1
* cell instance sg13cmos5l_dfrbpq_1_59 r0 *1 0,0
Xsg13cmos5l_dfrbpq_1_59 \$7335 \$11750 \$11314 \$10031 VPWR VGND
+ sg13cmos5l_dfrbpq_1
* cell instance sg13cmos5l_dfrbpq_1_60 r0 *1 0,0
Xsg13cmos5l_dfrbpq_1_60 \$944 \$669 \$1436 \$2135 VPWR VGND sg13cmos5l_dfrbpq_1
* cell instance sg13cmos5l_dfrbpq_1_61 r0 *1 0,0
Xsg13cmos5l_dfrbpq_1_61 \$5340 \$5335 \$5622 \$1179 VPWR VGND
+ sg13cmos5l_dfrbpq_1
* cell instance sg13cmos5l_dfrbpq_1_62 r0 *1 0,0
Xsg13cmos5l_dfrbpq_1_62 \$7330 \$16097 \$15599 \$15863 VPWR VGND
+ sg13cmos5l_dfrbpq_1
* cell instance sg13cmos5l_dfrbpq_1_63 r0 *1 0,0
Xsg13cmos5l_dfrbpq_1_63 \$7335 \$13090 \$6408 \$10031 VPWR VGND
+ sg13cmos5l_dfrbpq_1
* cell instance sg13cmos5l_dfrbpq_1_64 r0 *1 0,0
Xsg13cmos5l_dfrbpq_1_64 \$7330 \$8179 \$6211 \$5861 VPWR VGND
+ sg13cmos5l_dfrbpq_1
* cell instance sg13cmos5l_dfrbpq_1_65 r0 *1 0,0
Xsg13cmos5l_dfrbpq_1_65 \$944 \$441 \$960 \$949 VPWR VGND sg13cmos5l_dfrbpq_1
* cell instance sg13cmos5l_dfrbpq_1_66 r0 *1 0,0
Xsg13cmos5l_dfrbpq_1_66 \$944 \$128 \$937 \$949 VPWR VGND sg13cmos5l_dfrbpq_1
* cell instance sg13cmos5l_dfrbpq_1_67 r0 *1 0,0
Xsg13cmos5l_dfrbpq_1_67 \$6235 \$6714 \$6572 \$5861 VPWR VGND
+ sg13cmos5l_dfrbpq_1
* cell instance sg13cmos5l_dfrbpq_1_68 r0 *1 0,0
Xsg13cmos5l_dfrbpq_1_68 \$3895 \$4599 \$4787 \$3587 VPWR VGND
+ sg13cmos5l_dfrbpq_1
* cell instance sg13cmos5l_dfrbpq_1_69 r0 *1 0,0
Xsg13cmos5l_dfrbpq_1_69 \$2585 \$152 \$1287 \$949 VPWR VGND sg13cmos5l_dfrbpq_1
* cell instance sg13cmos5l_dfrbpq_1_70 r0 *1 0,0
Xsg13cmos5l_dfrbpq_1_70 \$8180 \$10698 \$10292 \$10031 VPWR VGND
+ sg13cmos5l_dfrbpq_1
* cell instance sg13cmos5l_dfrbpq_1_71 r0 *1 0,0
Xsg13cmos5l_dfrbpq_1_71 \$7587 \$11735 \$11763 \$10031 VPWR VGND
+ sg13cmos5l_dfrbpq_1
* cell instance sg13cmos5l_dfrbpq_1_72 r0 *1 0,0
Xsg13cmos5l_dfrbpq_1_72 \$7587 \$12652 \$3419 \$10031 VPWR VGND
+ sg13cmos5l_dfrbpq_1
* cell instance sg13cmos5l_dfrbpq_1_73 r0 *1 0,0
Xsg13cmos5l_dfrbpq_1_73 \$944 \$719 \$1048 \$949 VPWR VGND sg13cmos5l_dfrbpq_1
* cell instance sg13cmos5l_dfrbpq_1_74 r0 *1 0,0
Xsg13cmos5l_dfrbpq_1_74 \$5340 \$5345 \$5630 \$5861 VPWR VGND
+ sg13cmos5l_dfrbpq_1
* cell instance sg13cmos5l_dfrbpq_1_75 r0 *1 0,0
Xsg13cmos5l_dfrbpq_1_75 \$7587 \$15862 \$15176 \$15863 VPWR VGND
+ sg13cmos5l_dfrbpq_1
* cell instance sg13cmos5l_dfrbpq_1_76 r0 *1 0,0
Xsg13cmos5l_dfrbpq_1_76 \$7330 \$9504 \$4362 \$10031 VPWR VGND
+ sg13cmos5l_dfrbpq_1
* cell instance sg13cmos5l_dfrbpq_1_77 r0 *1 0,0
Xsg13cmos5l_dfrbpq_1_77 \$944 \$785 \$1154 \$949 VPWR VGND sg13cmos5l_dfrbpq_1
* cell instance sg13cmos5l_dfrbpq_1_78 r0 *1 0,0
Xsg13cmos5l_dfrbpq_1_78 \$7587 \$14190 uio_out[1] \$15863 VPWR VGND
+ sg13cmos5l_dfrbpq_1
* cell instance sg13cmos5l_dfrbpq_1_79 r0 *1 0,0
Xsg13cmos5l_dfrbpq_1_79 \$7587 \$16599 uio_out[0] \$15863 VPWR VGND
+ sg13cmos5l_dfrbpq_1
* cell instance sg13cmos5l_dfrbpq_1_80 r0 *1 0,0
Xsg13cmos5l_dfrbpq_1_80 \$5340 \$5281 \$5270 \$3587 VPWR VGND
+ sg13cmos5l_dfrbpq_1
* cell instance sg13cmos5l_dfrbpq_1_81 r0 *1 0,0
Xsg13cmos5l_dfrbpq_1_81 \$1055 \$621 \$1307 \$949 VPWR VGND sg13cmos5l_dfrbpq_1
* cell instance sg13cmos5l_dfrbpq_1_82 r0 *1 0,0
Xsg13cmos5l_dfrbpq_1_82 \$2585 \$151 \$1166 \$949 VPWR VGND sg13cmos5l_dfrbpq_1
* cell instance sg13cmos5l_dfrbpq_1_83 r0 *1 0,0
Xsg13cmos5l_dfrbpq_1_83 \$1055 \$50 \$1193 \$949 VPWR VGND sg13cmos5l_dfrbpq_1
* cell instance sg13cmos5l_dfrbpq_1_84 r0 *1 0,0
Xsg13cmos5l_dfrbpq_1_84 \$3018 \$3583 \$3745 \$3587 VPWR VGND
+ sg13cmos5l_dfrbpq_1
* cell instance sg13cmos5l_dfrbpq_1_85 r0 *1 0,0
Xsg13cmos5l_dfrbpq_1_85 \$3944 \$3922 \$3751 \$3587 VPWR VGND
+ sg13cmos5l_dfrbpq_1
* cell instance sg13cmos5l_dfrbpq_1_86 r0 *1 0,0
Xsg13cmos5l_dfrbpq_1_86 \$2585 \$2895 \$2748 \$1179 VPWR VGND
+ sg13cmos5l_dfrbpq_1
* cell instance sg13cmos5l_dfrbpq_1_87 r0 *1 0,0
Xsg13cmos5l_dfrbpq_1_87 \$2899 \$841 \$3467 \$3459 VPWR VGND sg13cmos5l_dfrbpq_1
* cell instance sg13cmos5l_dfrbpq_1_88 r0 *1 0,0
Xsg13cmos5l_dfrbpq_1_88 \$3944 \$4150 \$4146 \$3587 VPWR VGND
+ sg13cmos5l_dfrbpq_1
* cell instance sg13cmos5l_dfrbpq_1_89 r0 *1 0,0
Xsg13cmos5l_dfrbpq_1_89 \$2899 \$4387 \$4374 \$3067 VPWR VGND
+ sg13cmos5l_dfrbpq_1
* cell instance sg13cmos5l_dfrbpq_1_90 r0 *1 0,0
Xsg13cmos5l_dfrbpq_1_90 \$1055 \$310 \$1062 \$1074 VPWR VGND sg13cmos5l_dfrbpq_1
* cell instance sg13cmos5l_dfrbpq_1_91 r0 *1 0,0
Xsg13cmos5l_dfrbpq_1_91 \$1682 \$2557 \$2465 \$1074 VPWR VGND
+ sg13cmos5l_dfrbpq_1
* cell instance sg13cmos5l_dfrbpq_1_92 r0 *1 0,0
Xsg13cmos5l_dfrbpq_1_92 \$1055 \$1197 \$1474 \$1074 VPWR VGND
+ sg13cmos5l_dfrbpq_1
* cell instance sg13cmos5l_dfrbpq_1_93 r0 *1 0,0
Xsg13cmos5l_dfrbpq_1_93 \$1055 \$1080 \$1681 \$1074 VPWR VGND
+ sg13cmos5l_dfrbpq_1
* cell instance sg13cmos5l_dfrbpq_1_94 r0 *1 0,0
Xsg13cmos5l_dfrbpq_1_94 \$3944 \$4160 \$3938 \$3067 VPWR VGND
+ sg13cmos5l_dfrbpq_1
* cell instance sg13cmos5l_dfrbpq_1_95 r0 *1 0,0
Xsg13cmos5l_dfrbpq_1_95 \$2899 \$2909 \$2921 \$1074 VPWR VGND
+ sg13cmos5l_dfrbpq_1
* cell instance sg13cmos5l_dfrbpq_1_96 r0 *1 0,0
Xsg13cmos5l_dfrbpq_1_96 \$1682 \$1475 \$1486 \$1074 VPWR VGND
+ sg13cmos5l_dfrbpq_1
* cell instance sg13cmos5l_dfrbpq_1_97 r0 *1 0,0
Xsg13cmos5l_dfrbpq_1_97 \$2899 \$3475 \$3605 \$3067 VPWR VGND
+ sg13cmos5l_dfrbpq_1
* cell instance sg13cmos5l_dfrbpq_1_98 r0 *1 0,0
Xsg13cmos5l_dfrbpq_1_98 \$1682 \$2477 \$2329 \$1074 VPWR VGND
+ sg13cmos5l_dfrbpq_1
* cell instance sg13cmos5l_dfrbpq_1_99 r0 *1 0,0
Xsg13cmos5l_dfrbpq_1_99 \$1682 \$1684 \$1694 \$1497 VPWR VGND
+ sg13cmos5l_dfrbpq_1
* cell instance sg13cmos5l_dfrbpq_1_100 r0 *1 0,0
Xsg13cmos5l_dfrbpq_1_100 \$1682 \$749 \$1859 \$1074 VPWR VGND
+ sg13cmos5l_dfrbpq_1
* cell instance sg13cmos5l_dfrbpq_1_101 r0 *1 0,0
Xsg13cmos5l_dfrbpq_1_101 \$3944 \$4393 \$3931 \$3067 VPWR VGND
+ sg13cmos5l_dfrbpq_1
* cell instance sg13cmos5l_dfrbpq_1_102 r0 *1 0,0
Xsg13cmos5l_dfrbpq_1_102 \$2899 \$3958 \$4182 \$3067 VPWR VGND
+ sg13cmos5l_dfrbpq_1
* cell instance sg13cmos5l_dfrbpq_1_103 r0 *1 0,0
Xsg13cmos5l_dfrbpq_1_103 \$2899 \$3079 \$3068 \$1497 VPWR VGND
+ sg13cmos5l_dfrbpq_1
* cell instance sg13cmos5l_dfrbpq_1_104 r0 *1 0,0
Xsg13cmos5l_dfrbpq_1_104 \$1507 \$3774 \$3785 \$3067 VPWR VGND
+ sg13cmos5l_dfrbpq_1
* cell instance sg13cmos5l_dfrbpq_1_105 r0 *1 0,0
Xsg13cmos5l_dfrbpq_1_105 \$1682 \$1499 \$1487 \$1497 VPWR VGND
+ sg13cmos5l_dfrbpq_1
* cell instance sg13cmos5l_dfrbpq_1_106 r0 *1 0,0
Xsg13cmos5l_dfrbpq_1_106 \$3944 \$4185 \$4196 \$3459 VPWR VGND
+ sg13cmos5l_dfrbpq_1
* cell instance sg13cmos5l_dfrbpq_1_107 r0 *1 0,0
Xsg13cmos5l_dfrbpq_1_107 \$1507 \$638 \$1696 \$1497 VPWR VGND
+ sg13cmos5l_dfrbpq_1
* cell instance sg13cmos5l_dfrbpq_1_108 r0 *1 0,0
Xsg13cmos5l_dfrbpq_1_108 \$1507 \$809 \$1715 \$1345 VPWR VGND
+ sg13cmos5l_dfrbpq_1
* cell instance sg13cmos5l_dfrbpq_1_109 r0 *1 0,0
Xsg13cmos5l_dfrbpq_1_109 \$1520 \$1342 \$1512 \$1345 VPWR VGND
+ sg13cmos5l_dfrbpq_1
* cell instance sg13cmos5l_dfrbpq_1_110 r0 *1 0,0
Xsg13cmos5l_dfrbpq_1_110 \$1520 \$984 \$1356 \$1345 VPWR VGND
+ sg13cmos5l_dfrbpq_1
* cell instance sg13cmos5l_dfrbpq_1_111 r0 *1 0,0
Xsg13cmos5l_dfrbpq_1_111 \$1507 \$4442 \$4440 \$1114 VPWR VGND
+ sg13cmos5l_dfrbpq_1
* cell instance sg13cmos5l_dfrbpq_1_112 r0 *1 0,0
Xsg13cmos5l_dfrbpq_1_112 \$4228 \$4225 \$4463 \$1114 VPWR VGND
+ sg13cmos5l_dfrbpq_1
* cell instance sg13cmos5l_dfrbpq_1_113 r0 *1 0,0
Xsg13cmos5l_dfrbpq_1_113 \$3944 \$3995 \$4005 \$1114 VPWR VGND
+ sg13cmos5l_dfrbpq_1
* cell instance sg13cmos5l_dfrbpq_1_114 r0 *1 0,0
Xsg13cmos5l_dfrbpq_1_114 \$1520 \$388 \$1368 \$1345 VPWR VGND
+ sg13cmos5l_dfrbpq_1
* cell instance sg13cmos5l_dfrbpq_1_115 r0 *1 0,0
Xsg13cmos5l_dfrbpq_1_115 \$1520 \$1535 \$1543 \$1345 VPWR VGND
+ sg13cmos5l_dfrbpq_1
* cell instance sg13cmos5l_dfrbpq_1_116 r0 *1 0,0
Xsg13cmos5l_dfrbpq_1_116 \$1520 \$428 \$1629 \$1114 VPWR VGND
+ sg13cmos5l_dfrbpq_1
* cell instance sg13cmos5l_dfrbpq_1_117 r0 *1 0,0
Xsg13cmos5l_dfrbpq_1_117 \$1520 \$1913 \$1905 \$1345 VPWR VGND
+ sg13cmos5l_dfrbpq_1
* cell instance sg13cmos5l_dfrbpq_1_118 r0 *1 0,0
Xsg13cmos5l_dfrbpq_1_118 \$4228 \$4466 \$4477 \$1114 VPWR VGND
+ sg13cmos5l_dfrbpq_1
* cell instance sg13cmos5l_dfrbpq_1_119 r0 *1 0,0
Xsg13cmos5l_dfrbpq_1_119 \$1375 \$549 \$1547 \$1345 VPWR VGND
+ sg13cmos5l_dfrbpq_1
* cell instance sg13cmos5l_dfrbpq_1_120 r0 *1 0,0
Xsg13cmos5l_dfrbpq_1_120 \$4228 \$3820 \$3827 \$1114 VPWR VGND
+ sg13cmos5l_dfrbpq_1
* cell instance sg13cmos5l_dfrbpq_1_121 r0 *1 0,0
Xsg13cmos5l_dfrbpq_1_121 \$1375 \$1217 \$1229 \$1345 VPWR VGND
+ sg13cmos5l_dfrbpq_1
* cell instance sg13cmos5l_dfrbpq_1_122 r0 *1 0,0
Xsg13cmos5l_dfrbpq_1_122 \$3377 \$825 \$1023 \$1114 VPWR VGND
+ sg13cmos5l_dfrbpq_1
* cell instance sg13cmos5l_dfrbpq_1_123 r0 *1 0,0
Xsg13cmos5l_dfrbpq_1_123 \$4228 \$4246 \$4488 \$3652 VPWR VGND
+ sg13cmos5l_dfrbpq_1
* cell instance sg13cmos5l_dfrbpq_1_124 r0 *1 0,0
Xsg13cmos5l_dfrbpq_1_124 \$1375 \$1552 \$1753 \$1556 VPWR VGND
+ sg13cmos5l_dfrbpq_1
* cell instance sg13cmos5l_dfrbpq_1_125 r0 *1 0,0
Xsg13cmos5l_dfrbpq_1_125 \$1375 \$1233 \$1564 \$1556 VPWR VGND
+ sg13cmos5l_dfrbpq_1
* cell instance sg13cmos5l_dfrbpq_1_126 r0 *1 0,0
Xsg13cmos5l_dfrbpq_1_126 \$3636 \$4493 \$4491 \$4673 VPWR VGND
+ sg13cmos5l_dfrbpq_1
* cell instance sg13cmos5l_dfrbpq_1_127 r0 *1 0,0
Xsg13cmos5l_dfrbpq_1_127 \$1507 \$2671 \$2680 \$1556 VPWR VGND
+ sg13cmos5l_dfrbpq_1
* cell instance sg13cmos5l_dfrbpq_1_128 r0 *1 0,0
Xsg13cmos5l_dfrbpq_1_128 \$3377 \$3639 \$3640 \$3652 VPWR VGND
+ sg13cmos5l_dfrbpq_1
* cell instance sg13cmos5l_dfrbpq_1_129 r0 *1 0,0
Xsg13cmos5l_dfrbpq_1_129 \$4228 \$3829 \$4020 \$3652 VPWR VGND
+ sg13cmos5l_dfrbpq_1
* cell instance sg13cmos5l_dfrbpq_1_130 r0 *1 0,0
Xsg13cmos5l_dfrbpq_1_130 \$1127 \$2369 \$2226 \$2802 VPWR VGND
+ sg13cmos5l_dfrbpq_1
* cell instance sg13cmos5l_dfrbpq_1_131 r0 *1 0,0
Xsg13cmos5l_dfrbpq_1_131 \$3636 \$4255 \$1915 \$3652 VPWR VGND
+ sg13cmos5l_dfrbpq_1
* cell instance sg13cmos5l_dfrbpq_1_132 r0 *1 0,0
Xsg13cmos5l_dfrbpq_1_132 \$1127 \$1237 \$1118 \$1556 VPWR VGND
+ sg13cmos5l_dfrbpq_1
* cell instance sg13cmos5l_dfrbpq_1_133 r0 *1 0,0
Xsg13cmos5l_dfrbpq_1_133 \$1765 \$1758 \$1935 \$1556 VPWR VGND
+ sg13cmos5l_dfrbpq_1
* cell instance sg13cmos5l_dfrbpq_1_134 r0 *1 0,0
Xsg13cmos5l_dfrbpq_1_134 \$1252 \$1244 \$1400 \$1556 VPWR VGND
+ sg13cmos5l_dfrbpq_1
* cell instance sg13cmos5l_dfrbpq_1_135 r0 *1 0,0
Xsg13cmos5l_dfrbpq_1_135 \$1127 \$1027 \$1139 \$1556 VPWR VGND
+ sg13cmos5l_dfrbpq_1
* cell instance sg13cmos5l_dfrbpq_1_136 r0 *1 0,0
Xsg13cmos5l_dfrbpq_1_136 \$3377 \$3125 \$2965 \$2802 VPWR VGND
+ sg13cmos5l_dfrbpq_1
* cell instance sg13cmos5l_dfrbpq_1_137 r0 *1 0,0
Xsg13cmos5l_dfrbpq_1_137 \$3636 \$4501 \$4263 \$3652 VPWR VGND
+ sg13cmos5l_dfrbpq_1
* cell instance sg13cmos5l_dfrbpq_1_138 r0 *1 0,0
Xsg13cmos5l_dfrbpq_1_138 \$1765 \$1572 \$1583 \$1556 VPWR VGND
+ sg13cmos5l_dfrbpq_1
* cell instance sg13cmos5l_dfrbpq_1_139 r0 *1 0,0
Xsg13cmos5l_dfrbpq_1_139 \$3377 \$3530 \$3653 \$3652 VPWR VGND
+ sg13cmos5l_dfrbpq_1
* cell instance sg13cmos5l_dfrbpq_1_140 r0 *1 0,0
Xsg13cmos5l_dfrbpq_1_140 \$3636 \$3531 \$3676 \$3652 VPWR VGND
+ sg13cmos5l_dfrbpq_1
* cell instance sg13cmos5l_dfrbpq_1_141 r0 *1 0,0
Xsg13cmos5l_dfrbpq_1_141 \$3636 \$4041 \$4050 \$3652 VPWR VGND
+ sg13cmos5l_dfrbpq_1
* cell instance sg13cmos5l_dfrbpq_1_142 r0 *1 0,0
Xsg13cmos5l_dfrbpq_1_142 \$1252 \$1257 \$1270 \$1261 VPWR VGND
+ sg13cmos5l_dfrbpq_1
* cell instance sg13cmos5l_dfrbpq_1_143 r0 *1 0,0
Xsg13cmos5l_dfrbpq_1_143 \$1375 \$1585 \$1785 \$1261 VPWR VGND
+ sg13cmos5l_dfrbpq_1
* cell instance sg13cmos5l_dfrbpq_1_144 r0 *1 0,0
Xsg13cmos5l_dfrbpq_1_144 \$3377 \$3261 \$3398 \$3274 VPWR VGND
+ sg13cmos5l_dfrbpq_1
* cell instance sg13cmos5l_dfrbpq_1_145 r0 *1 0,0
Xsg13cmos5l_dfrbpq_1_145 \$1127 \$2688 \$2383 \$2540 VPWR VGND
+ sg13cmos5l_dfrbpq_1
* cell instance sg13cmos5l_dfrbpq_1_146 r0 *1 0,0
Xsg13cmos5l_dfrbpq_1_146 \$1127 \$1409 \$1592 \$1261 VPWR VGND
+ sg13cmos5l_dfrbpq_1
* cell instance sg13cmos5l_dfrbpq_1_147 r0 *1 0,0
Xsg13cmos5l_dfrbpq_1_147 \$2522 \$2821 \$2961 \$2540 VPWR VGND
+ sg13cmos5l_dfrbpq_1
* cell instance sg13cmos5l_dfrbpq_1_148 r0 *1 0,0
Xsg13cmos5l_dfrbpq_1_148 \$1252 \$2524 \$2382 \$2540 VPWR VGND
+ sg13cmos5l_dfrbpq_1
* cell instance sg13cmos5l_dfrbpq_1_149 r0 *1 0,0
Xsg13cmos5l_dfrbpq_1_149 \$3636 \$3540 \$3845 \$3274 VPWR VGND
+ sg13cmos5l_dfrbpq_1
* cell instance sg13cmos5l_dfrbpq_1_150 r0 *1 0,0
Xsg13cmos5l_dfrbpq_1_150 \$3264 \$4697 \$4668 \$3542 VPWR VGND
+ sg13cmos5l_dfrbpq_1
* cell instance sg13cmos5l_dfrbpq_1_151 r0 *1 0,0
Xsg13cmos5l_dfrbpq_1_151 \$2522 \$2825 \$2819 \$2540 VPWR VGND
+ sg13cmos5l_dfrbpq_1
* cell instance sg13cmos5l_dfrbpq_1_152 r0 *1 0,0
Xsg13cmos5l_dfrbpq_1_152 \$4047 \$4709 \$5052 \$3542 VPWR VGND
+ sg13cmos5l_dfrbpq_1
* cell instance sg13cmos5l_dfrbpq_1_153 r0 *1 0,0
Xsg13cmos5l_dfrbpq_1_153 \$3264 \$3133 \$3248 \$3274 VPWR VGND
+ sg13cmos5l_dfrbpq_1
* cell instance sg13cmos5l_dfrbpq_1_154 r0 *1 0,0
Xsg13cmos5l_dfrbpq_1_154 \$1252 \$1145 \$1271 \$1261 VPWR VGND
+ sg13cmos5l_dfrbpq_1
* cell instance sg13cmos5l_dfrbpq_1_155 r0 *1 0,0
Xsg13cmos5l_dfrbpq_1_155 \$4053 \$3551 \$3862 \$3542 VPWR VGND
+ sg13cmos5l_dfrbpq_1
* cell instance sg13cmos5l_dfrbpq_1_156 r0 *1 0,0
Xsg13cmos5l_dfrbpq_1_156 \$4053 \$5468 \$5475 \$3542 VPWR VGND
+ sg13cmos5l_dfrbpq_1
* cell instance sg13cmos5l_dfrbpq_1_157 r0 *1 0,0
Xsg13cmos5l_dfrbpq_1_157 \$4053 \$5136 \$5141 \$3542 VPWR VGND
+ sg13cmos5l_dfrbpq_1
* cell instance sg13cmos5l_dfrbpq_1_158 r0 *1 0,0
Xsg13cmos5l_dfrbpq_1_158 \$4047 \$5895 \$5901 \$4220 VPWR VGND
+ sg13cmos5l_dfrbpq_1
* cell instance sg13cmos5l_dfrbpq_1_159 r0 *1 0,0
Xsg13cmos5l_dfrbpq_1_159 \$1765 \$2245 \$2238 \$2802 VPWR VGND
+ sg13cmos5l_dfrbpq_1
* cell instance sg13cmos5l_dfrbpq_1_160 r0 *1 0,0
Xsg13cmos5l_dfrbpq_1_160 \$2522 \$2403 \$2233 \$2540 VPWR VGND
+ sg13cmos5l_dfrbpq_1
* cell instance sg13cmos5l_dfrbpq_1_161 r0 *1 0,0
Xsg13cmos5l_dfrbpq_1_161 \$1252 \$2532 \$2236 \$2540 VPWR VGND
+ sg13cmos5l_dfrbpq_1
* cell instance sg13cmos5l_dfrbpq_1_162 r0 *1 0,0
Xsg13cmos5l_dfrbpq_1_162 \$1765 \$1423 \$1622 \$1261 VPWR VGND
+ sg13cmos5l_dfrbpq_1
* cell instance sg13cmos5l_dfrbpq_1_163 r0 *1 0,0
Xsg13cmos5l_dfrbpq_1_163 \$1375 \$1600 \$1601 \$1261 VPWR VGND
+ sg13cmos5l_dfrbpq_1
* cell instance sg13cmos5l_dfrbpq_1_164 r0 *1 0,0
Xsg13cmos5l_dfrbpq_1_164 \$1765 \$1956 \$1788 \$1261 VPWR VGND
+ sg13cmos5l_dfrbpq_1
* cell instance sg13cmos5l_dfrbpq_1_165 r0 *1 0,0
Xsg13cmos5l_dfrbpq_1_165 \$2522 \$2990 \$2971 \$2802 VPWR VGND
+ sg13cmos5l_dfrbpq_1
* cell instance sg13cmos5l_dfrbpq_1_166 r0 *1 0,0
Xsg13cmos5l_dfrbpq_1_166 \$2522 \$2705 \$2817 \$2540 VPWR VGND
+ sg13cmos5l_dfrbpq_1
* cell instance sg13cmos5l_dfrbpq_1_167 r0 *1 0,0
Xsg13cmos5l_dfrbpq_1_167 \$1127 \$1796 \$1790 \$1261 VPWR VGND
+ sg13cmos5l_dfrbpq_1
* cell instance sg13cmos5l_dfrbpq_1_168 r0 *1 0,0
Xsg13cmos5l_dfrbpq_1_168 \$3264 \$3403 \$3858 \$3274 VPWR VGND
+ sg13cmos5l_dfrbpq_1
* cell instance sg13cmos5l_dfrbpq_1_169 r0 *1 0,0
Xsg13cmos5l_dfrbpq_1_169 \$4053 \$3869 \$3709 \$3274 VPWR VGND
+ sg13cmos5l_dfrbpq_1
* cell instance sg13cmos5l_dfrbpq_1_170 r0 *1 0,0
Xsg13cmos5l_dfrbpq_1_170 \$4053 \$4527 \$4525 \$4673 VPWR VGND
+ sg13cmos5l_dfrbpq_1
* cell instance sg13cmos5l_dfrbpq_1_171 r0 *1 0,0
Xsg13cmos5l_dfrbpq_1_171 \$1252 \$2407 \$2235 \$2540 VPWR VGND
+ sg13cmos5l_dfrbpq_1
* cell instance sg13cmos5l_dfrbpq_1_172 r0 *1 0,0
Xsg13cmos5l_dfrbpq_1_172 \$3264 \$3548 \$4057 \$3274 VPWR VGND
+ sg13cmos5l_dfrbpq_1
* cell instance sg13cmos5l_dfrbpq_1_173 r0 *1 0,0
Xsg13cmos5l_dfrbpq_1_173 \$4053 \$4291 \$4109 \$3274 VPWR VGND
+ sg13cmos5l_dfrbpq_1
* cell instance sg13cmos5l_dfrbpq_1_174 r0 *1 0,0
Xsg13cmos5l_dfrbpq_1_174 \$4047 \$4719 \$5077 \$4673 VPWR VGND
+ sg13cmos5l_dfrbpq_1
* cell instance sg13cmos5l_dfrbpq_1_175 r0 *1 0,0
Xsg13cmos5l_dfrbpq_1_175 \$4047 \$5073 \$5067 \$3542 VPWR VGND
+ sg13cmos5l_dfrbpq_1
* cell instance sg13cmos5l_dfrbpq_1_176 r0 *1 0,0
Xsg13cmos5l_dfrbpq_1_176 \$3264 \$3146 \$3165 \$3274 VPWR VGND
+ sg13cmos5l_dfrbpq_1
* cell instance sg13cmos5l_dfrbpq_1_177 r0 *1 0,0
Xsg13cmos5l_dfrbpq_1_177 \$4047 \$5225 \$5546 \$3542 VPWR VGND
+ sg13cmos5l_dfrbpq_1
* cell instance sg13cmos5l_dlygate4sd3_1_0 r0 *1 0,0
Xsg13cmos5l_dlygate4sd3_1_0 \$4311 VPWR VGND \$4547 sg13cmos5l_dlygate4sd3_1
* cell instance sg13cmos5l_dlygate4sd3_1_1 r0 *1 0,0
Xsg13cmos5l_dlygate4sd3_1_1 \$4733 VPWR VGND \$5096 sg13cmos5l_dlygate4sd3_1
* cell instance sg13cmos5l_dlygate4sd3_1_2 r0 *1 0,0
Xsg13cmos5l_dlygate4sd3_1_2 \$7262 VPWR VGND \$7703 sg13cmos5l_dlygate4sd3_1
* cell instance sg13cmos5l_dlygate4sd3_1_3 r0 *1 0,0
Xsg13cmos5l_dlygate4sd3_1_3 \$5161 VPWR VGND \$5244 sg13cmos5l_dlygate4sd3_1
* cell instance sg13cmos5l_dlygate4sd3_1_4 r0 *1 0,0
Xsg13cmos5l_dlygate4sd3_1_4 \$2434 VPWR VGND \$2578 sg13cmos5l_dlygate4sd3_1
* cell instance sg13cmos5l_dlygate4sd3_1_5 r0 *1 0,0
Xsg13cmos5l_dlygate4sd3_1_5 \$2270 VPWR VGND \$2288 sg13cmos5l_dlygate4sd3_1
* cell instance sg13cmos5l_dlygate4sd3_1_6 r0 *1 0,0
Xsg13cmos5l_dlygate4sd3_1_6 \$2732 VPWR VGND \$3423 sg13cmos5l_dlygate4sd3_1
* cell instance sg13cmos5l_dlygate4sd3_1_7 r0 *1 0,0
Xsg13cmos5l_dlygate4sd3_1_7 \$10873 VPWR VGND \$10703 sg13cmos5l_dlygate4sd3_1
* cell instance sg13cmos5l_dlygate4sd3_1_8 r0 *1 0,0
Xsg13cmos5l_dlygate4sd3_1_8 \$5548 VPWR VGND \$5239 sg13cmos5l_dlygate4sd3_1
* cell instance sg13cmos5l_dlygate4sd3_1_9 r0 *1 0,0
Xsg13cmos5l_dlygate4sd3_1_9 \$6178 VPWR VGND \$5906 sg13cmos5l_dlygate4sd3_1
* cell instance sg13cmos5l_dlygate4sd3_1_10 r0 *1 0,0
Xsg13cmos5l_dlygate4sd3_1_10 \$6697 VPWR VGND \$6560 sg13cmos5l_dlygate4sd3_1
* cell instance sg13cmos5l_dlygate4sd3_1_11 r0 *1 0,0
Xsg13cmos5l_dlygate4sd3_1_11 \$6562 VPWR VGND \$7310 sg13cmos5l_dlygate4sd3_1
* cell instance sg13cmos5l_dlygate4sd3_1_12 r0 *1 0,0
Xsg13cmos5l_dlygate4sd3_1_12 \$7529 VPWR VGND \$7309 sg13cmos5l_dlygate4sd3_1
* cell instance sg13cmos5l_dlygate4sd3_1_13 r0 *1 0,0
Xsg13cmos5l_dlygate4sd3_1_13 \$5092 VPWR VGND \$4574 sg13cmos5l_dlygate4sd3_1
* cell instance sg13cmos5l_dlygate4sd3_1_14 r0 *1 0,0
Xsg13cmos5l_dlygate4sd3_1_14 \$1997 VPWR VGND \$1993 sg13cmos5l_dlygate4sd3_1
* cell instance sg13cmos5l_dlygate4sd3_1_15 r0 *1 0,0
Xsg13cmos5l_dlygate4sd3_1_15 \$3162 VPWR VGND \$3010 sg13cmos5l_dlygate4sd3_1
* cell instance sg13cmos5l_dlygate4sd3_1_16 r0 *1 0,0
Xsg13cmos5l_dlygate4sd3_1_16 \$7801 VPWR VGND \$8174 sg13cmos5l_dlygate4sd3_1
* cell instance sg13cmos5l_dlygate4sd3_1_17 r0 *1 0,0
Xsg13cmos5l_dlygate4sd3_1_17 \$2591 VPWR VGND \$2284 sg13cmos5l_dlygate4sd3_1
* cell instance sg13cmos5l_dlygate4sd3_1_18 r0 *1 0,0
Xsg13cmos5l_dlygate4sd3_1_18 \$2142 VPWR VGND \$1819 sg13cmos5l_dlygate4sd3_1
* cell instance sg13cmos5l_dlygate4sd3_1_19 r0 *1 0,0
Xsg13cmos5l_dlygate4sd3_1_19 \$3022 VPWR VGND \$3025 sg13cmos5l_dlygate4sd3_1
* cell instance sg13cmos5l_dlygate4sd3_1_20 r0 *1 0,0
Xsg13cmos5l_dlygate4sd3_1_20 \$1820 VPWR VGND \$1818 sg13cmos5l_dlygate4sd3_1
* cell instance sg13cmos5l_dlygate4sd3_1_21 r0 *1 0,0
Xsg13cmos5l_dlygate4sd3_1_21 \$2292 VPWR VGND \$2282 sg13cmos5l_dlygate4sd3_1
* cell instance sg13cmos5l_dlygate4sd3_1_22 r0 *1 0,0
Xsg13cmos5l_dlygate4sd3_1_22 \$5100 VPWR VGND \$5104 sg13cmos5l_dlygate4sd3_1
* cell instance sg13cmos5l_dlygate4sd3_1_23 r0 *1 0,0
Xsg13cmos5l_dlygate4sd3_1_23 \$7254 VPWR VGND \$7252 sg13cmos5l_dlygate4sd3_1
* cell instance sg13cmos5l_dlygate4sd3_1_24 r0 *1 0,0
Xsg13cmos5l_dlygate4sd3_1_24 \$2846 VPWR VGND \$2721 sg13cmos5l_dlygate4sd3_1
* cell instance sg13cmos5l_dlygate4sd3_1_25 r0 *1 0,0
Xsg13cmos5l_dlygate4sd3_1_25 \$3171 VPWR VGND \$3315 sg13cmos5l_dlygate4sd3_1
* cell instance sg13cmos5l_dlygate4sd3_1_26 r0 *1 0,0
Xsg13cmos5l_dlygate4sd3_1_26 \$2731 VPWR VGND \$2599 sg13cmos5l_dlygate4sd3_1
* cell instance sg13cmos5l_dlygate4sd3_1_27 r0 *1 0,0
Xsg13cmos5l_dlygate4sd3_1_27 \$5602 VPWR VGND \$6068 sg13cmos5l_dlygate4sd3_1
* cell instance sg13cmos5l_dlygate4sd3_1_28 r0 *1 0,0
Xsg13cmos5l_dlygate4sd3_1_28 \$6365 VPWR VGND \$6066 sg13cmos5l_dlygate4sd3_1
* cell instance sg13cmos5l_dlygate4sd3_1_29 r0 *1 0,0
Xsg13cmos5l_dlygate4sd3_1_29 \$9502 VPWR VGND \$9358 sg13cmos5l_dlygate4sd3_1
* cell instance sg13cmos5l_dlygate4sd3_1_30 r0 *1 0,0
Xsg13cmos5l_dlygate4sd3_1_30 \$7584 VPWR VGND \$13835 sg13cmos5l_dlygate4sd3_1
* cell instance sg13cmos5l_dlygate4sd3_1_31 r0 *1 0,0
Xsg13cmos5l_dlygate4sd3_1_31 \$3882 VPWR VGND \$4578 sg13cmos5l_dlygate4sd3_1
* cell instance sg13cmos5l_dlygate4sd3_1_32 r0 *1 0,0
Xsg13cmos5l_dlygate4sd3_1_32 \$5099 VPWR VGND \$5254 sg13cmos5l_dlygate4sd3_1
* cell instance sg13cmos5l_dlygate4sd3_1_33 r0 *1 0,0
Xsg13cmos5l_dlygate4sd3_1_33 \$1639 VPWR VGND \$1824 sg13cmos5l_dlygate4sd3_1
* cell instance sg13cmos5l_dlygate4sd3_1_34 r0 *1 0,0
Xsg13cmos5l_dlygate4sd3_1_34 \$1823 VPWR VGND \$2005 sg13cmos5l_dlygate4sd3_1
* cell instance sg13cmos5l_dlygate4sd3_1_35 r0 *1 0,0
Xsg13cmos5l_dlygate4sd3_1_35 \$7651 VPWR VGND \$7318 sg13cmos5l_dlygate4sd3_1
* cell instance sg13cmos5l_dlygate4sd3_1_36 r0 *1 0,0
Xsg13cmos5l_dlygate4sd3_1_36 \$10172 VPWR VGND \$9956 sg13cmos5l_dlygate4sd3_1
* cell instance sg13cmos5l_dlygate4sd3_1_37 r0 *1 0,0
Xsg13cmos5l_dlygate4sd3_1_37 uio_out[6] VPWR VGND \$11604
+ sg13cmos5l_dlygate4sd3_1
* cell instance sg13cmos5l_dlygate4sd3_1_38 r0 *1 0,0
Xsg13cmos5l_dlygate4sd3_1_38 \$2734 VPWR VGND \$2737 sg13cmos5l_dlygate4sd3_1
* cell instance sg13cmos5l_dlygate4sd3_1_39 r0 *1 0,0
Xsg13cmos5l_dlygate4sd3_1_39 \$3322 VPWR VGND \$3183 sg13cmos5l_dlygate4sd3_1
* cell instance sg13cmos5l_dlygate4sd3_1_40 r0 *1 0,0
Xsg13cmos5l_dlygate4sd3_1_40 uio_out[2] VPWR VGND \$15744
+ sg13cmos5l_dlygate4sd3_1
* cell instance sg13cmos5l_dlygate4sd3_1_41 r0 *1 0,0
Xsg13cmos5l_dlygate4sd3_1_41 \$3887 VPWR VGND \$4328 sg13cmos5l_dlygate4sd3_1
* cell instance sg13cmos5l_dlygate4sd3_1_42 r0 *1 0,0
Xsg13cmos5l_dlygate4sd3_1_42 \$3182 VPWR VGND \$3187 sg13cmos5l_dlygate4sd3_1
* cell instance sg13cmos5l_dlygate4sd3_1_43 r0 *1 0,0
Xsg13cmos5l_dlygate4sd3_1_43 \$1831 VPWR VGND \$1640 sg13cmos5l_dlygate4sd3_1
* cell instance sg13cmos5l_dlygate4sd3_1_44 r0 *1 0,0
Xsg13cmos5l_dlygate4sd3_1_44 \$4126 VPWR VGND \$3885 sg13cmos5l_dlygate4sd3_1
* cell instance sg13cmos5l_dlygate4sd3_1_45 r0 *1 0,0
Xsg13cmos5l_dlygate4sd3_1_45 \$7255 VPWR VGND \$7321 sg13cmos5l_dlygate4sd3_1
* cell instance sg13cmos5l_dlygate4sd3_1_46 r0 *1 0,0
Xsg13cmos5l_dlygate4sd3_1_46 \$2598 VPWR VGND \$3323 sg13cmos5l_dlygate4sd3_1
* cell instance sg13cmos5l_dlygate4sd3_1_47 r0 *1 0,0
Xsg13cmos5l_dlygate4sd3_1_47 \$15592 VPWR VGND \$15167 sg13cmos5l_dlygate4sd3_1
* cell instance sg13cmos5l_dlygate4sd3_1_48 r0 *1 0,0
Xsg13cmos5l_dlygate4sd3_1_48 uio_out[7] VPWR VGND \$14262
+ sg13cmos5l_dlygate4sd3_1
* cell instance sg13cmos5l_dlygate4sd3_1_49 r0 *1 0,0
Xsg13cmos5l_dlygate4sd3_1_49 \$5308 VPWR VGND \$5908 sg13cmos5l_dlygate4sd3_1
* cell instance sg13cmos5l_dlygate4sd3_1_50 r0 *1 0,0
Xsg13cmos5l_dlygate4sd3_1_50 \$7332 VPWR VGND \$12641 sg13cmos5l_dlygate4sd3_1
* cell instance sg13cmos5l_dlygate4sd3_1_51 r0 *1 0,0
Xsg13cmos5l_dlygate4sd3_1_51 \$4759 VPWR VGND \$4129 sg13cmos5l_dlygate4sd3_1
* cell instance sg13cmos5l_dlygate4sd3_1_52 r0 *1 0,0
Xsg13cmos5l_dlygate4sd3_1_52 \$5116 VPWR VGND \$9352 sg13cmos5l_dlygate4sd3_1
* cell instance sg13cmos5l_dlygate4sd3_1_53 r0 *1 0,0
Xsg13cmos5l_dlygate4sd3_1_53 \$9363 VPWR VGND \$9957 sg13cmos5l_dlygate4sd3_1
* cell instance sg13cmos5l_dlygate4sd3_1_54 r0 *1 0,0
Xsg13cmos5l_dlygate4sd3_1_54 uio_out[4] VPWR VGND \$10876
+ sg13cmos5l_dlygate4sd3_1
* cell instance sg13cmos5l_dlygate4sd3_1_55 r0 *1 0,0
Xsg13cmos5l_dlygate4sd3_1_55 \$3434 VPWR VGND \$3557 sg13cmos5l_dlygate4sd3_1
* cell instance sg13cmos5l_dlygate4sd3_1_56 r0 *1 0,0
Xsg13cmos5l_dlygate4sd3_1_56 \$3722 VPWR VGND \$3888 sg13cmos5l_dlygate4sd3_1
* cell instance sg13cmos5l_dlygate4sd3_1_57 r0 *1 0,0
Xsg13cmos5l_dlygate4sd3_1_57 uio_out[3] VPWR VGND \$11897
+ sg13cmos5l_dlygate4sd3_1
* cell instance sg13cmos5l_dlygate4sd3_1_58 r0 *1 0,0
Xsg13cmos5l_dlygate4sd3_1_58 \$5115 VPWR VGND \$5334 sg13cmos5l_dlygate4sd3_1
* cell instance sg13cmos5l_dlygate4sd3_1_59 r0 *1 0,0
Xsg13cmos5l_dlygate4sd3_1_59 \$3899 VPWR VGND \$3726 sg13cmos5l_dlygate4sd3_1
* cell instance sg13cmos5l_dlygate4sd3_1_60 r0 *1 0,0
Xsg13cmos5l_dlygate4sd3_1_60 \$5190 VPWR VGND \$5107 sg13cmos5l_dlygate4sd3_1
* cell instance sg13cmos5l_dlygate4sd3_1_61 r0 *1 0,0
Xsg13cmos5l_dlygate4sd3_1_61 \$7014 VPWR VGND \$7325 sg13cmos5l_dlygate4sd3_1
* cell instance sg13cmos5l_dlygate4sd3_1_62 r0 *1 0,0
Xsg13cmos5l_dlygate4sd3_1_62 \$14184 VPWR VGND \$13749 sg13cmos5l_dlygate4sd3_1
* cell instance sg13cmos5l_dlygate4sd3_1_63 r0 *1 0,0
Xsg13cmos5l_dlygate4sd3_1_63 \$3569 VPWR VGND \$3437 sg13cmos5l_dlygate4sd3_1
* cell instance sg13cmos5l_dlygate4sd3_1_64 r0 *1 0,0
Xsg13cmos5l_dlygate4sd3_1_64 \$4342 VPWR VGND \$3717 sg13cmos5l_dlygate4sd3_1
* cell instance sg13cmos5l_dlygate4sd3_1_65 r0 *1 0,0
Xsg13cmos5l_dlygate4sd3_1_65 \$7586 VPWR VGND \$12873 sg13cmos5l_dlygate4sd3_1
* cell instance sg13cmos5l_dlygate4sd3_1_66 r0 *1 0,0
Xsg13cmos5l_dlygate4sd3_1_66 \$3573 VPWR VGND \$3438 sg13cmos5l_dlygate4sd3_1
* cell instance sg13cmos5l_dlygate4sd3_1_67 r0 *1 0,0
Xsg13cmos5l_dlygate4sd3_1_67 \$5117 VPWR VGND \$4774 sg13cmos5l_dlygate4sd3_1
* cell instance sg13cmos5l_dlygate4sd3_1_68 r0 *1 0,0
Xsg13cmos5l_dlygate4sd3_1_68 \$3906 VPWR VGND \$4134 sg13cmos5l_dlygate4sd3_1
* cell instance sg13cmos5l_dlygate4sd3_1_69 r0 *1 0,0
Xsg13cmos5l_dlygate4sd3_1_69 \$7888 VPWR VGND \$8923 sg13cmos5l_dlygate4sd3_1
* cell instance sg13cmos5l_dlygate4sd3_1_70 r0 *1 0,0
Xsg13cmos5l_dlygate4sd3_1_70 \$10716 VPWR VGND \$11315 sg13cmos5l_dlygate4sd3_1
* cell instance sg13cmos5l_dlygate4sd3_1_71 r0 *1 0,0
Xsg13cmos5l_dlygate4sd3_1_71 uio_out[5] VPWR VGND \$16816
+ sg13cmos5l_dlygate4sd3_1
* cell instance sg13cmos5l_dlygate4sd3_1_72 r0 *1 0,0
Xsg13cmos5l_dlygate4sd3_1_72 \$11314 VPWR VGND \$11899 sg13cmos5l_dlygate4sd3_1
* cell instance sg13cmos5l_dlygate4sd3_1_73 r0 *1 0,0
Xsg13cmos5l_dlygate4sd3_1_73 \$6713 VPWR VGND \$7015 sg13cmos5l_dlygate4sd3_1
* cell instance sg13cmos5l_dlygate4sd3_1_74 r0 *1 0,0
Xsg13cmos5l_dlygate4sd3_1_74 \$15599 VPWR VGND \$16187 sg13cmos5l_dlygate4sd3_1
* cell instance sg13cmos5l_dlygate4sd3_1_75 r0 *1 0,0
Xsg13cmos5l_dlygate4sd3_1_75 \$3903 VPWR VGND \$3905 sg13cmos5l_dlygate4sd3_1
* cell instance sg13cmos5l_dlygate4sd3_1_76 r0 *1 0,0
Xsg13cmos5l_dlygate4sd3_1_76 \$14704 VPWR VGND \$14269 sg13cmos5l_dlygate4sd3_1
* cell instance sg13cmos5l_dlygate4sd3_1_77 r0 *1 0,0
Xsg13cmos5l_dlygate4sd3_1_77 \$6204 VPWR VGND \$5910 sg13cmos5l_dlygate4sd3_1
* cell instance sg13cmos5l_dlygate4sd3_1_78 r0 *1 0,0
Xsg13cmos5l_dlygate4sd3_1_78 \$5622 VPWR VGND \$5337 sg13cmos5l_dlygate4sd3_1
* cell instance sg13cmos5l_dlygate4sd3_1_79 r0 *1 0,0
Xsg13cmos5l_dlygate4sd3_1_79 \$9794 VPWR VGND \$10286 sg13cmos5l_dlygate4sd3_1
* cell instance sg13cmos5l_dlygate4sd3_1_80 r0 *1 0,0
Xsg13cmos5l_dlygate4sd3_1_80 \$5270 VPWR VGND \$5203 sg13cmos5l_dlygate4sd3_1
* cell instance sg13cmos5l_dlygate4sd3_1_81 r0 *1 0,0
Xsg13cmos5l_dlygate4sd3_1_81 \$5612 VPWR VGND \$5344 sg13cmos5l_dlygate4sd3_1
* cell instance sg13cmos5l_dlygate4sd3_1_82 r0 *1 0,0
Xsg13cmos5l_dlygate4sd3_1_82 \$3912 VPWR VGND \$3733 sg13cmos5l_dlygate4sd3_1
* cell instance sg13cmos5l_dlygate4sd3_1_83 r0 *1 0,0
Xsg13cmos5l_dlygate4sd3_1_83 \$5233 VPWR VGND \$5126 sg13cmos5l_dlygate4sd3_1
* cell instance sg13cmos5l_dlygate4sd3_1_84 r0 *1 0,0
Xsg13cmos5l_dlygate4sd3_1_84 \$2743 VPWR VGND \$2881 sg13cmos5l_dlygate4sd3_1
* cell instance sg13cmos5l_dlygate4sd3_1_85 r0 *1 0,0
Xsg13cmos5l_dlygate4sd3_1_85 \$5250 VPWR VGND \$5208 sg13cmos5l_dlygate4sd3_1
* cell instance sg13cmos5l_dlygate4sd3_1_86 r0 *1 0,0
Xsg13cmos5l_dlygate4sd3_1_86 \$6408 VPWR VGND \$13362 sg13cmos5l_dlygate4sd3_1
* cell instance sg13cmos5l_dlygate4sd3_1_87 r0 *1 0,0
Xsg13cmos5l_dlygate4sd3_1_87 \$6572 VPWR VGND \$6568 sg13cmos5l_dlygate4sd3_1
* cell instance sg13cmos5l_dlygate4sd3_1_88 r0 *1 0,0
Xsg13cmos5l_dlygate4sd3_1_88 \$6211 VPWR VGND \$9368 sg13cmos5l_dlygate4sd3_1
* cell instance sg13cmos5l_dlygate4sd3_1_89 r0 *1 0,0
Xsg13cmos5l_dlygate4sd3_1_89 \$4362 VPWR VGND \$10289 sg13cmos5l_dlygate4sd3_1
* cell instance sg13cmos5l_dlygate4sd3_1_90 r0 *1 0,0
Xsg13cmos5l_dlygate4sd3_1_90 \$11763 VPWR VGND \$12351 sg13cmos5l_dlygate4sd3_1
* cell instance sg13cmos5l_dlygate4sd3_1_91 r0 *1 0,0
Xsg13cmos5l_dlygate4sd3_1_91 \$3419 VPWR VGND \$12874 sg13cmos5l_dlygate4sd3_1
* cell instance sg13cmos5l_dlygate4sd3_1_92 r0 *1 0,0
Xsg13cmos5l_dlygate4sd3_1_92 \$5199 VPWR VGND \$5212 sg13cmos5l_dlygate4sd3_1
* cell instance sg13cmos5l_dlygate4sd3_1_93 r0 *1 0,0
Xsg13cmos5l_dlygate4sd3_1_93 \$5256 VPWR VGND \$5213 sg13cmos5l_dlygate4sd3_1
* cell instance sg13cmos5l_dlygate4sd3_1_94 r0 *1 0,0
Xsg13cmos5l_dlygate4sd3_1_94 \$10292 VPWR VGND \$11317 sg13cmos5l_dlygate4sd3_1
* cell instance sg13cmos5l_dlygate4sd3_1_95 r0 *1 0,0
Xsg13cmos5l_dlygate4sd3_1_95 uio_out[0] VPWR VGND \$16818
+ sg13cmos5l_dlygate4sd3_1
* cell instance sg13cmos5l_dlygate4sd3_1_96 r0 *1 0,0
Xsg13cmos5l_dlygate4sd3_1_96 \$15176 VPWR VGND \$16295 sg13cmos5l_dlygate4sd3_1
* cell instance sg13cmos5l_dlygate4sd3_1_97 r0 *1 0,0
Xsg13cmos5l_dlygate4sd3_1_97 \$5630 VPWR VGND \$5491 sg13cmos5l_dlygate4sd3_1
* cell instance sg13cmos5l_dlygate4sd3_1_98 r0 *1 0,0
Xsg13cmos5l_dlygate4sd3_1_98 uio_out[1] VPWR VGND \$13942
+ sg13cmos5l_dlygate4sd3_1
* cell instance sg13cmos5l_dlygate4sd3_1_99 r0 *1 0,0
Xsg13cmos5l_dlygate4sd3_1_99 \$4787 VPWR VGND \$4601 sg13cmos5l_dlygate4sd3_1
* cell instance sg13cmos5l_dlygate4sd3_1_100 r0 *1 0,0
Xsg13cmos5l_dlygate4sd3_1_100 \$4146 VPWR VGND \$4149 sg13cmos5l_dlygate4sd3_1
* cell instance sg13cmos5l_dlygate4sd3_1_101 r0 *1 0,0
Xsg13cmos5l_dlygate4sd3_1_101 \$3581 VPWR VGND \$3583 sg13cmos5l_dlygate4sd3_1
* cell instance sg13cmos5l_dlygate4sd3_1_102 r0 *1 0,0
Xsg13cmos5l_dlygate4sd3_1_102 \$5176 VPWR VGND \$4796 sg13cmos5l_dlygate4sd3_1
* cell instance sg13cmos5l_dlygate4sd3_1_103 r0 *1 0,0
Xsg13cmos5l_dlygate4sd3_1_103 \$3736 VPWR VGND \$3582 sg13cmos5l_dlygate4sd3_1
* cell instance sg13cmos5l_dlygate4sd3_1_104 r0 *1 0,0
Xsg13cmos5l_dlygate4sd3_1_104 \$3917 VPWR VGND \$3922 sg13cmos5l_dlygate4sd3_1
* cell instance sg13cmos5l_dlygate4sd3_1_105 r0 *1 0,0
Xsg13cmos5l_dlygate4sd3_1_105 \$2748 VPWR VGND \$3062 sg13cmos5l_dlygate4sd3_1
* cell instance sg13cmos5l_dlygate4sd3_1_106 r0 *1 0,0
Xsg13cmos5l_dlygate4sd3_1_106 \$3745 VPWR VGND \$3734 sg13cmos5l_dlygate4sd3_1
* cell instance sg13cmos5l_dlygate4sd3_1_107 r0 *1 0,0
Xsg13cmos5l_dlygate4sd3_1_107 \$4577 VPWR VGND \$4801 sg13cmos5l_dlygate4sd3_1
* cell instance sg13cmos5l_dlygate4sd3_1_108 r0 *1 0,0
Xsg13cmos5l_dlygate4sd3_1_108 \$3751 VPWR VGND \$3739 sg13cmos5l_dlygate4sd3_1
* cell instance sg13cmos5l_dlygate4sd3_1_109 r0 *1 0,0
Xsg13cmos5l_dlygate4sd3_1_109 \$4130 VPWR VGND \$4805 sg13cmos5l_dlygate4sd3_1
* cell instance sg13cmos5l_dlygate4sd3_1_110 r0 *1 0,0
Xsg13cmos5l_dlygate4sd3_1_110 \$4374 VPWR VGND \$4386 sg13cmos5l_dlygate4sd3_1
* cell instance sg13cmos5l_dlygate4sd3_1_111 r0 *1 0,0
Xsg13cmos5l_dlygate4sd3_1_111 \$4327 VPWR VGND \$4813 sg13cmos5l_dlygate4sd3_1
* cell instance sg13cmos5l_dlygate4sd3_1_112 r0 *1 0,0
Xsg13cmos5l_dlygate4sd3_1_112 \$3937 VPWR VGND \$4160 sg13cmos5l_dlygate4sd3_1
* cell instance sg13cmos5l_dlygate4sd3_1_113 r0 *1 0,0
Xsg13cmos5l_dlygate4sd3_1_113 \$2900 VPWR VGND \$2904 sg13cmos5l_dlygate4sd3_1
* cell instance sg13cmos5l_dlygate4sd3_1_114 r0 *1 0,0
Xsg13cmos5l_dlygate4sd3_1_114 \$3938 VPWR VGND \$3752 sg13cmos5l_dlygate4sd3_1
* cell instance sg13cmos5l_dlygate4sd3_1_115 r0 *1 0,0
Xsg13cmos5l_dlygate4sd3_1_115 \$2625 VPWR VGND \$2557 sg13cmos5l_dlygate4sd3_1
* cell instance sg13cmos5l_dlygate4sd3_1_116 r0 *1 0,0
Xsg13cmos5l_dlygate4sd3_1_116 \$2465 VPWR VGND \$2630 sg13cmos5l_dlygate4sd3_1
* cell instance sg13cmos5l_dlygate4sd3_1_117 r0 *1 0,0
Xsg13cmos5l_dlygate4sd3_1_117 \$3949 VPWR VGND \$4393 sg13cmos5l_dlygate4sd3_1
* cell instance sg13cmos5l_dlygate4sd3_1_118 r0 *1 0,0
Xsg13cmos5l_dlygate4sd3_1_118 \$3931 VPWR VGND \$3759 sg13cmos5l_dlygate4sd3_1
* cell instance sg13cmos5l_dlygate4sd3_1_119 r0 *1 0,0
Xsg13cmos5l_dlygate4sd3_1_119 \$4567 VPWR VGND \$4834 sg13cmos5l_dlygate4sd3_1
* cell instance sg13cmos5l_dlygate4sd3_1_120 r0 *1 0,0
Xsg13cmos5l_dlygate4sd3_1_120 \$3605 VPWR VGND \$3555 sg13cmos5l_dlygate4sd3_1
* cell instance sg13cmos5l_dlygate4sd3_1_121 r0 *1 0,0
Xsg13cmos5l_dlygate4sd3_1_121 \$2921 VPWR VGND \$2756 sg13cmos5l_dlygate4sd3_1
* cell instance sg13cmos5l_dlygate4sd3_1_122 r0 *1 0,0
Xsg13cmos5l_dlygate4sd3_1_122 \$2329 VPWR VGND \$2325 sg13cmos5l_dlygate4sd3_1
* cell instance sg13cmos5l_dlygate4sd3_1_123 r0 *1 0,0
Xsg13cmos5l_dlygate4sd3_1_123 \$3068 VPWR VGND \$3225 sg13cmos5l_dlygate4sd3_1
* cell instance sg13cmos5l_dlygate4sd3_1_124 r0 *1 0,0
Xsg13cmos5l_dlygate4sd3_1_124 \$1694 VPWR VGND \$2049 sg13cmos5l_dlygate4sd3_1
* cell instance sg13cmos5l_dlygate4sd3_1_125 r0 *1 0,0
Xsg13cmos5l_dlygate4sd3_1_125 \$2758 VPWR VGND \$3616 sg13cmos5l_dlygate4sd3_1
* cell instance sg13cmos5l_dlygate4sd3_1_126 r0 *1 0,0
Xsg13cmos5l_dlygate4sd3_1_126 \$4182 VPWR VGND \$3961 sg13cmos5l_dlygate4sd3_1
* cell instance sg13cmos5l_dlygate4sd3_1_127 r0 *1 0,0
Xsg13cmos5l_dlygate4sd3_1_127 \$3785 VPWR VGND \$3612 sg13cmos5l_dlygate4sd3_1
* cell instance sg13cmos5l_dlygate4sd3_1_128 r0 *1 0,0
Xsg13cmos5l_dlygate4sd3_1_128 \$3973 VPWR VGND \$4901 sg13cmos5l_dlygate4sd3_1
* cell instance sg13cmos5l_dlygate4sd3_1_129 r0 *1 0,0
Xsg13cmos5l_dlygate4sd3_1_129 \$3971 VPWR VGND \$4630 sg13cmos5l_dlygate4sd3_1
* cell instance sg13cmos5l_dlygate4sd3_1_130 r0 *1 0,0
Xsg13cmos5l_dlygate4sd3_1_130 \$4196 VPWR VGND \$3963 sg13cmos5l_dlygate4sd3_1
* cell instance sg13cmos5l_dlygate4sd3_1_131 r0 *1 0,0
Xsg13cmos5l_dlygate4sd3_1_131 \$4398 VPWR VGND \$4426 sg13cmos5l_dlygate4sd3_1
* cell instance sg13cmos5l_dlygate4sd3_1_132 r0 *1 0,0
Xsg13cmos5l_dlygate4sd3_1_132 \$3975 VPWR VGND \$4308 sg13cmos5l_dlygate4sd3_1
* cell instance sg13cmos5l_dlygate4sd3_1_133 r0 *1 0,0
Xsg13cmos5l_dlygate4sd3_1_133 \$3977 VPWR VGND \$4638 sg13cmos5l_dlygate4sd3_1
* cell instance sg13cmos5l_dlygate4sd3_1_134 r0 *1 0,0
Xsg13cmos5l_dlygate4sd3_1_134 \$3962 VPWR VGND \$4649 sg13cmos5l_dlygate4sd3_1
* cell instance sg13cmos5l_dlygate4sd3_1_135 r0 *1 0,0
Xsg13cmos5l_dlygate4sd3_1_135 \$3978 VPWR VGND \$4912 sg13cmos5l_dlygate4sd3_1
* cell instance sg13cmos5l_dlygate4sd3_1_136 r0 *1 0,0
Xsg13cmos5l_dlygate4sd3_1_136 \$3980 VPWR VGND \$4914 sg13cmos5l_dlygate4sd3_1
* cell instance sg13cmos5l_dlygate4sd3_1_137 r0 *1 0,0
Xsg13cmos5l_dlygate4sd3_1_137 \$3983 VPWR VGND \$4650 sg13cmos5l_dlygate4sd3_1
* cell instance sg13cmos5l_dlygate4sd3_1_138 r0 *1 0,0
Xsg13cmos5l_dlygate4sd3_1_138 \$3981 VPWR VGND \$4920 sg13cmos5l_dlygate4sd3_1
* cell instance sg13cmos5l_dlygate4sd3_1_139 r0 *1 0,0
Xsg13cmos5l_dlygate4sd3_1_139 \$4441 VPWR VGND \$4442 sg13cmos5l_dlygate4sd3_1
* cell instance sg13cmos5l_dlygate4sd3_1_140 r0 *1 0,0
Xsg13cmos5l_dlygate4sd3_1_140 \$3990 VPWR VGND \$3979 sg13cmos5l_dlygate4sd3_1
* cell instance sg13cmos5l_dlygate4sd3_1_141 r0 *1 0,0
Xsg13cmos5l_dlygate4sd3_1_141 \$3806 VPWR VGND \$3982 sg13cmos5l_dlygate4sd3_1
* cell instance sg13cmos5l_dlygate4sd3_1_142 r0 *1 0,0
Xsg13cmos5l_dlygate4sd3_1_142 \$3994 VPWR VGND \$3984 sg13cmos5l_dlygate4sd3_1
* cell instance sg13cmos5l_dlygate4sd3_1_143 r0 *1 0,0
Xsg13cmos5l_dlygate4sd3_1_143 \$4440 VPWR VGND \$4230 sg13cmos5l_dlygate4sd3_1
* cell instance sg13cmos5l_dlygate4sd3_1_144 r0 *1 0,0
Xsg13cmos5l_dlygate4sd3_1_144 \$1905 VPWR VGND \$2082 sg13cmos5l_dlygate4sd3_1
* cell instance sg13cmos5l_dlygate4sd3_1_145 r0 *1 0,0
Xsg13cmos5l_dlygate4sd3_1_145 \$4463 VPWR VGND \$4223 sg13cmos5l_dlygate4sd3_1
* cell instance sg13cmos5l_dlygate4sd3_1_146 r0 *1 0,0
Xsg13cmos5l_dlygate4sd3_1_146 \$3814 VPWR VGND \$3809 sg13cmos5l_dlygate4sd3_1
* cell instance sg13cmos5l_dlygate4sd3_1_147 r0 *1 0,0
Xsg13cmos5l_dlygate4sd3_1_147 \$1543 VPWR VGND \$1725 sg13cmos5l_dlygate4sd3_1
* cell instance sg13cmos5l_dlygate4sd3_1_148 r0 *1 0,0
Xsg13cmos5l_dlygate4sd3_1_148 \$5078 VPWR VGND \$4961 sg13cmos5l_dlygate4sd3_1
* cell instance sg13cmos5l_dlygate4sd3_1_149 r0 *1 0,0
Xsg13cmos5l_dlygate4sd3_1_149 \$4668 VPWR VGND \$4199 sg13cmos5l_dlygate4sd3_1
* cell instance sg13cmos5l_dlygate4sd3_1_150 r0 *1 0,0
Xsg13cmos5l_dlygate4sd3_1_150 \$3819 VPWR VGND \$3714 sg13cmos5l_dlygate4sd3_1
* cell instance sg13cmos5l_dlygate4sd3_1_151 r0 *1 0,0
Xsg13cmos5l_dlygate4sd3_1_151 \$4005 VPWR VGND \$3632 sg13cmos5l_dlygate4sd3_1
* cell instance sg13cmos5l_dlygate4sd3_1_152 r0 *1 0,0
Xsg13cmos5l_dlygate4sd3_1_152 \$2207 VPWR VGND \$2213 sg13cmos5l_dlygate4sd3_1
* cell instance sg13cmos5l_dlygate4sd3_1_153 r0 *1 0,0
Xsg13cmos5l_dlygate4sd3_1_153 \$4039 VPWR VGND \$3974 sg13cmos5l_dlygate4sd3_1
* cell instance sg13cmos5l_dlygate4sd3_1_154 r0 *1 0,0
Xsg13cmos5l_dlygate4sd3_1_154 \$4241 VPWR VGND \$3976 sg13cmos5l_dlygate4sd3_1
* cell instance sg13cmos5l_dlygate4sd3_1_155 r0 *1 0,0
Xsg13cmos5l_dlygate4sd3_1_155 \$5130 VPWR VGND \$4977 sg13cmos5l_dlygate4sd3_1
* cell instance sg13cmos5l_dlygate4sd3_1_156 r0 *1 0,0
Xsg13cmos5l_dlygate4sd3_1_156 \$3827 VPWR VGND \$3815 sg13cmos5l_dlygate4sd3_1
* cell instance sg13cmos5l_dlygate4sd3_1_157 r0 *1 0,0
Xsg13cmos5l_dlygate4sd3_1_157 \$4245 VPWR VGND \$3972 sg13cmos5l_dlygate4sd3_1
* cell instance sg13cmos5l_dlygate4sd3_1_158 r0 *1 0,0
Xsg13cmos5l_dlygate4sd3_1_158 \$3640 VPWR VGND \$4006 sg13cmos5l_dlygate4sd3_1
* cell instance sg13cmos5l_dlygate4sd3_1_159 r0 *1 0,0
Xsg13cmos5l_dlygate4sd3_1_159 \$4477 VPWR VGND \$4233 sg13cmos5l_dlygate4sd3_1
* cell instance sg13cmos5l_dlygate4sd3_1_160 r0 *1 0,0
Xsg13cmos5l_dlygate4sd3_1_160 \$4020 VPWR VGND \$4007 sg13cmos5l_dlygate4sd3_1
* cell instance sg13cmos5l_dlygate4sd3_1_161 r0 *1 0,0
Xsg13cmos5l_dlygate4sd3_1_161 \$1229 VPWR VGND \$1382 sg13cmos5l_dlygate4sd3_1
* cell instance sg13cmos5l_dlygate4sd3_1_162 r0 *1 0,0
Xsg13cmos5l_dlygate4sd3_1_162 \$4488 VPWR VGND \$4675 sg13cmos5l_dlygate4sd3_1
* cell instance sg13cmos5l_dlygate4sd3_1_163 r0 *1 0,0
Xsg13cmos5l_dlygate4sd3_1_163 \$1753 VPWR VGND \$1551 sg13cmos5l_dlygate4sd3_1
* cell instance sg13cmos5l_dlygate4sd3_1_164 r0 *1 0,0
Xsg13cmos5l_dlygate4sd3_1_164 \$4679 VPWR VGND \$5001 sg13cmos5l_dlygate4sd3_1
* cell instance sg13cmos5l_dlygate4sd3_1_165 r0 *1 0,0
Xsg13cmos5l_dlygate4sd3_1_165 \$4492 VPWR VGND \$4493 sg13cmos5l_dlygate4sd3_1
* cell instance sg13cmos5l_dlygate4sd3_1_166 r0 *1 0,0
Xsg13cmos5l_dlygate4sd3_1_166 \$1118 VPWR VGND \$1236 sg13cmos5l_dlygate4sd3_1
* cell instance sg13cmos5l_dlygate4sd3_1_167 r0 *1 0,0
Xsg13cmos5l_dlygate4sd3_1_167 \$1745 VPWR VGND \$2677 sg13cmos5l_dlygate4sd3_1
* cell instance sg13cmos5l_dlygate4sd3_1_168 r0 *1 0,0
Xsg13cmos5l_dlygate4sd3_1_168 \$3653 VPWR VGND \$3834 sg13cmos5l_dlygate4sd3_1
* cell instance sg13cmos5l_dlygate4sd3_1_169 r0 *1 0,0
Xsg13cmos5l_dlygate4sd3_1_169 \$1564 VPWR VGND \$1232 sg13cmos5l_dlygate4sd3_1
* cell instance sg13cmos5l_dlygate4sd3_1_170 r0 *1 0,0
Xsg13cmos5l_dlygate4sd3_1_170 \$2226 VPWR VGND \$2368 sg13cmos5l_dlygate4sd3_1
* cell instance sg13cmos5l_dlygate4sd3_1_171 r0 *1 0,0
Xsg13cmos5l_dlygate4sd3_1_171 \$2680 VPWR VGND \$2678 sg13cmos5l_dlygate4sd3_1
* cell instance sg13cmos5l_dlygate4sd3_1_172 r0 *1 0,0
Xsg13cmos5l_dlygate4sd3_1_172 \$4263 VPWR VGND \$4259 sg13cmos5l_dlygate4sd3_1
* cell instance sg13cmos5l_dlygate4sd3_1_173 r0 *1 0,0
Xsg13cmos5l_dlygate4sd3_1_173 \$1400 VPWR VGND \$1243 sg13cmos5l_dlygate4sd3_1
* cell instance sg13cmos5l_dlygate4sd3_1_174 r0 *1 0,0
Xsg13cmos5l_dlygate4sd3_1_174 \$1139 VPWR VGND \$1026 sg13cmos5l_dlygate4sd3_1
* cell instance sg13cmos5l_dlygate4sd3_1_175 r0 *1 0,0
Xsg13cmos5l_dlygate4sd3_1_175 \$2965 VPWR VGND \$3123 sg13cmos5l_dlygate4sd3_1
* cell instance sg13cmos5l_dlygate4sd3_1_176 r0 *1 0,0
Xsg13cmos5l_dlygate4sd3_1_176 \$1915 VPWR VGND \$4257 sg13cmos5l_dlygate4sd3_1
* cell instance sg13cmos5l_dlygate4sd3_1_177 r0 *1 0,0
Xsg13cmos5l_dlygate4sd3_1_177 \$1935 VPWR VGND \$1757 sg13cmos5l_dlygate4sd3_1
* cell instance sg13cmos5l_dlygate4sd3_1_178 r0 *1 0,0
Xsg13cmos5l_dlygate4sd3_1_178 \$1583 VPWR VGND \$1571 sg13cmos5l_dlygate4sd3_1
* cell instance sg13cmos5l_dlygate4sd3_1_179 r0 *1 0,0
Xsg13cmos5l_dlygate4sd3_1_179 \$4491 VPWR VGND \$4681 sg13cmos5l_dlygate4sd3_1
* cell instance sg13cmos5l_dlygate4sd3_1_180 r0 *1 0,0
Xsg13cmos5l_dlygate4sd3_1_180 \$3845 VPWR VGND \$3839 sg13cmos5l_dlygate4sd3_1
* cell instance sg13cmos5l_dlygate4sd3_1_181 r0 *1 0,0
Xsg13cmos5l_dlygate4sd3_1_181 \$3676 VPWR VGND \$3533 sg13cmos5l_dlygate4sd3_1
* cell instance sg13cmos5l_dlygate4sd3_1_182 r0 *1 0,0
Xsg13cmos5l_dlygate4sd3_1_182 \$2382 VPWR VGND \$2231 sg13cmos5l_dlygate4sd3_1
* cell instance sg13cmos5l_dlygate4sd3_1_183 r0 *1 0,0
Xsg13cmos5l_dlygate4sd3_1_183 \$1584 VPWR VGND \$1585 sg13cmos5l_dlygate4sd3_1
* cell instance sg13cmos5l_dlygate4sd3_1_184 r0 *1 0,0
Xsg13cmos5l_dlygate4sd3_1_184 \$1270 VPWR VGND \$1404 sg13cmos5l_dlygate4sd3_1
* cell instance sg13cmos5l_dlygate4sd3_1_185 r0 *1 0,0
Xsg13cmos5l_dlygate4sd3_1_185 \$4050 VPWR VGND \$4512 sg13cmos5l_dlygate4sd3_1
* cell instance sg13cmos5l_dlygate4sd3_1_186 r0 *1 0,0
Xsg13cmos5l_dlygate4sd3_1_186 \$5207 VPWR VGND \$5020 sg13cmos5l_dlygate4sd3_1
* cell instance sg13cmos5l_dlygate4sd3_1_187 r0 *1 0,0
Xsg13cmos5l_dlygate4sd3_1_187 \$2383 VPWR VGND \$2687 sg13cmos5l_dlygate4sd3_1
* cell instance sg13cmos5l_dlygate4sd3_1_188 r0 *1 0,0
Xsg13cmos5l_dlygate4sd3_1_188 \$3165 VPWR VGND \$3137 sg13cmos5l_dlygate4sd3_1
* cell instance sg13cmos5l_dlygate4sd3_1_189 r0 *1 0,0
Xsg13cmos5l_dlygate4sd3_1_189 \$3248 VPWR VGND \$3265 sg13cmos5l_dlygate4sd3_1
* cell instance sg13cmos5l_dlygate4sd3_1_190 r0 *1 0,0
Xsg13cmos5l_dlygate4sd3_1_190 \$3689 VPWR VGND \$3535 sg13cmos5l_dlygate4sd3_1
* cell instance sg13cmos5l_dlygate4sd3_1_191 r0 *1 0,0
Xsg13cmos5l_dlygate4sd3_1_191 \$2103 VPWR VGND \$3854 sg13cmos5l_dlygate4sd3_1
* cell instance sg13cmos5l_dlygate4sd3_1_192 r0 *1 0,0
Xsg13cmos5l_dlygate4sd3_1_192 \$1271 VPWR VGND \$1144 sg13cmos5l_dlygate4sd3_1
* cell instance sg13cmos5l_dlygate4sd3_1_193 r0 *1 0,0
Xsg13cmos5l_dlygate4sd3_1_193 \$1785 VPWR VGND \$1943 sg13cmos5l_dlygate4sd3_1
* cell instance sg13cmos5l_dlygate4sd3_1_194 r0 *1 0,0
Xsg13cmos5l_dlygate4sd3_1_194 \$1592 VPWR VGND \$1408 sg13cmos5l_dlygate4sd3_1
* cell instance sg13cmos5l_dlygate4sd3_1_195 r0 *1 0,0
Xsg13cmos5l_dlygate4sd3_1_195 \$3398 VPWR VGND \$3130 sg13cmos5l_dlygate4sd3_1
* cell instance sg13cmos5l_dlygate4sd3_1_196 r0 *1 0,0
Xsg13cmos5l_dlygate4sd3_1_196 \$3858 VPWR VGND \$3544 sg13cmos5l_dlygate4sd3_1
* cell instance sg13cmos5l_dlygate4sd3_1_197 r0 *1 0,0
Xsg13cmos5l_dlygate4sd3_1_197 \$2236 VPWR VGND \$2570 sg13cmos5l_dlygate4sd3_1
* cell instance sg13cmos5l_dlygate4sd3_1_198 r0 *1 0,0
Xsg13cmos5l_dlygate4sd3_1_198 \$4057 VPWR VGND \$3847 sg13cmos5l_dlygate4sd3_1
* cell instance sg13cmos5l_dlygate4sd3_1_199 r0 *1 0,0
Xsg13cmos5l_dlygate4sd3_1_199 \$1601 VPWR VGND \$1598 sg13cmos5l_dlygate4sd3_1
* cell instance sg13cmos5l_dlygate4sd3_1_200 r0 *1 0,0
Xsg13cmos5l_dlygate4sd3_1_200 \$2819 VPWR VGND \$3140 sg13cmos5l_dlygate4sd3_1
* cell instance sg13cmos5l_dlygate4sd3_1_201 r0 *1 0,0
Xsg13cmos5l_dlygate4sd3_1_201 \$5053 VPWR VGND \$4709 sg13cmos5l_dlygate4sd3_1
* cell instance sg13cmos5l_dlygate4sd3_1_202 r0 *1 0,0
Xsg13cmos5l_dlygate4sd3_1_202 \$3862 VPWR VGND \$3691 sg13cmos5l_dlygate4sd3_1
* cell instance sg13cmos5l_dlygate4sd3_1_203 r0 *1 0,0
Xsg13cmos5l_dlygate4sd3_1_203 \$7256 VPWR VGND \$5284 sg13cmos5l_dlygate4sd3_1
* cell instance sg13cmos5l_dlygate4sd3_1_204 r0 *1 0,0
Xsg13cmos5l_dlygate4sd3_1_204 \$5833 VPWR VGND \$5313 sg13cmos5l_dlygate4sd3_1
* cell instance sg13cmos5l_dlygate4sd3_1_205 r0 *1 0,0
Xsg13cmos5l_dlygate4sd3_1_205 \$2961 VPWR VGND \$2823 sg13cmos5l_dlygate4sd3_1
* cell instance sg13cmos5l_dlygate4sd3_1_206 r0 *1 0,0
Xsg13cmos5l_dlygate4sd3_1_206 \$3694 VPWR VGND \$3692 sg13cmos5l_dlygate4sd3_1
* cell instance sg13cmos5l_dlygate4sd3_1_207 r0 *1 0,0
Xsg13cmos5l_dlygate4sd3_1_207 \$3865 VPWR VGND \$3869 sg13cmos5l_dlygate4sd3_1
* cell instance sg13cmos5l_dlygate4sd3_1_208 r0 *1 0,0
Xsg13cmos5l_dlygate4sd3_1_208 \$5141 VPWR VGND \$5135 sg13cmos5l_dlygate4sd3_1
* cell instance sg13cmos5l_dlygate4sd3_1_209 r0 *1 0,0
Xsg13cmos5l_dlygate4sd3_1_209 \$5052 VPWR VGND \$5068 sg13cmos5l_dlygate4sd3_1
* cell instance sg13cmos5l_dlygate4sd3_1_210 r0 *1 0,0
Xsg13cmos5l_dlygate4sd3_1_210 \$4287 VPWR VGND \$4291 sg13cmos5l_dlygate4sd3_1
* cell instance sg13cmos5l_dlygate4sd3_1_211 r0 *1 0,0
Xsg13cmos5l_dlygate4sd3_1_211 \$4715 VPWR VGND \$4719 sg13cmos5l_dlygate4sd3_1
* cell instance sg13cmos5l_dlygate4sd3_1_212 r0 *1 0,0
Xsg13cmos5l_dlygate4sd3_1_212 \$4525 VPWR VGND \$4281 sg13cmos5l_dlygate4sd3_1
* cell instance sg13cmos5l_dlygate4sd3_1_213 r0 *1 0,0
Xsg13cmos5l_dlygate4sd3_1_213 \$2233 VPWR VGND \$2402 sg13cmos5l_dlygate4sd3_1
* cell instance sg13cmos5l_dlygate4sd3_1_214 r0 *1 0,0
Xsg13cmos5l_dlygate4sd3_1_214 \$5069 VPWR VGND \$5073 sg13cmos5l_dlygate4sd3_1
* cell instance sg13cmos5l_dlygate4sd3_1_215 r0 *1 0,0
Xsg13cmos5l_dlygate4sd3_1_215 \$1622 VPWR VGND \$1422 sg13cmos5l_dlygate4sd3_1
* cell instance sg13cmos5l_dlygate4sd3_1_216 r0 *1 0,0
Xsg13cmos5l_dlygate4sd3_1_216 \$1788 VPWR VGND \$1797 sg13cmos5l_dlygate4sd3_1
* cell instance sg13cmos5l_dlygate4sd3_1_217 r0 *1 0,0
Xsg13cmos5l_dlygate4sd3_1_217 \$2971 VPWR VGND \$2989 sg13cmos5l_dlygate4sd3_1
* cell instance sg13cmos5l_dlygate4sd3_1_218 r0 *1 0,0
Xsg13cmos5l_dlygate4sd3_1_218 \$2817 VPWR VGND \$2704 sg13cmos5l_dlygate4sd3_1
* cell instance sg13cmos5l_dlygate4sd3_1_219 r0 *1 0,0
Xsg13cmos5l_dlygate4sd3_1_219 \$5475 VPWR VGND \$5589 sg13cmos5l_dlygate4sd3_1
* cell instance sg13cmos5l_dlygate4sd3_1_220 r0 *1 0,0
Xsg13cmos5l_dlygate4sd3_1_220 \$3709 VPWR VGND \$3693 sg13cmos5l_dlygate4sd3_1
* cell instance sg13cmos5l_dlygate4sd3_1_221 r0 *1 0,0
Xsg13cmos5l_dlygate4sd3_1_221 \$5901 VPWR VGND \$5834 sg13cmos5l_dlygate4sd3_1
* cell instance sg13cmos5l_dlygate4sd3_1_222 r0 *1 0,0
Xsg13cmos5l_dlygate4sd3_1_222 \$1790 VPWR VGND \$1795 sg13cmos5l_dlygate4sd3_1
* cell instance sg13cmos5l_dlygate4sd3_1_223 r0 *1 0,0
Xsg13cmos5l_dlygate4sd3_1_223 \$5224 VPWR VGND \$5225 sg13cmos5l_dlygate4sd3_1
* cell instance sg13cmos5l_dlygate4sd3_1_224 r0 *1 0,0
Xsg13cmos5l_dlygate4sd3_1_224 \$2238 VPWR VGND \$2244 sg13cmos5l_dlygate4sd3_1
* cell instance sg13cmos5l_dlygate4sd3_1_225 r0 *1 0,0
Xsg13cmos5l_dlygate4sd3_1_225 \$4109 VPWR VGND \$4069 sg13cmos5l_dlygate4sd3_1
* cell instance sg13cmos5l_dlygate4sd3_1_226 r0 *1 0,0
Xsg13cmos5l_dlygate4sd3_1_226 \$2235 VPWR VGND \$2406 sg13cmos5l_dlygate4sd3_1
* cell instance sg13cmos5l_dlygate4sd3_1_227 r0 *1 0,0
Xsg13cmos5l_dlygate4sd3_1_227 \$5077 VPWR VGND \$4059 sg13cmos5l_dlygate4sd3_1
* cell instance sg13cmos5l_dlygate4sd3_1_228 r0 *1 0,0
Xsg13cmos5l_dlygate4sd3_1_228 \$5067 VPWR VGND \$5296 sg13cmos5l_dlygate4sd3_1
* cell instance sg13cmos5l_dlygate4sd3_1_229 r0 *1 0,0
Xsg13cmos5l_dlygate4sd3_1_229 \$5546 VPWR VGND \$5590 sg13cmos5l_dlygate4sd3_1
* cell instance sg13cmos5l_fill_1_0 r0 *1 0,0
Xsg13cmos5l_fill_1_0 VPWR VGND sg13cmos5l_fill_1
* cell instance sg13cmos5l_fill_1_1 r0 *1 0,0
Xsg13cmos5l_fill_1_1 VPWR VGND sg13cmos5l_fill_1
* cell instance sg13cmos5l_fill_1_2 r0 *1 0,0
Xsg13cmos5l_fill_1_2 VPWR VGND sg13cmos5l_fill_1
* cell instance sg13cmos5l_fill_1_3 r0 *1 0,0
Xsg13cmos5l_fill_1_3 VPWR VGND sg13cmos5l_fill_1
* cell instance sg13cmos5l_fill_1_4 r0 *1 0,0
Xsg13cmos5l_fill_1_4 VPWR VGND sg13cmos5l_fill_1
* cell instance sg13cmos5l_fill_1_5 r0 *1 0,0
Xsg13cmos5l_fill_1_5 VPWR VGND sg13cmos5l_fill_1
* cell instance sg13cmos5l_fill_1_6 r0 *1 0,0
Xsg13cmos5l_fill_1_6 VPWR VGND sg13cmos5l_fill_1
* cell instance sg13cmos5l_fill_1_7 r0 *1 0,0
Xsg13cmos5l_fill_1_7 VPWR VGND sg13cmos5l_fill_1
* cell instance sg13cmos5l_fill_1_8 r0 *1 0,0
Xsg13cmos5l_fill_1_8 VPWR VGND sg13cmos5l_fill_1
* cell instance sg13cmos5l_fill_1_9 r0 *1 0,0
Xsg13cmos5l_fill_1_9 VPWR VGND sg13cmos5l_fill_1
* cell instance sg13cmos5l_fill_1_10 r0 *1 0,0
Xsg13cmos5l_fill_1_10 VPWR VGND sg13cmos5l_fill_1
* cell instance sg13cmos5l_fill_1_11 r0 *1 0,0
Xsg13cmos5l_fill_1_11 VPWR VGND sg13cmos5l_fill_1
* cell instance sg13cmos5l_fill_1_12 r0 *1 0,0
Xsg13cmos5l_fill_1_12 VPWR VGND sg13cmos5l_fill_1
* cell instance sg13cmos5l_fill_1_13 r0 *1 0,0
Xsg13cmos5l_fill_1_13 VPWR VGND sg13cmos5l_fill_1
* cell instance sg13cmos5l_fill_1_14 r0 *1 0,0
Xsg13cmos5l_fill_1_14 VPWR VGND sg13cmos5l_fill_1
* cell instance sg13cmos5l_fill_1_15 r0 *1 0,0
Xsg13cmos5l_fill_1_15 VPWR VGND sg13cmos5l_fill_1
* cell instance sg13cmos5l_fill_1_16 r0 *1 0,0
Xsg13cmos5l_fill_1_16 VPWR VGND sg13cmos5l_fill_1
* cell instance sg13cmos5l_fill_1_17 r0 *1 0,0
Xsg13cmos5l_fill_1_17 VPWR VGND sg13cmos5l_fill_1
* cell instance sg13cmos5l_fill_1_18 r0 *1 0,0
Xsg13cmos5l_fill_1_18 VPWR VGND sg13cmos5l_fill_1
* cell instance sg13cmos5l_fill_1_19 r0 *1 0,0
Xsg13cmos5l_fill_1_19 VPWR VGND sg13cmos5l_fill_1
* cell instance sg13cmos5l_fill_1_20 r0 *1 0,0
Xsg13cmos5l_fill_1_20 VPWR VGND sg13cmos5l_fill_1
* cell instance sg13cmos5l_fill_1_21 r0 *1 0,0
Xsg13cmos5l_fill_1_21 VPWR VGND sg13cmos5l_fill_1
* cell instance sg13cmos5l_fill_1_22 r0 *1 0,0
Xsg13cmos5l_fill_1_22 VPWR VGND sg13cmos5l_fill_1
* cell instance sg13cmos5l_fill_1_23 r0 *1 0,0
Xsg13cmos5l_fill_1_23 VPWR VGND sg13cmos5l_fill_1
* cell instance sg13cmos5l_fill_1_24 r0 *1 0,0
Xsg13cmos5l_fill_1_24 VPWR VGND sg13cmos5l_fill_1
* cell instance sg13cmos5l_fill_1_25 r0 *1 0,0
Xsg13cmos5l_fill_1_25 VPWR VGND sg13cmos5l_fill_1
* cell instance sg13cmos5l_fill_1_26 r0 *1 0,0
Xsg13cmos5l_fill_1_26 VPWR VGND sg13cmos5l_fill_1
* cell instance sg13cmos5l_fill_1_27 r0 *1 0,0
Xsg13cmos5l_fill_1_27 VPWR VGND sg13cmos5l_fill_1
* cell instance sg13cmos5l_fill_1_28 r0 *1 0,0
Xsg13cmos5l_fill_1_28 VPWR VGND sg13cmos5l_fill_1
* cell instance sg13cmos5l_fill_1_29 r0 *1 0,0
Xsg13cmos5l_fill_1_29 VPWR VGND sg13cmos5l_fill_1
* cell instance sg13cmos5l_fill_1_30 r0 *1 0,0
Xsg13cmos5l_fill_1_30 VPWR VGND sg13cmos5l_fill_1
* cell instance sg13cmos5l_fill_1_31 r0 *1 0,0
Xsg13cmos5l_fill_1_31 VPWR VGND sg13cmos5l_fill_1
* cell instance sg13cmos5l_fill_1_32 r0 *1 0,0
Xsg13cmos5l_fill_1_32 VPWR VGND sg13cmos5l_fill_1
* cell instance sg13cmos5l_fill_1_33 r0 *1 0,0
Xsg13cmos5l_fill_1_33 VPWR VGND sg13cmos5l_fill_1
* cell instance sg13cmos5l_fill_1_34 r0 *1 0,0
Xsg13cmos5l_fill_1_34 VPWR VGND sg13cmos5l_fill_1
* cell instance sg13cmos5l_fill_1_35 r0 *1 0,0
Xsg13cmos5l_fill_1_35 VPWR VGND sg13cmos5l_fill_1
* cell instance sg13cmos5l_fill_1_36 r0 *1 0,0
Xsg13cmos5l_fill_1_36 VPWR VGND sg13cmos5l_fill_1
* cell instance sg13cmos5l_fill_1_37 r0 *1 0,0
Xsg13cmos5l_fill_1_37 VPWR VGND sg13cmos5l_fill_1
* cell instance sg13cmos5l_fill_1_38 r0 *1 0,0
Xsg13cmos5l_fill_1_38 VPWR VGND sg13cmos5l_fill_1
* cell instance sg13cmos5l_fill_1_39 r0 *1 0,0
Xsg13cmos5l_fill_1_39 VPWR VGND sg13cmos5l_fill_1
* cell instance sg13cmos5l_fill_1_40 r0 *1 0,0
Xsg13cmos5l_fill_1_40 VPWR VGND sg13cmos5l_fill_1
* cell instance sg13cmos5l_fill_1_41 r0 *1 0,0
Xsg13cmos5l_fill_1_41 VPWR VGND sg13cmos5l_fill_1
* cell instance sg13cmos5l_fill_1_42 r0 *1 0,0
Xsg13cmos5l_fill_1_42 VPWR VGND sg13cmos5l_fill_1
* cell instance sg13cmos5l_fill_1_43 r0 *1 0,0
Xsg13cmos5l_fill_1_43 VPWR VGND sg13cmos5l_fill_1
* cell instance sg13cmos5l_fill_1_44 r0 *1 0,0
Xsg13cmos5l_fill_1_44 VPWR VGND sg13cmos5l_fill_1
* cell instance sg13cmos5l_fill_1_45 r0 *1 0,0
Xsg13cmos5l_fill_1_45 VPWR VGND sg13cmos5l_fill_1
* cell instance sg13cmos5l_fill_1_46 r0 *1 0,0
Xsg13cmos5l_fill_1_46 VPWR VGND sg13cmos5l_fill_1
* cell instance sg13cmos5l_fill_1_47 r0 *1 0,0
Xsg13cmos5l_fill_1_47 VPWR VGND sg13cmos5l_fill_1
* cell instance sg13cmos5l_fill_1_48 r0 *1 0,0
Xsg13cmos5l_fill_1_48 VPWR VGND sg13cmos5l_fill_1
* cell instance sg13cmos5l_fill_1_49 r0 *1 0,0
Xsg13cmos5l_fill_1_49 VPWR VGND sg13cmos5l_fill_1
* cell instance sg13cmos5l_fill_1_50 r0 *1 0,0
Xsg13cmos5l_fill_1_50 VPWR VGND sg13cmos5l_fill_1
* cell instance sg13cmos5l_fill_1_51 r0 *1 0,0
Xsg13cmos5l_fill_1_51 VPWR VGND sg13cmos5l_fill_1
* cell instance sg13cmos5l_fill_1_52 r0 *1 0,0
Xsg13cmos5l_fill_1_52 VPWR VGND sg13cmos5l_fill_1
* cell instance sg13cmos5l_fill_1_53 r0 *1 0,0
Xsg13cmos5l_fill_1_53 VPWR VGND sg13cmos5l_fill_1
* cell instance sg13cmos5l_fill_1_54 r0 *1 0,0
Xsg13cmos5l_fill_1_54 VPWR VGND sg13cmos5l_fill_1
* cell instance sg13cmos5l_fill_1_55 r0 *1 0,0
Xsg13cmos5l_fill_1_55 VPWR VGND sg13cmos5l_fill_1
* cell instance sg13cmos5l_fill_1_56 r0 *1 0,0
Xsg13cmos5l_fill_1_56 VPWR VGND sg13cmos5l_fill_1
* cell instance sg13cmos5l_fill_1_57 r0 *1 0,0
Xsg13cmos5l_fill_1_57 VPWR VGND sg13cmos5l_fill_1
* cell instance sg13cmos5l_fill_1_58 r0 *1 0,0
Xsg13cmos5l_fill_1_58 VPWR VGND sg13cmos5l_fill_1
* cell instance sg13cmos5l_fill_1_59 r0 *1 0,0
Xsg13cmos5l_fill_1_59 VPWR VGND sg13cmos5l_fill_1
* cell instance sg13cmos5l_fill_1_60 r0 *1 0,0
Xsg13cmos5l_fill_1_60 VPWR VGND sg13cmos5l_fill_1
* cell instance sg13cmos5l_fill_1_61 r0 *1 0,0
Xsg13cmos5l_fill_1_61 VPWR VGND sg13cmos5l_fill_1
* cell instance sg13cmos5l_fill_1_62 r0 *1 0,0
Xsg13cmos5l_fill_1_62 VPWR VGND sg13cmos5l_fill_1
* cell instance sg13cmos5l_fill_1_63 r0 *1 0,0
Xsg13cmos5l_fill_1_63 VPWR VGND sg13cmos5l_fill_1
* cell instance sg13cmos5l_fill_1_64 r0 *1 0,0
Xsg13cmos5l_fill_1_64 VPWR VGND sg13cmos5l_fill_1
* cell instance sg13cmos5l_fill_1_65 r0 *1 0,0
Xsg13cmos5l_fill_1_65 VPWR VGND sg13cmos5l_fill_1
* cell instance sg13cmos5l_fill_1_66 r0 *1 0,0
Xsg13cmos5l_fill_1_66 VPWR VGND sg13cmos5l_fill_1
* cell instance sg13cmos5l_fill_1_67 r0 *1 0,0
Xsg13cmos5l_fill_1_67 VPWR VGND sg13cmos5l_fill_1
* cell instance sg13cmos5l_fill_1_68 r0 *1 0,0
Xsg13cmos5l_fill_1_68 VPWR VGND sg13cmos5l_fill_1
* cell instance sg13cmos5l_fill_1_69 r0 *1 0,0
Xsg13cmos5l_fill_1_69 VPWR VGND sg13cmos5l_fill_1
* cell instance sg13cmos5l_fill_1_70 r0 *1 0,0
Xsg13cmos5l_fill_1_70 VPWR VGND sg13cmos5l_fill_1
* cell instance sg13cmos5l_fill_1_71 r0 *1 0,0
Xsg13cmos5l_fill_1_71 VPWR VGND sg13cmos5l_fill_1
* cell instance sg13cmos5l_fill_1_72 r0 *1 0,0
Xsg13cmos5l_fill_1_72 VPWR VGND sg13cmos5l_fill_1
* cell instance sg13cmos5l_fill_1_73 r0 *1 0,0
Xsg13cmos5l_fill_1_73 VPWR VGND sg13cmos5l_fill_1
* cell instance sg13cmos5l_fill_1_74 r0 *1 0,0
Xsg13cmos5l_fill_1_74 VPWR VGND sg13cmos5l_fill_1
* cell instance sg13cmos5l_fill_1_75 r0 *1 0,0
Xsg13cmos5l_fill_1_75 VPWR VGND sg13cmos5l_fill_1
* cell instance sg13cmos5l_fill_1_76 r0 *1 0,0
Xsg13cmos5l_fill_1_76 VPWR VGND sg13cmos5l_fill_1
* cell instance sg13cmos5l_fill_1_77 r0 *1 0,0
Xsg13cmos5l_fill_1_77 VPWR VGND sg13cmos5l_fill_1
* cell instance sg13cmos5l_fill_1_78 r0 *1 0,0
Xsg13cmos5l_fill_1_78 VPWR VGND sg13cmos5l_fill_1
* cell instance sg13cmos5l_fill_1_79 r0 *1 0,0
Xsg13cmos5l_fill_1_79 VPWR VGND sg13cmos5l_fill_1
* cell instance sg13cmos5l_fill_1_80 r0 *1 0,0
Xsg13cmos5l_fill_1_80 VPWR VGND sg13cmos5l_fill_1
* cell instance sg13cmos5l_fill_1_81 r0 *1 0,0
Xsg13cmos5l_fill_1_81 VPWR VGND sg13cmos5l_fill_1
* cell instance sg13cmos5l_fill_1_82 r0 *1 0,0
Xsg13cmos5l_fill_1_82 VPWR VGND sg13cmos5l_fill_1
* cell instance sg13cmos5l_fill_1_83 r0 *1 0,0
Xsg13cmos5l_fill_1_83 VPWR VGND sg13cmos5l_fill_1
* cell instance sg13cmos5l_fill_1_84 r0 *1 0,0
Xsg13cmos5l_fill_1_84 VPWR VGND sg13cmos5l_fill_1
* cell instance sg13cmos5l_fill_1_85 r0 *1 0,0
Xsg13cmos5l_fill_1_85 VPWR VGND sg13cmos5l_fill_1
* cell instance sg13cmos5l_fill_1_86 r0 *1 0,0
Xsg13cmos5l_fill_1_86 VPWR VGND sg13cmos5l_fill_1
* cell instance sg13cmos5l_fill_1_87 r0 *1 0,0
Xsg13cmos5l_fill_1_87 VPWR VGND sg13cmos5l_fill_1
* cell instance sg13cmos5l_fill_1_88 r0 *1 0,0
Xsg13cmos5l_fill_1_88 VPWR VGND sg13cmos5l_fill_1
* cell instance sg13cmos5l_fill_1_89 r0 *1 0,0
Xsg13cmos5l_fill_1_89 VPWR VGND sg13cmos5l_fill_1
* cell instance sg13cmos5l_fill_1_90 r0 *1 0,0
Xsg13cmos5l_fill_1_90 VPWR VGND sg13cmos5l_fill_1
* cell instance sg13cmos5l_fill_1_91 r0 *1 0,0
Xsg13cmos5l_fill_1_91 VPWR VGND sg13cmos5l_fill_1
* cell instance sg13cmos5l_fill_1_92 r0 *1 0,0
Xsg13cmos5l_fill_1_92 VPWR VGND sg13cmos5l_fill_1
* cell instance sg13cmos5l_fill_1_93 r0 *1 0,0
Xsg13cmos5l_fill_1_93 VPWR VGND sg13cmos5l_fill_1
* cell instance sg13cmos5l_fill_1_94 r0 *1 0,0
Xsg13cmos5l_fill_1_94 VPWR VGND sg13cmos5l_fill_1
* cell instance sg13cmos5l_fill_1_95 r0 *1 0,0
Xsg13cmos5l_fill_1_95 VPWR VGND sg13cmos5l_fill_1
* cell instance sg13cmos5l_fill_1_96 r0 *1 0,0
Xsg13cmos5l_fill_1_96 VPWR VGND sg13cmos5l_fill_1
* cell instance sg13cmos5l_fill_1_97 r0 *1 0,0
Xsg13cmos5l_fill_1_97 VPWR VGND sg13cmos5l_fill_1
* cell instance sg13cmos5l_fill_1_98 r0 *1 0,0
Xsg13cmos5l_fill_1_98 VPWR VGND sg13cmos5l_fill_1
* cell instance sg13cmos5l_fill_1_99 r0 *1 0,0
Xsg13cmos5l_fill_1_99 VPWR VGND sg13cmos5l_fill_1
* cell instance sg13cmos5l_fill_1_100 r0 *1 0,0
Xsg13cmos5l_fill_1_100 VPWR VGND sg13cmos5l_fill_1
* cell instance sg13cmos5l_fill_1_101 r0 *1 0,0
Xsg13cmos5l_fill_1_101 VPWR VGND sg13cmos5l_fill_1
* cell instance sg13cmos5l_fill_1_102 r0 *1 0,0
Xsg13cmos5l_fill_1_102 VPWR VGND sg13cmos5l_fill_1
* cell instance sg13cmos5l_fill_1_103 r0 *1 0,0
Xsg13cmos5l_fill_1_103 VPWR VGND sg13cmos5l_fill_1
* cell instance sg13cmos5l_fill_1_104 r0 *1 0,0
Xsg13cmos5l_fill_1_104 VPWR VGND sg13cmos5l_fill_1
* cell instance sg13cmos5l_fill_1_105 r0 *1 0,0
Xsg13cmos5l_fill_1_105 VPWR VGND sg13cmos5l_fill_1
* cell instance sg13cmos5l_fill_1_106 r0 *1 0,0
Xsg13cmos5l_fill_1_106 VPWR VGND sg13cmos5l_fill_1
* cell instance sg13cmos5l_fill_1_107 r0 *1 0,0
Xsg13cmos5l_fill_1_107 VPWR VGND sg13cmos5l_fill_1
* cell instance sg13cmos5l_fill_1_108 r0 *1 0,0
Xsg13cmos5l_fill_1_108 VPWR VGND sg13cmos5l_fill_1
* cell instance sg13cmos5l_fill_1_109 r0 *1 0,0
Xsg13cmos5l_fill_1_109 VPWR VGND sg13cmos5l_fill_1
* cell instance sg13cmos5l_fill_1_110 r0 *1 0,0
Xsg13cmos5l_fill_1_110 VPWR VGND sg13cmos5l_fill_1
* cell instance sg13cmos5l_fill_1_111 r0 *1 0,0
Xsg13cmos5l_fill_1_111 VPWR VGND sg13cmos5l_fill_1
* cell instance sg13cmos5l_fill_1_112 r0 *1 0,0
Xsg13cmos5l_fill_1_112 VPWR VGND sg13cmos5l_fill_1
* cell instance sg13cmos5l_fill_1_113 r0 *1 0,0
Xsg13cmos5l_fill_1_113 VPWR VGND sg13cmos5l_fill_1
* cell instance sg13cmos5l_fill_1_114 r0 *1 0,0
Xsg13cmos5l_fill_1_114 VPWR VGND sg13cmos5l_fill_1
* cell instance sg13cmos5l_fill_1_115 r0 *1 0,0
Xsg13cmos5l_fill_1_115 VPWR VGND sg13cmos5l_fill_1
* cell instance sg13cmos5l_fill_1_116 r0 *1 0,0
Xsg13cmos5l_fill_1_116 VPWR VGND sg13cmos5l_fill_1
* cell instance sg13cmos5l_fill_1_117 r0 *1 0,0
Xsg13cmos5l_fill_1_117 VPWR VGND sg13cmos5l_fill_1
* cell instance sg13cmos5l_fill_1_118 r0 *1 0,0
Xsg13cmos5l_fill_1_118 VPWR VGND sg13cmos5l_fill_1
* cell instance sg13cmos5l_fill_1_119 r0 *1 0,0
Xsg13cmos5l_fill_1_119 VPWR VGND sg13cmos5l_fill_1
* cell instance sg13cmos5l_fill_1_120 r0 *1 0,0
Xsg13cmos5l_fill_1_120 VPWR VGND sg13cmos5l_fill_1
* cell instance sg13cmos5l_fill_1_121 r0 *1 0,0
Xsg13cmos5l_fill_1_121 VPWR VGND sg13cmos5l_fill_1
* cell instance sg13cmos5l_fill_1_122 r0 *1 0,0
Xsg13cmos5l_fill_1_122 VPWR VGND sg13cmos5l_fill_1
* cell instance sg13cmos5l_fill_1_123 r0 *1 0,0
Xsg13cmos5l_fill_1_123 VPWR VGND sg13cmos5l_fill_1
* cell instance sg13cmos5l_fill_1_124 r0 *1 0,0
Xsg13cmos5l_fill_1_124 VPWR VGND sg13cmos5l_fill_1
* cell instance sg13cmos5l_fill_1_125 r0 *1 0,0
Xsg13cmos5l_fill_1_125 VPWR VGND sg13cmos5l_fill_1
* cell instance sg13cmos5l_fill_1_126 r0 *1 0,0
Xsg13cmos5l_fill_1_126 VPWR VGND sg13cmos5l_fill_1
* cell instance sg13cmos5l_fill_1_127 r0 *1 0,0
Xsg13cmos5l_fill_1_127 VPWR VGND sg13cmos5l_fill_1
* cell instance sg13cmos5l_fill_1_128 r0 *1 0,0
Xsg13cmos5l_fill_1_128 VPWR VGND sg13cmos5l_fill_1
* cell instance sg13cmos5l_fill_1_129 r0 *1 0,0
Xsg13cmos5l_fill_1_129 VPWR VGND sg13cmos5l_fill_1
* cell instance sg13cmos5l_fill_1_130 r0 *1 0,0
Xsg13cmos5l_fill_1_130 VPWR VGND sg13cmos5l_fill_1
* cell instance sg13cmos5l_fill_1_131 r0 *1 0,0
Xsg13cmos5l_fill_1_131 VPWR VGND sg13cmos5l_fill_1
* cell instance sg13cmos5l_fill_1_132 r0 *1 0,0
Xsg13cmos5l_fill_1_132 VPWR VGND sg13cmos5l_fill_1
* cell instance sg13cmos5l_fill_1_133 r0 *1 0,0
Xsg13cmos5l_fill_1_133 VPWR VGND sg13cmos5l_fill_1
* cell instance sg13cmos5l_fill_1_134 r0 *1 0,0
Xsg13cmos5l_fill_1_134 VPWR VGND sg13cmos5l_fill_1
* cell instance sg13cmos5l_fill_1_135 r0 *1 0,0
Xsg13cmos5l_fill_1_135 VPWR VGND sg13cmos5l_fill_1
* cell instance sg13cmos5l_fill_1_136 r0 *1 0,0
Xsg13cmos5l_fill_1_136 VPWR VGND sg13cmos5l_fill_1
* cell instance sg13cmos5l_fill_1_137 r0 *1 0,0
Xsg13cmos5l_fill_1_137 VPWR VGND sg13cmos5l_fill_1
* cell instance sg13cmos5l_fill_1_138 r0 *1 0,0
Xsg13cmos5l_fill_1_138 VPWR VGND sg13cmos5l_fill_1
* cell instance sg13cmos5l_fill_1_139 r0 *1 0,0
Xsg13cmos5l_fill_1_139 VPWR VGND sg13cmos5l_fill_1
* cell instance sg13cmos5l_fill_1_140 r0 *1 0,0
Xsg13cmos5l_fill_1_140 VPWR VGND sg13cmos5l_fill_1
* cell instance sg13cmos5l_fill_1_141 r0 *1 0,0
Xsg13cmos5l_fill_1_141 VPWR VGND sg13cmos5l_fill_1
* cell instance sg13cmos5l_fill_1_142 r0 *1 0,0
Xsg13cmos5l_fill_1_142 VPWR VGND sg13cmos5l_fill_1
* cell instance sg13cmos5l_fill_1_143 r0 *1 0,0
Xsg13cmos5l_fill_1_143 VPWR VGND sg13cmos5l_fill_1
* cell instance sg13cmos5l_fill_1_144 r0 *1 0,0
Xsg13cmos5l_fill_1_144 VPWR VGND sg13cmos5l_fill_1
* cell instance sg13cmos5l_fill_1_145 r0 *1 0,0
Xsg13cmos5l_fill_1_145 VPWR VGND sg13cmos5l_fill_1
* cell instance sg13cmos5l_fill_1_146 r0 *1 0,0
Xsg13cmos5l_fill_1_146 VPWR VGND sg13cmos5l_fill_1
* cell instance sg13cmos5l_fill_1_147 r0 *1 0,0
Xsg13cmos5l_fill_1_147 VPWR VGND sg13cmos5l_fill_1
* cell instance sg13cmos5l_fill_1_148 r0 *1 0,0
Xsg13cmos5l_fill_1_148 VPWR VGND sg13cmos5l_fill_1
* cell instance sg13cmos5l_fill_1_149 r0 *1 0,0
Xsg13cmos5l_fill_1_149 VPWR VGND sg13cmos5l_fill_1
* cell instance sg13cmos5l_fill_1_150 r0 *1 0,0
Xsg13cmos5l_fill_1_150 VPWR VGND sg13cmos5l_fill_1
* cell instance sg13cmos5l_fill_1_151 r0 *1 0,0
Xsg13cmos5l_fill_1_151 VPWR VGND sg13cmos5l_fill_1
* cell instance sg13cmos5l_fill_1_152 r0 *1 0,0
Xsg13cmos5l_fill_1_152 VPWR VGND sg13cmos5l_fill_1
* cell instance sg13cmos5l_fill_1_153 r0 *1 0,0
Xsg13cmos5l_fill_1_153 VPWR VGND sg13cmos5l_fill_1
* cell instance sg13cmos5l_fill_1_154 r0 *1 0,0
Xsg13cmos5l_fill_1_154 VPWR VGND sg13cmos5l_fill_1
* cell instance sg13cmos5l_fill_1_155 r0 *1 0,0
Xsg13cmos5l_fill_1_155 VPWR VGND sg13cmos5l_fill_1
* cell instance sg13cmos5l_fill_1_156 r0 *1 0,0
Xsg13cmos5l_fill_1_156 VPWR VGND sg13cmos5l_fill_1
* cell instance sg13cmos5l_fill_1_157 r0 *1 0,0
Xsg13cmos5l_fill_1_157 VPWR VGND sg13cmos5l_fill_1
* cell instance sg13cmos5l_fill_1_158 r0 *1 0,0
Xsg13cmos5l_fill_1_158 VPWR VGND sg13cmos5l_fill_1
* cell instance sg13cmos5l_fill_1_159 r0 *1 0,0
Xsg13cmos5l_fill_1_159 VPWR VGND sg13cmos5l_fill_1
* cell instance sg13cmos5l_fill_1_160 r0 *1 0,0
Xsg13cmos5l_fill_1_160 VPWR VGND sg13cmos5l_fill_1
* cell instance sg13cmos5l_fill_1_161 r0 *1 0,0
Xsg13cmos5l_fill_1_161 VPWR VGND sg13cmos5l_fill_1
* cell instance sg13cmos5l_fill_1_162 r0 *1 0,0
Xsg13cmos5l_fill_1_162 VPWR VGND sg13cmos5l_fill_1
* cell instance sg13cmos5l_fill_1_163 r0 *1 0,0
Xsg13cmos5l_fill_1_163 VPWR VGND sg13cmos5l_fill_1
* cell instance sg13cmos5l_fill_1_164 r0 *1 0,0
Xsg13cmos5l_fill_1_164 VPWR VGND sg13cmos5l_fill_1
* cell instance sg13cmos5l_fill_1_165 r0 *1 0,0
Xsg13cmos5l_fill_1_165 VPWR VGND sg13cmos5l_fill_1
* cell instance sg13cmos5l_fill_1_166 r0 *1 0,0
Xsg13cmos5l_fill_1_166 VPWR VGND sg13cmos5l_fill_1
* cell instance sg13cmos5l_fill_1_167 r0 *1 0,0
Xsg13cmos5l_fill_1_167 VPWR VGND sg13cmos5l_fill_1
* cell instance sg13cmos5l_fill_1_168 r0 *1 0,0
Xsg13cmos5l_fill_1_168 VPWR VGND sg13cmos5l_fill_1
* cell instance sg13cmos5l_fill_1_169 r0 *1 0,0
Xsg13cmos5l_fill_1_169 VPWR VGND sg13cmos5l_fill_1
* cell instance sg13cmos5l_fill_1_170 r0 *1 0,0
Xsg13cmos5l_fill_1_170 VPWR VGND sg13cmos5l_fill_1
* cell instance sg13cmos5l_fill_1_171 r0 *1 0,0
Xsg13cmos5l_fill_1_171 VPWR VGND sg13cmos5l_fill_1
* cell instance sg13cmos5l_fill_1_172 r0 *1 0,0
Xsg13cmos5l_fill_1_172 VPWR VGND sg13cmos5l_fill_1
* cell instance sg13cmos5l_fill_1_173 r0 *1 0,0
Xsg13cmos5l_fill_1_173 VPWR VGND sg13cmos5l_fill_1
* cell instance sg13cmos5l_fill_1_174 r0 *1 0,0
Xsg13cmos5l_fill_1_174 VPWR VGND sg13cmos5l_fill_1
* cell instance sg13cmos5l_fill_1_175 r0 *1 0,0
Xsg13cmos5l_fill_1_175 VPWR VGND sg13cmos5l_fill_1
* cell instance sg13cmos5l_fill_1_176 r0 *1 0,0
Xsg13cmos5l_fill_1_176 VPWR VGND sg13cmos5l_fill_1
* cell instance sg13cmos5l_fill_1_177 r0 *1 0,0
Xsg13cmos5l_fill_1_177 VPWR VGND sg13cmos5l_fill_1
* cell instance sg13cmos5l_fill_1_178 r0 *1 0,0
Xsg13cmos5l_fill_1_178 VPWR VGND sg13cmos5l_fill_1
* cell instance sg13cmos5l_fill_1_179 r0 *1 0,0
Xsg13cmos5l_fill_1_179 VPWR VGND sg13cmos5l_fill_1
* cell instance sg13cmos5l_fill_1_180 r0 *1 0,0
Xsg13cmos5l_fill_1_180 VPWR VGND sg13cmos5l_fill_1
* cell instance sg13cmos5l_fill_1_181 r0 *1 0,0
Xsg13cmos5l_fill_1_181 VPWR VGND sg13cmos5l_fill_1
* cell instance sg13cmos5l_fill_1_182 r0 *1 0,0
Xsg13cmos5l_fill_1_182 VPWR VGND sg13cmos5l_fill_1
* cell instance sg13cmos5l_fill_1_183 r0 *1 0,0
Xsg13cmos5l_fill_1_183 VPWR VGND sg13cmos5l_fill_1
* cell instance sg13cmos5l_fill_1_184 r0 *1 0,0
Xsg13cmos5l_fill_1_184 VPWR VGND sg13cmos5l_fill_1
* cell instance sg13cmos5l_fill_1_185 r0 *1 0,0
Xsg13cmos5l_fill_1_185 VPWR VGND sg13cmos5l_fill_1
* cell instance sg13cmos5l_fill_1_186 r0 *1 0,0
Xsg13cmos5l_fill_1_186 VPWR VGND sg13cmos5l_fill_1
* cell instance sg13cmos5l_fill_1_187 r0 *1 0,0
Xsg13cmos5l_fill_1_187 VPWR VGND sg13cmos5l_fill_1
* cell instance sg13cmos5l_fill_1_188 r0 *1 0,0
Xsg13cmos5l_fill_1_188 VPWR VGND sg13cmos5l_fill_1
* cell instance sg13cmos5l_fill_1_189 r0 *1 0,0
Xsg13cmos5l_fill_1_189 VPWR VGND sg13cmos5l_fill_1
* cell instance sg13cmos5l_fill_1_190 r0 *1 0,0
Xsg13cmos5l_fill_1_190 VPWR VGND sg13cmos5l_fill_1
* cell instance sg13cmos5l_fill_1_191 r0 *1 0,0
Xsg13cmos5l_fill_1_191 VPWR VGND sg13cmos5l_fill_1
* cell instance sg13cmos5l_fill_1_192 r0 *1 0,0
Xsg13cmos5l_fill_1_192 VPWR VGND sg13cmos5l_fill_1
* cell instance sg13cmos5l_fill_1_193 r0 *1 0,0
Xsg13cmos5l_fill_1_193 VPWR VGND sg13cmos5l_fill_1
* cell instance sg13cmos5l_fill_1_194 r0 *1 0,0
Xsg13cmos5l_fill_1_194 VPWR VGND sg13cmos5l_fill_1
* cell instance sg13cmos5l_fill_1_195 r0 *1 0,0
Xsg13cmos5l_fill_1_195 VPWR VGND sg13cmos5l_fill_1
* cell instance sg13cmos5l_fill_1_196 r0 *1 0,0
Xsg13cmos5l_fill_1_196 VPWR VGND sg13cmos5l_fill_1
* cell instance sg13cmos5l_fill_1_197 r0 *1 0,0
Xsg13cmos5l_fill_1_197 VPWR VGND sg13cmos5l_fill_1
* cell instance sg13cmos5l_fill_1_198 r0 *1 0,0
Xsg13cmos5l_fill_1_198 VPWR VGND sg13cmos5l_fill_1
* cell instance sg13cmos5l_fill_1_199 r0 *1 0,0
Xsg13cmos5l_fill_1_199 VPWR VGND sg13cmos5l_fill_1
* cell instance sg13cmos5l_fill_1_200 r0 *1 0,0
Xsg13cmos5l_fill_1_200 VPWR VGND sg13cmos5l_fill_1
* cell instance sg13cmos5l_fill_1_201 r0 *1 0,0
Xsg13cmos5l_fill_1_201 VPWR VGND sg13cmos5l_fill_1
* cell instance sg13cmos5l_fill_1_202 r0 *1 0,0
Xsg13cmos5l_fill_1_202 VPWR VGND sg13cmos5l_fill_1
* cell instance sg13cmos5l_fill_1_203 r0 *1 0,0
Xsg13cmos5l_fill_1_203 VPWR VGND sg13cmos5l_fill_1
* cell instance sg13cmos5l_fill_1_204 r0 *1 0,0
Xsg13cmos5l_fill_1_204 VPWR VGND sg13cmos5l_fill_1
* cell instance sg13cmos5l_fill_1_205 r0 *1 0,0
Xsg13cmos5l_fill_1_205 VPWR VGND sg13cmos5l_fill_1
* cell instance sg13cmos5l_fill_1_206 r0 *1 0,0
Xsg13cmos5l_fill_1_206 VPWR VGND sg13cmos5l_fill_1
* cell instance sg13cmos5l_fill_1_207 r0 *1 0,0
Xsg13cmos5l_fill_1_207 VPWR VGND sg13cmos5l_fill_1
* cell instance sg13cmos5l_fill_1_208 r0 *1 0,0
Xsg13cmos5l_fill_1_208 VPWR VGND sg13cmos5l_fill_1
* cell instance sg13cmos5l_fill_1_209 r0 *1 0,0
Xsg13cmos5l_fill_1_209 VPWR VGND sg13cmos5l_fill_1
* cell instance sg13cmos5l_fill_1_210 r0 *1 0,0
Xsg13cmos5l_fill_1_210 VPWR VGND sg13cmos5l_fill_1
* cell instance sg13cmos5l_fill_1_211 r0 *1 0,0
Xsg13cmos5l_fill_1_211 VPWR VGND sg13cmos5l_fill_1
* cell instance sg13cmos5l_fill_1_212 r0 *1 0,0
Xsg13cmos5l_fill_1_212 VPWR VGND sg13cmos5l_fill_1
* cell instance sg13cmos5l_fill_1_213 r0 *1 0,0
Xsg13cmos5l_fill_1_213 VPWR VGND sg13cmos5l_fill_1
* cell instance sg13cmos5l_fill_1_214 r0 *1 0,0
Xsg13cmos5l_fill_1_214 VPWR VGND sg13cmos5l_fill_1
* cell instance sg13cmos5l_fill_1_215 r0 *1 0,0
Xsg13cmos5l_fill_1_215 VPWR VGND sg13cmos5l_fill_1
* cell instance sg13cmos5l_fill_1_216 r0 *1 0,0
Xsg13cmos5l_fill_1_216 VPWR VGND sg13cmos5l_fill_1
* cell instance sg13cmos5l_fill_1_217 r0 *1 0,0
Xsg13cmos5l_fill_1_217 VPWR VGND sg13cmos5l_fill_1
* cell instance sg13cmos5l_fill_1_218 r0 *1 0,0
Xsg13cmos5l_fill_1_218 VPWR VGND sg13cmos5l_fill_1
* cell instance sg13cmos5l_fill_1_219 r0 *1 0,0
Xsg13cmos5l_fill_1_219 VPWR VGND sg13cmos5l_fill_1
* cell instance sg13cmos5l_fill_1_220 r0 *1 0,0
Xsg13cmos5l_fill_1_220 VPWR VGND sg13cmos5l_fill_1
* cell instance sg13cmos5l_fill_1_221 r0 *1 0,0
Xsg13cmos5l_fill_1_221 VPWR VGND sg13cmos5l_fill_1
* cell instance sg13cmos5l_fill_1_222 r0 *1 0,0
Xsg13cmos5l_fill_1_222 VPWR VGND sg13cmos5l_fill_1
* cell instance sg13cmos5l_fill_1_223 r0 *1 0,0
Xsg13cmos5l_fill_1_223 VPWR VGND sg13cmos5l_fill_1
* cell instance sg13cmos5l_fill_1_224 r0 *1 0,0
Xsg13cmos5l_fill_1_224 VPWR VGND sg13cmos5l_fill_1
* cell instance sg13cmos5l_fill_1_225 r0 *1 0,0
Xsg13cmos5l_fill_1_225 VPWR VGND sg13cmos5l_fill_1
* cell instance sg13cmos5l_fill_1_226 r0 *1 0,0
Xsg13cmos5l_fill_1_226 VPWR VGND sg13cmos5l_fill_1
* cell instance sg13cmos5l_fill_1_227 r0 *1 0,0
Xsg13cmos5l_fill_1_227 VPWR VGND sg13cmos5l_fill_1
* cell instance sg13cmos5l_fill_1_228 r0 *1 0,0
Xsg13cmos5l_fill_1_228 VPWR VGND sg13cmos5l_fill_1
* cell instance sg13cmos5l_fill_1_229 r0 *1 0,0
Xsg13cmos5l_fill_1_229 VPWR VGND sg13cmos5l_fill_1
* cell instance sg13cmos5l_fill_1_230 r0 *1 0,0
Xsg13cmos5l_fill_1_230 VPWR VGND sg13cmos5l_fill_1
* cell instance sg13cmos5l_fill_1_231 r0 *1 0,0
Xsg13cmos5l_fill_1_231 VPWR VGND sg13cmos5l_fill_1
* cell instance sg13cmos5l_fill_1_232 r0 *1 0,0
Xsg13cmos5l_fill_1_232 VPWR VGND sg13cmos5l_fill_1
* cell instance sg13cmos5l_fill_1_233 r0 *1 0,0
Xsg13cmos5l_fill_1_233 VPWR VGND sg13cmos5l_fill_1
* cell instance sg13cmos5l_fill_1_234 r0 *1 0,0
Xsg13cmos5l_fill_1_234 VPWR VGND sg13cmos5l_fill_1
* cell instance sg13cmos5l_fill_1_235 r0 *1 0,0
Xsg13cmos5l_fill_1_235 VPWR VGND sg13cmos5l_fill_1
* cell instance sg13cmos5l_fill_1_236 r0 *1 0,0
Xsg13cmos5l_fill_1_236 VPWR VGND sg13cmos5l_fill_1
* cell instance sg13cmos5l_fill_1_237 r0 *1 0,0
Xsg13cmos5l_fill_1_237 VPWR VGND sg13cmos5l_fill_1
* cell instance sg13cmos5l_fill_1_238 r0 *1 0,0
Xsg13cmos5l_fill_1_238 VPWR VGND sg13cmos5l_fill_1
* cell instance sg13cmos5l_fill_1_239 r0 *1 0,0
Xsg13cmos5l_fill_1_239 VPWR VGND sg13cmos5l_fill_1
* cell instance sg13cmos5l_fill_1_240 r0 *1 0,0
Xsg13cmos5l_fill_1_240 VPWR VGND sg13cmos5l_fill_1
* cell instance sg13cmos5l_fill_1_241 r0 *1 0,0
Xsg13cmos5l_fill_1_241 VPWR VGND sg13cmos5l_fill_1
* cell instance sg13cmos5l_fill_1_242 r0 *1 0,0
Xsg13cmos5l_fill_1_242 VPWR VGND sg13cmos5l_fill_1
* cell instance sg13cmos5l_fill_1_243 r0 *1 0,0
Xsg13cmos5l_fill_1_243 VPWR VGND sg13cmos5l_fill_1
* cell instance sg13cmos5l_fill_1_244 r0 *1 0,0
Xsg13cmos5l_fill_1_244 VPWR VGND sg13cmos5l_fill_1
* cell instance sg13cmos5l_fill_1_245 r0 *1 0,0
Xsg13cmos5l_fill_1_245 VPWR VGND sg13cmos5l_fill_1
* cell instance sg13cmos5l_fill_1_246 r0 *1 0,0
Xsg13cmos5l_fill_1_246 VPWR VGND sg13cmos5l_fill_1
* cell instance sg13cmos5l_fill_1_247 r0 *1 0,0
Xsg13cmos5l_fill_1_247 VPWR VGND sg13cmos5l_fill_1
* cell instance sg13cmos5l_fill_1_248 r0 *1 0,0
Xsg13cmos5l_fill_1_248 VPWR VGND sg13cmos5l_fill_1
* cell instance sg13cmos5l_fill_1_249 r0 *1 0,0
Xsg13cmos5l_fill_1_249 VPWR VGND sg13cmos5l_fill_1
* cell instance sg13cmos5l_fill_1_250 r0 *1 0,0
Xsg13cmos5l_fill_1_250 VPWR VGND sg13cmos5l_fill_1
* cell instance sg13cmos5l_fill_1_251 r0 *1 0,0
Xsg13cmos5l_fill_1_251 VPWR VGND sg13cmos5l_fill_1
* cell instance sg13cmos5l_fill_1_252 r0 *1 0,0
Xsg13cmos5l_fill_1_252 VPWR VGND sg13cmos5l_fill_1
* cell instance sg13cmos5l_fill_1_253 r0 *1 0,0
Xsg13cmos5l_fill_1_253 VPWR VGND sg13cmos5l_fill_1
* cell instance sg13cmos5l_fill_1_254 r0 *1 0,0
Xsg13cmos5l_fill_1_254 VPWR VGND sg13cmos5l_fill_1
* cell instance sg13cmos5l_fill_1_255 r0 *1 0,0
Xsg13cmos5l_fill_1_255 VPWR VGND sg13cmos5l_fill_1
* cell instance sg13cmos5l_fill_1_256 r0 *1 0,0
Xsg13cmos5l_fill_1_256 VPWR VGND sg13cmos5l_fill_1
* cell instance sg13cmos5l_fill_1_257 r0 *1 0,0
Xsg13cmos5l_fill_1_257 VPWR VGND sg13cmos5l_fill_1
* cell instance sg13cmos5l_fill_1_258 r0 *1 0,0
Xsg13cmos5l_fill_1_258 VPWR VGND sg13cmos5l_fill_1
* cell instance sg13cmos5l_fill_1_259 r0 *1 0,0
Xsg13cmos5l_fill_1_259 VPWR VGND sg13cmos5l_fill_1
* cell instance sg13cmos5l_fill_1_260 r0 *1 0,0
Xsg13cmos5l_fill_1_260 VPWR VGND sg13cmos5l_fill_1
* cell instance sg13cmos5l_fill_1_261 r0 *1 0,0
Xsg13cmos5l_fill_1_261 VPWR VGND sg13cmos5l_fill_1
* cell instance sg13cmos5l_fill_1_262 r0 *1 0,0
Xsg13cmos5l_fill_1_262 VPWR VGND sg13cmos5l_fill_1
* cell instance sg13cmos5l_fill_1_263 r0 *1 0,0
Xsg13cmos5l_fill_1_263 VPWR VGND sg13cmos5l_fill_1
* cell instance sg13cmos5l_fill_1_264 r0 *1 0,0
Xsg13cmos5l_fill_1_264 VPWR VGND sg13cmos5l_fill_1
* cell instance sg13cmos5l_fill_1_265 r0 *1 0,0
Xsg13cmos5l_fill_1_265 VPWR VGND sg13cmos5l_fill_1
* cell instance sg13cmos5l_fill_1_266 r0 *1 0,0
Xsg13cmos5l_fill_1_266 VPWR VGND sg13cmos5l_fill_1
* cell instance sg13cmos5l_fill_1_267 r0 *1 0,0
Xsg13cmos5l_fill_1_267 VPWR VGND sg13cmos5l_fill_1
* cell instance sg13cmos5l_fill_1_268 r0 *1 0,0
Xsg13cmos5l_fill_1_268 VPWR VGND sg13cmos5l_fill_1
* cell instance sg13cmos5l_fill_1_269 r0 *1 0,0
Xsg13cmos5l_fill_1_269 VPWR VGND sg13cmos5l_fill_1
* cell instance sg13cmos5l_fill_1_270 r0 *1 0,0
Xsg13cmos5l_fill_1_270 VPWR VGND sg13cmos5l_fill_1
* cell instance sg13cmos5l_fill_1_271 r0 *1 0,0
Xsg13cmos5l_fill_1_271 VPWR VGND sg13cmos5l_fill_1
* cell instance sg13cmos5l_fill_1_272 r0 *1 0,0
Xsg13cmos5l_fill_1_272 VPWR VGND sg13cmos5l_fill_1
* cell instance sg13cmos5l_fill_1_273 r0 *1 0,0
Xsg13cmos5l_fill_1_273 VPWR VGND sg13cmos5l_fill_1
* cell instance sg13cmos5l_fill_1_274 r0 *1 0,0
Xsg13cmos5l_fill_1_274 VPWR VGND sg13cmos5l_fill_1
* cell instance sg13cmos5l_fill_1_275 r0 *1 0,0
Xsg13cmos5l_fill_1_275 VPWR VGND sg13cmos5l_fill_1
* cell instance sg13cmos5l_fill_1_276 r0 *1 0,0
Xsg13cmos5l_fill_1_276 VPWR VGND sg13cmos5l_fill_1
* cell instance sg13cmos5l_fill_1_277 r0 *1 0,0
Xsg13cmos5l_fill_1_277 VPWR VGND sg13cmos5l_fill_1
* cell instance sg13cmos5l_fill_1_278 r0 *1 0,0
Xsg13cmos5l_fill_1_278 VPWR VGND sg13cmos5l_fill_1
* cell instance sg13cmos5l_fill_1_279 r0 *1 0,0
Xsg13cmos5l_fill_1_279 VPWR VGND sg13cmos5l_fill_1
* cell instance sg13cmos5l_fill_1_280 r0 *1 0,0
Xsg13cmos5l_fill_1_280 VPWR VGND sg13cmos5l_fill_1
* cell instance sg13cmos5l_fill_1_281 r0 *1 0,0
Xsg13cmos5l_fill_1_281 VPWR VGND sg13cmos5l_fill_1
* cell instance sg13cmos5l_fill_1_282 r0 *1 0,0
Xsg13cmos5l_fill_1_282 VPWR VGND sg13cmos5l_fill_1
* cell instance sg13cmos5l_fill_1_283 r0 *1 0,0
Xsg13cmos5l_fill_1_283 VPWR VGND sg13cmos5l_fill_1
* cell instance sg13cmos5l_fill_1_284 r0 *1 0,0
Xsg13cmos5l_fill_1_284 VPWR VGND sg13cmos5l_fill_1
* cell instance sg13cmos5l_fill_1_285 r0 *1 0,0
Xsg13cmos5l_fill_1_285 VPWR VGND sg13cmos5l_fill_1
* cell instance sg13cmos5l_fill_1_286 r0 *1 0,0
Xsg13cmos5l_fill_1_286 VPWR VGND sg13cmos5l_fill_1
* cell instance sg13cmos5l_fill_1_287 r0 *1 0,0
Xsg13cmos5l_fill_1_287 VPWR VGND sg13cmos5l_fill_1
* cell instance sg13cmos5l_fill_1_288 r0 *1 0,0
Xsg13cmos5l_fill_1_288 VPWR VGND sg13cmos5l_fill_1
* cell instance sg13cmos5l_fill_1_289 r0 *1 0,0
Xsg13cmos5l_fill_1_289 VPWR VGND sg13cmos5l_fill_1
* cell instance sg13cmos5l_fill_1_290 r0 *1 0,0
Xsg13cmos5l_fill_1_290 VPWR VGND sg13cmos5l_fill_1
* cell instance sg13cmos5l_fill_1_291 r0 *1 0,0
Xsg13cmos5l_fill_1_291 VPWR VGND sg13cmos5l_fill_1
* cell instance sg13cmos5l_fill_1_292 r0 *1 0,0
Xsg13cmos5l_fill_1_292 VPWR VGND sg13cmos5l_fill_1
* cell instance sg13cmos5l_fill_1_293 r0 *1 0,0
Xsg13cmos5l_fill_1_293 VPWR VGND sg13cmos5l_fill_1
* cell instance sg13cmos5l_fill_1_294 r0 *1 0,0
Xsg13cmos5l_fill_1_294 VPWR VGND sg13cmos5l_fill_1
* cell instance sg13cmos5l_fill_1_295 r0 *1 0,0
Xsg13cmos5l_fill_1_295 VPWR VGND sg13cmos5l_fill_1
* cell instance sg13cmos5l_fill_1_296 r0 *1 0,0
Xsg13cmos5l_fill_1_296 VPWR VGND sg13cmos5l_fill_1
* cell instance sg13cmos5l_fill_1_297 r0 *1 0,0
Xsg13cmos5l_fill_1_297 VPWR VGND sg13cmos5l_fill_1
* cell instance sg13cmos5l_fill_1_298 r0 *1 0,0
Xsg13cmos5l_fill_1_298 VPWR VGND sg13cmos5l_fill_1
* cell instance sg13cmos5l_fill_1_299 r0 *1 0,0
Xsg13cmos5l_fill_1_299 VPWR VGND sg13cmos5l_fill_1
* cell instance sg13cmos5l_fill_1_300 r0 *1 0,0
Xsg13cmos5l_fill_1_300 VPWR VGND sg13cmos5l_fill_1
* cell instance sg13cmos5l_fill_1_301 r0 *1 0,0
Xsg13cmos5l_fill_1_301 VPWR VGND sg13cmos5l_fill_1
* cell instance sg13cmos5l_fill_1_302 r0 *1 0,0
Xsg13cmos5l_fill_1_302 VPWR VGND sg13cmos5l_fill_1
* cell instance sg13cmos5l_fill_1_303 r0 *1 0,0
Xsg13cmos5l_fill_1_303 VPWR VGND sg13cmos5l_fill_1
* cell instance sg13cmos5l_fill_1_304 r0 *1 0,0
Xsg13cmos5l_fill_1_304 VPWR VGND sg13cmos5l_fill_1
* cell instance sg13cmos5l_fill_1_305 r0 *1 0,0
Xsg13cmos5l_fill_1_305 VPWR VGND sg13cmos5l_fill_1
* cell instance sg13cmos5l_fill_1_306 r0 *1 0,0
Xsg13cmos5l_fill_1_306 VPWR VGND sg13cmos5l_fill_1
* cell instance sg13cmos5l_fill_1_307 r0 *1 0,0
Xsg13cmos5l_fill_1_307 VPWR VGND sg13cmos5l_fill_1
* cell instance sg13cmos5l_fill_1_308 r0 *1 0,0
Xsg13cmos5l_fill_1_308 VPWR VGND sg13cmos5l_fill_1
* cell instance sg13cmos5l_fill_1_309 r0 *1 0,0
Xsg13cmos5l_fill_1_309 VPWR VGND sg13cmos5l_fill_1
* cell instance sg13cmos5l_fill_1_310 r0 *1 0,0
Xsg13cmos5l_fill_1_310 VPWR VGND sg13cmos5l_fill_1
* cell instance sg13cmos5l_fill_1_311 r0 *1 0,0
Xsg13cmos5l_fill_1_311 VPWR VGND sg13cmos5l_fill_1
* cell instance sg13cmos5l_fill_1_312 r0 *1 0,0
Xsg13cmos5l_fill_1_312 VPWR VGND sg13cmos5l_fill_1
* cell instance sg13cmos5l_fill_1_313 r0 *1 0,0
Xsg13cmos5l_fill_1_313 VPWR VGND sg13cmos5l_fill_1
* cell instance sg13cmos5l_fill_1_314 r0 *1 0,0
Xsg13cmos5l_fill_1_314 VPWR VGND sg13cmos5l_fill_1
* cell instance sg13cmos5l_fill_1_315 r0 *1 0,0
Xsg13cmos5l_fill_1_315 VPWR VGND sg13cmos5l_fill_1
* cell instance sg13cmos5l_fill_1_316 r0 *1 0,0
Xsg13cmos5l_fill_1_316 VPWR VGND sg13cmos5l_fill_1
* cell instance sg13cmos5l_fill_1_317 r0 *1 0,0
Xsg13cmos5l_fill_1_317 VPWR VGND sg13cmos5l_fill_1
* cell instance sg13cmos5l_fill_1_318 r0 *1 0,0
Xsg13cmos5l_fill_1_318 VPWR VGND sg13cmos5l_fill_1
* cell instance sg13cmos5l_fill_1_319 r0 *1 0,0
Xsg13cmos5l_fill_1_319 VPWR VGND sg13cmos5l_fill_1
* cell instance sg13cmos5l_fill_1_320 r0 *1 0,0
Xsg13cmos5l_fill_1_320 VPWR VGND sg13cmos5l_fill_1
* cell instance sg13cmos5l_fill_1_321 r0 *1 0,0
Xsg13cmos5l_fill_1_321 VPWR VGND sg13cmos5l_fill_1
* cell instance sg13cmos5l_fill_1_322 r0 *1 0,0
Xsg13cmos5l_fill_1_322 VPWR VGND sg13cmos5l_fill_1
* cell instance sg13cmos5l_fill_1_323 r0 *1 0,0
Xsg13cmos5l_fill_1_323 VPWR VGND sg13cmos5l_fill_1
* cell instance sg13cmos5l_fill_1_324 r0 *1 0,0
Xsg13cmos5l_fill_1_324 VPWR VGND sg13cmos5l_fill_1
* cell instance sg13cmos5l_fill_1_325 r0 *1 0,0
Xsg13cmos5l_fill_1_325 VPWR VGND sg13cmos5l_fill_1
* cell instance sg13cmos5l_fill_1_326 r0 *1 0,0
Xsg13cmos5l_fill_1_326 VPWR VGND sg13cmos5l_fill_1
* cell instance sg13cmos5l_fill_1_327 r0 *1 0,0
Xsg13cmos5l_fill_1_327 VPWR VGND sg13cmos5l_fill_1
* cell instance sg13cmos5l_fill_1_328 r0 *1 0,0
Xsg13cmos5l_fill_1_328 VPWR VGND sg13cmos5l_fill_1
* cell instance sg13cmos5l_fill_1_329 r0 *1 0,0
Xsg13cmos5l_fill_1_329 VPWR VGND sg13cmos5l_fill_1
* cell instance sg13cmos5l_fill_1_330 r0 *1 0,0
Xsg13cmos5l_fill_1_330 VPWR VGND sg13cmos5l_fill_1
* cell instance sg13cmos5l_fill_1_331 r0 *1 0,0
Xsg13cmos5l_fill_1_331 VPWR VGND sg13cmos5l_fill_1
* cell instance sg13cmos5l_fill_1_332 r0 *1 0,0
Xsg13cmos5l_fill_1_332 VPWR VGND sg13cmos5l_fill_1
* cell instance sg13cmos5l_fill_1_333 r0 *1 0,0
Xsg13cmos5l_fill_1_333 VPWR VGND sg13cmos5l_fill_1
* cell instance sg13cmos5l_fill_1_334 r0 *1 0,0
Xsg13cmos5l_fill_1_334 VPWR VGND sg13cmos5l_fill_1
* cell instance sg13cmos5l_fill_1_335 r0 *1 0,0
Xsg13cmos5l_fill_1_335 VPWR VGND sg13cmos5l_fill_1
* cell instance sg13cmos5l_fill_1_336 r0 *1 0,0
Xsg13cmos5l_fill_1_336 VPWR VGND sg13cmos5l_fill_1
* cell instance sg13cmos5l_fill_1_337 r0 *1 0,0
Xsg13cmos5l_fill_1_337 VPWR VGND sg13cmos5l_fill_1
* cell instance sg13cmos5l_fill_1_338 r0 *1 0,0
Xsg13cmos5l_fill_1_338 VPWR VGND sg13cmos5l_fill_1
* cell instance sg13cmos5l_fill_1_339 r0 *1 0,0
Xsg13cmos5l_fill_1_339 VPWR VGND sg13cmos5l_fill_1
* cell instance sg13cmos5l_fill_1_340 r0 *1 0,0
Xsg13cmos5l_fill_1_340 VPWR VGND sg13cmos5l_fill_1
* cell instance sg13cmos5l_fill_1_341 r0 *1 0,0
Xsg13cmos5l_fill_1_341 VPWR VGND sg13cmos5l_fill_1
* cell instance sg13cmos5l_fill_1_342 r0 *1 0,0
Xsg13cmos5l_fill_1_342 VPWR VGND sg13cmos5l_fill_1
* cell instance sg13cmos5l_fill_1_343 r0 *1 0,0
Xsg13cmos5l_fill_1_343 VPWR VGND sg13cmos5l_fill_1
* cell instance sg13cmos5l_fill_1_344 r0 *1 0,0
Xsg13cmos5l_fill_1_344 VPWR VGND sg13cmos5l_fill_1
* cell instance sg13cmos5l_fill_1_345 r0 *1 0,0
Xsg13cmos5l_fill_1_345 VPWR VGND sg13cmos5l_fill_1
* cell instance sg13cmos5l_fill_1_346 r0 *1 0,0
Xsg13cmos5l_fill_1_346 VPWR VGND sg13cmos5l_fill_1
* cell instance sg13cmos5l_fill_1_347 r0 *1 0,0
Xsg13cmos5l_fill_1_347 VPWR VGND sg13cmos5l_fill_1
* cell instance sg13cmos5l_fill_1_348 r0 *1 0,0
Xsg13cmos5l_fill_1_348 VPWR VGND sg13cmos5l_fill_1
* cell instance sg13cmos5l_fill_1_349 r0 *1 0,0
Xsg13cmos5l_fill_1_349 VPWR VGND sg13cmos5l_fill_1
* cell instance sg13cmos5l_fill_1_350 r0 *1 0,0
Xsg13cmos5l_fill_1_350 VPWR VGND sg13cmos5l_fill_1
* cell instance sg13cmos5l_fill_1_351 r0 *1 0,0
Xsg13cmos5l_fill_1_351 VPWR VGND sg13cmos5l_fill_1
* cell instance sg13cmos5l_fill_1_352 r0 *1 0,0
Xsg13cmos5l_fill_1_352 VPWR VGND sg13cmos5l_fill_1
* cell instance sg13cmos5l_fill_1_353 r0 *1 0,0
Xsg13cmos5l_fill_1_353 VPWR VGND sg13cmos5l_fill_1
* cell instance sg13cmos5l_fill_1_354 r0 *1 0,0
Xsg13cmos5l_fill_1_354 VPWR VGND sg13cmos5l_fill_1
* cell instance sg13cmos5l_fill_1_355 r0 *1 0,0
Xsg13cmos5l_fill_1_355 VPWR VGND sg13cmos5l_fill_1
* cell instance sg13cmos5l_fill_1_356 r0 *1 0,0
Xsg13cmos5l_fill_1_356 VPWR VGND sg13cmos5l_fill_1
* cell instance sg13cmos5l_fill_1_357 r0 *1 0,0
Xsg13cmos5l_fill_1_357 VPWR VGND sg13cmos5l_fill_1
* cell instance sg13cmos5l_fill_1_358 r0 *1 0,0
Xsg13cmos5l_fill_1_358 VPWR VGND sg13cmos5l_fill_1
* cell instance sg13cmos5l_fill_1_359 r0 *1 0,0
Xsg13cmos5l_fill_1_359 VPWR VGND sg13cmos5l_fill_1
* cell instance sg13cmos5l_fill_1_360 r0 *1 0,0
Xsg13cmos5l_fill_1_360 VPWR VGND sg13cmos5l_fill_1
* cell instance sg13cmos5l_fill_1_361 r0 *1 0,0
Xsg13cmos5l_fill_1_361 VPWR VGND sg13cmos5l_fill_1
* cell instance sg13cmos5l_fill_1_362 r0 *1 0,0
Xsg13cmos5l_fill_1_362 VPWR VGND sg13cmos5l_fill_1
* cell instance sg13cmos5l_fill_1_363 r0 *1 0,0
Xsg13cmos5l_fill_1_363 VPWR VGND sg13cmos5l_fill_1
* cell instance sg13cmos5l_fill_1_364 r0 *1 0,0
Xsg13cmos5l_fill_1_364 VPWR VGND sg13cmos5l_fill_1
* cell instance sg13cmos5l_fill_1_365 r0 *1 0,0
Xsg13cmos5l_fill_1_365 VPWR VGND sg13cmos5l_fill_1
* cell instance sg13cmos5l_fill_1_366 r0 *1 0,0
Xsg13cmos5l_fill_1_366 VPWR VGND sg13cmos5l_fill_1
* cell instance sg13cmos5l_fill_1_367 r0 *1 0,0
Xsg13cmos5l_fill_1_367 VPWR VGND sg13cmos5l_fill_1
* cell instance sg13cmos5l_fill_1_368 r0 *1 0,0
Xsg13cmos5l_fill_1_368 VPWR VGND sg13cmos5l_fill_1
* cell instance sg13cmos5l_fill_1_369 r0 *1 0,0
Xsg13cmos5l_fill_1_369 VPWR VGND sg13cmos5l_fill_1
* cell instance sg13cmos5l_fill_1_370 r0 *1 0,0
Xsg13cmos5l_fill_1_370 VPWR VGND sg13cmos5l_fill_1
* cell instance sg13cmos5l_fill_1_371 r0 *1 0,0
Xsg13cmos5l_fill_1_371 VPWR VGND sg13cmos5l_fill_1
* cell instance sg13cmos5l_fill_1_372 r0 *1 0,0
Xsg13cmos5l_fill_1_372 VPWR VGND sg13cmos5l_fill_1
* cell instance sg13cmos5l_fill_1_373 r0 *1 0,0
Xsg13cmos5l_fill_1_373 VPWR VGND sg13cmos5l_fill_1
* cell instance sg13cmos5l_fill_1_374 r0 *1 0,0
Xsg13cmos5l_fill_1_374 VPWR VGND sg13cmos5l_fill_1
* cell instance sg13cmos5l_fill_1_375 r0 *1 0,0
Xsg13cmos5l_fill_1_375 VPWR VGND sg13cmos5l_fill_1
* cell instance sg13cmos5l_fill_1_376 r0 *1 0,0
Xsg13cmos5l_fill_1_376 VPWR VGND sg13cmos5l_fill_1
* cell instance sg13cmos5l_fill_1_377 r0 *1 0,0
Xsg13cmos5l_fill_1_377 VPWR VGND sg13cmos5l_fill_1
* cell instance sg13cmos5l_fill_1_378 r0 *1 0,0
Xsg13cmos5l_fill_1_378 VPWR VGND sg13cmos5l_fill_1
* cell instance sg13cmos5l_fill_1_379 r0 *1 0,0
Xsg13cmos5l_fill_1_379 VPWR VGND sg13cmos5l_fill_1
* cell instance sg13cmos5l_fill_1_380 r0 *1 0,0
Xsg13cmos5l_fill_1_380 VPWR VGND sg13cmos5l_fill_1
* cell instance sg13cmos5l_fill_1_381 r0 *1 0,0
Xsg13cmos5l_fill_1_381 VPWR VGND sg13cmos5l_fill_1
* cell instance sg13cmos5l_fill_1_382 r0 *1 0,0
Xsg13cmos5l_fill_1_382 VPWR VGND sg13cmos5l_fill_1
* cell instance sg13cmos5l_fill_1_383 r0 *1 0,0
Xsg13cmos5l_fill_1_383 VPWR VGND sg13cmos5l_fill_1
* cell instance sg13cmos5l_fill_1_384 r0 *1 0,0
Xsg13cmos5l_fill_1_384 VPWR VGND sg13cmos5l_fill_1
* cell instance sg13cmos5l_fill_1_385 r0 *1 0,0
Xsg13cmos5l_fill_1_385 VPWR VGND sg13cmos5l_fill_1
* cell instance sg13cmos5l_fill_1_386 r0 *1 0,0
Xsg13cmos5l_fill_1_386 VPWR VGND sg13cmos5l_fill_1
* cell instance sg13cmos5l_fill_1_387 r0 *1 0,0
Xsg13cmos5l_fill_1_387 VPWR VGND sg13cmos5l_fill_1
* cell instance sg13cmos5l_fill_1_388 r0 *1 0,0
Xsg13cmos5l_fill_1_388 VPWR VGND sg13cmos5l_fill_1
* cell instance sg13cmos5l_fill_1_389 r0 *1 0,0
Xsg13cmos5l_fill_1_389 VPWR VGND sg13cmos5l_fill_1
* cell instance sg13cmos5l_fill_1_390 r0 *1 0,0
Xsg13cmos5l_fill_1_390 VPWR VGND sg13cmos5l_fill_1
* cell instance sg13cmos5l_fill_1_391 r0 *1 0,0
Xsg13cmos5l_fill_1_391 VPWR VGND sg13cmos5l_fill_1
* cell instance sg13cmos5l_fill_1_392 r0 *1 0,0
Xsg13cmos5l_fill_1_392 VPWR VGND sg13cmos5l_fill_1
* cell instance sg13cmos5l_fill_1_393 r0 *1 0,0
Xsg13cmos5l_fill_1_393 VPWR VGND sg13cmos5l_fill_1
* cell instance sg13cmos5l_fill_1_394 r0 *1 0,0
Xsg13cmos5l_fill_1_394 VPWR VGND sg13cmos5l_fill_1
* cell instance sg13cmos5l_fill_1_395 r0 *1 0,0
Xsg13cmos5l_fill_1_395 VPWR VGND sg13cmos5l_fill_1
* cell instance sg13cmos5l_fill_1_396 r0 *1 0,0
Xsg13cmos5l_fill_1_396 VPWR VGND sg13cmos5l_fill_1
* cell instance sg13cmos5l_fill_1_397 r0 *1 0,0
Xsg13cmos5l_fill_1_397 VPWR VGND sg13cmos5l_fill_1
* cell instance sg13cmos5l_fill_1_398 r0 *1 0,0
Xsg13cmos5l_fill_1_398 VPWR VGND sg13cmos5l_fill_1
* cell instance sg13cmos5l_fill_1_399 r0 *1 0,0
Xsg13cmos5l_fill_1_399 VPWR VGND sg13cmos5l_fill_1
* cell instance sg13cmos5l_fill_1_400 r0 *1 0,0
Xsg13cmos5l_fill_1_400 VPWR VGND sg13cmos5l_fill_1
* cell instance sg13cmos5l_fill_1_401 r0 *1 0,0
Xsg13cmos5l_fill_1_401 VPWR VGND sg13cmos5l_fill_1
* cell instance sg13cmos5l_fill_1_402 r0 *1 0,0
Xsg13cmos5l_fill_1_402 VPWR VGND sg13cmos5l_fill_1
* cell instance sg13cmos5l_fill_1_403 r0 *1 0,0
Xsg13cmos5l_fill_1_403 VPWR VGND sg13cmos5l_fill_1
* cell instance sg13cmos5l_fill_1_404 r0 *1 0,0
Xsg13cmos5l_fill_1_404 VPWR VGND sg13cmos5l_fill_1
* cell instance sg13cmos5l_fill_1_405 r0 *1 0,0
Xsg13cmos5l_fill_1_405 VPWR VGND sg13cmos5l_fill_1
* cell instance sg13cmos5l_fill_1_406 r0 *1 0,0
Xsg13cmos5l_fill_1_406 VPWR VGND sg13cmos5l_fill_1
* cell instance sg13cmos5l_fill_1_407 r0 *1 0,0
Xsg13cmos5l_fill_1_407 VPWR VGND sg13cmos5l_fill_1
* cell instance sg13cmos5l_fill_1_408 r0 *1 0,0
Xsg13cmos5l_fill_1_408 VPWR VGND sg13cmos5l_fill_1
* cell instance sg13cmos5l_fill_1_409 r0 *1 0,0
Xsg13cmos5l_fill_1_409 VPWR VGND sg13cmos5l_fill_1
* cell instance sg13cmos5l_fill_1_410 r0 *1 0,0
Xsg13cmos5l_fill_1_410 VPWR VGND sg13cmos5l_fill_1
* cell instance sg13cmos5l_fill_1_411 r0 *1 0,0
Xsg13cmos5l_fill_1_411 VPWR VGND sg13cmos5l_fill_1
* cell instance sg13cmos5l_fill_1_412 r0 *1 0,0
Xsg13cmos5l_fill_1_412 VPWR VGND sg13cmos5l_fill_1
* cell instance sg13cmos5l_fill_1_413 r0 *1 0,0
Xsg13cmos5l_fill_1_413 VPWR VGND sg13cmos5l_fill_1
* cell instance sg13cmos5l_fill_1_414 r0 *1 0,0
Xsg13cmos5l_fill_1_414 VPWR VGND sg13cmos5l_fill_1
* cell instance sg13cmos5l_fill_1_415 r0 *1 0,0
Xsg13cmos5l_fill_1_415 VPWR VGND sg13cmos5l_fill_1
* cell instance sg13cmos5l_fill_1_416 r0 *1 0,0
Xsg13cmos5l_fill_1_416 VPWR VGND sg13cmos5l_fill_1
* cell instance sg13cmos5l_fill_1_417 r0 *1 0,0
Xsg13cmos5l_fill_1_417 VPWR VGND sg13cmos5l_fill_1
* cell instance sg13cmos5l_fill_1_418 r0 *1 0,0
Xsg13cmos5l_fill_1_418 VPWR VGND sg13cmos5l_fill_1
* cell instance sg13cmos5l_fill_1_419 r0 *1 0,0
Xsg13cmos5l_fill_1_419 VPWR VGND sg13cmos5l_fill_1
* cell instance sg13cmos5l_fill_1_420 r0 *1 0,0
Xsg13cmos5l_fill_1_420 VPWR VGND sg13cmos5l_fill_1
* cell instance sg13cmos5l_fill_1_421 r0 *1 0,0
Xsg13cmos5l_fill_1_421 VPWR VGND sg13cmos5l_fill_1
* cell instance sg13cmos5l_fill_1_422 r0 *1 0,0
Xsg13cmos5l_fill_1_422 VPWR VGND sg13cmos5l_fill_1
* cell instance sg13cmos5l_fill_1_423 r0 *1 0,0
Xsg13cmos5l_fill_1_423 VPWR VGND sg13cmos5l_fill_1
* cell instance sg13cmos5l_fill_1_424 r0 *1 0,0
Xsg13cmos5l_fill_1_424 VPWR VGND sg13cmos5l_fill_1
* cell instance sg13cmos5l_fill_1_425 r0 *1 0,0
Xsg13cmos5l_fill_1_425 VPWR VGND sg13cmos5l_fill_1
* cell instance sg13cmos5l_fill_1_426 r0 *1 0,0
Xsg13cmos5l_fill_1_426 VPWR VGND sg13cmos5l_fill_1
* cell instance sg13cmos5l_fill_1_427 r0 *1 0,0
Xsg13cmos5l_fill_1_427 VPWR VGND sg13cmos5l_fill_1
* cell instance sg13cmos5l_fill_1_428 r0 *1 0,0
Xsg13cmos5l_fill_1_428 VPWR VGND sg13cmos5l_fill_1
* cell instance sg13cmos5l_fill_1_429 r0 *1 0,0
Xsg13cmos5l_fill_1_429 VPWR VGND sg13cmos5l_fill_1
* cell instance sg13cmos5l_fill_1_430 r0 *1 0,0
Xsg13cmos5l_fill_1_430 VPWR VGND sg13cmos5l_fill_1
* cell instance sg13cmos5l_fill_1_431 r0 *1 0,0
Xsg13cmos5l_fill_1_431 VPWR VGND sg13cmos5l_fill_1
* cell instance sg13cmos5l_fill_1_432 r0 *1 0,0
Xsg13cmos5l_fill_1_432 VPWR VGND sg13cmos5l_fill_1
* cell instance sg13cmos5l_fill_1_433 r0 *1 0,0
Xsg13cmos5l_fill_1_433 VPWR VGND sg13cmos5l_fill_1
* cell instance sg13cmos5l_fill_1_434 r0 *1 0,0
Xsg13cmos5l_fill_1_434 VPWR VGND sg13cmos5l_fill_1
* cell instance sg13cmos5l_fill_1_435 r0 *1 0,0
Xsg13cmos5l_fill_1_435 VPWR VGND sg13cmos5l_fill_1
* cell instance sg13cmos5l_fill_1_436 r0 *1 0,0
Xsg13cmos5l_fill_1_436 VPWR VGND sg13cmos5l_fill_1
* cell instance sg13cmos5l_fill_1_437 r0 *1 0,0
Xsg13cmos5l_fill_1_437 VPWR VGND sg13cmos5l_fill_1
* cell instance sg13cmos5l_fill_1_438 r0 *1 0,0
Xsg13cmos5l_fill_1_438 VPWR VGND sg13cmos5l_fill_1
* cell instance sg13cmos5l_fill_1_439 r0 *1 0,0
Xsg13cmos5l_fill_1_439 VPWR VGND sg13cmos5l_fill_1
* cell instance sg13cmos5l_fill_1_440 r0 *1 0,0
Xsg13cmos5l_fill_1_440 VPWR VGND sg13cmos5l_fill_1
* cell instance sg13cmos5l_fill_1_441 r0 *1 0,0
Xsg13cmos5l_fill_1_441 VPWR VGND sg13cmos5l_fill_1
* cell instance sg13cmos5l_fill_1_442 r0 *1 0,0
Xsg13cmos5l_fill_1_442 VPWR VGND sg13cmos5l_fill_1
* cell instance sg13cmos5l_fill_1_443 r0 *1 0,0
Xsg13cmos5l_fill_1_443 VPWR VGND sg13cmos5l_fill_1
* cell instance sg13cmos5l_fill_1_444 r0 *1 0,0
Xsg13cmos5l_fill_1_444 VPWR VGND sg13cmos5l_fill_1
* cell instance sg13cmos5l_fill_1_445 r0 *1 0,0
Xsg13cmos5l_fill_1_445 VPWR VGND sg13cmos5l_fill_1
* cell instance sg13cmos5l_fill_1_446 r0 *1 0,0
Xsg13cmos5l_fill_1_446 VPWR VGND sg13cmos5l_fill_1
* cell instance sg13cmos5l_fill_1_447 r0 *1 0,0
Xsg13cmos5l_fill_1_447 VPWR VGND sg13cmos5l_fill_1
* cell instance sg13cmos5l_fill_1_448 r0 *1 0,0
Xsg13cmos5l_fill_1_448 VPWR VGND sg13cmos5l_fill_1
* cell instance sg13cmos5l_fill_1_449 r0 *1 0,0
Xsg13cmos5l_fill_1_449 VPWR VGND sg13cmos5l_fill_1
* cell instance sg13cmos5l_fill_1_450 r0 *1 0,0
Xsg13cmos5l_fill_1_450 VPWR VGND sg13cmos5l_fill_1
* cell instance sg13cmos5l_fill_1_451 r0 *1 0,0
Xsg13cmos5l_fill_1_451 VPWR VGND sg13cmos5l_fill_1
* cell instance sg13cmos5l_fill_1_452 r0 *1 0,0
Xsg13cmos5l_fill_1_452 VPWR VGND sg13cmos5l_fill_1
* cell instance sg13cmos5l_fill_1_453 r0 *1 0,0
Xsg13cmos5l_fill_1_453 VPWR VGND sg13cmos5l_fill_1
* cell instance sg13cmos5l_fill_1_454 r0 *1 0,0
Xsg13cmos5l_fill_1_454 VPWR VGND sg13cmos5l_fill_1
* cell instance sg13cmos5l_fill_1_455 r0 *1 0,0
Xsg13cmos5l_fill_1_455 VPWR VGND sg13cmos5l_fill_1
* cell instance sg13cmos5l_fill_1_456 r0 *1 0,0
Xsg13cmos5l_fill_1_456 VPWR VGND sg13cmos5l_fill_1
* cell instance sg13cmos5l_fill_1_457 r0 *1 0,0
Xsg13cmos5l_fill_1_457 VPWR VGND sg13cmos5l_fill_1
* cell instance sg13cmos5l_fill_1_458 r0 *1 0,0
Xsg13cmos5l_fill_1_458 VPWR VGND sg13cmos5l_fill_1
* cell instance sg13cmos5l_fill_1_459 r0 *1 0,0
Xsg13cmos5l_fill_1_459 VPWR VGND sg13cmos5l_fill_1
* cell instance sg13cmos5l_fill_1_460 r0 *1 0,0
Xsg13cmos5l_fill_1_460 VPWR VGND sg13cmos5l_fill_1
* cell instance sg13cmos5l_fill_1_461 r0 *1 0,0
Xsg13cmos5l_fill_1_461 VPWR VGND sg13cmos5l_fill_1
* cell instance sg13cmos5l_fill_1_462 r0 *1 0,0
Xsg13cmos5l_fill_1_462 VPWR VGND sg13cmos5l_fill_1
* cell instance sg13cmos5l_fill_1_463 r0 *1 0,0
Xsg13cmos5l_fill_1_463 VPWR VGND sg13cmos5l_fill_1
* cell instance sg13cmos5l_fill_1_464 r0 *1 0,0
Xsg13cmos5l_fill_1_464 VPWR VGND sg13cmos5l_fill_1
* cell instance sg13cmos5l_fill_1_465 r0 *1 0,0
Xsg13cmos5l_fill_1_465 VPWR VGND sg13cmos5l_fill_1
* cell instance sg13cmos5l_fill_1_466 r0 *1 0,0
Xsg13cmos5l_fill_1_466 VPWR VGND sg13cmos5l_fill_1
* cell instance sg13cmos5l_fill_1_467 r0 *1 0,0
Xsg13cmos5l_fill_1_467 VPWR VGND sg13cmos5l_fill_1
* cell instance sg13cmos5l_fill_1_468 r0 *1 0,0
Xsg13cmos5l_fill_1_468 VPWR VGND sg13cmos5l_fill_1
* cell instance sg13cmos5l_fill_1_469 r0 *1 0,0
Xsg13cmos5l_fill_1_469 VPWR VGND sg13cmos5l_fill_1
* cell instance sg13cmos5l_fill_1_470 r0 *1 0,0
Xsg13cmos5l_fill_1_470 VPWR VGND sg13cmos5l_fill_1
* cell instance sg13cmos5l_fill_1_471 r0 *1 0,0
Xsg13cmos5l_fill_1_471 VPWR VGND sg13cmos5l_fill_1
* cell instance sg13cmos5l_fill_1_472 r0 *1 0,0
Xsg13cmos5l_fill_1_472 VPWR VGND sg13cmos5l_fill_1
* cell instance sg13cmos5l_fill_1_473 r0 *1 0,0
Xsg13cmos5l_fill_1_473 VPWR VGND sg13cmos5l_fill_1
* cell instance sg13cmos5l_fill_1_474 r0 *1 0,0
Xsg13cmos5l_fill_1_474 VPWR VGND sg13cmos5l_fill_1
* cell instance sg13cmos5l_fill_1_475 r0 *1 0,0
Xsg13cmos5l_fill_1_475 VPWR VGND sg13cmos5l_fill_1
* cell instance sg13cmos5l_fill_1_476 r0 *1 0,0
Xsg13cmos5l_fill_1_476 VPWR VGND sg13cmos5l_fill_1
* cell instance sg13cmos5l_fill_1_477 r0 *1 0,0
Xsg13cmos5l_fill_1_477 VPWR VGND sg13cmos5l_fill_1
* cell instance sg13cmos5l_fill_1_478 r0 *1 0,0
Xsg13cmos5l_fill_1_478 VPWR VGND sg13cmos5l_fill_1
* cell instance sg13cmos5l_fill_1_479 r0 *1 0,0
Xsg13cmos5l_fill_1_479 VPWR VGND sg13cmos5l_fill_1
* cell instance sg13cmos5l_fill_1_480 r0 *1 0,0
Xsg13cmos5l_fill_1_480 VPWR VGND sg13cmos5l_fill_1
* cell instance sg13cmos5l_fill_1_481 r0 *1 0,0
Xsg13cmos5l_fill_1_481 VPWR VGND sg13cmos5l_fill_1
* cell instance sg13cmos5l_fill_1_482 r0 *1 0,0
Xsg13cmos5l_fill_1_482 VPWR VGND sg13cmos5l_fill_1
* cell instance sg13cmos5l_fill_1_483 r0 *1 0,0
Xsg13cmos5l_fill_1_483 VPWR VGND sg13cmos5l_fill_1
* cell instance sg13cmos5l_fill_1_484 r0 *1 0,0
Xsg13cmos5l_fill_1_484 VPWR VGND sg13cmos5l_fill_1
* cell instance sg13cmos5l_fill_1_485 r0 *1 0,0
Xsg13cmos5l_fill_1_485 VPWR VGND sg13cmos5l_fill_1
* cell instance sg13cmos5l_fill_1_486 r0 *1 0,0
Xsg13cmos5l_fill_1_486 VPWR VGND sg13cmos5l_fill_1
* cell instance sg13cmos5l_fill_1_487 r0 *1 0,0
Xsg13cmos5l_fill_1_487 VPWR VGND sg13cmos5l_fill_1
* cell instance sg13cmos5l_fill_1_488 r0 *1 0,0
Xsg13cmos5l_fill_1_488 VPWR VGND sg13cmos5l_fill_1
* cell instance sg13cmos5l_fill_1_489 r0 *1 0,0
Xsg13cmos5l_fill_1_489 VPWR VGND sg13cmos5l_fill_1
* cell instance sg13cmos5l_fill_1_490 r0 *1 0,0
Xsg13cmos5l_fill_1_490 VPWR VGND sg13cmos5l_fill_1
* cell instance sg13cmos5l_fill_1_491 r0 *1 0,0
Xsg13cmos5l_fill_1_491 VPWR VGND sg13cmos5l_fill_1
* cell instance sg13cmos5l_fill_1_492 r0 *1 0,0
Xsg13cmos5l_fill_1_492 VPWR VGND sg13cmos5l_fill_1
* cell instance sg13cmos5l_fill_1_493 r0 *1 0,0
Xsg13cmos5l_fill_1_493 VPWR VGND sg13cmos5l_fill_1
* cell instance sg13cmos5l_fill_1_494 r0 *1 0,0
Xsg13cmos5l_fill_1_494 VPWR VGND sg13cmos5l_fill_1
* cell instance sg13cmos5l_fill_1_495 r0 *1 0,0
Xsg13cmos5l_fill_1_495 VPWR VGND sg13cmos5l_fill_1
* cell instance sg13cmos5l_fill_1_496 r0 *1 0,0
Xsg13cmos5l_fill_1_496 VPWR VGND sg13cmos5l_fill_1
* cell instance sg13cmos5l_fill_1_497 r0 *1 0,0
Xsg13cmos5l_fill_1_497 VPWR VGND sg13cmos5l_fill_1
* cell instance sg13cmos5l_fill_1_498 r0 *1 0,0
Xsg13cmos5l_fill_1_498 VPWR VGND sg13cmos5l_fill_1
* cell instance sg13cmos5l_fill_1_499 r0 *1 0,0
Xsg13cmos5l_fill_1_499 VPWR VGND sg13cmos5l_fill_1
* cell instance sg13cmos5l_fill_1_500 r0 *1 0,0
Xsg13cmos5l_fill_1_500 VPWR VGND sg13cmos5l_fill_1
* cell instance sg13cmos5l_fill_1_501 r0 *1 0,0
Xsg13cmos5l_fill_1_501 VPWR VGND sg13cmos5l_fill_1
* cell instance sg13cmos5l_fill_1_502 r0 *1 0,0
Xsg13cmos5l_fill_1_502 VPWR VGND sg13cmos5l_fill_1
* cell instance sg13cmos5l_fill_1_503 r0 *1 0,0
Xsg13cmos5l_fill_1_503 VPWR VGND sg13cmos5l_fill_1
* cell instance sg13cmos5l_fill_1_504 r0 *1 0,0
Xsg13cmos5l_fill_1_504 VPWR VGND sg13cmos5l_fill_1
* cell instance sg13cmos5l_fill_1_505 r0 *1 0,0
Xsg13cmos5l_fill_1_505 VPWR VGND sg13cmos5l_fill_1
* cell instance sg13cmos5l_fill_1_506 r0 *1 0,0
Xsg13cmos5l_fill_1_506 VPWR VGND sg13cmos5l_fill_1
* cell instance sg13cmos5l_fill_1_507 r0 *1 0,0
Xsg13cmos5l_fill_1_507 VPWR VGND sg13cmos5l_fill_1
* cell instance sg13cmos5l_fill_1_508 r0 *1 0,0
Xsg13cmos5l_fill_1_508 VPWR VGND sg13cmos5l_fill_1
* cell instance sg13cmos5l_fill_1_509 r0 *1 0,0
Xsg13cmos5l_fill_1_509 VPWR VGND sg13cmos5l_fill_1
* cell instance sg13cmos5l_fill_1_510 r0 *1 0,0
Xsg13cmos5l_fill_1_510 VPWR VGND sg13cmos5l_fill_1
* cell instance sg13cmos5l_fill_1_511 r0 *1 0,0
Xsg13cmos5l_fill_1_511 VPWR VGND sg13cmos5l_fill_1
* cell instance sg13cmos5l_fill_1_512 r0 *1 0,0
Xsg13cmos5l_fill_1_512 VPWR VGND sg13cmos5l_fill_1
* cell instance sg13cmos5l_fill_1_513 r0 *1 0,0
Xsg13cmos5l_fill_1_513 VPWR VGND sg13cmos5l_fill_1
* cell instance sg13cmos5l_fill_1_514 r0 *1 0,0
Xsg13cmos5l_fill_1_514 VPWR VGND sg13cmos5l_fill_1
* cell instance sg13cmos5l_fill_1_515 r0 *1 0,0
Xsg13cmos5l_fill_1_515 VPWR VGND sg13cmos5l_fill_1
* cell instance sg13cmos5l_fill_1_516 r0 *1 0,0
Xsg13cmos5l_fill_1_516 VPWR VGND sg13cmos5l_fill_1
* cell instance sg13cmos5l_fill_1_517 r0 *1 0,0
Xsg13cmos5l_fill_1_517 VPWR VGND sg13cmos5l_fill_1
* cell instance sg13cmos5l_fill_1_518 r0 *1 0,0
Xsg13cmos5l_fill_1_518 VPWR VGND sg13cmos5l_fill_1
* cell instance sg13cmos5l_fill_1_519 r0 *1 0,0
Xsg13cmos5l_fill_1_519 VPWR VGND sg13cmos5l_fill_1
* cell instance sg13cmos5l_fill_1_520 r0 *1 0,0
Xsg13cmos5l_fill_1_520 VPWR VGND sg13cmos5l_fill_1
* cell instance sg13cmos5l_fill_1_521 r0 *1 0,0
Xsg13cmos5l_fill_1_521 VPWR VGND sg13cmos5l_fill_1
* cell instance sg13cmos5l_fill_1_522 r0 *1 0,0
Xsg13cmos5l_fill_1_522 VPWR VGND sg13cmos5l_fill_1
* cell instance sg13cmos5l_fill_1_523 r0 *1 0,0
Xsg13cmos5l_fill_1_523 VPWR VGND sg13cmos5l_fill_1
* cell instance sg13cmos5l_fill_1_524 r0 *1 0,0
Xsg13cmos5l_fill_1_524 VPWR VGND sg13cmos5l_fill_1
* cell instance sg13cmos5l_fill_1_525 r0 *1 0,0
Xsg13cmos5l_fill_1_525 VPWR VGND sg13cmos5l_fill_1
* cell instance sg13cmos5l_fill_1_526 r0 *1 0,0
Xsg13cmos5l_fill_1_526 VPWR VGND sg13cmos5l_fill_1
* cell instance sg13cmos5l_fill_1_527 r0 *1 0,0
Xsg13cmos5l_fill_1_527 VPWR VGND sg13cmos5l_fill_1
* cell instance sg13cmos5l_fill_1_528 r0 *1 0,0
Xsg13cmos5l_fill_1_528 VPWR VGND sg13cmos5l_fill_1
* cell instance sg13cmos5l_fill_1_529 r0 *1 0,0
Xsg13cmos5l_fill_1_529 VPWR VGND sg13cmos5l_fill_1
* cell instance sg13cmos5l_fill_1_530 r0 *1 0,0
Xsg13cmos5l_fill_1_530 VPWR VGND sg13cmos5l_fill_1
* cell instance sg13cmos5l_fill_1_531 r0 *1 0,0
Xsg13cmos5l_fill_1_531 VPWR VGND sg13cmos5l_fill_1
* cell instance sg13cmos5l_fill_1_532 r0 *1 0,0
Xsg13cmos5l_fill_1_532 VPWR VGND sg13cmos5l_fill_1
* cell instance sg13cmos5l_fill_1_533 r0 *1 0,0
Xsg13cmos5l_fill_1_533 VPWR VGND sg13cmos5l_fill_1
* cell instance sg13cmos5l_fill_1_534 r0 *1 0,0
Xsg13cmos5l_fill_1_534 VPWR VGND sg13cmos5l_fill_1
* cell instance sg13cmos5l_fill_1_535 r0 *1 0,0
Xsg13cmos5l_fill_1_535 VPWR VGND sg13cmos5l_fill_1
* cell instance sg13cmos5l_fill_1_536 r0 *1 0,0
Xsg13cmos5l_fill_1_536 VPWR VGND sg13cmos5l_fill_1
* cell instance sg13cmos5l_fill_1_537 r0 *1 0,0
Xsg13cmos5l_fill_1_537 VPWR VGND sg13cmos5l_fill_1
* cell instance sg13cmos5l_fill_1_538 r0 *1 0,0
Xsg13cmos5l_fill_1_538 VPWR VGND sg13cmos5l_fill_1
* cell instance sg13cmos5l_fill_1_539 r0 *1 0,0
Xsg13cmos5l_fill_1_539 VPWR VGND sg13cmos5l_fill_1
* cell instance sg13cmos5l_fill_1_540 r0 *1 0,0
Xsg13cmos5l_fill_1_540 VPWR VGND sg13cmos5l_fill_1
* cell instance sg13cmos5l_fill_1_541 r0 *1 0,0
Xsg13cmos5l_fill_1_541 VPWR VGND sg13cmos5l_fill_1
* cell instance sg13cmos5l_fill_1_542 r0 *1 0,0
Xsg13cmos5l_fill_1_542 VPWR VGND sg13cmos5l_fill_1
* cell instance sg13cmos5l_fill_1_543 r0 *1 0,0
Xsg13cmos5l_fill_1_543 VPWR VGND sg13cmos5l_fill_1
* cell instance sg13cmos5l_fill_1_544 r0 *1 0,0
Xsg13cmos5l_fill_1_544 VPWR VGND sg13cmos5l_fill_1
* cell instance sg13cmos5l_fill_1_545 r0 *1 0,0
Xsg13cmos5l_fill_1_545 VPWR VGND sg13cmos5l_fill_1
* cell instance sg13cmos5l_fill_1_546 r0 *1 0,0
Xsg13cmos5l_fill_1_546 VPWR VGND sg13cmos5l_fill_1
* cell instance sg13cmos5l_fill_1_547 r0 *1 0,0
Xsg13cmos5l_fill_1_547 VPWR VGND sg13cmos5l_fill_1
* cell instance sg13cmos5l_fill_1_548 r0 *1 0,0
Xsg13cmos5l_fill_1_548 VPWR VGND sg13cmos5l_fill_1
* cell instance sg13cmos5l_fill_1_549 r0 *1 0,0
Xsg13cmos5l_fill_1_549 VPWR VGND sg13cmos5l_fill_1
* cell instance sg13cmos5l_fill_1_550 r0 *1 0,0
Xsg13cmos5l_fill_1_550 VPWR VGND sg13cmos5l_fill_1
* cell instance sg13cmos5l_fill_1_551 r0 *1 0,0
Xsg13cmos5l_fill_1_551 VPWR VGND sg13cmos5l_fill_1
* cell instance sg13cmos5l_fill_1_552 r0 *1 0,0
Xsg13cmos5l_fill_1_552 VPWR VGND sg13cmos5l_fill_1
* cell instance sg13cmos5l_fill_1_553 r0 *1 0,0
Xsg13cmos5l_fill_1_553 VPWR VGND sg13cmos5l_fill_1
* cell instance sg13cmos5l_fill_1_554 r0 *1 0,0
Xsg13cmos5l_fill_1_554 VPWR VGND sg13cmos5l_fill_1
* cell instance sg13cmos5l_fill_1_555 r0 *1 0,0
Xsg13cmos5l_fill_1_555 VPWR VGND sg13cmos5l_fill_1
* cell instance sg13cmos5l_fill_1_556 r0 *1 0,0
Xsg13cmos5l_fill_1_556 VPWR VGND sg13cmos5l_fill_1
* cell instance sg13cmos5l_fill_1_557 r0 *1 0,0
Xsg13cmos5l_fill_1_557 VPWR VGND sg13cmos5l_fill_1
* cell instance sg13cmos5l_fill_1_558 r0 *1 0,0
Xsg13cmos5l_fill_1_558 VPWR VGND sg13cmos5l_fill_1
* cell instance sg13cmos5l_fill_1_559 r0 *1 0,0
Xsg13cmos5l_fill_1_559 VPWR VGND sg13cmos5l_fill_1
* cell instance sg13cmos5l_fill_1_560 r0 *1 0,0
Xsg13cmos5l_fill_1_560 VPWR VGND sg13cmos5l_fill_1
* cell instance sg13cmos5l_fill_1_561 r0 *1 0,0
Xsg13cmos5l_fill_1_561 VPWR VGND sg13cmos5l_fill_1
* cell instance sg13cmos5l_fill_1_562 r0 *1 0,0
Xsg13cmos5l_fill_1_562 VPWR VGND sg13cmos5l_fill_1
* cell instance sg13cmos5l_fill_1_563 r0 *1 0,0
Xsg13cmos5l_fill_1_563 VPWR VGND sg13cmos5l_fill_1
* cell instance sg13cmos5l_fill_1_564 r0 *1 0,0
Xsg13cmos5l_fill_1_564 VPWR VGND sg13cmos5l_fill_1
* cell instance sg13cmos5l_fill_1_565 r0 *1 0,0
Xsg13cmos5l_fill_1_565 VPWR VGND sg13cmos5l_fill_1
* cell instance sg13cmos5l_fill_1_566 r0 *1 0,0
Xsg13cmos5l_fill_1_566 VPWR VGND sg13cmos5l_fill_1
* cell instance sg13cmos5l_fill_1_567 r0 *1 0,0
Xsg13cmos5l_fill_1_567 VPWR VGND sg13cmos5l_fill_1
* cell instance sg13cmos5l_fill_1_568 r0 *1 0,0
Xsg13cmos5l_fill_1_568 VPWR VGND sg13cmos5l_fill_1
* cell instance sg13cmos5l_fill_1_569 r0 *1 0,0
Xsg13cmos5l_fill_1_569 VPWR VGND sg13cmos5l_fill_1
* cell instance sg13cmos5l_fill_1_570 r0 *1 0,0
Xsg13cmos5l_fill_1_570 VPWR VGND sg13cmos5l_fill_1
* cell instance sg13cmos5l_fill_1_571 r0 *1 0,0
Xsg13cmos5l_fill_1_571 VPWR VGND sg13cmos5l_fill_1
* cell instance sg13cmos5l_fill_1_572 r0 *1 0,0
Xsg13cmos5l_fill_1_572 VPWR VGND sg13cmos5l_fill_1
* cell instance sg13cmos5l_fill_1_573 r0 *1 0,0
Xsg13cmos5l_fill_1_573 VPWR VGND sg13cmos5l_fill_1
* cell instance sg13cmos5l_fill_1_574 r0 *1 0,0
Xsg13cmos5l_fill_1_574 VPWR VGND sg13cmos5l_fill_1
* cell instance sg13cmos5l_fill_1_575 r0 *1 0,0
Xsg13cmos5l_fill_1_575 VPWR VGND sg13cmos5l_fill_1
* cell instance sg13cmos5l_fill_1_576 r0 *1 0,0
Xsg13cmos5l_fill_1_576 VPWR VGND sg13cmos5l_fill_1
* cell instance sg13cmos5l_fill_1_577 r0 *1 0,0
Xsg13cmos5l_fill_1_577 VPWR VGND sg13cmos5l_fill_1
* cell instance sg13cmos5l_fill_1_578 r0 *1 0,0
Xsg13cmos5l_fill_1_578 VPWR VGND sg13cmos5l_fill_1
* cell instance sg13cmos5l_fill_1_579 r0 *1 0,0
Xsg13cmos5l_fill_1_579 VPWR VGND sg13cmos5l_fill_1
* cell instance sg13cmos5l_fill_1_580 r0 *1 0,0
Xsg13cmos5l_fill_1_580 VPWR VGND sg13cmos5l_fill_1
* cell instance sg13cmos5l_fill_1_581 r0 *1 0,0
Xsg13cmos5l_fill_1_581 VPWR VGND sg13cmos5l_fill_1
* cell instance sg13cmos5l_fill_1_582 r0 *1 0,0
Xsg13cmos5l_fill_1_582 VPWR VGND sg13cmos5l_fill_1
* cell instance sg13cmos5l_fill_1_583 r0 *1 0,0
Xsg13cmos5l_fill_1_583 VPWR VGND sg13cmos5l_fill_1
* cell instance sg13cmos5l_fill_1_584 r0 *1 0,0
Xsg13cmos5l_fill_1_584 VPWR VGND sg13cmos5l_fill_1
* cell instance sg13cmos5l_fill_1_585 r0 *1 0,0
Xsg13cmos5l_fill_1_585 VPWR VGND sg13cmos5l_fill_1
* cell instance sg13cmos5l_fill_1_586 r0 *1 0,0
Xsg13cmos5l_fill_1_586 VPWR VGND sg13cmos5l_fill_1
* cell instance sg13cmos5l_fill_1_587 r0 *1 0,0
Xsg13cmos5l_fill_1_587 VPWR VGND sg13cmos5l_fill_1
* cell instance sg13cmos5l_fill_1_588 r0 *1 0,0
Xsg13cmos5l_fill_1_588 VPWR VGND sg13cmos5l_fill_1
* cell instance sg13cmos5l_fill_1_589 r0 *1 0,0
Xsg13cmos5l_fill_1_589 VPWR VGND sg13cmos5l_fill_1
* cell instance sg13cmos5l_fill_1_590 r0 *1 0,0
Xsg13cmos5l_fill_1_590 VPWR VGND sg13cmos5l_fill_1
* cell instance sg13cmos5l_fill_1_591 r0 *1 0,0
Xsg13cmos5l_fill_1_591 VPWR VGND sg13cmos5l_fill_1
* cell instance sg13cmos5l_fill_1_592 r0 *1 0,0
Xsg13cmos5l_fill_1_592 VPWR VGND sg13cmos5l_fill_1
* cell instance sg13cmos5l_fill_1_593 r0 *1 0,0
Xsg13cmos5l_fill_1_593 VPWR VGND sg13cmos5l_fill_1
* cell instance sg13cmos5l_fill_1_594 r0 *1 0,0
Xsg13cmos5l_fill_1_594 VPWR VGND sg13cmos5l_fill_1
* cell instance sg13cmos5l_fill_1_595 r0 *1 0,0
Xsg13cmos5l_fill_1_595 VPWR VGND sg13cmos5l_fill_1
* cell instance sg13cmos5l_fill_1_596 r0 *1 0,0
Xsg13cmos5l_fill_1_596 VPWR VGND sg13cmos5l_fill_1
* cell instance sg13cmos5l_fill_1_597 r0 *1 0,0
Xsg13cmos5l_fill_1_597 VPWR VGND sg13cmos5l_fill_1
* cell instance sg13cmos5l_fill_1_598 r0 *1 0,0
Xsg13cmos5l_fill_1_598 VPWR VGND sg13cmos5l_fill_1
* cell instance sg13cmos5l_fill_1_599 r0 *1 0,0
Xsg13cmos5l_fill_1_599 VPWR VGND sg13cmos5l_fill_1
* cell instance sg13cmos5l_fill_1_600 r0 *1 0,0
Xsg13cmos5l_fill_1_600 VPWR VGND sg13cmos5l_fill_1
* cell instance sg13cmos5l_fill_1_601 r0 *1 0,0
Xsg13cmos5l_fill_1_601 VPWR VGND sg13cmos5l_fill_1
* cell instance sg13cmos5l_fill_1_602 r0 *1 0,0
Xsg13cmos5l_fill_1_602 VPWR VGND sg13cmos5l_fill_1
* cell instance sg13cmos5l_fill_1_603 r0 *1 0,0
Xsg13cmos5l_fill_1_603 VPWR VGND sg13cmos5l_fill_1
* cell instance sg13cmos5l_fill_1_604 r0 *1 0,0
Xsg13cmos5l_fill_1_604 VPWR VGND sg13cmos5l_fill_1
* cell instance sg13cmos5l_fill_1_605 r0 *1 0,0
Xsg13cmos5l_fill_1_605 VPWR VGND sg13cmos5l_fill_1
* cell instance sg13cmos5l_fill_1_606 r0 *1 0,0
Xsg13cmos5l_fill_1_606 VPWR VGND sg13cmos5l_fill_1
* cell instance sg13cmos5l_fill_1_607 r0 *1 0,0
Xsg13cmos5l_fill_1_607 VPWR VGND sg13cmos5l_fill_1
* cell instance sg13cmos5l_fill_1_608 r0 *1 0,0
Xsg13cmos5l_fill_1_608 VPWR VGND sg13cmos5l_fill_1
* cell instance sg13cmos5l_fill_1_609 r0 *1 0,0
Xsg13cmos5l_fill_1_609 VPWR VGND sg13cmos5l_fill_1
* cell instance sg13cmos5l_fill_1_610 r0 *1 0,0
Xsg13cmos5l_fill_1_610 VPWR VGND sg13cmos5l_fill_1
* cell instance sg13cmos5l_fill_1_611 r0 *1 0,0
Xsg13cmos5l_fill_1_611 VPWR VGND sg13cmos5l_fill_1
* cell instance sg13cmos5l_fill_1_612 r0 *1 0,0
Xsg13cmos5l_fill_1_612 VPWR VGND sg13cmos5l_fill_1
* cell instance sg13cmos5l_fill_1_613 r0 *1 0,0
Xsg13cmos5l_fill_1_613 VPWR VGND sg13cmos5l_fill_1
* cell instance sg13cmos5l_fill_1_614 r0 *1 0,0
Xsg13cmos5l_fill_1_614 VPWR VGND sg13cmos5l_fill_1
* cell instance sg13cmos5l_fill_1_615 r0 *1 0,0
Xsg13cmos5l_fill_1_615 VPWR VGND sg13cmos5l_fill_1
* cell instance sg13cmos5l_fill_1_616 r0 *1 0,0
Xsg13cmos5l_fill_1_616 VPWR VGND sg13cmos5l_fill_1
* cell instance sg13cmos5l_fill_1_617 r0 *1 0,0
Xsg13cmos5l_fill_1_617 VPWR VGND sg13cmos5l_fill_1
* cell instance sg13cmos5l_fill_1_618 r0 *1 0,0
Xsg13cmos5l_fill_1_618 VPWR VGND sg13cmos5l_fill_1
* cell instance sg13cmos5l_fill_1_619 r0 *1 0,0
Xsg13cmos5l_fill_1_619 VPWR VGND sg13cmos5l_fill_1
* cell instance sg13cmos5l_fill_1_620 r0 *1 0,0
Xsg13cmos5l_fill_1_620 VPWR VGND sg13cmos5l_fill_1
* cell instance sg13cmos5l_fill_1_621 r0 *1 0,0
Xsg13cmos5l_fill_1_621 VPWR VGND sg13cmos5l_fill_1
* cell instance sg13cmos5l_fill_1_622 r0 *1 0,0
Xsg13cmos5l_fill_1_622 VPWR VGND sg13cmos5l_fill_1
* cell instance sg13cmos5l_fill_1_623 r0 *1 0,0
Xsg13cmos5l_fill_1_623 VPWR VGND sg13cmos5l_fill_1
* cell instance sg13cmos5l_fill_1_624 r0 *1 0,0
Xsg13cmos5l_fill_1_624 VPWR VGND sg13cmos5l_fill_1
* cell instance sg13cmos5l_fill_1_625 r0 *1 0,0
Xsg13cmos5l_fill_1_625 VPWR VGND sg13cmos5l_fill_1
* cell instance sg13cmos5l_fill_1_626 r0 *1 0,0
Xsg13cmos5l_fill_1_626 VPWR VGND sg13cmos5l_fill_1
* cell instance sg13cmos5l_fill_1_627 r0 *1 0,0
Xsg13cmos5l_fill_1_627 VPWR VGND sg13cmos5l_fill_1
* cell instance sg13cmos5l_fill_1_628 r0 *1 0,0
Xsg13cmos5l_fill_1_628 VPWR VGND sg13cmos5l_fill_1
* cell instance sg13cmos5l_fill_1_629 r0 *1 0,0
Xsg13cmos5l_fill_1_629 VPWR VGND sg13cmos5l_fill_1
* cell instance sg13cmos5l_fill_1_630 r0 *1 0,0
Xsg13cmos5l_fill_1_630 VPWR VGND sg13cmos5l_fill_1
* cell instance sg13cmos5l_fill_1_631 r0 *1 0,0
Xsg13cmos5l_fill_1_631 VPWR VGND sg13cmos5l_fill_1
* cell instance sg13cmos5l_fill_2_0 r0 *1 0,0
Xsg13cmos5l_fill_2_0 VPWR VGND sg13cmos5l_fill_2
* cell instance sg13cmos5l_fill_2_1 r0 *1 0,0
Xsg13cmos5l_fill_2_1 VPWR VGND sg13cmos5l_fill_2
* cell instance sg13cmos5l_fill_2_2 r0 *1 0,0
Xsg13cmos5l_fill_2_2 VPWR VGND sg13cmos5l_fill_2
* cell instance sg13cmos5l_fill_2_3 r0 *1 0,0
Xsg13cmos5l_fill_2_3 VPWR VGND sg13cmos5l_fill_2
* cell instance sg13cmos5l_fill_2_4 r0 *1 0,0
Xsg13cmos5l_fill_2_4 VPWR VGND sg13cmos5l_fill_2
* cell instance sg13cmos5l_fill_2_5 r0 *1 0,0
Xsg13cmos5l_fill_2_5 VPWR VGND sg13cmos5l_fill_2
* cell instance sg13cmos5l_fill_2_6 r0 *1 0,0
Xsg13cmos5l_fill_2_6 VPWR VGND sg13cmos5l_fill_2
* cell instance sg13cmos5l_fill_2_7 r0 *1 0,0
Xsg13cmos5l_fill_2_7 VPWR VGND sg13cmos5l_fill_2
* cell instance sg13cmos5l_fill_2_8 r0 *1 0,0
Xsg13cmos5l_fill_2_8 VPWR VGND sg13cmos5l_fill_2
* cell instance sg13cmos5l_fill_2_9 r0 *1 0,0
Xsg13cmos5l_fill_2_9 VPWR VGND sg13cmos5l_fill_2
* cell instance sg13cmos5l_fill_2_10 r0 *1 0,0
Xsg13cmos5l_fill_2_10 VPWR VGND sg13cmos5l_fill_2
* cell instance sg13cmos5l_fill_2_11 r0 *1 0,0
Xsg13cmos5l_fill_2_11 VPWR VGND sg13cmos5l_fill_2
* cell instance sg13cmos5l_fill_2_12 r0 *1 0,0
Xsg13cmos5l_fill_2_12 VPWR VGND sg13cmos5l_fill_2
* cell instance sg13cmos5l_fill_2_13 r0 *1 0,0
Xsg13cmos5l_fill_2_13 VPWR VGND sg13cmos5l_fill_2
* cell instance sg13cmos5l_fill_2_14 r0 *1 0,0
Xsg13cmos5l_fill_2_14 VPWR VGND sg13cmos5l_fill_2
* cell instance sg13cmos5l_fill_2_15 r0 *1 0,0
Xsg13cmos5l_fill_2_15 VPWR VGND sg13cmos5l_fill_2
* cell instance sg13cmos5l_fill_2_16 r0 *1 0,0
Xsg13cmos5l_fill_2_16 VPWR VGND sg13cmos5l_fill_2
* cell instance sg13cmos5l_fill_2_17 r0 *1 0,0
Xsg13cmos5l_fill_2_17 VPWR VGND sg13cmos5l_fill_2
* cell instance sg13cmos5l_fill_2_18 r0 *1 0,0
Xsg13cmos5l_fill_2_18 VPWR VGND sg13cmos5l_fill_2
* cell instance sg13cmos5l_fill_2_19 r0 *1 0,0
Xsg13cmos5l_fill_2_19 VPWR VGND sg13cmos5l_fill_2
* cell instance sg13cmos5l_fill_2_20 r0 *1 0,0
Xsg13cmos5l_fill_2_20 VPWR VGND sg13cmos5l_fill_2
* cell instance sg13cmos5l_fill_2_21 r0 *1 0,0
Xsg13cmos5l_fill_2_21 VPWR VGND sg13cmos5l_fill_2
* cell instance sg13cmos5l_fill_2_22 r0 *1 0,0
Xsg13cmos5l_fill_2_22 VPWR VGND sg13cmos5l_fill_2
* cell instance sg13cmos5l_fill_2_23 r0 *1 0,0
Xsg13cmos5l_fill_2_23 VPWR VGND sg13cmos5l_fill_2
* cell instance sg13cmos5l_fill_2_24 r0 *1 0,0
Xsg13cmos5l_fill_2_24 VPWR VGND sg13cmos5l_fill_2
* cell instance sg13cmos5l_fill_2_25 r0 *1 0,0
Xsg13cmos5l_fill_2_25 VPWR VGND sg13cmos5l_fill_2
* cell instance sg13cmos5l_fill_2_26 r0 *1 0,0
Xsg13cmos5l_fill_2_26 VPWR VGND sg13cmos5l_fill_2
* cell instance sg13cmos5l_fill_2_27 r0 *1 0,0
Xsg13cmos5l_fill_2_27 VPWR VGND sg13cmos5l_fill_2
* cell instance sg13cmos5l_fill_2_28 r0 *1 0,0
Xsg13cmos5l_fill_2_28 VPWR VGND sg13cmos5l_fill_2
* cell instance sg13cmos5l_fill_2_29 r0 *1 0,0
Xsg13cmos5l_fill_2_29 VPWR VGND sg13cmos5l_fill_2
* cell instance sg13cmos5l_fill_2_30 r0 *1 0,0
Xsg13cmos5l_fill_2_30 VPWR VGND sg13cmos5l_fill_2
* cell instance sg13cmos5l_fill_2_31 r0 *1 0,0
Xsg13cmos5l_fill_2_31 VPWR VGND sg13cmos5l_fill_2
* cell instance sg13cmos5l_fill_2_32 r0 *1 0,0
Xsg13cmos5l_fill_2_32 VPWR VGND sg13cmos5l_fill_2
* cell instance sg13cmos5l_fill_2_33 r0 *1 0,0
Xsg13cmos5l_fill_2_33 VPWR VGND sg13cmos5l_fill_2
* cell instance sg13cmos5l_fill_2_34 r0 *1 0,0
Xsg13cmos5l_fill_2_34 VPWR VGND sg13cmos5l_fill_2
* cell instance sg13cmos5l_fill_2_35 r0 *1 0,0
Xsg13cmos5l_fill_2_35 VPWR VGND sg13cmos5l_fill_2
* cell instance sg13cmos5l_fill_2_36 r0 *1 0,0
Xsg13cmos5l_fill_2_36 VPWR VGND sg13cmos5l_fill_2
* cell instance sg13cmos5l_fill_2_37 r0 *1 0,0
Xsg13cmos5l_fill_2_37 VPWR VGND sg13cmos5l_fill_2
* cell instance sg13cmos5l_fill_2_38 r0 *1 0,0
Xsg13cmos5l_fill_2_38 VPWR VGND sg13cmos5l_fill_2
* cell instance sg13cmos5l_fill_2_39 r0 *1 0,0
Xsg13cmos5l_fill_2_39 VPWR VGND sg13cmos5l_fill_2
* cell instance sg13cmos5l_fill_2_40 r0 *1 0,0
Xsg13cmos5l_fill_2_40 VPWR VGND sg13cmos5l_fill_2
* cell instance sg13cmos5l_fill_2_41 r0 *1 0,0
Xsg13cmos5l_fill_2_41 VPWR VGND sg13cmos5l_fill_2
* cell instance sg13cmos5l_fill_2_42 r0 *1 0,0
Xsg13cmos5l_fill_2_42 VPWR VGND sg13cmos5l_fill_2
* cell instance sg13cmos5l_fill_2_43 r0 *1 0,0
Xsg13cmos5l_fill_2_43 VPWR VGND sg13cmos5l_fill_2
* cell instance sg13cmos5l_fill_2_44 r0 *1 0,0
Xsg13cmos5l_fill_2_44 VPWR VGND sg13cmos5l_fill_2
* cell instance sg13cmos5l_fill_2_45 r0 *1 0,0
Xsg13cmos5l_fill_2_45 VPWR VGND sg13cmos5l_fill_2
* cell instance sg13cmos5l_fill_2_46 r0 *1 0,0
Xsg13cmos5l_fill_2_46 VPWR VGND sg13cmos5l_fill_2
* cell instance sg13cmos5l_fill_2_47 r0 *1 0,0
Xsg13cmos5l_fill_2_47 VPWR VGND sg13cmos5l_fill_2
* cell instance sg13cmos5l_fill_2_48 r0 *1 0,0
Xsg13cmos5l_fill_2_48 VPWR VGND sg13cmos5l_fill_2
* cell instance sg13cmos5l_fill_2_49 r0 *1 0,0
Xsg13cmos5l_fill_2_49 VPWR VGND sg13cmos5l_fill_2
* cell instance sg13cmos5l_fill_2_50 r0 *1 0,0
Xsg13cmos5l_fill_2_50 VPWR VGND sg13cmos5l_fill_2
* cell instance sg13cmos5l_fill_2_51 r0 *1 0,0
Xsg13cmos5l_fill_2_51 VPWR VGND sg13cmos5l_fill_2
* cell instance sg13cmos5l_fill_2_52 r0 *1 0,0
Xsg13cmos5l_fill_2_52 VPWR VGND sg13cmos5l_fill_2
* cell instance sg13cmos5l_fill_2_53 r0 *1 0,0
Xsg13cmos5l_fill_2_53 VPWR VGND sg13cmos5l_fill_2
* cell instance sg13cmos5l_fill_2_54 r0 *1 0,0
Xsg13cmos5l_fill_2_54 VPWR VGND sg13cmos5l_fill_2
* cell instance sg13cmos5l_fill_2_55 r0 *1 0,0
Xsg13cmos5l_fill_2_55 VPWR VGND sg13cmos5l_fill_2
* cell instance sg13cmos5l_fill_2_56 r0 *1 0,0
Xsg13cmos5l_fill_2_56 VPWR VGND sg13cmos5l_fill_2
* cell instance sg13cmos5l_fill_2_57 r0 *1 0,0
Xsg13cmos5l_fill_2_57 VPWR VGND sg13cmos5l_fill_2
* cell instance sg13cmos5l_fill_2_58 r0 *1 0,0
Xsg13cmos5l_fill_2_58 VPWR VGND sg13cmos5l_fill_2
* cell instance sg13cmos5l_fill_2_59 r0 *1 0,0
Xsg13cmos5l_fill_2_59 VPWR VGND sg13cmos5l_fill_2
* cell instance sg13cmos5l_fill_2_60 r0 *1 0,0
Xsg13cmos5l_fill_2_60 VPWR VGND sg13cmos5l_fill_2
* cell instance sg13cmos5l_fill_2_61 r0 *1 0,0
Xsg13cmos5l_fill_2_61 VPWR VGND sg13cmos5l_fill_2
* cell instance sg13cmos5l_fill_2_62 r0 *1 0,0
Xsg13cmos5l_fill_2_62 VPWR VGND sg13cmos5l_fill_2
* cell instance sg13cmos5l_fill_2_63 r0 *1 0,0
Xsg13cmos5l_fill_2_63 VPWR VGND sg13cmos5l_fill_2
* cell instance sg13cmos5l_fill_2_64 r0 *1 0,0
Xsg13cmos5l_fill_2_64 VPWR VGND sg13cmos5l_fill_2
* cell instance sg13cmos5l_fill_2_65 r0 *1 0,0
Xsg13cmos5l_fill_2_65 VPWR VGND sg13cmos5l_fill_2
* cell instance sg13cmos5l_fill_2_66 r0 *1 0,0
Xsg13cmos5l_fill_2_66 VPWR VGND sg13cmos5l_fill_2
* cell instance sg13cmos5l_fill_2_67 r0 *1 0,0
Xsg13cmos5l_fill_2_67 VPWR VGND sg13cmos5l_fill_2
* cell instance sg13cmos5l_fill_2_68 r0 *1 0,0
Xsg13cmos5l_fill_2_68 VPWR VGND sg13cmos5l_fill_2
* cell instance sg13cmos5l_fill_2_69 r0 *1 0,0
Xsg13cmos5l_fill_2_69 VPWR VGND sg13cmos5l_fill_2
* cell instance sg13cmos5l_fill_2_70 r0 *1 0,0
Xsg13cmos5l_fill_2_70 VPWR VGND sg13cmos5l_fill_2
* cell instance sg13cmos5l_fill_2_71 r0 *1 0,0
Xsg13cmos5l_fill_2_71 VPWR VGND sg13cmos5l_fill_2
* cell instance sg13cmos5l_fill_2_72 r0 *1 0,0
Xsg13cmos5l_fill_2_72 VPWR VGND sg13cmos5l_fill_2
* cell instance sg13cmos5l_fill_2_73 r0 *1 0,0
Xsg13cmos5l_fill_2_73 VPWR VGND sg13cmos5l_fill_2
* cell instance sg13cmos5l_fill_2_74 r0 *1 0,0
Xsg13cmos5l_fill_2_74 VPWR VGND sg13cmos5l_fill_2
* cell instance sg13cmos5l_fill_2_75 r0 *1 0,0
Xsg13cmos5l_fill_2_75 VPWR VGND sg13cmos5l_fill_2
* cell instance sg13cmos5l_fill_2_76 r0 *1 0,0
Xsg13cmos5l_fill_2_76 VPWR VGND sg13cmos5l_fill_2
* cell instance sg13cmos5l_fill_2_77 r0 *1 0,0
Xsg13cmos5l_fill_2_77 VPWR VGND sg13cmos5l_fill_2
* cell instance sg13cmos5l_fill_2_78 r0 *1 0,0
Xsg13cmos5l_fill_2_78 VPWR VGND sg13cmos5l_fill_2
* cell instance sg13cmos5l_fill_2_79 r0 *1 0,0
Xsg13cmos5l_fill_2_79 VPWR VGND sg13cmos5l_fill_2
* cell instance sg13cmos5l_fill_2_80 r0 *1 0,0
Xsg13cmos5l_fill_2_80 VPWR VGND sg13cmos5l_fill_2
* cell instance sg13cmos5l_fill_2_81 r0 *1 0,0
Xsg13cmos5l_fill_2_81 VPWR VGND sg13cmos5l_fill_2
* cell instance sg13cmos5l_fill_2_82 r0 *1 0,0
Xsg13cmos5l_fill_2_82 VPWR VGND sg13cmos5l_fill_2
* cell instance sg13cmos5l_fill_2_83 r0 *1 0,0
Xsg13cmos5l_fill_2_83 VPWR VGND sg13cmos5l_fill_2
* cell instance sg13cmos5l_fill_2_84 r0 *1 0,0
Xsg13cmos5l_fill_2_84 VPWR VGND sg13cmos5l_fill_2
* cell instance sg13cmos5l_fill_2_85 r0 *1 0,0
Xsg13cmos5l_fill_2_85 VPWR VGND sg13cmos5l_fill_2
* cell instance sg13cmos5l_fill_2_86 r0 *1 0,0
Xsg13cmos5l_fill_2_86 VPWR VGND sg13cmos5l_fill_2
* cell instance sg13cmos5l_fill_2_87 r0 *1 0,0
Xsg13cmos5l_fill_2_87 VPWR VGND sg13cmos5l_fill_2
* cell instance sg13cmos5l_fill_2_88 r0 *1 0,0
Xsg13cmos5l_fill_2_88 VPWR VGND sg13cmos5l_fill_2
* cell instance sg13cmos5l_fill_2_89 r0 *1 0,0
Xsg13cmos5l_fill_2_89 VPWR VGND sg13cmos5l_fill_2
* cell instance sg13cmos5l_fill_2_90 r0 *1 0,0
Xsg13cmos5l_fill_2_90 VPWR VGND sg13cmos5l_fill_2
* cell instance sg13cmos5l_fill_2_91 r0 *1 0,0
Xsg13cmos5l_fill_2_91 VPWR VGND sg13cmos5l_fill_2
* cell instance sg13cmos5l_fill_2_92 r0 *1 0,0
Xsg13cmos5l_fill_2_92 VPWR VGND sg13cmos5l_fill_2
* cell instance sg13cmos5l_fill_2_93 r0 *1 0,0
Xsg13cmos5l_fill_2_93 VPWR VGND sg13cmos5l_fill_2
* cell instance sg13cmos5l_fill_2_94 r0 *1 0,0
Xsg13cmos5l_fill_2_94 VPWR VGND sg13cmos5l_fill_2
* cell instance sg13cmos5l_fill_2_95 r0 *1 0,0
Xsg13cmos5l_fill_2_95 VPWR VGND sg13cmos5l_fill_2
* cell instance sg13cmos5l_fill_2_96 r0 *1 0,0
Xsg13cmos5l_fill_2_96 VPWR VGND sg13cmos5l_fill_2
* cell instance sg13cmos5l_fill_2_97 r0 *1 0,0
Xsg13cmos5l_fill_2_97 VPWR VGND sg13cmos5l_fill_2
* cell instance sg13cmos5l_fill_2_98 r0 *1 0,0
Xsg13cmos5l_fill_2_98 VPWR VGND sg13cmos5l_fill_2
* cell instance sg13cmos5l_fill_2_99 r0 *1 0,0
Xsg13cmos5l_fill_2_99 VPWR VGND sg13cmos5l_fill_2
* cell instance sg13cmos5l_fill_2_100 r0 *1 0,0
Xsg13cmos5l_fill_2_100 VPWR VGND sg13cmos5l_fill_2
* cell instance sg13cmos5l_fill_2_101 r0 *1 0,0
Xsg13cmos5l_fill_2_101 VPWR VGND sg13cmos5l_fill_2
* cell instance sg13cmos5l_fill_2_102 r0 *1 0,0
Xsg13cmos5l_fill_2_102 VPWR VGND sg13cmos5l_fill_2
* cell instance sg13cmos5l_fill_2_103 r0 *1 0,0
Xsg13cmos5l_fill_2_103 VPWR VGND sg13cmos5l_fill_2
* cell instance sg13cmos5l_fill_2_104 r0 *1 0,0
Xsg13cmos5l_fill_2_104 VPWR VGND sg13cmos5l_fill_2
* cell instance sg13cmos5l_fill_2_105 r0 *1 0,0
Xsg13cmos5l_fill_2_105 VPWR VGND sg13cmos5l_fill_2
* cell instance sg13cmos5l_fill_2_106 r0 *1 0,0
Xsg13cmos5l_fill_2_106 VPWR VGND sg13cmos5l_fill_2
* cell instance sg13cmos5l_fill_2_107 r0 *1 0,0
Xsg13cmos5l_fill_2_107 VPWR VGND sg13cmos5l_fill_2
* cell instance sg13cmos5l_fill_2_108 r0 *1 0,0
Xsg13cmos5l_fill_2_108 VPWR VGND sg13cmos5l_fill_2
* cell instance sg13cmos5l_fill_2_109 r0 *1 0,0
Xsg13cmos5l_fill_2_109 VPWR VGND sg13cmos5l_fill_2
* cell instance sg13cmos5l_fill_2_110 r0 *1 0,0
Xsg13cmos5l_fill_2_110 VPWR VGND sg13cmos5l_fill_2
* cell instance sg13cmos5l_fill_2_111 r0 *1 0,0
Xsg13cmos5l_fill_2_111 VPWR VGND sg13cmos5l_fill_2
* cell instance sg13cmos5l_fill_2_112 r0 *1 0,0
Xsg13cmos5l_fill_2_112 VPWR VGND sg13cmos5l_fill_2
* cell instance sg13cmos5l_fill_2_113 r0 *1 0,0
Xsg13cmos5l_fill_2_113 VPWR VGND sg13cmos5l_fill_2
* cell instance sg13cmos5l_fill_2_114 r0 *1 0,0
Xsg13cmos5l_fill_2_114 VPWR VGND sg13cmos5l_fill_2
* cell instance sg13cmos5l_fill_2_115 r0 *1 0,0
Xsg13cmos5l_fill_2_115 VPWR VGND sg13cmos5l_fill_2
* cell instance sg13cmos5l_fill_2_116 r0 *1 0,0
Xsg13cmos5l_fill_2_116 VPWR VGND sg13cmos5l_fill_2
* cell instance sg13cmos5l_fill_2_117 r0 *1 0,0
Xsg13cmos5l_fill_2_117 VPWR VGND sg13cmos5l_fill_2
* cell instance sg13cmos5l_fill_2_118 r0 *1 0,0
Xsg13cmos5l_fill_2_118 VPWR VGND sg13cmos5l_fill_2
* cell instance sg13cmos5l_fill_2_119 r0 *1 0,0
Xsg13cmos5l_fill_2_119 VPWR VGND sg13cmos5l_fill_2
* cell instance sg13cmos5l_fill_2_120 r0 *1 0,0
Xsg13cmos5l_fill_2_120 VPWR VGND sg13cmos5l_fill_2
* cell instance sg13cmos5l_fill_2_121 r0 *1 0,0
Xsg13cmos5l_fill_2_121 VPWR VGND sg13cmos5l_fill_2
* cell instance sg13cmos5l_fill_2_122 r0 *1 0,0
Xsg13cmos5l_fill_2_122 VPWR VGND sg13cmos5l_fill_2
* cell instance sg13cmos5l_fill_2_123 r0 *1 0,0
Xsg13cmos5l_fill_2_123 VPWR VGND sg13cmos5l_fill_2
* cell instance sg13cmos5l_fill_2_124 r0 *1 0,0
Xsg13cmos5l_fill_2_124 VPWR VGND sg13cmos5l_fill_2
* cell instance sg13cmos5l_fill_2_125 r0 *1 0,0
Xsg13cmos5l_fill_2_125 VPWR VGND sg13cmos5l_fill_2
* cell instance sg13cmos5l_fill_2_126 r0 *1 0,0
Xsg13cmos5l_fill_2_126 VPWR VGND sg13cmos5l_fill_2
* cell instance sg13cmos5l_fill_2_127 r0 *1 0,0
Xsg13cmos5l_fill_2_127 VPWR VGND sg13cmos5l_fill_2
* cell instance sg13cmos5l_fill_2_128 r0 *1 0,0
Xsg13cmos5l_fill_2_128 VPWR VGND sg13cmos5l_fill_2
* cell instance sg13cmos5l_fill_2_129 r0 *1 0,0
Xsg13cmos5l_fill_2_129 VPWR VGND sg13cmos5l_fill_2
* cell instance sg13cmos5l_fill_2_130 r0 *1 0,0
Xsg13cmos5l_fill_2_130 VPWR VGND sg13cmos5l_fill_2
* cell instance sg13cmos5l_fill_2_131 r0 *1 0,0
Xsg13cmos5l_fill_2_131 VPWR VGND sg13cmos5l_fill_2
* cell instance sg13cmos5l_fill_2_132 r0 *1 0,0
Xsg13cmos5l_fill_2_132 VPWR VGND sg13cmos5l_fill_2
* cell instance sg13cmos5l_fill_2_133 r0 *1 0,0
Xsg13cmos5l_fill_2_133 VPWR VGND sg13cmos5l_fill_2
* cell instance sg13cmos5l_fill_2_134 r0 *1 0,0
Xsg13cmos5l_fill_2_134 VPWR VGND sg13cmos5l_fill_2
* cell instance sg13cmos5l_fill_2_135 r0 *1 0,0
Xsg13cmos5l_fill_2_135 VPWR VGND sg13cmos5l_fill_2
* cell instance sg13cmos5l_fill_2_136 r0 *1 0,0
Xsg13cmos5l_fill_2_136 VPWR VGND sg13cmos5l_fill_2
* cell instance sg13cmos5l_fill_2_137 r0 *1 0,0
Xsg13cmos5l_fill_2_137 VPWR VGND sg13cmos5l_fill_2
* cell instance sg13cmos5l_fill_2_138 r0 *1 0,0
Xsg13cmos5l_fill_2_138 VPWR VGND sg13cmos5l_fill_2
* cell instance sg13cmos5l_fill_2_139 r0 *1 0,0
Xsg13cmos5l_fill_2_139 VPWR VGND sg13cmos5l_fill_2
* cell instance sg13cmos5l_fill_2_140 r0 *1 0,0
Xsg13cmos5l_fill_2_140 VPWR VGND sg13cmos5l_fill_2
* cell instance sg13cmos5l_fill_2_141 r0 *1 0,0
Xsg13cmos5l_fill_2_141 VPWR VGND sg13cmos5l_fill_2
* cell instance sg13cmos5l_fill_2_142 r0 *1 0,0
Xsg13cmos5l_fill_2_142 VPWR VGND sg13cmos5l_fill_2
* cell instance sg13cmos5l_fill_2_143 r0 *1 0,0
Xsg13cmos5l_fill_2_143 VPWR VGND sg13cmos5l_fill_2
* cell instance sg13cmos5l_fill_2_144 r0 *1 0,0
Xsg13cmos5l_fill_2_144 VPWR VGND sg13cmos5l_fill_2
* cell instance sg13cmos5l_fill_2_145 r0 *1 0,0
Xsg13cmos5l_fill_2_145 VPWR VGND sg13cmos5l_fill_2
* cell instance sg13cmos5l_fill_2_146 r0 *1 0,0
Xsg13cmos5l_fill_2_146 VPWR VGND sg13cmos5l_fill_2
* cell instance sg13cmos5l_fill_2_147 r0 *1 0,0
Xsg13cmos5l_fill_2_147 VPWR VGND sg13cmos5l_fill_2
* cell instance sg13cmos5l_fill_2_148 r0 *1 0,0
Xsg13cmos5l_fill_2_148 VPWR VGND sg13cmos5l_fill_2
* cell instance sg13cmos5l_fill_2_149 r0 *1 0,0
Xsg13cmos5l_fill_2_149 VPWR VGND sg13cmos5l_fill_2
* cell instance sg13cmos5l_fill_2_150 r0 *1 0,0
Xsg13cmos5l_fill_2_150 VPWR VGND sg13cmos5l_fill_2
* cell instance sg13cmos5l_fill_2_151 r0 *1 0,0
Xsg13cmos5l_fill_2_151 VPWR VGND sg13cmos5l_fill_2
* cell instance sg13cmos5l_fill_2_152 r0 *1 0,0
Xsg13cmos5l_fill_2_152 VPWR VGND sg13cmos5l_fill_2
* cell instance sg13cmos5l_fill_2_153 r0 *1 0,0
Xsg13cmos5l_fill_2_153 VPWR VGND sg13cmos5l_fill_2
* cell instance sg13cmos5l_fill_2_154 r0 *1 0,0
Xsg13cmos5l_fill_2_154 VPWR VGND sg13cmos5l_fill_2
* cell instance sg13cmos5l_fill_2_155 r0 *1 0,0
Xsg13cmos5l_fill_2_155 VPWR VGND sg13cmos5l_fill_2
* cell instance sg13cmos5l_fill_2_156 r0 *1 0,0
Xsg13cmos5l_fill_2_156 VPWR VGND sg13cmos5l_fill_2
* cell instance sg13cmos5l_fill_2_157 r0 *1 0,0
Xsg13cmos5l_fill_2_157 VPWR VGND sg13cmos5l_fill_2
* cell instance sg13cmos5l_fill_2_158 r0 *1 0,0
Xsg13cmos5l_fill_2_158 VPWR VGND sg13cmos5l_fill_2
* cell instance sg13cmos5l_fill_2_159 r0 *1 0,0
Xsg13cmos5l_fill_2_159 VPWR VGND sg13cmos5l_fill_2
* cell instance sg13cmos5l_fill_2_160 r0 *1 0,0
Xsg13cmos5l_fill_2_160 VPWR VGND sg13cmos5l_fill_2
* cell instance sg13cmos5l_fill_2_161 r0 *1 0,0
Xsg13cmos5l_fill_2_161 VPWR VGND sg13cmos5l_fill_2
* cell instance sg13cmos5l_fill_2_162 r0 *1 0,0
Xsg13cmos5l_fill_2_162 VPWR VGND sg13cmos5l_fill_2
* cell instance sg13cmos5l_fill_2_163 r0 *1 0,0
Xsg13cmos5l_fill_2_163 VPWR VGND sg13cmos5l_fill_2
* cell instance sg13cmos5l_fill_2_164 r0 *1 0,0
Xsg13cmos5l_fill_2_164 VPWR VGND sg13cmos5l_fill_2
* cell instance sg13cmos5l_fill_2_165 r0 *1 0,0
Xsg13cmos5l_fill_2_165 VPWR VGND sg13cmos5l_fill_2
* cell instance sg13cmos5l_fill_2_166 r0 *1 0,0
Xsg13cmos5l_fill_2_166 VPWR VGND sg13cmos5l_fill_2
* cell instance sg13cmos5l_fill_2_167 r0 *1 0,0
Xsg13cmos5l_fill_2_167 VPWR VGND sg13cmos5l_fill_2
* cell instance sg13cmos5l_fill_2_168 r0 *1 0,0
Xsg13cmos5l_fill_2_168 VPWR VGND sg13cmos5l_fill_2
* cell instance sg13cmos5l_fill_2_169 r0 *1 0,0
Xsg13cmos5l_fill_2_169 VPWR VGND sg13cmos5l_fill_2
* cell instance sg13cmos5l_fill_2_170 r0 *1 0,0
Xsg13cmos5l_fill_2_170 VPWR VGND sg13cmos5l_fill_2
* cell instance sg13cmos5l_fill_2_171 r0 *1 0,0
Xsg13cmos5l_fill_2_171 VPWR VGND sg13cmos5l_fill_2
* cell instance sg13cmos5l_fill_2_172 r0 *1 0,0
Xsg13cmos5l_fill_2_172 VPWR VGND sg13cmos5l_fill_2
* cell instance sg13cmos5l_fill_2_173 r0 *1 0,0
Xsg13cmos5l_fill_2_173 VPWR VGND sg13cmos5l_fill_2
* cell instance sg13cmos5l_fill_2_174 r0 *1 0,0
Xsg13cmos5l_fill_2_174 VPWR VGND sg13cmos5l_fill_2
* cell instance sg13cmos5l_fill_2_175 r0 *1 0,0
Xsg13cmos5l_fill_2_175 VPWR VGND sg13cmos5l_fill_2
* cell instance sg13cmos5l_fill_2_176 r0 *1 0,0
Xsg13cmos5l_fill_2_176 VPWR VGND sg13cmos5l_fill_2
* cell instance sg13cmos5l_fill_2_177 r0 *1 0,0
Xsg13cmos5l_fill_2_177 VPWR VGND sg13cmos5l_fill_2
* cell instance sg13cmos5l_fill_2_178 r0 *1 0,0
Xsg13cmos5l_fill_2_178 VPWR VGND sg13cmos5l_fill_2
* cell instance sg13cmos5l_fill_2_179 r0 *1 0,0
Xsg13cmos5l_fill_2_179 VPWR VGND sg13cmos5l_fill_2
* cell instance sg13cmos5l_fill_2_180 r0 *1 0,0
Xsg13cmos5l_fill_2_180 VPWR VGND sg13cmos5l_fill_2
* cell instance sg13cmos5l_fill_2_181 r0 *1 0,0
Xsg13cmos5l_fill_2_181 VPWR VGND sg13cmos5l_fill_2
* cell instance sg13cmos5l_fill_2_182 r0 *1 0,0
Xsg13cmos5l_fill_2_182 VPWR VGND sg13cmos5l_fill_2
* cell instance sg13cmos5l_fill_2_183 r0 *1 0,0
Xsg13cmos5l_fill_2_183 VPWR VGND sg13cmos5l_fill_2
* cell instance sg13cmos5l_fill_2_184 r0 *1 0,0
Xsg13cmos5l_fill_2_184 VPWR VGND sg13cmos5l_fill_2
* cell instance sg13cmos5l_fill_2_185 r0 *1 0,0
Xsg13cmos5l_fill_2_185 VPWR VGND sg13cmos5l_fill_2
* cell instance sg13cmos5l_fill_2_186 r0 *1 0,0
Xsg13cmos5l_fill_2_186 VPWR VGND sg13cmos5l_fill_2
* cell instance sg13cmos5l_fill_2_187 r0 *1 0,0
Xsg13cmos5l_fill_2_187 VPWR VGND sg13cmos5l_fill_2
* cell instance sg13cmos5l_fill_2_188 r0 *1 0,0
Xsg13cmos5l_fill_2_188 VPWR VGND sg13cmos5l_fill_2
* cell instance sg13cmos5l_fill_2_189 r0 *1 0,0
Xsg13cmos5l_fill_2_189 VPWR VGND sg13cmos5l_fill_2
* cell instance sg13cmos5l_fill_2_190 r0 *1 0,0
Xsg13cmos5l_fill_2_190 VPWR VGND sg13cmos5l_fill_2
* cell instance sg13cmos5l_fill_2_191 r0 *1 0,0
Xsg13cmos5l_fill_2_191 VPWR VGND sg13cmos5l_fill_2
* cell instance sg13cmos5l_fill_2_192 r0 *1 0,0
Xsg13cmos5l_fill_2_192 VPWR VGND sg13cmos5l_fill_2
* cell instance sg13cmos5l_fill_2_193 r0 *1 0,0
Xsg13cmos5l_fill_2_193 VPWR VGND sg13cmos5l_fill_2
* cell instance sg13cmos5l_fill_2_194 r0 *1 0,0
Xsg13cmos5l_fill_2_194 VPWR VGND sg13cmos5l_fill_2
* cell instance sg13cmos5l_fill_2_195 r0 *1 0,0
Xsg13cmos5l_fill_2_195 VPWR VGND sg13cmos5l_fill_2
* cell instance sg13cmos5l_fill_2_196 r0 *1 0,0
Xsg13cmos5l_fill_2_196 VPWR VGND sg13cmos5l_fill_2
* cell instance sg13cmos5l_fill_2_197 r0 *1 0,0
Xsg13cmos5l_fill_2_197 VPWR VGND sg13cmos5l_fill_2
* cell instance sg13cmos5l_fill_2_198 r0 *1 0,0
Xsg13cmos5l_fill_2_198 VPWR VGND sg13cmos5l_fill_2
* cell instance sg13cmos5l_fill_2_199 r0 *1 0,0
Xsg13cmos5l_fill_2_199 VPWR VGND sg13cmos5l_fill_2
* cell instance sg13cmos5l_fill_2_200 r0 *1 0,0
Xsg13cmos5l_fill_2_200 VPWR VGND sg13cmos5l_fill_2
* cell instance sg13cmos5l_fill_2_201 r0 *1 0,0
Xsg13cmos5l_fill_2_201 VPWR VGND sg13cmos5l_fill_2
* cell instance sg13cmos5l_fill_2_202 r0 *1 0,0
Xsg13cmos5l_fill_2_202 VPWR VGND sg13cmos5l_fill_2
* cell instance sg13cmos5l_fill_2_203 r0 *1 0,0
Xsg13cmos5l_fill_2_203 VPWR VGND sg13cmos5l_fill_2
* cell instance sg13cmos5l_fill_2_204 r0 *1 0,0
Xsg13cmos5l_fill_2_204 VPWR VGND sg13cmos5l_fill_2
* cell instance sg13cmos5l_fill_2_205 r0 *1 0,0
Xsg13cmos5l_fill_2_205 VPWR VGND sg13cmos5l_fill_2
* cell instance sg13cmos5l_fill_2_206 r0 *1 0,0
Xsg13cmos5l_fill_2_206 VPWR VGND sg13cmos5l_fill_2
* cell instance sg13cmos5l_fill_2_207 r0 *1 0,0
Xsg13cmos5l_fill_2_207 VPWR VGND sg13cmos5l_fill_2
* cell instance sg13cmos5l_fill_2_208 r0 *1 0,0
Xsg13cmos5l_fill_2_208 VPWR VGND sg13cmos5l_fill_2
* cell instance sg13cmos5l_fill_2_209 r0 *1 0,0
Xsg13cmos5l_fill_2_209 VPWR VGND sg13cmos5l_fill_2
* cell instance sg13cmos5l_fill_2_210 r0 *1 0,0
Xsg13cmos5l_fill_2_210 VPWR VGND sg13cmos5l_fill_2
* cell instance sg13cmos5l_fill_2_211 r0 *1 0,0
Xsg13cmos5l_fill_2_211 VPWR VGND sg13cmos5l_fill_2
* cell instance sg13cmos5l_fill_2_212 r0 *1 0,0
Xsg13cmos5l_fill_2_212 VPWR VGND sg13cmos5l_fill_2
* cell instance sg13cmos5l_fill_2_213 r0 *1 0,0
Xsg13cmos5l_fill_2_213 VPWR VGND sg13cmos5l_fill_2
* cell instance sg13cmos5l_fill_2_214 r0 *1 0,0
Xsg13cmos5l_fill_2_214 VPWR VGND sg13cmos5l_fill_2
* cell instance sg13cmos5l_fill_2_215 r0 *1 0,0
Xsg13cmos5l_fill_2_215 VPWR VGND sg13cmos5l_fill_2
* cell instance sg13cmos5l_fill_2_216 r0 *1 0,0
Xsg13cmos5l_fill_2_216 VPWR VGND sg13cmos5l_fill_2
* cell instance sg13cmos5l_fill_2_217 r0 *1 0,0
Xsg13cmos5l_fill_2_217 VPWR VGND sg13cmos5l_fill_2
* cell instance sg13cmos5l_fill_2_218 r0 *1 0,0
Xsg13cmos5l_fill_2_218 VPWR VGND sg13cmos5l_fill_2
* cell instance sg13cmos5l_fill_2_219 r0 *1 0,0
Xsg13cmos5l_fill_2_219 VPWR VGND sg13cmos5l_fill_2
* cell instance sg13cmos5l_fill_2_220 r0 *1 0,0
Xsg13cmos5l_fill_2_220 VPWR VGND sg13cmos5l_fill_2
* cell instance sg13cmos5l_fill_2_221 r0 *1 0,0
Xsg13cmos5l_fill_2_221 VPWR VGND sg13cmos5l_fill_2
* cell instance sg13cmos5l_fill_2_222 r0 *1 0,0
Xsg13cmos5l_fill_2_222 VPWR VGND sg13cmos5l_fill_2
* cell instance sg13cmos5l_fill_2_223 r0 *1 0,0
Xsg13cmos5l_fill_2_223 VPWR VGND sg13cmos5l_fill_2
* cell instance sg13cmos5l_fill_2_224 r0 *1 0,0
Xsg13cmos5l_fill_2_224 VPWR VGND sg13cmos5l_fill_2
* cell instance sg13cmos5l_fill_2_225 r0 *1 0,0
Xsg13cmos5l_fill_2_225 VPWR VGND sg13cmos5l_fill_2
* cell instance sg13cmos5l_fill_2_226 r0 *1 0,0
Xsg13cmos5l_fill_2_226 VPWR VGND sg13cmos5l_fill_2
* cell instance sg13cmos5l_fill_2_227 r0 *1 0,0
Xsg13cmos5l_fill_2_227 VPWR VGND sg13cmos5l_fill_2
* cell instance sg13cmos5l_fill_2_228 r0 *1 0,0
Xsg13cmos5l_fill_2_228 VPWR VGND sg13cmos5l_fill_2
* cell instance sg13cmos5l_fill_2_229 r0 *1 0,0
Xsg13cmos5l_fill_2_229 VPWR VGND sg13cmos5l_fill_2
* cell instance sg13cmos5l_fill_2_230 r0 *1 0,0
Xsg13cmos5l_fill_2_230 VPWR VGND sg13cmos5l_fill_2
* cell instance sg13cmos5l_fill_2_231 r0 *1 0,0
Xsg13cmos5l_fill_2_231 VPWR VGND sg13cmos5l_fill_2
* cell instance sg13cmos5l_fill_2_232 r0 *1 0,0
Xsg13cmos5l_fill_2_232 VPWR VGND sg13cmos5l_fill_2
* cell instance sg13cmos5l_fill_2_233 r0 *1 0,0
Xsg13cmos5l_fill_2_233 VPWR VGND sg13cmos5l_fill_2
* cell instance sg13cmos5l_fill_2_234 r0 *1 0,0
Xsg13cmos5l_fill_2_234 VPWR VGND sg13cmos5l_fill_2
* cell instance sg13cmos5l_fill_2_235 r0 *1 0,0
Xsg13cmos5l_fill_2_235 VPWR VGND sg13cmos5l_fill_2
* cell instance sg13cmos5l_fill_2_236 r0 *1 0,0
Xsg13cmos5l_fill_2_236 VPWR VGND sg13cmos5l_fill_2
* cell instance sg13cmos5l_fill_2_237 r0 *1 0,0
Xsg13cmos5l_fill_2_237 VPWR VGND sg13cmos5l_fill_2
* cell instance sg13cmos5l_fill_2_238 r0 *1 0,0
Xsg13cmos5l_fill_2_238 VPWR VGND sg13cmos5l_fill_2
* cell instance sg13cmos5l_fill_2_239 r0 *1 0,0
Xsg13cmos5l_fill_2_239 VPWR VGND sg13cmos5l_fill_2
* cell instance sg13cmos5l_fill_2_240 r0 *1 0,0
Xsg13cmos5l_fill_2_240 VPWR VGND sg13cmos5l_fill_2
* cell instance sg13cmos5l_fill_2_241 r0 *1 0,0
Xsg13cmos5l_fill_2_241 VPWR VGND sg13cmos5l_fill_2
* cell instance sg13cmos5l_fill_2_242 r0 *1 0,0
Xsg13cmos5l_fill_2_242 VPWR VGND sg13cmos5l_fill_2
* cell instance sg13cmos5l_fill_2_243 r0 *1 0,0
Xsg13cmos5l_fill_2_243 VPWR VGND sg13cmos5l_fill_2
* cell instance sg13cmos5l_fill_2_244 r0 *1 0,0
Xsg13cmos5l_fill_2_244 VPWR VGND sg13cmos5l_fill_2
* cell instance sg13cmos5l_fill_2_245 r0 *1 0,0
Xsg13cmos5l_fill_2_245 VPWR VGND sg13cmos5l_fill_2
* cell instance sg13cmos5l_fill_2_246 r0 *1 0,0
Xsg13cmos5l_fill_2_246 VPWR VGND sg13cmos5l_fill_2
* cell instance sg13cmos5l_fill_2_247 r0 *1 0,0
Xsg13cmos5l_fill_2_247 VPWR VGND sg13cmos5l_fill_2
* cell instance sg13cmos5l_fill_2_248 r0 *1 0,0
Xsg13cmos5l_fill_2_248 VPWR VGND sg13cmos5l_fill_2
* cell instance sg13cmos5l_fill_2_249 r0 *1 0,0
Xsg13cmos5l_fill_2_249 VPWR VGND sg13cmos5l_fill_2
* cell instance sg13cmos5l_fill_2_250 r0 *1 0,0
Xsg13cmos5l_fill_2_250 VPWR VGND sg13cmos5l_fill_2
* cell instance sg13cmos5l_fill_2_251 r0 *1 0,0
Xsg13cmos5l_fill_2_251 VPWR VGND sg13cmos5l_fill_2
* cell instance sg13cmos5l_fill_2_252 r0 *1 0,0
Xsg13cmos5l_fill_2_252 VPWR VGND sg13cmos5l_fill_2
* cell instance sg13cmos5l_fill_2_253 r0 *1 0,0
Xsg13cmos5l_fill_2_253 VPWR VGND sg13cmos5l_fill_2
* cell instance sg13cmos5l_fill_2_254 r0 *1 0,0
Xsg13cmos5l_fill_2_254 VPWR VGND sg13cmos5l_fill_2
* cell instance sg13cmos5l_fill_2_255 r0 *1 0,0
Xsg13cmos5l_fill_2_255 VPWR VGND sg13cmos5l_fill_2
* cell instance sg13cmos5l_fill_2_256 r0 *1 0,0
Xsg13cmos5l_fill_2_256 VPWR VGND sg13cmos5l_fill_2
* cell instance sg13cmos5l_fill_2_257 r0 *1 0,0
Xsg13cmos5l_fill_2_257 VPWR VGND sg13cmos5l_fill_2
* cell instance sg13cmos5l_fill_2_258 r0 *1 0,0
Xsg13cmos5l_fill_2_258 VPWR VGND sg13cmos5l_fill_2
* cell instance sg13cmos5l_fill_2_259 r0 *1 0,0
Xsg13cmos5l_fill_2_259 VPWR VGND sg13cmos5l_fill_2
* cell instance sg13cmos5l_fill_2_260 r0 *1 0,0
Xsg13cmos5l_fill_2_260 VPWR VGND sg13cmos5l_fill_2
* cell instance sg13cmos5l_fill_2_261 r0 *1 0,0
Xsg13cmos5l_fill_2_261 VPWR VGND sg13cmos5l_fill_2
* cell instance sg13cmos5l_fill_2_262 r0 *1 0,0
Xsg13cmos5l_fill_2_262 VPWR VGND sg13cmos5l_fill_2
* cell instance sg13cmos5l_fill_2_263 r0 *1 0,0
Xsg13cmos5l_fill_2_263 VPWR VGND sg13cmos5l_fill_2
* cell instance sg13cmos5l_fill_2_264 r0 *1 0,0
Xsg13cmos5l_fill_2_264 VPWR VGND sg13cmos5l_fill_2
* cell instance sg13cmos5l_fill_2_265 r0 *1 0,0
Xsg13cmos5l_fill_2_265 VPWR VGND sg13cmos5l_fill_2
* cell instance sg13cmos5l_fill_2_266 r0 *1 0,0
Xsg13cmos5l_fill_2_266 VPWR VGND sg13cmos5l_fill_2
* cell instance sg13cmos5l_fill_2_267 r0 *1 0,0
Xsg13cmos5l_fill_2_267 VPWR VGND sg13cmos5l_fill_2
* cell instance sg13cmos5l_fill_2_268 r0 *1 0,0
Xsg13cmos5l_fill_2_268 VPWR VGND sg13cmos5l_fill_2
* cell instance sg13cmos5l_fill_2_269 r0 *1 0,0
Xsg13cmos5l_fill_2_269 VPWR VGND sg13cmos5l_fill_2
* cell instance sg13cmos5l_fill_2_270 r0 *1 0,0
Xsg13cmos5l_fill_2_270 VPWR VGND sg13cmos5l_fill_2
* cell instance sg13cmos5l_fill_2_271 r0 *1 0,0
Xsg13cmos5l_fill_2_271 VPWR VGND sg13cmos5l_fill_2
* cell instance sg13cmos5l_fill_2_272 r0 *1 0,0
Xsg13cmos5l_fill_2_272 VPWR VGND sg13cmos5l_fill_2
* cell instance sg13cmos5l_fill_2_273 r0 *1 0,0
Xsg13cmos5l_fill_2_273 VPWR VGND sg13cmos5l_fill_2
* cell instance sg13cmos5l_fill_2_274 r0 *1 0,0
Xsg13cmos5l_fill_2_274 VPWR VGND sg13cmos5l_fill_2
* cell instance sg13cmos5l_fill_2_275 r0 *1 0,0
Xsg13cmos5l_fill_2_275 VPWR VGND sg13cmos5l_fill_2
* cell instance sg13cmos5l_fill_2_276 r0 *1 0,0
Xsg13cmos5l_fill_2_276 VPWR VGND sg13cmos5l_fill_2
* cell instance sg13cmos5l_fill_2_277 r0 *1 0,0
Xsg13cmos5l_fill_2_277 VPWR VGND sg13cmos5l_fill_2
* cell instance sg13cmos5l_fill_2_278 r0 *1 0,0
Xsg13cmos5l_fill_2_278 VPWR VGND sg13cmos5l_fill_2
* cell instance sg13cmos5l_fill_2_279 r0 *1 0,0
Xsg13cmos5l_fill_2_279 VPWR VGND sg13cmos5l_fill_2
* cell instance sg13cmos5l_fill_2_280 r0 *1 0,0
Xsg13cmos5l_fill_2_280 VPWR VGND sg13cmos5l_fill_2
* cell instance sg13cmos5l_fill_2_281 r0 *1 0,0
Xsg13cmos5l_fill_2_281 VPWR VGND sg13cmos5l_fill_2
* cell instance sg13cmos5l_fill_2_282 r0 *1 0,0
Xsg13cmos5l_fill_2_282 VPWR VGND sg13cmos5l_fill_2
* cell instance sg13cmos5l_fill_2_283 r0 *1 0,0
Xsg13cmos5l_fill_2_283 VPWR VGND sg13cmos5l_fill_2
* cell instance sg13cmos5l_fill_2_284 r0 *1 0,0
Xsg13cmos5l_fill_2_284 VPWR VGND sg13cmos5l_fill_2
* cell instance sg13cmos5l_fill_2_285 r0 *1 0,0
Xsg13cmos5l_fill_2_285 VPWR VGND sg13cmos5l_fill_2
* cell instance sg13cmos5l_fill_2_286 r0 *1 0,0
Xsg13cmos5l_fill_2_286 VPWR VGND sg13cmos5l_fill_2
* cell instance sg13cmos5l_fill_2_287 r0 *1 0,0
Xsg13cmos5l_fill_2_287 VPWR VGND sg13cmos5l_fill_2
* cell instance sg13cmos5l_fill_2_288 r0 *1 0,0
Xsg13cmos5l_fill_2_288 VPWR VGND sg13cmos5l_fill_2
* cell instance sg13cmos5l_fill_2_289 r0 *1 0,0
Xsg13cmos5l_fill_2_289 VPWR VGND sg13cmos5l_fill_2
* cell instance sg13cmos5l_fill_2_290 r0 *1 0,0
Xsg13cmos5l_fill_2_290 VPWR VGND sg13cmos5l_fill_2
* cell instance sg13cmos5l_fill_2_291 r0 *1 0,0
Xsg13cmos5l_fill_2_291 VPWR VGND sg13cmos5l_fill_2
* cell instance sg13cmos5l_fill_2_292 r0 *1 0,0
Xsg13cmos5l_fill_2_292 VPWR VGND sg13cmos5l_fill_2
* cell instance sg13cmos5l_fill_2_293 r0 *1 0,0
Xsg13cmos5l_fill_2_293 VPWR VGND sg13cmos5l_fill_2
* cell instance sg13cmos5l_fill_2_294 r0 *1 0,0
Xsg13cmos5l_fill_2_294 VPWR VGND sg13cmos5l_fill_2
* cell instance sg13cmos5l_fill_2_295 r0 *1 0,0
Xsg13cmos5l_fill_2_295 VPWR VGND sg13cmos5l_fill_2
* cell instance sg13cmos5l_fill_2_296 r0 *1 0,0
Xsg13cmos5l_fill_2_296 VPWR VGND sg13cmos5l_fill_2
* cell instance sg13cmos5l_fill_2_297 r0 *1 0,0
Xsg13cmos5l_fill_2_297 VPWR VGND sg13cmos5l_fill_2
* cell instance sg13cmos5l_fill_2_298 r0 *1 0,0
Xsg13cmos5l_fill_2_298 VPWR VGND sg13cmos5l_fill_2
* cell instance sg13cmos5l_fill_2_299 r0 *1 0,0
Xsg13cmos5l_fill_2_299 VPWR VGND sg13cmos5l_fill_2
* cell instance sg13cmos5l_fill_2_300 r0 *1 0,0
Xsg13cmos5l_fill_2_300 VPWR VGND sg13cmos5l_fill_2
* cell instance sg13cmos5l_fill_2_301 r0 *1 0,0
Xsg13cmos5l_fill_2_301 VPWR VGND sg13cmos5l_fill_2
* cell instance sg13cmos5l_fill_2_302 r0 *1 0,0
Xsg13cmos5l_fill_2_302 VPWR VGND sg13cmos5l_fill_2
* cell instance sg13cmos5l_fill_2_303 r0 *1 0,0
Xsg13cmos5l_fill_2_303 VPWR VGND sg13cmos5l_fill_2
* cell instance sg13cmos5l_fill_2_304 r0 *1 0,0
Xsg13cmos5l_fill_2_304 VPWR VGND sg13cmos5l_fill_2
* cell instance sg13cmos5l_fill_2_305 r0 *1 0,0
Xsg13cmos5l_fill_2_305 VPWR VGND sg13cmos5l_fill_2
* cell instance sg13cmos5l_fill_2_306 r0 *1 0,0
Xsg13cmos5l_fill_2_306 VPWR VGND sg13cmos5l_fill_2
* cell instance sg13cmos5l_fill_2_307 r0 *1 0,0
Xsg13cmos5l_fill_2_307 VPWR VGND sg13cmos5l_fill_2
* cell instance sg13cmos5l_fill_2_308 r0 *1 0,0
Xsg13cmos5l_fill_2_308 VPWR VGND sg13cmos5l_fill_2
* cell instance sg13cmos5l_fill_2_309 r0 *1 0,0
Xsg13cmos5l_fill_2_309 VPWR VGND sg13cmos5l_fill_2
* cell instance sg13cmos5l_fill_2_310 r0 *1 0,0
Xsg13cmos5l_fill_2_310 VPWR VGND sg13cmos5l_fill_2
* cell instance sg13cmos5l_fill_2_311 r0 *1 0,0
Xsg13cmos5l_fill_2_311 VPWR VGND sg13cmos5l_fill_2
* cell instance sg13cmos5l_fill_2_312 r0 *1 0,0
Xsg13cmos5l_fill_2_312 VPWR VGND sg13cmos5l_fill_2
* cell instance sg13cmos5l_fill_2_313 r0 *1 0,0
Xsg13cmos5l_fill_2_313 VPWR VGND sg13cmos5l_fill_2
* cell instance sg13cmos5l_fill_2_314 r0 *1 0,0
Xsg13cmos5l_fill_2_314 VPWR VGND sg13cmos5l_fill_2
* cell instance sg13cmos5l_fill_2_315 r0 *1 0,0
Xsg13cmos5l_fill_2_315 VPWR VGND sg13cmos5l_fill_2
* cell instance sg13cmos5l_fill_2_316 r0 *1 0,0
Xsg13cmos5l_fill_2_316 VPWR VGND sg13cmos5l_fill_2
* cell instance sg13cmos5l_fill_2_317 r0 *1 0,0
Xsg13cmos5l_fill_2_317 VPWR VGND sg13cmos5l_fill_2
* cell instance sg13cmos5l_fill_2_318 r0 *1 0,0
Xsg13cmos5l_fill_2_318 VPWR VGND sg13cmos5l_fill_2
* cell instance sg13cmos5l_fill_2_319 r0 *1 0,0
Xsg13cmos5l_fill_2_319 VPWR VGND sg13cmos5l_fill_2
* cell instance sg13cmos5l_fill_2_320 r0 *1 0,0
Xsg13cmos5l_fill_2_320 VPWR VGND sg13cmos5l_fill_2
* cell instance sg13cmos5l_fill_2_321 r0 *1 0,0
Xsg13cmos5l_fill_2_321 VPWR VGND sg13cmos5l_fill_2
* cell instance sg13cmos5l_fill_2_322 r0 *1 0,0
Xsg13cmos5l_fill_2_322 VPWR VGND sg13cmos5l_fill_2
* cell instance sg13cmos5l_fill_2_323 r0 *1 0,0
Xsg13cmos5l_fill_2_323 VPWR VGND sg13cmos5l_fill_2
* cell instance sg13cmos5l_fill_2_324 r0 *1 0,0
Xsg13cmos5l_fill_2_324 VPWR VGND sg13cmos5l_fill_2
* cell instance sg13cmos5l_fill_2_325 r0 *1 0,0
Xsg13cmos5l_fill_2_325 VPWR VGND sg13cmos5l_fill_2
* cell instance sg13cmos5l_fill_2_326 r0 *1 0,0
Xsg13cmos5l_fill_2_326 VPWR VGND sg13cmos5l_fill_2
* cell instance sg13cmos5l_fill_2_327 r0 *1 0,0
Xsg13cmos5l_fill_2_327 VPWR VGND sg13cmos5l_fill_2
* cell instance sg13cmos5l_fill_2_328 r0 *1 0,0
Xsg13cmos5l_fill_2_328 VPWR VGND sg13cmos5l_fill_2
* cell instance sg13cmos5l_fill_2_329 r0 *1 0,0
Xsg13cmos5l_fill_2_329 VPWR VGND sg13cmos5l_fill_2
* cell instance sg13cmos5l_fill_2_330 r0 *1 0,0
Xsg13cmos5l_fill_2_330 VPWR VGND sg13cmos5l_fill_2
* cell instance sg13cmos5l_fill_2_331 r0 *1 0,0
Xsg13cmos5l_fill_2_331 VPWR VGND sg13cmos5l_fill_2
* cell instance sg13cmos5l_fill_2_332 r0 *1 0,0
Xsg13cmos5l_fill_2_332 VPWR VGND sg13cmos5l_fill_2
* cell instance sg13cmos5l_fill_2_333 r0 *1 0,0
Xsg13cmos5l_fill_2_333 VPWR VGND sg13cmos5l_fill_2
* cell instance sg13cmos5l_fill_2_334 r0 *1 0,0
Xsg13cmos5l_fill_2_334 VPWR VGND sg13cmos5l_fill_2
* cell instance sg13cmos5l_fill_2_335 r0 *1 0,0
Xsg13cmos5l_fill_2_335 VPWR VGND sg13cmos5l_fill_2
* cell instance sg13cmos5l_fill_2_336 r0 *1 0,0
Xsg13cmos5l_fill_2_336 VPWR VGND sg13cmos5l_fill_2
* cell instance sg13cmos5l_fill_2_337 r0 *1 0,0
Xsg13cmos5l_fill_2_337 VPWR VGND sg13cmos5l_fill_2
* cell instance sg13cmos5l_fill_2_338 r0 *1 0,0
Xsg13cmos5l_fill_2_338 VPWR VGND sg13cmos5l_fill_2
* cell instance sg13cmos5l_fill_2_339 r0 *1 0,0
Xsg13cmos5l_fill_2_339 VPWR VGND sg13cmos5l_fill_2
* cell instance sg13cmos5l_fill_2_340 r0 *1 0,0
Xsg13cmos5l_fill_2_340 VPWR VGND sg13cmos5l_fill_2
* cell instance sg13cmos5l_fill_2_341 r0 *1 0,0
Xsg13cmos5l_fill_2_341 VPWR VGND sg13cmos5l_fill_2
* cell instance sg13cmos5l_fill_2_342 r0 *1 0,0
Xsg13cmos5l_fill_2_342 VPWR VGND sg13cmos5l_fill_2
* cell instance sg13cmos5l_fill_2_343 r0 *1 0,0
Xsg13cmos5l_fill_2_343 VPWR VGND sg13cmos5l_fill_2
* cell instance sg13cmos5l_fill_2_344 r0 *1 0,0
Xsg13cmos5l_fill_2_344 VPWR VGND sg13cmos5l_fill_2
* cell instance sg13cmos5l_fill_2_345 r0 *1 0,0
Xsg13cmos5l_fill_2_345 VPWR VGND sg13cmos5l_fill_2
* cell instance sg13cmos5l_fill_2_346 r0 *1 0,0
Xsg13cmos5l_fill_2_346 VPWR VGND sg13cmos5l_fill_2
* cell instance sg13cmos5l_fill_2_347 r0 *1 0,0
Xsg13cmos5l_fill_2_347 VPWR VGND sg13cmos5l_fill_2
* cell instance sg13cmos5l_fill_2_348 r0 *1 0,0
Xsg13cmos5l_fill_2_348 VPWR VGND sg13cmos5l_fill_2
* cell instance sg13cmos5l_fill_2_349 r0 *1 0,0
Xsg13cmos5l_fill_2_349 VPWR VGND sg13cmos5l_fill_2
* cell instance sg13cmos5l_fill_2_350 r0 *1 0,0
Xsg13cmos5l_fill_2_350 VPWR VGND sg13cmos5l_fill_2
* cell instance sg13cmos5l_fill_2_351 r0 *1 0,0
Xsg13cmos5l_fill_2_351 VPWR VGND sg13cmos5l_fill_2
* cell instance sg13cmos5l_fill_2_352 r0 *1 0,0
Xsg13cmos5l_fill_2_352 VPWR VGND sg13cmos5l_fill_2
* cell instance sg13cmos5l_fill_2_353 r0 *1 0,0
Xsg13cmos5l_fill_2_353 VPWR VGND sg13cmos5l_fill_2
* cell instance sg13cmos5l_fill_2_354 r0 *1 0,0
Xsg13cmos5l_fill_2_354 VPWR VGND sg13cmos5l_fill_2
* cell instance sg13cmos5l_fill_2_355 r0 *1 0,0
Xsg13cmos5l_fill_2_355 VPWR VGND sg13cmos5l_fill_2
* cell instance sg13cmos5l_fill_2_356 r0 *1 0,0
Xsg13cmos5l_fill_2_356 VPWR VGND sg13cmos5l_fill_2
* cell instance sg13cmos5l_fill_2_357 r0 *1 0,0
Xsg13cmos5l_fill_2_357 VPWR VGND sg13cmos5l_fill_2
* cell instance sg13cmos5l_fill_2_358 r0 *1 0,0
Xsg13cmos5l_fill_2_358 VPWR VGND sg13cmos5l_fill_2
* cell instance sg13cmos5l_fill_2_359 r0 *1 0,0
Xsg13cmos5l_fill_2_359 VPWR VGND sg13cmos5l_fill_2
* cell instance sg13cmos5l_fill_2_360 r0 *1 0,0
Xsg13cmos5l_fill_2_360 VPWR VGND sg13cmos5l_fill_2
* cell instance sg13cmos5l_fill_2_361 r0 *1 0,0
Xsg13cmos5l_fill_2_361 VPWR VGND sg13cmos5l_fill_2
* cell instance sg13cmos5l_fill_2_362 r0 *1 0,0
Xsg13cmos5l_fill_2_362 VPWR VGND sg13cmos5l_fill_2
* cell instance sg13cmos5l_fill_2_363 r0 *1 0,0
Xsg13cmos5l_fill_2_363 VPWR VGND sg13cmos5l_fill_2
* cell instance sg13cmos5l_fill_2_364 r0 *1 0,0
Xsg13cmos5l_fill_2_364 VPWR VGND sg13cmos5l_fill_2
* cell instance sg13cmos5l_fill_2_365 r0 *1 0,0
Xsg13cmos5l_fill_2_365 VPWR VGND sg13cmos5l_fill_2
* cell instance sg13cmos5l_fill_2_366 r0 *1 0,0
Xsg13cmos5l_fill_2_366 VPWR VGND sg13cmos5l_fill_2
* cell instance sg13cmos5l_fill_2_367 r0 *1 0,0
Xsg13cmos5l_fill_2_367 VPWR VGND sg13cmos5l_fill_2
* cell instance sg13cmos5l_fill_2_368 r0 *1 0,0
Xsg13cmos5l_fill_2_368 VPWR VGND sg13cmos5l_fill_2
* cell instance sg13cmos5l_fill_2_369 r0 *1 0,0
Xsg13cmos5l_fill_2_369 VPWR VGND sg13cmos5l_fill_2
* cell instance sg13cmos5l_fill_2_370 r0 *1 0,0
Xsg13cmos5l_fill_2_370 VPWR VGND sg13cmos5l_fill_2
* cell instance sg13cmos5l_fill_2_371 r0 *1 0,0
Xsg13cmos5l_fill_2_371 VPWR VGND sg13cmos5l_fill_2
* cell instance sg13cmos5l_fill_2_372 r0 *1 0,0
Xsg13cmos5l_fill_2_372 VPWR VGND sg13cmos5l_fill_2
* cell instance sg13cmos5l_fill_2_373 r0 *1 0,0
Xsg13cmos5l_fill_2_373 VPWR VGND sg13cmos5l_fill_2
* cell instance sg13cmos5l_fill_2_374 r0 *1 0,0
Xsg13cmos5l_fill_2_374 VPWR VGND sg13cmos5l_fill_2
* cell instance sg13cmos5l_fill_2_375 r0 *1 0,0
Xsg13cmos5l_fill_2_375 VPWR VGND sg13cmos5l_fill_2
* cell instance sg13cmos5l_fill_2_376 r0 *1 0,0
Xsg13cmos5l_fill_2_376 VPWR VGND sg13cmos5l_fill_2
* cell instance sg13cmos5l_fill_2_377 r0 *1 0,0
Xsg13cmos5l_fill_2_377 VPWR VGND sg13cmos5l_fill_2
* cell instance sg13cmos5l_fill_2_378 r0 *1 0,0
Xsg13cmos5l_fill_2_378 VPWR VGND sg13cmos5l_fill_2
* cell instance sg13cmos5l_fill_2_379 r0 *1 0,0
Xsg13cmos5l_fill_2_379 VPWR VGND sg13cmos5l_fill_2
* cell instance sg13cmos5l_fill_2_380 r0 *1 0,0
Xsg13cmos5l_fill_2_380 VPWR VGND sg13cmos5l_fill_2
* cell instance sg13cmos5l_fill_2_381 r0 *1 0,0
Xsg13cmos5l_fill_2_381 VPWR VGND sg13cmos5l_fill_2
* cell instance sg13cmos5l_fill_2_382 r0 *1 0,0
Xsg13cmos5l_fill_2_382 VPWR VGND sg13cmos5l_fill_2
* cell instance sg13cmos5l_fill_2_383 r0 *1 0,0
Xsg13cmos5l_fill_2_383 VPWR VGND sg13cmos5l_fill_2
* cell instance sg13cmos5l_fill_2_384 r0 *1 0,0
Xsg13cmos5l_fill_2_384 VPWR VGND sg13cmos5l_fill_2
* cell instance sg13cmos5l_fill_2_385 r0 *1 0,0
Xsg13cmos5l_fill_2_385 VPWR VGND sg13cmos5l_fill_2
* cell instance sg13cmos5l_fill_2_386 r0 *1 0,0
Xsg13cmos5l_fill_2_386 VPWR VGND sg13cmos5l_fill_2
* cell instance sg13cmos5l_fill_2_387 r0 *1 0,0
Xsg13cmos5l_fill_2_387 VPWR VGND sg13cmos5l_fill_2
* cell instance sg13cmos5l_fill_2_388 r0 *1 0,0
Xsg13cmos5l_fill_2_388 VPWR VGND sg13cmos5l_fill_2
* cell instance sg13cmos5l_fill_2_389 r0 *1 0,0
Xsg13cmos5l_fill_2_389 VPWR VGND sg13cmos5l_fill_2
* cell instance sg13cmos5l_fill_2_390 r0 *1 0,0
Xsg13cmos5l_fill_2_390 VPWR VGND sg13cmos5l_fill_2
* cell instance sg13cmos5l_fill_2_391 r0 *1 0,0
Xsg13cmos5l_fill_2_391 VPWR VGND sg13cmos5l_fill_2
* cell instance sg13cmos5l_fill_2_392 r0 *1 0,0
Xsg13cmos5l_fill_2_392 VPWR VGND sg13cmos5l_fill_2
* cell instance sg13cmos5l_fill_2_393 r0 *1 0,0
Xsg13cmos5l_fill_2_393 VPWR VGND sg13cmos5l_fill_2
* cell instance sg13cmos5l_fill_2_394 r0 *1 0,0
Xsg13cmos5l_fill_2_394 VPWR VGND sg13cmos5l_fill_2
* cell instance sg13cmos5l_fill_2_395 r0 *1 0,0
Xsg13cmos5l_fill_2_395 VPWR VGND sg13cmos5l_fill_2
* cell instance sg13cmos5l_fill_2_396 r0 *1 0,0
Xsg13cmos5l_fill_2_396 VPWR VGND sg13cmos5l_fill_2
* cell instance sg13cmos5l_fill_2_397 r0 *1 0,0
Xsg13cmos5l_fill_2_397 VPWR VGND sg13cmos5l_fill_2
* cell instance sg13cmos5l_fill_2_398 r0 *1 0,0
Xsg13cmos5l_fill_2_398 VPWR VGND sg13cmos5l_fill_2
* cell instance sg13cmos5l_fill_2_399 r0 *1 0,0
Xsg13cmos5l_fill_2_399 VPWR VGND sg13cmos5l_fill_2
* cell instance sg13cmos5l_fill_2_400 r0 *1 0,0
Xsg13cmos5l_fill_2_400 VPWR VGND sg13cmos5l_fill_2
* cell instance sg13cmos5l_fill_2_401 r0 *1 0,0
Xsg13cmos5l_fill_2_401 VPWR VGND sg13cmos5l_fill_2
* cell instance sg13cmos5l_fill_2_402 r0 *1 0,0
Xsg13cmos5l_fill_2_402 VPWR VGND sg13cmos5l_fill_2
* cell instance sg13cmos5l_fill_2_403 r0 *1 0,0
Xsg13cmos5l_fill_2_403 VPWR VGND sg13cmos5l_fill_2
* cell instance sg13cmos5l_fill_2_404 r0 *1 0,0
Xsg13cmos5l_fill_2_404 VPWR VGND sg13cmos5l_fill_2
* cell instance sg13cmos5l_fill_2_405 r0 *1 0,0
Xsg13cmos5l_fill_2_405 VPWR VGND sg13cmos5l_fill_2
* cell instance sg13cmos5l_fill_2_406 r0 *1 0,0
Xsg13cmos5l_fill_2_406 VPWR VGND sg13cmos5l_fill_2
* cell instance sg13cmos5l_fill_2_407 r0 *1 0,0
Xsg13cmos5l_fill_2_407 VPWR VGND sg13cmos5l_fill_2
* cell instance sg13cmos5l_fill_2_408 r0 *1 0,0
Xsg13cmos5l_fill_2_408 VPWR VGND sg13cmos5l_fill_2
* cell instance sg13cmos5l_fill_2_409 r0 *1 0,0
Xsg13cmos5l_fill_2_409 VPWR VGND sg13cmos5l_fill_2
* cell instance sg13cmos5l_fill_2_410 r0 *1 0,0
Xsg13cmos5l_fill_2_410 VPWR VGND sg13cmos5l_fill_2
* cell instance sg13cmos5l_fill_2_411 r0 *1 0,0
Xsg13cmos5l_fill_2_411 VPWR VGND sg13cmos5l_fill_2
* cell instance sg13cmos5l_fill_2_412 r0 *1 0,0
Xsg13cmos5l_fill_2_412 VPWR VGND sg13cmos5l_fill_2
* cell instance sg13cmos5l_fill_2_413 r0 *1 0,0
Xsg13cmos5l_fill_2_413 VPWR VGND sg13cmos5l_fill_2
* cell instance sg13cmos5l_fill_2_414 r0 *1 0,0
Xsg13cmos5l_fill_2_414 VPWR VGND sg13cmos5l_fill_2
* cell instance sg13cmos5l_fill_2_415 r0 *1 0,0
Xsg13cmos5l_fill_2_415 VPWR VGND sg13cmos5l_fill_2
* cell instance sg13cmos5l_fill_2_416 r0 *1 0,0
Xsg13cmos5l_fill_2_416 VPWR VGND sg13cmos5l_fill_2
* cell instance sg13cmos5l_fill_2_417 r0 *1 0,0
Xsg13cmos5l_fill_2_417 VPWR VGND sg13cmos5l_fill_2
* cell instance sg13cmos5l_fill_2_418 r0 *1 0,0
Xsg13cmos5l_fill_2_418 VPWR VGND sg13cmos5l_fill_2
* cell instance sg13cmos5l_fill_2_419 r0 *1 0,0
Xsg13cmos5l_fill_2_419 VPWR VGND sg13cmos5l_fill_2
* cell instance sg13cmos5l_fill_2_420 r0 *1 0,0
Xsg13cmos5l_fill_2_420 VPWR VGND sg13cmos5l_fill_2
* cell instance sg13cmos5l_fill_2_421 r0 *1 0,0
Xsg13cmos5l_fill_2_421 VPWR VGND sg13cmos5l_fill_2
* cell instance sg13cmos5l_fill_2_422 r0 *1 0,0
Xsg13cmos5l_fill_2_422 VPWR VGND sg13cmos5l_fill_2
* cell instance sg13cmos5l_fill_2_423 r0 *1 0,0
Xsg13cmos5l_fill_2_423 VPWR VGND sg13cmos5l_fill_2
* cell instance sg13cmos5l_fill_2_424 r0 *1 0,0
Xsg13cmos5l_fill_2_424 VPWR VGND sg13cmos5l_fill_2
* cell instance sg13cmos5l_fill_2_425 r0 *1 0,0
Xsg13cmos5l_fill_2_425 VPWR VGND sg13cmos5l_fill_2
* cell instance sg13cmos5l_fill_2_426 r0 *1 0,0
Xsg13cmos5l_fill_2_426 VPWR VGND sg13cmos5l_fill_2
* cell instance sg13cmos5l_fill_2_427 r0 *1 0,0
Xsg13cmos5l_fill_2_427 VPWR VGND sg13cmos5l_fill_2
* cell instance sg13cmos5l_fill_2_428 r0 *1 0,0
Xsg13cmos5l_fill_2_428 VPWR VGND sg13cmos5l_fill_2
* cell instance sg13cmos5l_fill_2_429 r0 *1 0,0
Xsg13cmos5l_fill_2_429 VPWR VGND sg13cmos5l_fill_2
* cell instance sg13cmos5l_fill_2_430 r0 *1 0,0
Xsg13cmos5l_fill_2_430 VPWR VGND sg13cmos5l_fill_2
* cell instance sg13cmos5l_fill_2_431 r0 *1 0,0
Xsg13cmos5l_fill_2_431 VPWR VGND sg13cmos5l_fill_2
* cell instance sg13cmos5l_fill_2_432 r0 *1 0,0
Xsg13cmos5l_fill_2_432 VPWR VGND sg13cmos5l_fill_2
* cell instance sg13cmos5l_fill_2_433 r0 *1 0,0
Xsg13cmos5l_fill_2_433 VPWR VGND sg13cmos5l_fill_2
* cell instance sg13cmos5l_fill_2_434 r0 *1 0,0
Xsg13cmos5l_fill_2_434 VPWR VGND sg13cmos5l_fill_2
* cell instance sg13cmos5l_fill_2_435 r0 *1 0,0
Xsg13cmos5l_fill_2_435 VPWR VGND sg13cmos5l_fill_2
* cell instance sg13cmos5l_fill_2_436 r0 *1 0,0
Xsg13cmos5l_fill_2_436 VPWR VGND sg13cmos5l_fill_2
* cell instance sg13cmos5l_fill_2_437 r0 *1 0,0
Xsg13cmos5l_fill_2_437 VPWR VGND sg13cmos5l_fill_2
* cell instance sg13cmos5l_fill_2_438 r0 *1 0,0
Xsg13cmos5l_fill_2_438 VPWR VGND sg13cmos5l_fill_2
* cell instance sg13cmos5l_fill_2_439 r0 *1 0,0
Xsg13cmos5l_fill_2_439 VPWR VGND sg13cmos5l_fill_2
* cell instance sg13cmos5l_fill_2_440 r0 *1 0,0
Xsg13cmos5l_fill_2_440 VPWR VGND sg13cmos5l_fill_2
* cell instance sg13cmos5l_fill_2_441 r0 *1 0,0
Xsg13cmos5l_fill_2_441 VPWR VGND sg13cmos5l_fill_2
* cell instance sg13cmos5l_fill_2_442 r0 *1 0,0
Xsg13cmos5l_fill_2_442 VPWR VGND sg13cmos5l_fill_2
* cell instance sg13cmos5l_fill_2_443 r0 *1 0,0
Xsg13cmos5l_fill_2_443 VPWR VGND sg13cmos5l_fill_2
* cell instance sg13cmos5l_fill_2_444 r0 *1 0,0
Xsg13cmos5l_fill_2_444 VPWR VGND sg13cmos5l_fill_2
* cell instance sg13cmos5l_fill_2_445 r0 *1 0,0
Xsg13cmos5l_fill_2_445 VPWR VGND sg13cmos5l_fill_2
* cell instance sg13cmos5l_fill_2_446 r0 *1 0,0
Xsg13cmos5l_fill_2_446 VPWR VGND sg13cmos5l_fill_2
* cell instance sg13cmos5l_fill_2_447 r0 *1 0,0
Xsg13cmos5l_fill_2_447 VPWR VGND sg13cmos5l_fill_2
* cell instance sg13cmos5l_fill_2_448 r0 *1 0,0
Xsg13cmos5l_fill_2_448 VPWR VGND sg13cmos5l_fill_2
* cell instance sg13cmos5l_fill_2_449 r0 *1 0,0
Xsg13cmos5l_fill_2_449 VPWR VGND sg13cmos5l_fill_2
* cell instance sg13cmos5l_fill_2_450 r0 *1 0,0
Xsg13cmos5l_fill_2_450 VPWR VGND sg13cmos5l_fill_2
* cell instance sg13cmos5l_fill_2_451 r0 *1 0,0
Xsg13cmos5l_fill_2_451 VPWR VGND sg13cmos5l_fill_2
* cell instance sg13cmos5l_fill_2_452 r0 *1 0,0
Xsg13cmos5l_fill_2_452 VPWR VGND sg13cmos5l_fill_2
* cell instance sg13cmos5l_fill_2_453 r0 *1 0,0
Xsg13cmos5l_fill_2_453 VPWR VGND sg13cmos5l_fill_2
* cell instance sg13cmos5l_fill_2_454 r0 *1 0,0
Xsg13cmos5l_fill_2_454 VPWR VGND sg13cmos5l_fill_2
* cell instance sg13cmos5l_fill_2_455 r0 *1 0,0
Xsg13cmos5l_fill_2_455 VPWR VGND sg13cmos5l_fill_2
* cell instance sg13cmos5l_fill_2_456 r0 *1 0,0
Xsg13cmos5l_fill_2_456 VPWR VGND sg13cmos5l_fill_2
* cell instance sg13cmos5l_fill_2_457 r0 *1 0,0
Xsg13cmos5l_fill_2_457 VPWR VGND sg13cmos5l_fill_2
* cell instance sg13cmos5l_fill_2_458 r0 *1 0,0
Xsg13cmos5l_fill_2_458 VPWR VGND sg13cmos5l_fill_2
* cell instance sg13cmos5l_fill_2_459 r0 *1 0,0
Xsg13cmos5l_fill_2_459 VPWR VGND sg13cmos5l_fill_2
* cell instance sg13cmos5l_fill_2_460 r0 *1 0,0
Xsg13cmos5l_fill_2_460 VPWR VGND sg13cmos5l_fill_2
* cell instance sg13cmos5l_fill_2_461 r0 *1 0,0
Xsg13cmos5l_fill_2_461 VPWR VGND sg13cmos5l_fill_2
* cell instance sg13cmos5l_fill_2_462 r0 *1 0,0
Xsg13cmos5l_fill_2_462 VPWR VGND sg13cmos5l_fill_2
* cell instance sg13cmos5l_fill_2_463 r0 *1 0,0
Xsg13cmos5l_fill_2_463 VPWR VGND sg13cmos5l_fill_2
* cell instance sg13cmos5l_fill_2_464 r0 *1 0,0
Xsg13cmos5l_fill_2_464 VPWR VGND sg13cmos5l_fill_2
* cell instance sg13cmos5l_fill_2_465 r0 *1 0,0
Xsg13cmos5l_fill_2_465 VPWR VGND sg13cmos5l_fill_2
* cell instance sg13cmos5l_fill_2_466 r0 *1 0,0
Xsg13cmos5l_fill_2_466 VPWR VGND sg13cmos5l_fill_2
* cell instance sg13cmos5l_fill_2_467 r0 *1 0,0
Xsg13cmos5l_fill_2_467 VPWR VGND sg13cmos5l_fill_2
* cell instance sg13cmos5l_fill_2_468 r0 *1 0,0
Xsg13cmos5l_fill_2_468 VPWR VGND sg13cmos5l_fill_2
* cell instance sg13cmos5l_fill_2_469 r0 *1 0,0
Xsg13cmos5l_fill_2_469 VPWR VGND sg13cmos5l_fill_2
* cell instance sg13cmos5l_fill_2_470 r0 *1 0,0
Xsg13cmos5l_fill_2_470 VPWR VGND sg13cmos5l_fill_2
* cell instance sg13cmos5l_fill_2_471 r0 *1 0,0
Xsg13cmos5l_fill_2_471 VPWR VGND sg13cmos5l_fill_2
* cell instance sg13cmos5l_fill_2_472 r0 *1 0,0
Xsg13cmos5l_fill_2_472 VPWR VGND sg13cmos5l_fill_2
* cell instance sg13cmos5l_fill_2_473 r0 *1 0,0
Xsg13cmos5l_fill_2_473 VPWR VGND sg13cmos5l_fill_2
* cell instance sg13cmos5l_fill_2_474 r0 *1 0,0
Xsg13cmos5l_fill_2_474 VPWR VGND sg13cmos5l_fill_2
* cell instance sg13cmos5l_fill_2_475 r0 *1 0,0
Xsg13cmos5l_fill_2_475 VPWR VGND sg13cmos5l_fill_2
* cell instance sg13cmos5l_fill_2_476 r0 *1 0,0
Xsg13cmos5l_fill_2_476 VPWR VGND sg13cmos5l_fill_2
* cell instance sg13cmos5l_fill_2_477 r0 *1 0,0
Xsg13cmos5l_fill_2_477 VPWR VGND sg13cmos5l_fill_2
* cell instance sg13cmos5l_fill_2_478 r0 *1 0,0
Xsg13cmos5l_fill_2_478 VPWR VGND sg13cmos5l_fill_2
* cell instance sg13cmos5l_fill_2_479 r0 *1 0,0
Xsg13cmos5l_fill_2_479 VPWR VGND sg13cmos5l_fill_2
* cell instance sg13cmos5l_fill_2_480 r0 *1 0,0
Xsg13cmos5l_fill_2_480 VPWR VGND sg13cmos5l_fill_2
* cell instance sg13cmos5l_fill_2_481 r0 *1 0,0
Xsg13cmos5l_fill_2_481 VPWR VGND sg13cmos5l_fill_2
* cell instance sg13cmos5l_fill_2_482 r0 *1 0,0
Xsg13cmos5l_fill_2_482 VPWR VGND sg13cmos5l_fill_2
* cell instance sg13cmos5l_fill_2_483 r0 *1 0,0
Xsg13cmos5l_fill_2_483 VPWR VGND sg13cmos5l_fill_2
* cell instance sg13cmos5l_fill_2_484 r0 *1 0,0
Xsg13cmos5l_fill_2_484 VPWR VGND sg13cmos5l_fill_2
* cell instance sg13cmos5l_fill_2_485 r0 *1 0,0
Xsg13cmos5l_fill_2_485 VPWR VGND sg13cmos5l_fill_2
* cell instance sg13cmos5l_fill_2_486 r0 *1 0,0
Xsg13cmos5l_fill_2_486 VPWR VGND sg13cmos5l_fill_2
* cell instance sg13cmos5l_fill_2_487 r0 *1 0,0
Xsg13cmos5l_fill_2_487 VPWR VGND sg13cmos5l_fill_2
* cell instance sg13cmos5l_fill_2_488 r0 *1 0,0
Xsg13cmos5l_fill_2_488 VPWR VGND sg13cmos5l_fill_2
* cell instance sg13cmos5l_fill_2_489 r0 *1 0,0
Xsg13cmos5l_fill_2_489 VPWR VGND sg13cmos5l_fill_2
* cell instance sg13cmos5l_fill_2_490 r0 *1 0,0
Xsg13cmos5l_fill_2_490 VPWR VGND sg13cmos5l_fill_2
* cell instance sg13cmos5l_fill_2_491 r0 *1 0,0
Xsg13cmos5l_fill_2_491 VPWR VGND sg13cmos5l_fill_2
* cell instance sg13cmos5l_fill_2_492 r0 *1 0,0
Xsg13cmos5l_fill_2_492 VPWR VGND sg13cmos5l_fill_2
* cell instance sg13cmos5l_fill_2_493 r0 *1 0,0
Xsg13cmos5l_fill_2_493 VPWR VGND sg13cmos5l_fill_2
* cell instance sg13cmos5l_fill_2_494 r0 *1 0,0
Xsg13cmos5l_fill_2_494 VPWR VGND sg13cmos5l_fill_2
* cell instance sg13cmos5l_fill_2_495 r0 *1 0,0
Xsg13cmos5l_fill_2_495 VPWR VGND sg13cmos5l_fill_2
* cell instance sg13cmos5l_fill_2_496 r0 *1 0,0
Xsg13cmos5l_fill_2_496 VPWR VGND sg13cmos5l_fill_2
* cell instance sg13cmos5l_fill_2_497 r0 *1 0,0
Xsg13cmos5l_fill_2_497 VPWR VGND sg13cmos5l_fill_2
* cell instance sg13cmos5l_fill_2_498 r0 *1 0,0
Xsg13cmos5l_fill_2_498 VPWR VGND sg13cmos5l_fill_2
* cell instance sg13cmos5l_fill_2_499 r0 *1 0,0
Xsg13cmos5l_fill_2_499 VPWR VGND sg13cmos5l_fill_2
* cell instance sg13cmos5l_fill_2_500 r0 *1 0,0
Xsg13cmos5l_fill_2_500 VPWR VGND sg13cmos5l_fill_2
* cell instance sg13cmos5l_fill_2_501 r0 *1 0,0
Xsg13cmos5l_fill_2_501 VPWR VGND sg13cmos5l_fill_2
* cell instance sg13cmos5l_fill_2_502 r0 *1 0,0
Xsg13cmos5l_fill_2_502 VPWR VGND sg13cmos5l_fill_2
* cell instance sg13cmos5l_fill_2_503 r0 *1 0,0
Xsg13cmos5l_fill_2_503 VPWR VGND sg13cmos5l_fill_2
* cell instance sg13cmos5l_fill_2_504 r0 *1 0,0
Xsg13cmos5l_fill_2_504 VPWR VGND sg13cmos5l_fill_2
* cell instance sg13cmos5l_fill_2_505 r0 *1 0,0
Xsg13cmos5l_fill_2_505 VPWR VGND sg13cmos5l_fill_2
* cell instance sg13cmos5l_fill_2_506 r0 *1 0,0
Xsg13cmos5l_fill_2_506 VPWR VGND sg13cmos5l_fill_2
* cell instance sg13cmos5l_fill_2_507 r0 *1 0,0
Xsg13cmos5l_fill_2_507 VPWR VGND sg13cmos5l_fill_2
* cell instance sg13cmos5l_fill_2_508 r0 *1 0,0
Xsg13cmos5l_fill_2_508 VPWR VGND sg13cmos5l_fill_2
* cell instance sg13cmos5l_fill_2_509 r0 *1 0,0
Xsg13cmos5l_fill_2_509 VPWR VGND sg13cmos5l_fill_2
* cell instance sg13cmos5l_fill_2_510 r0 *1 0,0
Xsg13cmos5l_fill_2_510 VPWR VGND sg13cmos5l_fill_2
* cell instance sg13cmos5l_fill_2_511 r0 *1 0,0
Xsg13cmos5l_fill_2_511 VPWR VGND sg13cmos5l_fill_2
* cell instance sg13cmos5l_fill_2_512 r0 *1 0,0
Xsg13cmos5l_fill_2_512 VPWR VGND sg13cmos5l_fill_2
* cell instance sg13cmos5l_fill_2_513 r0 *1 0,0
Xsg13cmos5l_fill_2_513 VPWR VGND sg13cmos5l_fill_2
* cell instance sg13cmos5l_fill_2_514 r0 *1 0,0
Xsg13cmos5l_fill_2_514 VPWR VGND sg13cmos5l_fill_2
* cell instance sg13cmos5l_fill_2_515 r0 *1 0,0
Xsg13cmos5l_fill_2_515 VPWR VGND sg13cmos5l_fill_2
* cell instance sg13cmos5l_fill_2_516 r0 *1 0,0
Xsg13cmos5l_fill_2_516 VPWR VGND sg13cmos5l_fill_2
* cell instance sg13cmos5l_fill_2_517 r0 *1 0,0
Xsg13cmos5l_fill_2_517 VPWR VGND sg13cmos5l_fill_2
* cell instance sg13cmos5l_fill_2_518 r0 *1 0,0
Xsg13cmos5l_fill_2_518 VPWR VGND sg13cmos5l_fill_2
* cell instance sg13cmos5l_fill_2_519 r0 *1 0,0
Xsg13cmos5l_fill_2_519 VPWR VGND sg13cmos5l_fill_2
* cell instance sg13cmos5l_fill_2_520 r0 *1 0,0
Xsg13cmos5l_fill_2_520 VPWR VGND sg13cmos5l_fill_2
* cell instance sg13cmos5l_fill_2_521 r0 *1 0,0
Xsg13cmos5l_fill_2_521 VPWR VGND sg13cmos5l_fill_2
* cell instance sg13cmos5l_fill_2_522 r0 *1 0,0
Xsg13cmos5l_fill_2_522 VPWR VGND sg13cmos5l_fill_2
* cell instance sg13cmos5l_fill_2_523 r0 *1 0,0
Xsg13cmos5l_fill_2_523 VPWR VGND sg13cmos5l_fill_2
* cell instance sg13cmos5l_fill_2_524 r0 *1 0,0
Xsg13cmos5l_fill_2_524 VPWR VGND sg13cmos5l_fill_2
* cell instance sg13cmos5l_fill_2_525 r0 *1 0,0
Xsg13cmos5l_fill_2_525 VPWR VGND sg13cmos5l_fill_2
* cell instance sg13cmos5l_fill_2_526 r0 *1 0,0
Xsg13cmos5l_fill_2_526 VPWR VGND sg13cmos5l_fill_2
* cell instance sg13cmos5l_fill_2_527 r0 *1 0,0
Xsg13cmos5l_fill_2_527 VPWR VGND sg13cmos5l_fill_2
* cell instance sg13cmos5l_fill_2_528 r0 *1 0,0
Xsg13cmos5l_fill_2_528 VPWR VGND sg13cmos5l_fill_2
* cell instance sg13cmos5l_fill_2_529 r0 *1 0,0
Xsg13cmos5l_fill_2_529 VPWR VGND sg13cmos5l_fill_2
* cell instance sg13cmos5l_fill_2_530 r0 *1 0,0
Xsg13cmos5l_fill_2_530 VPWR VGND sg13cmos5l_fill_2
* cell instance sg13cmos5l_fill_2_531 r0 *1 0,0
Xsg13cmos5l_fill_2_531 VPWR VGND sg13cmos5l_fill_2
* cell instance sg13cmos5l_fill_2_532 r0 *1 0,0
Xsg13cmos5l_fill_2_532 VPWR VGND sg13cmos5l_fill_2
* cell instance sg13cmos5l_fill_2_533 r0 *1 0,0
Xsg13cmos5l_fill_2_533 VPWR VGND sg13cmos5l_fill_2
* cell instance sg13cmos5l_fill_2_534 r0 *1 0,0
Xsg13cmos5l_fill_2_534 VPWR VGND sg13cmos5l_fill_2
* cell instance sg13cmos5l_fill_2_535 r0 *1 0,0
Xsg13cmos5l_fill_2_535 VPWR VGND sg13cmos5l_fill_2
* cell instance sg13cmos5l_fill_2_536 r0 *1 0,0
Xsg13cmos5l_fill_2_536 VPWR VGND sg13cmos5l_fill_2
* cell instance sg13cmos5l_fill_2_537 r0 *1 0,0
Xsg13cmos5l_fill_2_537 VPWR VGND sg13cmos5l_fill_2
* cell instance sg13cmos5l_fill_2_538 r0 *1 0,0
Xsg13cmos5l_fill_2_538 VPWR VGND sg13cmos5l_fill_2
* cell instance sg13cmos5l_fill_2_539 r0 *1 0,0
Xsg13cmos5l_fill_2_539 VPWR VGND sg13cmos5l_fill_2
* cell instance sg13cmos5l_fill_2_540 r0 *1 0,0
Xsg13cmos5l_fill_2_540 VPWR VGND sg13cmos5l_fill_2
* cell instance sg13cmos5l_fill_2_541 r0 *1 0,0
Xsg13cmos5l_fill_2_541 VPWR VGND sg13cmos5l_fill_2
* cell instance sg13cmos5l_fill_2_542 r0 *1 0,0
Xsg13cmos5l_fill_2_542 VPWR VGND sg13cmos5l_fill_2
* cell instance sg13cmos5l_fill_2_543 r0 *1 0,0
Xsg13cmos5l_fill_2_543 VPWR VGND sg13cmos5l_fill_2
* cell instance sg13cmos5l_fill_2_544 r0 *1 0,0
Xsg13cmos5l_fill_2_544 VPWR VGND sg13cmos5l_fill_2
* cell instance sg13cmos5l_fill_2_545 r0 *1 0,0
Xsg13cmos5l_fill_2_545 VPWR VGND sg13cmos5l_fill_2
* cell instance sg13cmos5l_fill_2_546 r0 *1 0,0
Xsg13cmos5l_fill_2_546 VPWR VGND sg13cmos5l_fill_2
* cell instance sg13cmos5l_fill_2_547 r0 *1 0,0
Xsg13cmos5l_fill_2_547 VPWR VGND sg13cmos5l_fill_2
* cell instance sg13cmos5l_fill_2_548 r0 *1 0,0
Xsg13cmos5l_fill_2_548 VPWR VGND sg13cmos5l_fill_2
* cell instance sg13cmos5l_fill_2_549 r0 *1 0,0
Xsg13cmos5l_fill_2_549 VPWR VGND sg13cmos5l_fill_2
* cell instance sg13cmos5l_fill_2_550 r0 *1 0,0
Xsg13cmos5l_fill_2_550 VPWR VGND sg13cmos5l_fill_2
* cell instance sg13cmos5l_fill_2_551 r0 *1 0,0
Xsg13cmos5l_fill_2_551 VPWR VGND sg13cmos5l_fill_2
* cell instance sg13cmos5l_fill_2_552 r0 *1 0,0
Xsg13cmos5l_fill_2_552 VPWR VGND sg13cmos5l_fill_2
* cell instance sg13cmos5l_fill_2_553 r0 *1 0,0
Xsg13cmos5l_fill_2_553 VPWR VGND sg13cmos5l_fill_2
* cell instance sg13cmos5l_fill_2_554 r0 *1 0,0
Xsg13cmos5l_fill_2_554 VPWR VGND sg13cmos5l_fill_2
* cell instance sg13cmos5l_fill_2_555 r0 *1 0,0
Xsg13cmos5l_fill_2_555 VPWR VGND sg13cmos5l_fill_2
* cell instance sg13cmos5l_fill_2_556 r0 *1 0,0
Xsg13cmos5l_fill_2_556 VPWR VGND sg13cmos5l_fill_2
* cell instance sg13cmos5l_fill_2_557 r0 *1 0,0
Xsg13cmos5l_fill_2_557 VPWR VGND sg13cmos5l_fill_2
* cell instance sg13cmos5l_fill_2_558 r0 *1 0,0
Xsg13cmos5l_fill_2_558 VPWR VGND sg13cmos5l_fill_2
* cell instance sg13cmos5l_fill_2_559 r0 *1 0,0
Xsg13cmos5l_fill_2_559 VPWR VGND sg13cmos5l_fill_2
* cell instance sg13cmos5l_fill_2_560 r0 *1 0,0
Xsg13cmos5l_fill_2_560 VPWR VGND sg13cmos5l_fill_2
* cell instance sg13cmos5l_fill_2_561 r0 *1 0,0
Xsg13cmos5l_fill_2_561 VPWR VGND sg13cmos5l_fill_2
* cell instance sg13cmos5l_fill_2_562 r0 *1 0,0
Xsg13cmos5l_fill_2_562 VPWR VGND sg13cmos5l_fill_2
* cell instance sg13cmos5l_fill_2_563 r0 *1 0,0
Xsg13cmos5l_fill_2_563 VPWR VGND sg13cmos5l_fill_2
* cell instance sg13cmos5l_fill_2_564 r0 *1 0,0
Xsg13cmos5l_fill_2_564 VPWR VGND sg13cmos5l_fill_2
* cell instance sg13cmos5l_fill_2_565 r0 *1 0,0
Xsg13cmos5l_fill_2_565 VPWR VGND sg13cmos5l_fill_2
* cell instance sg13cmos5l_fill_2_566 r0 *1 0,0
Xsg13cmos5l_fill_2_566 VPWR VGND sg13cmos5l_fill_2
* cell instance sg13cmos5l_fill_2_567 r0 *1 0,0
Xsg13cmos5l_fill_2_567 VPWR VGND sg13cmos5l_fill_2
* cell instance sg13cmos5l_fill_2_568 r0 *1 0,0
Xsg13cmos5l_fill_2_568 VPWR VGND sg13cmos5l_fill_2
* cell instance sg13cmos5l_fill_2_569 r0 *1 0,0
Xsg13cmos5l_fill_2_569 VPWR VGND sg13cmos5l_fill_2
* cell instance sg13cmos5l_fill_2_570 r0 *1 0,0
Xsg13cmos5l_fill_2_570 VPWR VGND sg13cmos5l_fill_2
* cell instance sg13cmos5l_fill_2_571 r0 *1 0,0
Xsg13cmos5l_fill_2_571 VPWR VGND sg13cmos5l_fill_2
* cell instance sg13cmos5l_fill_2_572 r0 *1 0,0
Xsg13cmos5l_fill_2_572 VPWR VGND sg13cmos5l_fill_2
* cell instance sg13cmos5l_fill_2_573 r0 *1 0,0
Xsg13cmos5l_fill_2_573 VPWR VGND sg13cmos5l_fill_2
* cell instance sg13cmos5l_fill_2_574 r0 *1 0,0
Xsg13cmos5l_fill_2_574 VPWR VGND sg13cmos5l_fill_2
* cell instance sg13cmos5l_fill_2_575 r0 *1 0,0
Xsg13cmos5l_fill_2_575 VPWR VGND sg13cmos5l_fill_2
* cell instance sg13cmos5l_fill_2_576 r0 *1 0,0
Xsg13cmos5l_fill_2_576 VPWR VGND sg13cmos5l_fill_2
* cell instance sg13cmos5l_fill_2_577 r0 *1 0,0
Xsg13cmos5l_fill_2_577 VPWR VGND sg13cmos5l_fill_2
* cell instance sg13cmos5l_fill_2_578 r0 *1 0,0
Xsg13cmos5l_fill_2_578 VPWR VGND sg13cmos5l_fill_2
* cell instance sg13cmos5l_fill_2_579 r0 *1 0,0
Xsg13cmos5l_fill_2_579 VPWR VGND sg13cmos5l_fill_2
* cell instance sg13cmos5l_fill_2_580 r0 *1 0,0
Xsg13cmos5l_fill_2_580 VPWR VGND sg13cmos5l_fill_2
* cell instance sg13cmos5l_fill_2_581 r0 *1 0,0
Xsg13cmos5l_fill_2_581 VPWR VGND sg13cmos5l_fill_2
* cell instance sg13cmos5l_fill_2_582 r0 *1 0,0
Xsg13cmos5l_fill_2_582 VPWR VGND sg13cmos5l_fill_2
* cell instance sg13cmos5l_fill_2_583 r0 *1 0,0
Xsg13cmos5l_fill_2_583 VPWR VGND sg13cmos5l_fill_2
* cell instance sg13cmos5l_fill_2_584 r0 *1 0,0
Xsg13cmos5l_fill_2_584 VPWR VGND sg13cmos5l_fill_2
* cell instance sg13cmos5l_fill_2_585 r0 *1 0,0
Xsg13cmos5l_fill_2_585 VPWR VGND sg13cmos5l_fill_2
* cell instance sg13cmos5l_fill_2_586 r0 *1 0,0
Xsg13cmos5l_fill_2_586 VPWR VGND sg13cmos5l_fill_2
* cell instance sg13cmos5l_fill_2_587 r0 *1 0,0
Xsg13cmos5l_fill_2_587 VPWR VGND sg13cmos5l_fill_2
* cell instance sg13cmos5l_fill_2_588 r0 *1 0,0
Xsg13cmos5l_fill_2_588 VPWR VGND sg13cmos5l_fill_2
* cell instance sg13cmos5l_fill_2_589 r0 *1 0,0
Xsg13cmos5l_fill_2_589 VPWR VGND sg13cmos5l_fill_2
* cell instance sg13cmos5l_fill_2_590 r0 *1 0,0
Xsg13cmos5l_fill_2_590 VPWR VGND sg13cmos5l_fill_2
* cell instance sg13cmos5l_fill_2_591 r0 *1 0,0
Xsg13cmos5l_fill_2_591 VPWR VGND sg13cmos5l_fill_2
* cell instance sg13cmos5l_inv_1_0 r0 *1 0,0
Xsg13cmos5l_inv_1_0 \$2578 VPWR VGND \$2577 sg13cmos5l_inv_1
* cell instance sg13cmos5l_inv_1_1 r0 *1 0,0
Xsg13cmos5l_inv_1_1 \$7250 VPWR VGND \$7542 sg13cmos5l_inv_1
* cell instance sg13cmos5l_inv_1_2 r0 *1 0,0
Xsg13cmos5l_inv_1_2 \$1817 VPWR VGND \$2735 sg13cmos5l_inv_1
* cell instance sg13cmos5l_inv_1_3 r0 *1 0,0
Xsg13cmos5l_inv_1_3 \$7330 VPWR VGND \$7637 sg13cmos5l_inv_1
* cell instance sg13cmos5l_inv_1_4 r0 *1 0,0
Xsg13cmos5l_inv_1_4 \$2153 VPWR VGND \$2606 sg13cmos5l_inv_1
* cell instance sg13cmos5l_inv_1_5 r0 *1 0,0
Xsg13cmos5l_inv_1_5 \$2443 VPWR VGND \$2301 sg13cmos5l_inv_1
* cell instance sg13cmos5l_inv_1_6 r0 *1 0,0
Xsg13cmos5l_inv_1_6 \$3018 VPWR VGND \$3190 sg13cmos5l_inv_1
* cell instance sg13cmos5l_inv_1_7 r0 *1 0,0
Xsg13cmos5l_inv_1_7 \$937 VPWR VGND \$1642 sg13cmos5l_inv_1
* cell instance sg13cmos5l_inv_1_8 r0 *1 0,0
Xsg13cmos5l_inv_1_8 \$5340 VPWR VGND \$5875 sg13cmos5l_inv_1
* cell instance sg13cmos5l_inv_1_9 r0 *1 0,0
Xsg13cmos5l_inv_1_9 \$1447 VPWR VGND \$1316 sg13cmos5l_inv_1
* cell instance sg13cmos5l_inv_1_10 r0 *1 0,0
Xsg13cmos5l_inv_1_10 \$144 VPWR VGND \$143 sg13cmos5l_inv_1
* cell instance sg13cmos5l_inv_1_11 r0 *1 0,0
Xsg13cmos5l_inv_1_11 \$7335 VPWR VGND \$7333 sg13cmos5l_inv_1
* cell instance sg13cmos5l_inv_1_12 r0 *1 0,0
Xsg13cmos5l_inv_1_12 \$665 VPWR VGND \$666 sg13cmos5l_inv_1
* cell instance sg13cmos5l_inv_1_13 r0 *1 0,0
Xsg13cmos5l_inv_1_13 \$240 VPWR VGND \$830 sg13cmos5l_inv_1
* cell instance sg13cmos5l_inv_1_14 r0 *1 0,0
Xsg13cmos5l_inv_1_14 \$3910 VPWR VGND \$3575 sg13cmos5l_inv_1
* cell instance sg13cmos5l_inv_1_15 r0 *1 0,0
Xsg13cmos5l_inv_1_15 \$1287 VPWR VGND \$1449 sg13cmos5l_inv_1
* cell instance sg13cmos5l_inv_1_16 r0 *1 0,0
Xsg13cmos5l_inv_1_16 \$1154 VPWR VGND \$2160 sg13cmos5l_inv_1
* cell instance sg13cmos5l_inv_1_17 r0 *1 0,0
Xsg13cmos5l_inv_1_17 \$2306 VPWR VGND \$2615 sg13cmos5l_inv_1
* cell instance sg13cmos5l_inv_1_18 r0 *1 0,0
Xsg13cmos5l_inv_1_18 \$7587 VPWR VGND \$7559 sg13cmos5l_inv_1
* cell instance sg13cmos5l_inv_1_19 r0 *1 0,0
Xsg13cmos5l_inv_1_19 \$3197 VPWR VGND \$2464 sg13cmos5l_inv_1
* cell instance sg13cmos5l_inv_1_20 r0 *1 0,0
Xsg13cmos5l_inv_1_20 \$54 VPWR VGND \$45 sg13cmos5l_inv_1
* cell instance sg13cmos5l_inv_1_21 r0 *1 0,0
Xsg13cmos5l_inv_1_21 \$1166 VPWR VGND \$1850 sg13cmos5l_inv_1
* cell instance sg13cmos5l_inv_1_22 r0 *1 0,0
Xsg13cmos5l_inv_1_22 \$2319 VPWR VGND \$3196 sg13cmos5l_inv_1
* cell instance sg13cmos5l_inv_1_23 r0 *1 0,0
Xsg13cmos5l_inv_1_23 \$1456 VPWR VGND \$1455 sg13cmos5l_inv_1
* cell instance sg13cmos5l_inv_1_24 r0 *1 0,0
Xsg13cmos5l_inv_1_24 \$47 VPWR VGND \$29 sg13cmos5l_inv_1
* cell instance sg13cmos5l_inv_1_25 r0 *1 0,0
Xsg13cmos5l_inv_1_25 \$24 VPWR VGND \$453 sg13cmos5l_inv_1
* cell instance sg13cmos5l_inv_1_26 r0 *1 0,0
Xsg13cmos5l_inv_1_26 \$3739 VPWR VGND \$3743 sg13cmos5l_inv_1
* cell instance sg13cmos5l_inv_1_27 r0 *1 0,0
Xsg13cmos5l_inv_1_27 \$1055 VPWR VGND \$2460 sg13cmos5l_inv_1
* cell instance sg13cmos5l_inv_1_28 r0 *1 0,0
Xsg13cmos5l_inv_1_28 \$1307 VPWR VGND \$1653 sg13cmos5l_inv_1
* cell instance sg13cmos5l_inv_1_29 r0 *1 0,0
Xsg13cmos5l_inv_1_29 \$1062 VPWR VGND \$1655 sg13cmos5l_inv_1
* cell instance sg13cmos5l_inv_1_30 r0 *1 0,0
Xsg13cmos5l_inv_1_30 \$48 VPWR VGND \$53 sg13cmos5l_inv_1
* cell instance sg13cmos5l_inv_1_31 r0 *1 0,0
Xsg13cmos5l_inv_1_31 \$1193 VPWR VGND \$1657 sg13cmos5l_inv_1
* cell instance sg13cmos5l_inv_1_32 r0 *1 0,0
Xsg13cmos5l_inv_1_32 \$1463 VPWR VGND \$1313 sg13cmos5l_inv_1
* cell instance sg13cmos5l_inv_1_33 r0 *1 0,0
Xsg13cmos5l_inv_1_33 \$2039 VPWR VGND \$2174 sg13cmos5l_inv_1
* cell instance sg13cmos5l_inv_1_34 r0 *1 0,0
Xsg13cmos5l_inv_1_34 \$1310 VPWR VGND \$1322 sg13cmos5l_inv_1
* cell instance sg13cmos5l_inv_1_35 r0 *1 0,0
Xsg13cmos5l_inv_1_35 \$2630 VPWR VGND \$2626 sg13cmos5l_inv_1
* cell instance sg13cmos5l_inv_1_36 r0 *1 0,0
Xsg13cmos5l_inv_1_36 \$2351 VPWR VGND \$2176 sg13cmos5l_inv_1
* cell instance sg13cmos5l_inv_1_37 r0 *1 0,0
Xsg13cmos5l_inv_1_37 \$260 VPWR VGND \$208 sg13cmos5l_inv_1
* cell instance sg13cmos5l_inv_1_38 r0 *1 0,0
Xsg13cmos5l_inv_1_38 \$3225 VPWR VGND \$2488 sg13cmos5l_inv_1
* cell instance sg13cmos5l_inv_1_39 r0 *1 0,0
Xsg13cmos5l_inv_1_39 \$1658 VPWR VGND \$2502 sg13cmos5l_inv_1
* cell instance sg13cmos5l_inv_1_40 r0 *1 0,0
Xsg13cmos5l_inv_1_40 \$17246 VPWR VGND \$17285 sg13cmos5l_inv_1
* cell instance sg13cmos5l_inv_1_41 r0 *1 0,0
Xsg13cmos5l_inv_1_41 \$17288 VPWR VGND \$17295 sg13cmos5l_inv_1
* cell instance sg13cmos5l_inv_1_42 r0 *1 0,0
Xsg13cmos5l_inv_1_42 \$1701 VPWR VGND \$1700 sg13cmos5l_inv_1
* cell instance sg13cmos5l_inv_1_43 r0 *1 0,0
Xsg13cmos5l_inv_1_43 \$3090 VPWR VGND \$3091 sg13cmos5l_inv_1
* cell instance sg13cmos5l_inv_1_44 r0 *1 0,0
Xsg13cmos5l_inv_1_44 \$1893 VPWR VGND \$2644 sg13cmos5l_inv_1
* cell instance sg13cmos5l_inv_1_45 r0 *1 0,0
Xsg13cmos5l_inv_1_45 \$3502 VPWR VGND \$3792 sg13cmos5l_inv_1
* cell instance sg13cmos5l_inv_1_46 r0 *1 0,0
Xsg13cmos5l_inv_1_46 \$2446 VPWR VGND \$2647 sg13cmos5l_inv_1
* cell instance sg13cmos5l_inv_1_47 r0 *1 0,0
Xsg13cmos5l_inv_1_47 \$1507 VPWR VGND \$2933 sg13cmos5l_inv_1
* cell instance sg13cmos5l_inv_1_48 r0 *1 0,0
Xsg13cmos5l_inv_1_48 \$3368 VPWR VGND \$3231 sg13cmos5l_inv_1
* cell instance sg13cmos5l_inv_1_49 r0 *1 0,0
Xsg13cmos5l_inv_1_49 \$2648 VPWR VGND \$2776 sg13cmos5l_inv_1
* cell instance sg13cmos5l_inv_1_50 r0 *1 0,0
Xsg13cmos5l_inv_1_50 \$3799 VPWR VGND \$3103 sg13cmos5l_inv_1
* cell instance sg13cmos5l_inv_1_51 r0 *1 0,0
Xsg13cmos5l_inv_1_51 \$3506 VPWR VGND \$3233 sg13cmos5l_inv_1
* cell instance sg13cmos5l_inv_1_52 r0 *1 0,0
Xsg13cmos5l_inv_1_52 \$3235 VPWR VGND \$2654 sg13cmos5l_inv_1
* cell instance sg13cmos5l_inv_1_53 r0 *1 0,0
Xsg13cmos5l_inv_1_53 \$3508 VPWR VGND \$3234 sg13cmos5l_inv_1
* cell instance sg13cmos5l_inv_1_54 r0 *1 0,0
Xsg13cmos5l_inv_1_54 \$4228 VPWR VGND \$4226 sg13cmos5l_inv_1
* cell instance sg13cmos5l_inv_1_55 r0 *1 0,0
Xsg13cmos5l_inv_1_55 \$1102 VPWR VGND \$1536 sg13cmos5l_inv_1
* cell instance sg13cmos5l_inv_1_56 r0 *1 0,0
Xsg13cmos5l_inv_1_56 \$3377 VPWR VGND \$3373 sg13cmos5l_inv_1
* cell instance sg13cmos5l_inv_1_57 r0 *1 0,0
Xsg13cmos5l_inv_1_57 \$2796 VPWR VGND \$2792 sg13cmos5l_inv_1
* cell instance sg13cmos5l_inv_1_58 r0 *1 0,0
Xsg13cmos5l_inv_1_58 \$2509 VPWR VGND \$2513 sg13cmos5l_inv_1
* cell instance sg13cmos5l_inv_1_59 r0 *1 0,0
Xsg13cmos5l_inv_1_59 \$2953 VPWR VGND \$3006 sg13cmos5l_inv_1
* cell instance sg13cmos5l_inv_1_60 r0 *1 0,0
Xsg13cmos5l_inv_1_60 \$2518 VPWR VGND \$2665 sg13cmos5l_inv_1
* cell instance sg13cmos5l_inv_1_61 r0 *1 0,0
Xsg13cmos5l_inv_1_61 \$2352 VPWR VGND \$2365 sg13cmos5l_inv_1
* cell instance sg13cmos5l_inv_1_62 r0 *1 0,0
Xsg13cmos5l_inv_1_62 \$2678 VPWR VGND \$2673 sg13cmos5l_inv_1
* cell instance sg13cmos5l_inv_1_63 r0 *1 0,0
Xsg13cmos5l_inv_1_63 \$1765 VPWR VGND \$2101 sg13cmos5l_inv_1
* cell instance sg13cmos5l_inv_1_64 r0 *1 0,0
Xsg13cmos5l_inv_1_64 \$2522 VPWR VGND \$2815 sg13cmos5l_inv_1
* cell instance sg13cmos5l_inv_1_65 r0 *1 0,0
Xsg13cmos5l_inv_1_65 \$4047 VPWR VGND \$4046 sg13cmos5l_inv_1
* cell instance sg13cmos5l_inv_1_66 r0 *1 0,0
Xsg13cmos5l_inv_1_66 \$4512 VPWR VGND \$4048 sg13cmos5l_inv_1
* cell instance sg13cmos5l_inv_1_67 r0 *1 0,0
Xsg13cmos5l_inv_1_67 \$1943 VPWR VGND \$1774 sg13cmos5l_inv_1
* cell instance sg13cmos5l_inv_1_68 r0 *1 0,0
Xsg13cmos5l_inv_1_68 \$3130 VPWR VGND \$3246 sg13cmos5l_inv_1
* cell instance sg13cmos5l_inv_1_69 r0 *1 0,0
Xsg13cmos5l_inv_1_69 \$3264 VPWR VGND \$3263 sg13cmos5l_inv_1
* cell instance sg13cmos5l_mux2_1_0 r0 *1 0,0
Xsg13cmos5l_mux2_1_0 \$4574 \$5096 \$4318 VPWR VGND \$4575 sg13cmos5l_mux2_1
* cell instance sg13cmos5l_mux2_1_1 r0 *1 0,0
Xsg13cmos5l_mux2_1_1 \$4547 \$3885 \$4318 VPWR VGND \$4114 sg13cmos5l_mux2_1
* cell instance sg13cmos5l_mux2_1_2 r0 *1 0,0
Xsg13cmos5l_mux2_1_2 \$5244 \$4574 \$4318 VPWR VGND \$5080 sg13cmos5l_mux2_1
* cell instance sg13cmos5l_mux2_1_3 r0 *1 0,0
Xsg13cmos5l_mux2_1_3 \$1855 \$5244 \$3883 VPWR VGND \$5250 sg13cmos5l_mux2_1
* cell instance sg13cmos5l_mux2_1_4 r0 *1 0,0
Xsg13cmos5l_mux2_1_4 \$5096 \$4129 \$4318 VPWR VGND \$4747 sg13cmos5l_mux2_1
* cell instance sg13cmos5l_mux2_1_5 r0 *1 0,0
Xsg13cmos5l_mux2_1_5 \$3025 \$3151 \$2865 VPWR VGND \$3162 sg13cmos5l_mux2_1
* cell instance sg13cmos5l_mux2_1_6 r0 *1 0,0
Xsg13cmos5l_mux2_1_6 \$12641 \$1855 \$9804 VPWR VGND \$13079 sg13cmos5l_mux2_1
* cell instance sg13cmos5l_mux2_1_7 r0 *1 0,0
Xsg13cmos5l_mux2_1_7 \$5107 \$5244 \$4318 VPWR VGND \$5173 sg13cmos5l_mux2_1
* cell instance sg13cmos5l_mux2_1_8 r0 *1 0,0
Xsg13cmos5l_mux2_1_8 \$4129 \$4547 \$4318 VPWR VGND \$4324 sg13cmos5l_mux2_1
* cell instance sg13cmos5l_mux2_1_9 r0 *1 0,0
Xsg13cmos5l_mux2_1_9 \$9956 \$1855 \$8320 VPWR VGND \$10250 sg13cmos5l_mux2_1
* cell instance sg13cmos5l_mux2_1_10 r0 *1 0,0
Xsg13cmos5l_mux2_1_10 \$1855 \$15744 \$11737 VPWR VGND \$15158 sg13cmos5l_mux2_1
* cell instance sg13cmos5l_mux2_1_11 r0 *1 0,0
Xsg13cmos5l_mux2_1_11 \$2744 \$5107 \$4318 VPWR VGND \$5108 sg13cmos5l_mux2_1
* cell instance sg13cmos5l_mux2_1_12 r0 *1 0,0
Xsg13cmos5l_mux2_1_12 \$2296 \$2288 \$2150 VPWR VGND \$2292 sg13cmos5l_mux2_1
* cell instance sg13cmos5l_mux2_1_13 r0 *1 0,0
Xsg13cmos5l_mux2_1_13 \$1855 \$15167 \$13940 VPWR VGND \$15142 sg13cmos5l_mux2_1
* cell instance sg13cmos5l_mux2_1_14 r0 *1 0,0
Xsg13cmos5l_mux2_1_14 \$2026 \$4129 \$3886 VPWR VGND \$4130 sg13cmos5l_mux2_1
* cell instance sg13cmos5l_mux2_1_15 r0 *1 0,0
Xsg13cmos5l_mux2_1_15 \$3885 \$3717 \$4318 VPWR VGND \$3715 sg13cmos5l_mux2_1
* cell instance sg13cmos5l_mux2_1_16 r0 *1 0,0
Xsg13cmos5l_mux2_1_16 \$2026 \$16816 \$11737 VPWR VGND \$16594 sg13cmos5l_mux2_1
* cell instance sg13cmos5l_mux2_1_17 r0 *1 0,0
Xsg13cmos5l_mux2_1_17 \$7529 \$7255 \$6432 VPWR VGND \$7716 sg13cmos5l_mux2_1
* cell instance sg13cmos5l_mux2_1_18 r0 *1 0,0
Xsg13cmos5l_mux2_1_18 \$10286 \$2026 \$8922 VPWR VGND \$9961 sg13cmos5l_mux2_1
* cell instance sg13cmos5l_mux2_1_19 r0 *1 0,0
Xsg13cmos5l_mux2_1_19 \$12873 \$2026 \$11895 VPWR VGND \$12645 sg13cmos5l_mux2_1
* cell instance sg13cmos5l_mux2_1_20 r0 *1 0,0
Xsg13cmos5l_mux2_1_20 \$7716 \$14184 \$3195 VPWR VGND uo_out[7]
+ sg13cmos5l_mux2_1
* cell instance sg13cmos5l_mux2_1_21 r0 *1 0,0
Xsg13cmos5l_mux2_1_21 \$7550 \$15592 \$2880 VPWR VGND uo_out[2]
+ sg13cmos5l_mux2_1
* cell instance sg13cmos5l_mux2_1_22 r0 *1 0,0
Xsg13cmos5l_mux2_1_22 \$7254 \$7262 \$6432 VPWR VGND \$8178 sg13cmos5l_mux2_1
* cell instance sg13cmos5l_mux2_1_23 r0 *1 0,0
Xsg13cmos5l_mux2_1_23 \$3726 \$3725 \$3728 VPWR VGND \$3722 sg13cmos5l_mux2_1
* cell instance sg13cmos5l_mux2_1_24 r0 *1 0,0
Xsg13cmos5l_mux2_1_24 \$6365 \$5548 \$6432 VPWR VGND \$6511 sg13cmos5l_mux2_1
* cell instance sg13cmos5l_mux2_1_25 r0 *1 0,0
Xsg13cmos5l_mux2_1_25 \$2026 \$16187 \$13940 VPWR VGND \$16097 sg13cmos5l_mux2_1
* cell instance sg13cmos5l_mux2_1_26 r0 *1 0,0
Xsg13cmos5l_mux2_1_26 \$6562 \$7014 \$6432 VPWR VGND \$7550 sg13cmos5l_mux2_1
* cell instance sg13cmos5l_mux2_1_27 r0 *1 0,0
Xsg13cmos5l_mux2_1_27 \$6511 \$10716 \$2880 VPWR VGND uo_out[4]
+ sg13cmos5l_mux2_1
* cell instance sg13cmos5l_mux2_1_28 r0 *1 0,0
Xsg13cmos5l_mux2_1_28 \$5337 \$2028 \$2623 VPWR VGND \$5335 sg13cmos5l_mux2_1
* cell instance sg13cmos5l_mux2_1_29 r0 *1 0,0
Xsg13cmos5l_mux2_1_29 \$5602 \$6204 \$6432 VPWR VGND \$6380 sg13cmos5l_mux2_1
* cell instance sg13cmos5l_mux2_1_30 r0 *1 0,0
Xsg13cmos5l_mux2_1_30 \$5126 \$2179 \$2623 VPWR VGND \$5195 sg13cmos5l_mux2_1
* cell instance sg13cmos5l_mux2_1_31 r0 *1 0,0
Xsg13cmos5l_mux2_1_31 \$4774 \$2130 \$2623 VPWR VGND \$4760 sg13cmos5l_mux2_1
* cell instance sg13cmos5l_mux2_1_32 r0 *1 0,0
Xsg13cmos5l_mux2_1_32 \$6380 \$14704 \$2880 VPWR VGND uo_out[1]
+ sg13cmos5l_mux2_1
* cell instance sg13cmos5l_mux2_1_33 r0 *1 0,0
Xsg13cmos5l_mux2_1_33 \$6697 \$6572 \$6432 VPWR VGND \$7216 sg13cmos5l_mux2_1
* cell instance sg13cmos5l_mux2_1_34 r0 *1 0,0
Xsg13cmos5l_mux2_1_34 \$7216 \$15599 \$3195 VPWR VGND uo_out[5]
+ sg13cmos5l_mux2_1
* cell instance sg13cmos5l_mux2_1_35 r0 *1 0,0
Xsg13cmos5l_mux2_1_35 \$7651 \$6713 \$6432 VPWR VGND \$7643 sg13cmos5l_mux2_1
* cell instance sg13cmos5l_mux2_1_36 r0 *1 0,0
Xsg13cmos5l_mux2_1_36 \$6178 \$5308 \$6432 VPWR VGND \$6384 sg13cmos5l_mux2_1
* cell instance sg13cmos5l_mux2_1_37 r0 *1 0,0
Xsg13cmos5l_mux2_1_37 \$3201 \$960 \$3205 VPWR VGND \$3197 sg13cmos5l_mux2_1
* cell instance sg13cmos5l_mux2_1_38 r0 *1 0,0
Xsg13cmos5l_mux2_1_38 \$8178 \$10292 \$3195 VPWR VGND uo_out[6]
+ sg13cmos5l_mux2_1
* cell instance sg13cmos5l_mux2_1_39 r0 *1 0,0
Xsg13cmos5l_mux2_1_39 \$7643 \$11763 \$2880 VPWR VGND uo_out[3]
+ sg13cmos5l_mux2_1
* cell instance sg13cmos5l_mux2_1_40 r0 *1 0,0
Xsg13cmos5l_mux2_1_40 \$6384 \$15176 \$2880 VPWR VGND uo_out[0]
+ sg13cmos5l_mux2_1
* cell instance sg13cmos5l_mux2_1_41 r0 *1 0,0
Xsg13cmos5l_mux2_1_41 \$5491 \$2030 \$2623 VPWR VGND \$5345 sg13cmos5l_mux2_1
* cell instance sg13cmos5l_mux2_1_42 r0 *1 0,0
Xsg13cmos5l_mux2_1_42 \$4601 \$3201 \$2623 VPWR VGND \$4599 sg13cmos5l_mux2_1
* cell instance sg13cmos5l_mux2_1_43 r0 *1 0,0
Xsg13cmos5l_mux2_1_43 \$5203 \$3206 \$2623 VPWR VGND \$5281 sg13cmos5l_mux2_1
* cell instance sg13cmos5l_mux2_1_44 r0 *1 0,0
Xsg13cmos5l_mux2_1_44 \$3057 \$1048 \$3205 VPWR VGND \$3058 sg13cmos5l_mux2_1
* cell instance sg13cmos5l_mux2_1_45 r0 *1 0,0
Xsg13cmos5l_mux2_1_45 \$4149 \$3057 \$2623 VPWR VGND \$4150 sg13cmos5l_mux2_1
* cell instance sg13cmos5l_mux2_1_46 r0 *1 0,0
Xsg13cmos5l_mux2_1_46 \$3206 \$1487 \$3205 VPWR VGND \$2739 sg13cmos5l_mux2_1
* cell instance sg13cmos5l_mux2_1_47 r0 *1 0,0
Xsg13cmos5l_mux2_1_47 \$3470 \$3467 \$3205 VPWR VGND \$2851 sg13cmos5l_mux2_1
* cell instance sg13cmos5l_mux2_1_48 r0 *1 0,0
Xsg13cmos5l_mux2_1_48 \$4386 \$3470 \$2623 VPWR VGND \$4387 sg13cmos5l_mux2_1
* cell instance sg13cmos5l_mux2_1_49 r0 *1 0,0
Xsg13cmos5l_mux2_1_49 \$1079 \$572 \$665 VPWR VGND \$1080 sg13cmos5l_mux2_1
* cell instance sg13cmos5l_mux2_1_50 r0 *1 0,0
Xsg13cmos5l_mux2_1_50 \$2030 \$1474 \$2182 VPWR VGND \$2155 sg13cmos5l_mux2_1
* cell instance sg13cmos5l_mux2_1_51 r0 *1 0,0
Xsg13cmos5l_mux2_1_51 \$2179 \$1681 \$2182 VPWR VGND \$2000 sg13cmos5l_mux2_1
* cell instance sg13cmos5l_mux2_1_52 r0 *1 0,0
Xsg13cmos5l_mux2_1_52 \$2130 \$1859 \$2182 VPWR VGND \$2151 sg13cmos5l_mux2_1
* cell instance sg13cmos5l_mux2_1_53 r0 *1 0,0
Xsg13cmos5l_mux2_1_53 \$2028 \$1486 \$2182 VPWR VGND \$2017 sg13cmos5l_mux2_1
* cell instance sg13cmos5l_mux2_1_54 r0 *1 0,0
Xsg13cmos5l_mux2_1_54 \$3961 \$3717 \$4567 VPWR VGND \$4398 sg13cmos5l_mux2_1
* cell instance sg13cmos5l_mux2_1_55 r0 *1 0,0
Xsg13cmos5l_mux2_1_55 \$3717 \$3963 \$4438 VPWR VGND \$4185 sg13cmos5l_mux2_1
* cell instance sg13cmos5l_mux2_1_56 r0 *1 0,0
Xsg13cmos5l_mux2_1_56 \$3612 \$3963 \$4567 VPWR VGND \$3962 sg13cmos5l_mux2_1
* cell instance sg13cmos5l_mux2_1_57 r0 *1 0,0
Xsg13cmos5l_mux2_1_57 \$1808 \$1696 \$1884 VPWR VGND \$1880 sg13cmos5l_mux2_1
* cell instance sg13cmos5l_mux2_1_58 r0 *1 0,0
Xsg13cmos5l_mux2_1_58 \$1886 \$1512 \$1884 VPWR VGND \$2189 sg13cmos5l_mux2_1
* cell instance sg13cmos5l_mux2_1_59 r0 *1 0,0
Xsg13cmos5l_mux2_1_59 \$1893 \$1715 \$1884 VPWR VGND \$1890 sg13cmos5l_mux2_1
* cell instance sg13cmos5l_mux2_1_60 r0 *1 0,0
Xsg13cmos5l_mux2_1_60 \$1896 \$1629 \$1884 VPWR VGND \$2057 sg13cmos5l_mux2_1
* cell instance sg13cmos5l_mux2_1_61 r0 *1 0,0
Xsg13cmos5l_mux2_1_61 \$3963 \$4440 \$4438 VPWR VGND \$4441 sg13cmos5l_mux2_1
* cell instance sg13cmos5l_mux2_1_62 r0 *1 0,0
Xsg13cmos5l_mux2_1_62 \$700 \$632 \$187 VPWR VGND \$650 sg13cmos5l_mux2_1
* cell instance sg13cmos5l_mux2_1_63 r0 *1 0,0
Xsg13cmos5l_mux2_1_63 \$1899 \$1023 \$1884 VPWR VGND \$2125 sg13cmos5l_mux2_1
* cell instance sg13cmos5l_mux2_1_64 r0 *1 0,0
Xsg13cmos5l_mux2_1_64 \$4223 \$1855 \$3772 VPWR VGND \$4225 sg13cmos5l_mux2_1
* cell instance sg13cmos5l_mux2_1_65 r0 *1 0,0
Xsg13cmos5l_mux2_1_65 \$1904 \$1356 \$1721 VPWR VGND \$1901 sg13cmos5l_mux2_1
* cell instance sg13cmos5l_mux2_1_66 r0 *1 0,0
Xsg13cmos5l_mux2_1_66 \$4223 \$4230 \$3812 VPWR VGND \$5078 sg13cmos5l_mux2_1
* cell instance sg13cmos5l_mux2_1_67 r0 *1 0,0
Xsg13cmos5l_mux2_1_67 \$4230 \$4233 \$4438 VPWR VGND \$4466 sg13cmos5l_mux2_1
* cell instance sg13cmos5l_mux2_1_68 r0 *1 0,0
Xsg13cmos5l_mux2_1_68 \$297 \$339 \$110 VPWR VGND \$336 sg13cmos5l_mux2_1
* cell instance sg13cmos5l_mux2_1_69 r0 *1 0,0
Xsg13cmos5l_mux2_1_69 \$3632 \$4233 \$3812 VPWR VGND \$5130 sg13cmos5l_mux2_1
* cell instance sg13cmos5l_mux2_1_70 r0 *1 0,0
Xsg13cmos5l_mux2_1_70 \$1738 \$1368 \$1721 VPWR VGND \$1740 sg13cmos5l_mux2_1
* cell instance sg13cmos5l_mux2_1_71 r0 *1 0,0
Xsg13cmos5l_mux2_1_71 \$1917 \$1547 \$1721 VPWR VGND \$1743 sg13cmos5l_mux2_1
* cell instance sg13cmos5l_mux2_1_72 r0 *1 0,0
Xsg13cmos5l_mux2_1_72 \$1381 \$1551 \$1566 VPWR VGND \$1552 sg13cmos5l_mux2_1
* cell instance sg13cmos5l_mux2_1_73 r0 *1 0,0
Xsg13cmos5l_mux2_1_73 \$1381 \$1232 \$1402 VPWR VGND \$1233 sg13cmos5l_mux2_1
* cell instance sg13cmos5l_mux2_1_74 r0 *1 0,0
Xsg13cmos5l_mux2_1_74 \$1381 \$1382 \$1285 VPWR VGND \$1217 sg13cmos5l_mux2_1
* cell instance sg13cmos5l_mux2_1_75 r0 *1 0,0
Xsg13cmos5l_mux2_1_75 \$4233 \$4491 \$4438 VPWR VGND \$4492 sg13cmos5l_mux2_1
* cell instance sg13cmos5l_mux2_1_76 r0 *1 0,0
Xsg13cmos5l_mux2_1_76 \$1381 \$1236 \$1122 VPWR VGND \$1237 sg13cmos5l_mux2_1
* cell instance sg13cmos5l_mux2_1_77 r0 *1 0,0
Xsg13cmos5l_mux2_1_77 \$4675 \$4681 \$4035 VPWR VGND \$4679 sg13cmos5l_mux2_1
* cell instance sg13cmos5l_mux2_1_78 r0 *1 0,0
Xsg13cmos5l_mux2_1_78 \$1739 \$2368 \$1285 VPWR VGND \$2369 sg13cmos5l_mux2_1
* cell instance sg13cmos5l_mux2_1_79 r0 *1 0,0
Xsg13cmos5l_mux2_1_79 \$1746 \$1757 \$1566 VPWR VGND \$1758 sg13cmos5l_mux2_1
* cell instance sg13cmos5l_mux2_1_80 r0 *1 0,0
Xsg13cmos5l_mux2_1_80 \$1746 \$1243 \$1285 VPWR VGND \$1244 sg13cmos5l_mux2_1
* cell instance sg13cmos5l_mux2_1_81 r0 *1 0,0
Xsg13cmos5l_mux2_1_81 \$3124 \$3123 \$1122 VPWR VGND \$3125 sg13cmos5l_mux2_1
* cell instance sg13cmos5l_mux2_1_82 r0 *1 0,0
Xsg13cmos5l_mux2_1_82 \$1746 \$1026 \$1122 VPWR VGND \$1027 sg13cmos5l_mux2_1
* cell instance sg13cmos5l_mux2_1_83 r0 *1 0,0
Xsg13cmos5l_mux2_1_83 \$1746 \$1571 \$1402 VPWR VGND \$1572 sg13cmos5l_mux2_1
* cell instance sg13cmos5l_mux2_1_84 r0 *1 0,0
Xsg13cmos5l_mux2_1_84 \$1357 \$1404 \$1402 VPWR VGND \$1257 sg13cmos5l_mux2_1
* cell instance sg13cmos5l_mux2_1_85 r0 *1 0,0
Xsg13cmos5l_mux2_1_85 \$1739 \$2687 \$1122 VPWR VGND \$2688 sg13cmos5l_mux2_1
* cell instance sg13cmos5l_mux2_1_86 r0 *1 0,0
Xsg13cmos5l_mux2_1_86 \$1357 \$1408 \$1285 VPWR VGND \$1409 sg13cmos5l_mux2_1
* cell instance sg13cmos5l_mux2_1_87 r0 *1 0,0
Xsg13cmos5l_mux2_1_87 \$1357 \$1144 \$1122 VPWR VGND \$1145 sg13cmos5l_mux2_1
* cell instance sg13cmos5l_mux2_1_88 r0 *1 0,0
Xsg13cmos5l_mux2_1_88 \$3124 \$3265 \$1402 VPWR VGND \$3133 sg13cmos5l_mux2_1
* cell instance sg13cmos5l_mux2_1_89 r0 *1 0,0
Xsg13cmos5l_mux2_1_89 \$1739 \$2231 \$1402 VPWR VGND \$2524 sg13cmos5l_mux2_1
* cell instance sg13cmos5l_mux2_1_90 r0 *1 0,0
Xsg13cmos5l_mux2_1_90 \$3124 \$2823 \$1285 VPWR VGND \$2821 sg13cmos5l_mux2_1
* cell instance sg13cmos5l_mux2_1_91 r0 *1 0,0
Xsg13cmos5l_mux2_1_91 \$2243 \$2570 \$1402 VPWR VGND \$2532 sg13cmos5l_mux2_1
* cell instance sg13cmos5l_mux2_1_92 r0 *1 0,0
Xsg13cmos5l_mux2_1_92 \$2949 \$3140 \$1402 VPWR VGND \$2825 sg13cmos5l_mux2_1
* cell instance sg13cmos5l_mux2_1_93 r0 *1 0,0
Xsg13cmos5l_mux2_1_93 \$1599 \$1598 \$1402 VPWR VGND \$1600 sg13cmos5l_mux2_1
* cell instance sg13cmos5l_mux2_1_94 r0 *1 0,0
Xsg13cmos5l_mux2_1_94 \$4681 \$5052 \$4438 VPWR VGND \$5053 sg13cmos5l_mux2_1
* cell instance sg13cmos5l_mux2_1_95 r0 *1 0,0
Xsg13cmos5l_mux2_1_95 \$5135 \$2026 \$3638 VPWR VGND \$5136 sg13cmos5l_mux2_1
* cell instance sg13cmos5l_mux2_1_96 r0 *1 0,0
Xsg13cmos5l_mux2_1_96 \$2949 \$3137 \$1566 VPWR VGND \$3146 sg13cmos5l_mux2_1
* cell instance sg13cmos5l_mux2_1_97 r0 *1 0,0
Xsg13cmos5l_mux2_1_97 \$1599 \$1422 \$1566 VPWR VGND \$1423 sg13cmos5l_mux2_1
* cell instance sg13cmos5l_mux2_1_98 r0 *1 0,0
Xsg13cmos5l_mux2_1_98 \$2243 \$2244 \$1122 VPWR VGND \$2245 sg13cmos5l_mux2_1
* cell instance sg13cmos5l_mux2_1_99 r0 *1 0,0
Xsg13cmos5l_mux2_1_99 \$2243 \$2402 \$1566 VPWR VGND \$2403 sg13cmos5l_mux2_1
* cell instance sg13cmos5l_mux2_1_100 r0 *1 0,0
Xsg13cmos5l_mux2_1_100 \$1599 \$1797 \$1285 VPWR VGND \$1956 sg13cmos5l_mux2_1
* cell instance sg13cmos5l_mux2_1_101 r0 *1 0,0
Xsg13cmos5l_mux2_1_101 \$1599 \$1795 \$1122 VPWR VGND \$1796 sg13cmos5l_mux2_1
* cell instance sg13cmos5l_mux2_1_102 r0 *1 0,0
Xsg13cmos5l_mux2_1_102 \$2949 \$2989 \$1122 VPWR VGND \$2990 sg13cmos5l_mux2_1
* cell instance sg13cmos5l_mux2_1_103 r0 *1 0,0
Xsg13cmos5l_mux2_1_103 \$5135 \$5068 \$4035 VPWR VGND \$5207 sg13cmos5l_mux2_1
* cell instance sg13cmos5l_mux2_1_104 r0 *1 0,0
Xsg13cmos5l_mux2_1_104 \$2949 \$2704 \$1285 VPWR VGND \$2705 sg13cmos5l_mux2_1
* cell instance sg13cmos5l_mux2_1_105 r0 *1 0,0
Xsg13cmos5l_mux2_1_105 \$2243 \$2406 \$1285 VPWR VGND \$2407 sg13cmos5l_mux2_1
* cell instance sg13cmos5l_mux2_1_106 r0 *1 0,0
Xsg13cmos5l_mux2_1_106 \$5068 \$5067 \$4438 VPWR VGND \$5069 sg13cmos5l_mux2_1
* cell instance sg13cmos5l_mux2_1_107 r0 *1 0,0
Xsg13cmos5l_mux2_1_107 \$5067 \$5590 \$4438 VPWR VGND \$5224 sg13cmos5l_mux2_1
* cell instance sg13cmos5l_mux2_1_108 r0 *1 0,0
Xsg13cmos5l_mux2_1_108 \$5589 \$5296 \$4035 VPWR VGND \$7256 sg13cmos5l_mux2_1
* cell instance sg13cmos5l_mux2_1_109 r0 *1 0,0
Xsg13cmos5l_mux2_1_109 \$5834 \$5590 \$4035 VPWR VGND \$5833 sg13cmos5l_mux2_1
* cell instance sg13cmos5l_mux4_1_0 r0 *1 0,0
Xsg13cmos5l_mux4_1_0 \$1753 \$1229 \$1564 \$1118 \$1920 \$1811 VPWR VGND \$2352
+ sg13cmos5l_mux4_1
* cell instance sg13cmos5l_mux4_1_1 r0 *1 0,0
Xsg13cmos5l_mux4_1_1 \$1935 \$1400 \$1583 \$1139 \$1920 \$1811 VPWR VGND \$1929
+ sg13cmos5l_mux4_1
* cell instance sg13cmos5l_mux4_1_2 r0 *1 0,0
Xsg13cmos5l_mux4_1_2 \$2680 \$2226 \$2382 \$2383 \$1920 \$1811 VPWR VGND \$2669
+ sg13cmos5l_mux4_1
* cell instance sg13cmos5l_mux4_1_3 r0 *1 0,0
Xsg13cmos5l_mux4_1_3 \$3165 \$2817 \$2819 \$2971 \$1920 \$1811 VPWR VGND \$2942
+ sg13cmos5l_mux4_1
* cell instance sg13cmos5l_mux4_1_4 r0 *1 0,0
Xsg13cmos5l_mux4_1_4 \$2233 \$2235 \$2236 \$2238 \$1743 \$1740 VPWR VGND \$2657
+ sg13cmos5l_mux4_1
* cell instance sg13cmos5l_mux4_1_5 r0 *1 0,0
Xsg13cmos5l_mux4_1_5 \$2233 \$2235 \$2236 \$2238 \$1920 \$1811 VPWR VGND \$2357
+ sg13cmos5l_mux4_1
* cell instance sg13cmos5l_mux4_1_6 r0 *1 0,0
Xsg13cmos5l_mux4_1_6 \$1785 \$1592 \$1270 \$1271 \$1659 \$1633 VPWR VGND \$2785
+ sg13cmos5l_mux4_1
* cell instance sg13cmos5l_mux4_1_7 r0 *1 0,0
Xsg13cmos5l_mux4_1_7 \$1622 \$1788 \$1601 \$1790 \$1743 \$1740 VPWR VGND \$2958
+ sg13cmos5l_mux4_1
* cell instance sg13cmos5l_mux4_1_8 r0 *1 0,0
Xsg13cmos5l_mux4_1_8 \$1622 \$1788 \$1601 \$1790 \$1920 \$1811 VPWR VGND \$2659
+ sg13cmos5l_mux4_1
* cell instance sg13cmos5l_nand2_1_0 r0 *1 0,0
Xsg13cmos5l_nand2_1_0 \$5239 \$5238 VPWR VGND \$5235 sg13cmos5l_nand2_1
* cell instance sg13cmos5l_nand2_1_1 r0 *1 0,0
Xsg13cmos5l_nand2_1_1 \$5906 \$5238 VPWR VGND \$5904 sg13cmos5l_nand2_1
* cell instance sg13cmos5l_nand2_1_2 r0 *1 0,0
Xsg13cmos5l_nand2_1_2 \$6560 \$5238 VPWR VGND \$6559 sg13cmos5l_nand2_1
* cell instance sg13cmos5l_nand2_1_3 r0 *1 0,0
Xsg13cmos5l_nand2_1_3 \$7309 \$7251 VPWR VGND \$7308 sg13cmos5l_nand2_1
* cell instance sg13cmos5l_nand2_1_4 r0 *1 0,0
Xsg13cmos5l_nand2_1_4 \$7310 \$5238 VPWR VGND \$7306 sg13cmos5l_nand2_1
* cell instance sg13cmos5l_nand2_1_5 r0 *1 0,0
Xsg13cmos5l_nand2_1_5 \$7252 \$7251 VPWR VGND \$7199 sg13cmos5l_nand2_1
* cell instance sg13cmos5l_nand2_1_6 r0 *1 0,0
Xsg13cmos5l_nand2_1_6 \$11604 \$11737 VPWR VGND \$11738 sg13cmos5l_nand2_1
* cell instance sg13cmos5l_nand2_1_7 r0 *1 0,0
Xsg13cmos5l_nand2_1_7 \$3883 \$4574 VPWR VGND \$5099 sg13cmos5l_nand2_1
* cell instance sg13cmos5l_nand2_1_8 r0 *1 0,0
Xsg13cmos5l_nand2_1_8 \$7318 \$5238 VPWR VGND \$7316 sg13cmos5l_nand2_1
* cell instance sg13cmos5l_nand2_1_9 r0 *1 0,0
Xsg13cmos5l_nand2_1_9 \$3883 \$4547 VPWR VGND \$3882 sg13cmos5l_nand2_1
* cell instance sg13cmos5l_nand2_1_10 r0 *1 0,0
Xsg13cmos5l_nand2_1_10 \$3883 \$5096 VPWR VGND \$5100 sg13cmos5l_nand2_1
* cell instance sg13cmos5l_nand2_1_11 r0 *1 0,0
Xsg13cmos5l_nand2_1_11 \$14262 \$14111 VPWR VGND \$14261 sg13cmos5l_nand2_1
* cell instance sg13cmos5l_nand2_1_12 r0 *1 0,0
Xsg13cmos5l_nand2_1_12 \$5908 \$5238 VPWR VGND \$5703 sg13cmos5l_nand2_1
* cell instance sg13cmos5l_nand2_1_13 r0 *1 0,0
Xsg13cmos5l_nand2_1_13 \$7321 \$7251 VPWR VGND \$7322 sg13cmos5l_nand2_1
* cell instance sg13cmos5l_nand2_1_14 r0 *1 0,0
Xsg13cmos5l_nand2_1_14 \$3883 \$3885 VPWR VGND \$3887 sg13cmos5l_nand2_1
* cell instance sg13cmos5l_nand2_1_15 r0 *1 0,0
Xsg13cmos5l_nand2_1_15 \$10876 \$11737 VPWR VGND \$10874 sg13cmos5l_nand2_1
* cell instance sg13cmos5l_nand2_1_16 r0 *1 0,0
Xsg13cmos5l_nand2_1_16 \$1833 \$1640 VPWR VGND \$1832 sg13cmos5l_nand2_1
* cell instance sg13cmos5l_nand2_1_17 r0 *1 0,0
Xsg13cmos5l_nand2_1_17 \$11897 \$11737 VPWR VGND \$11745 sg13cmos5l_nand2_1
* cell instance sg13cmos5l_nand2_1_18 r0 *1 0,0
Xsg13cmos5l_nand2_1_18 \$7325 \$5587 VPWR VGND \$7327 sg13cmos5l_nand2_1
* cell instance sg13cmos5l_nand2_1_19 r0 *1 0,0
Xsg13cmos5l_nand2_1_19 \$2735 \$2875 VPWR VGND \$2874 sg13cmos5l_nand2_1
* cell instance sg13cmos5l_nand2_1_20 r0 *1 0,0
Xsg13cmos5l_nand2_1_20 \$13749 \$13940 VPWR VGND \$13836 sg13cmos5l_nand2_1
* cell instance sg13cmos5l_nand2_1_21 r0 *1 0,0
Xsg13cmos5l_nand2_1_21 \$1804 \$1834 VPWR VGND \$1835 sg13cmos5l_nand2_1
* cell instance sg13cmos5l_nand2_1_22 r0 *1 0,0
Xsg13cmos5l_nand2_1_22 \$2153 \$3323 VPWR VGND \$3189 sg13cmos5l_nand2_1
* cell instance sg13cmos5l_nand2_1_23 r0 *1 0,0
Xsg13cmos5l_nand2_1_23 \$3437 \$3435 VPWR VGND \$3436 sg13cmos5l_nand2_1
* cell instance sg13cmos5l_nand2_1_24 r0 *1 0,0
Xsg13cmos5l_nand2_1_24 \$3886 \$5107 VPWR VGND \$5115 sg13cmos5l_nand2_1
* cell instance sg13cmos5l_nand2_1_25 r0 *1 0,0
Xsg13cmos5l_nand2_1_25 \$11315 \$10283 VPWR VGND \$10284 sg13cmos5l_nand2_1
* cell instance sg13cmos5l_nand2_1_26 r0 *1 0,0
Xsg13cmos5l_nand2_1_26 \$1447 \$1642 VPWR VGND \$1644 sg13cmos5l_nand2_1
* cell instance sg13cmos5l_nand2_1_27 r0 *1 0,0
Xsg13cmos5l_nand2_1_27 \$7015 \$5587 VPWR VGND \$6779 sg13cmos5l_nand2_1
* cell instance sg13cmos5l_nand2_1_28 r0 *1 0,0
Xsg13cmos5l_nand2_1_28 \$14269 \$13940 VPWR VGND \$14268 sg13cmos5l_nand2_1
* cell instance sg13cmos5l_nand2_1_29 r0 *1 0,0
Xsg13cmos5l_nand2_1_29 \$3435 \$3446 VPWR VGND \$3447 sg13cmos5l_nand2_1
* cell instance sg13cmos5l_nand2_1_30 r0 *1 0,0
Xsg13cmos5l_nand2_1_30 \$5910 \$5587 VPWR VGND \$5876 sg13cmos5l_nand2_1
* cell instance sg13cmos5l_nand2_1_31 r0 *1 0,0
Xsg13cmos5l_nand2_1_31 \$6568 \$5587 VPWR VGND \$6512 sg13cmos5l_nand2_1
* cell instance sg13cmos5l_nand2_1_32 r0 *1 0,0
Xsg13cmos5l_nand2_1_32 \$1299 \$1300 VPWR VGND \$2877 sg13cmos5l_nand2_1
* cell instance sg13cmos5l_nand2_1_33 r0 *1 0,0
Xsg13cmos5l_nand2_1_33 \$2446 \$3339 VPWR VGND \$3444 sg13cmos5l_nand2_1
* cell instance sg13cmos5l_nand2_1_34 r0 *1 0,0
Xsg13cmos5l_nand2_1_34 \$3726 \$3575 VPWR VGND \$3446 sg13cmos5l_nand2_1
* cell instance sg13cmos5l_nand2_1_35 r0 *1 0,0
Xsg13cmos5l_nand2_1_35 \$2880 \$2743 VPWR VGND \$1451 sg13cmos5l_nand2_1
* cell instance sg13cmos5l_nand2_1_36 r0 *1 0,0
Xsg13cmos5l_nand2_1_36 \$12351 \$10283 VPWR VGND \$11900 sg13cmos5l_nand2_1
* cell instance sg13cmos5l_nand2_1_37 r0 *1 0,0
Xsg13cmos5l_nand2_1_37 \$16818 \$14111 VPWR VGND \$16817 sg13cmos5l_nand2_1
* cell instance sg13cmos5l_nand2_1_38 r0 *1 0,0
Xsg13cmos5l_nand2_1_38 \$11317 \$10283 VPWR VGND \$10880 sg13cmos5l_nand2_1
* cell instance sg13cmos5l_nand2_1_39 r0 *1 0,0
Xsg13cmos5l_nand2_1_39 \$144 \$785 VPWR VGND \$786 sg13cmos5l_nand2_1
* cell instance sg13cmos5l_nand2_1_40 r0 *1 0,0
Xsg13cmos5l_nand2_1_40 \$2744 \$4834 VPWR VGND \$5198 sg13cmos5l_nand2_1
* cell instance sg13cmos5l_nand2_1_41 r0 *1 0,0
Xsg13cmos5l_nand2_1_41 \$9794 \$3451 VPWR VGND \$7557 sg13cmos5l_nand2_1
* cell instance sg13cmos5l_nand2_1_42 r0 *1 0,0
Xsg13cmos5l_nand2_1_42 \$5630 \$3443 VPWR VGND \$7219 sg13cmos5l_nand2_1
* cell instance sg13cmos5l_nand2_1_43 r0 *1 0,0
Xsg13cmos5l_nand2_1_43 \$16295 \$10283 VPWR VGND \$16294 sg13cmos5l_nand2_1
* cell instance sg13cmos5l_nand2_1_44 r0 *1 0,0
Xsg13cmos5l_nand2_1_44 \$2161 \$3193 VPWR VGND \$3342 sg13cmos5l_nand2_1
* cell instance sg13cmos5l_nand2_1_45 r0 *1 0,0
Xsg13cmos5l_nand2_1_45 \$1299 \$1848 VPWR VGND \$1304 sg13cmos5l_nand2_1
* cell instance sg13cmos5l_nand2_1_46 r0 *1 0,0
Xsg13cmos5l_nand2_1_46 \$7588 \$7720 VPWR VGND \$8181 sg13cmos5l_nand2_1
* cell instance sg13cmos5l_nand2_1_47 r0 *1 0,0
Xsg13cmos5l_nand2_1_47 \$13942 \$14111 VPWR VGND \$13677 sg13cmos5l_nand2_1
* cell instance sg13cmos5l_nand2_1_48 r0 *1 0,0
Xsg13cmos5l_nand2_1_48 \$1454 \$835 VPWR VGND \$836 sg13cmos5l_nand2_1
* cell instance sg13cmos5l_nand2_1_49 r0 *1 0,0
Xsg13cmos5l_nand2_1_49 \$152 \$128 VPWR VGND \$243 sg13cmos5l_nand2_1
* cell instance sg13cmos5l_nand2_1_50 r0 *1 0,0
Xsg13cmos5l_nand2_1_50 \$7588 \$7555 VPWR VGND \$7560 sg13cmos5l_nand2_1
* cell instance sg13cmos5l_nand2_1_51 r0 *1 0,0
Xsg13cmos5l_nand2_1_51 \$8181 \$8926 VPWR VGND \$3556 sg13cmos5l_nand2_1
* cell instance sg13cmos5l_nand2_1_52 r0 *1 0,0
Xsg13cmos5l_nand2_1_52 \$2166 \$2164 VPWR VGND \$1060 sg13cmos5l_nand2_1
* cell instance sg13cmos5l_nand2_1_53 r0 *1 0,0
Xsg13cmos5l_nand2_1_53 \$7560 \$7589 VPWR VGND \$3158 sg13cmos5l_nand2_1
* cell instance sg13cmos5l_nand2_1_54 r0 *1 0,0
Xsg13cmos5l_nand2_1_54 \$128 \$785 VPWR VGND \$790 sg13cmos5l_nand2_1
* cell instance sg13cmos5l_nand2_1_55 r0 *1 0,0
Xsg13cmos5l_nand2_1_55 \$1299 \$2454 VPWR VGND \$2310 sg13cmos5l_nand2_1
* cell instance sg13cmos5l_nand2_1_56 r0 *1 0,0
Xsg13cmos5l_nand2_1_56 \$50 \$457 VPWR VGND \$905 sg13cmos5l_nand2_1
* cell instance sg13cmos5l_nand2_1_57 r0 *1 0,0
Xsg13cmos5l_nand2_1_57 \$2621 \$3203 VPWR VGND \$3449 sg13cmos5l_nand2_1
* cell instance sg13cmos5l_nand2_1_58 r0 *1 0,0
Xsg13cmos5l_nand2_1_58 \$152 \$144 VPWR VGND \$306 sg13cmos5l_nand2_1
* cell instance sg13cmos5l_nand2_1_59 r0 *1 0,0
Xsg13cmos5l_nand2_1_59 \$1303 \$1624 VPWR VGND \$1459 sg13cmos5l_nand2_1
* cell instance sg13cmos5l_nand2_1_60 r0 *1 0,0
Xsg13cmos5l_nand2_1_60 \$24 \$48 VPWR VGND \$305 sg13cmos5l_nand2_1
* cell instance sg13cmos5l_nand2_1_61 r0 *1 0,0
Xsg13cmos5l_nand2_1_61 \$2788 \$3339 VPWR VGND \$3918 sg13cmos5l_nand2_1
* cell instance sg13cmos5l_nand2_1_62 r0 *1 0,0
Xsg13cmos5l_nand2_1_62 \$14 \$97 VPWR VGND \$671 sg13cmos5l_nand2_1
* cell instance sg13cmos5l_nand2_1_63 r0 *1 0,0
Xsg13cmos5l_nand2_1_63 \$30 \$246 VPWR VGND \$612 sg13cmos5l_nand2_1
* cell instance sg13cmos5l_nand2_1_64 r0 *1 0,0
Xsg13cmos5l_nand2_1_64 \$48 \$246 VPWR VGND \$729 sg13cmos5l_nand2_1
* cell instance sg13cmos5l_nand2_1_65 r0 *1 0,0
Xsg13cmos5l_nand2_1_65 \$130 \$128 VPWR VGND \$52 sg13cmos5l_nand2_1
* cell instance sg13cmos5l_nand2_1_66 r0 *1 0,0
Xsg13cmos5l_nand2_1_66 \$1311 \$1312 VPWR VGND \$1192 sg13cmos5l_nand2_1
* cell instance sg13cmos5l_nand2_1_67 r0 *1 0,0
Xsg13cmos5l_nand2_1_67 \$240 \$516 VPWR VGND \$628 sg13cmos5l_nand2_1
* cell instance sg13cmos5l_nand2_1_68 r0 *1 0,0
Xsg13cmos5l_nand2_1_68 \$2462 \$2463 VPWR VGND \$2023 sg13cmos5l_nand2_1
* cell instance sg13cmos5l_nand2_1_69 r0 *1 0,0
Xsg13cmos5l_nand2_1_69 \$729 \$735 VPWR VGND \$734 sg13cmos5l_nand2_1
* cell instance sg13cmos5l_nand2_1_70 r0 *1 0,0
Xsg13cmos5l_nand2_1_70 \$2495 \$2877 VPWR VGND \$2900 sg13cmos5l_nand2_1
* cell instance sg13cmos5l_nand2_1_71 r0 *1 0,0
Xsg13cmos5l_nand2_1_71 \$50 \$148 VPWR VGND \$154 sg13cmos5l_nand2_1
* cell instance sg13cmos5l_nand2_1_72 r0 *1 0,0
Xsg13cmos5l_nand2_1_72 \$1661 \$1662 VPWR VGND \$1317 sg13cmos5l_nand2_1
* cell instance sg13cmos5l_nand2_1_73 r0 *1 0,0
Xsg13cmos5l_nand2_1_73 \$163 \$204 VPWR VGND \$192 sg13cmos5l_nand2_1
* cell instance sg13cmos5l_nand2_1_74 r0 *1 0,0
Xsg13cmos5l_nand2_1_74 \$54 \$85 VPWR VGND \$59 sg13cmos5l_nand2_1
* cell instance sg13cmos5l_nand2_1_75 r0 *1 0,0
Xsg13cmos5l_nand2_1_75 \$1320 \$1310 VPWR VGND \$1063 sg13cmos5l_nand2_1
* cell instance sg13cmos5l_nand2_1_76 r0 *1 0,0
Xsg13cmos5l_nand2_1_76 \$153 \$210 VPWR VGND \$737 sg13cmos5l_nand2_1
* cell instance sg13cmos5l_nand2_1_77 r0 *1 0,0
Xsg13cmos5l_nand2_1_77 \$308 \$912 VPWR VGND \$849 sg13cmos5l_nand2_1
* cell instance sg13cmos5l_nand2_1_78 r0 *1 0,0
Xsg13cmos5l_nand2_1_78 \$1321 \$1463 VPWR VGND \$967 sg13cmos5l_nand2_1
* cell instance sg13cmos5l_nand2_1_79 r0 *1 0,0
Xsg13cmos5l_nand2_1_79 \$2849 \$3212 VPWR VGND \$3350 sg13cmos5l_nand2_1
* cell instance sg13cmos5l_nand2_1_80 r0 *1 0,0
Xsg13cmos5l_nand2_1_80 \$1667 \$1668 VPWR VGND \$1669 sg13cmos5l_nand2_1
* cell instance sg13cmos5l_nand2_1_81 r0 *1 0,0
Xsg13cmos5l_nand2_1_81 \$54 \$16 VPWR VGND \$33 sg13cmos5l_nand2_1
* cell instance sg13cmos5l_nand2_1_82 r0 *1 0,0
Xsg13cmos5l_nand2_1_82 \$50 \$47 VPWR VGND \$631 sg13cmos5l_nand2_1
* cell instance sg13cmos5l_nand2_1_83 r0 *1 0,0
Xsg13cmos5l_nand2_1_83 \$3156 \$3299 VPWR VGND \$2908 sg13cmos5l_nand2_1
* cell instance sg13cmos5l_nand2_1_84 r0 *1 0,0
Xsg13cmos5l_nand2_1_84 \$57 \$457 VPWR VGND \$848 sg13cmos5l_nand2_1
* cell instance sg13cmos5l_nand2_1_85 r0 *1 0,0
Xsg13cmos5l_nand2_1_85 \$3065 \$3214 VPWR VGND \$3064 sg13cmos5l_nand2_1
* cell instance sg13cmos5l_nand2_1_86 r0 *1 0,0
Xsg13cmos5l_nand2_1_86 \$310 \$631 VPWR VGND \$439 sg13cmos5l_nand2_1
* cell instance sg13cmos5l_nand2_1_87 r0 *1 0,0
Xsg13cmos5l_nand2_1_87 \$24 \$310 VPWR VGND \$471 sg13cmos5l_nand2_1
* cell instance sg13cmos5l_nand2_1_88 r0 *1 0,0
Xsg13cmos5l_nand2_1_88 \$3601 \$279 VPWR VGND \$3600 sg13cmos5l_nand2_1
* cell instance sg13cmos5l_nand2_1_89 r0 *1 0,0
Xsg13cmos5l_nand2_1_89 \$17259 \$4376 VPWR VGND \$17245 sg13cmos5l_nand2_1
* cell instance sg13cmos5l_nand2_1_90 r0 *1 0,0
Xsg13cmos5l_nand2_1_90 \$17262 \$4376 VPWR VGND \$17261 sg13cmos5l_nand2_1
* cell instance sg13cmos5l_nand2_1_91 r0 *1 0,0
Xsg13cmos5l_nand2_1_91 \$3218 \$2068 VPWR VGND \$3216 sg13cmos5l_nand2_1
* cell instance sg13cmos5l_nand2_1_92 r0 *1 0,0
Xsg13cmos5l_nand2_1_92 \$3601 \$144 VPWR VGND \$3764 sg13cmos5l_nand2_1
* cell instance sg13cmos5l_nand2_1_93 r0 *1 0,0
Xsg13cmos5l_nand2_1_93 \$3218 \$4359 VPWR VGND \$4394 sg13cmos5l_nand2_1
* cell instance sg13cmos5l_nand2_1_94 r0 *1 0,0
Xsg13cmos5l_nand2_1_94 \$166 \$261 VPWR VGND \$254 sg13cmos5l_nand2_1
* cell instance sg13cmos5l_nand2_1_95 r0 *1 0,0
Xsg13cmos5l_nand2_1_95 \$3601 \$1060 VPWR VGND \$3608 sg13cmos5l_nand2_1
* cell instance sg13cmos5l_nand2_1_96 r0 *1 0,0
Xsg13cmos5l_nand2_1_96 \$3218 \$4077 VPWR VGND \$4620 sg13cmos5l_nand2_1
* cell instance sg13cmos5l_nand2_1_97 r0 *1 0,0
Xsg13cmos5l_nand2_1_97 \$363 \$676 VPWR VGND \$635 sg13cmos5l_nand2_1
* cell instance sg13cmos5l_nand2_1_98 r0 *1 0,0
Xsg13cmos5l_nand2_1_98 \$3358 \$353 VPWR VGND \$3767 sg13cmos5l_nand2_1
* cell instance sg13cmos5l_nand2_1_99 r0 *1 0,0
Xsg13cmos5l_nand2_1_99 \$3358 \$665 VPWR VGND \$3489 sg13cmos5l_nand2_1
* cell instance sg13cmos5l_nand2_1_100 r0 *1 0,0
Xsg13cmos5l_nand2_1_100 \$3358 \$925 VPWR VGND \$3768 sg13cmos5l_nand2_1
* cell instance sg13cmos5l_nand2_1_101 r0 *1 0,0
Xsg13cmos5l_nand2_1_101 \$3068 \$2330 VPWR VGND \$2925 sg13cmos5l_nand2_1
* cell instance sg13cmos5l_nand2_1_102 r0 *1 0,0
Xsg13cmos5l_nand2_1_102 \$3358 \$898 VPWR VGND \$3357 sg13cmos5l_nand2_1
* cell instance sg13cmos5l_nand2_1_103 r0 *1 0,0
Xsg13cmos5l_nand2_1_103 \$3358 \$24 VPWR VGND \$3610 sg13cmos5l_nand2_1
* cell instance sg13cmos5l_nand2_1_104 r0 *1 0,0
Xsg13cmos5l_nand2_1_104 \$2488 \$2057 VPWR VGND \$2487 sg13cmos5l_nand2_1
* cell instance sg13cmos5l_nand2_1_105 r0 *1 0,0
Xsg13cmos5l_nand2_1_105 \$2849 \$2639 VPWR VGND \$3083 sg13cmos5l_nand2_1
* cell instance sg13cmos5l_nand2_1_106 r0 *1 0,0
Xsg13cmos5l_nand2_1_106 \$171 \$566 VPWR VGND \$683 sg13cmos5l_nand2_1
* cell instance sg13cmos5l_nand2_1_107 r0 *1 0,0
Xsg13cmos5l_nand2_1_107 \$1880 \$2189 VPWR VGND \$2458 sg13cmos5l_nand2_1
* cell instance sg13cmos5l_nand2_1_108 r0 *1 0,0
Xsg13cmos5l_nand2_1_108 \$166 \$268 VPWR VGND \$269 sg13cmos5l_nand2_1
* cell instance sg13cmos5l_nand2_1_109 r0 *1 0,0
Xsg13cmos5l_nand2_1_109 \$1696 \$2182 VPWR VGND \$1695 sg13cmos5l_nand2_1
* cell instance sg13cmos5l_nand2_1_110 r0 *1 0,0
Xsg13cmos5l_nand2_1_110 \$453 \$531 VPWR VGND \$533 sg13cmos5l_nand2_1
* cell instance sg13cmos5l_nand2_1_111 r0 *1 0,0
Xsg13cmos5l_nand2_1_111 \$310 \$246 VPWR VGND \$70 sg13cmos5l_nand2_1
* cell instance sg13cmos5l_nand2_1_112 r0 *1 0,0
Xsg13cmos5l_nand2_1_112 \$2056 \$2189 VPWR VGND \$2332 sg13cmos5l_nand2_1
* cell instance sg13cmos5l_nand2_1_113 r0 *1 0,0
Xsg13cmos5l_nand2_1_113 \$2332 \$2640 VPWR VGND \$2639 sg13cmos5l_nand2_1
* cell instance sg13cmos5l_nand2_1_114 r0 *1 0,0
Xsg13cmos5l_nand2_1_114 \$1880 \$1870 VPWR VGND \$2333 sg13cmos5l_nand2_1
* cell instance sg13cmos5l_nand2_1_115 r0 *1 0,0
Xsg13cmos5l_nand2_1_115 \$2744 \$3002 VPWR VGND \$4405 sg13cmos5l_nand2_1
* cell instance sg13cmos5l_nand2_1_116 r0 *1 0,0
Xsg13cmos5l_nand2_1_116 \$471 \$316 VPWR VGND \$472 sg13cmos5l_nand2_1
* cell instance sg13cmos5l_nand2_1_117 r0 *1 0,0
Xsg13cmos5l_nand2_1_117 \$2057 \$2125 VPWR VGND \$2335 sg13cmos5l_nand2_1
* cell instance sg13cmos5l_nand2_1_118 r0 *1 0,0
Xsg13cmos5l_nand2_1_118 \$42 \$25 VPWR VGND \$88 sg13cmos5l_nand2_1
* cell instance sg13cmos5l_nand2_1_119 r0 *1 0,0
Xsg13cmos5l_nand2_1_119 \$3501 \$3090 VPWR VGND \$3364 sg13cmos5l_nand2_1
* cell instance sg13cmos5l_nand2_1_120 r0 *1 0,0
Xsg13cmos5l_nand2_1_120 \$1701 \$1808 VPWR VGND \$1885 sg13cmos5l_nand2_1
* cell instance sg13cmos5l_nand2_1_121 r0 *1 0,0
Xsg13cmos5l_nand2_1_121 \$1701 \$1886 VPWR VGND \$2766 sg13cmos5l_nand2_1
* cell instance sg13cmos5l_nand2_1_122 r0 *1 0,0
Xsg13cmos5l_nand2_1_122 \$645 \$425 VPWR VGND \$989 sg13cmos5l_nand2_1
* cell instance sg13cmos5l_nand2_1_123 r0 *1 0,0
Xsg13cmos5l_nand2_1_123 \$261 \$299 VPWR VGND \$540 sg13cmos5l_nand2_1
* cell instance sg13cmos5l_nand2_1_124 r0 *1 0,0
Xsg13cmos5l_nand2_1_124 \$1897 \$2055 VPWR VGND \$2265 sg13cmos5l_nand2_1
* cell instance sg13cmos5l_nand2_1_125 r0 *1 0,0
Xsg13cmos5l_nand2_1_125 \$3085 \$3360 VPWR VGND \$3503 sg13cmos5l_nand2_1
* cell instance sg13cmos5l_nand2_1_126 r0 *1 0,0
Xsg13cmos5l_nand2_1_126 \$1001 \$1205 VPWR VGND \$981 sg13cmos5l_nand2_1
* cell instance sg13cmos5l_nand2_1_127 r0 *1 0,0
Xsg13cmos5l_nand2_1_127 \$1701 \$1896 VPWR VGND \$2342 sg13cmos5l_nand2_1
* cell instance sg13cmos5l_nand2_1_128 r0 *1 0,0
Xsg13cmos5l_nand2_1_128 \$2057 \$2055 VPWR VGND \$2492 sg13cmos5l_nand2_1
* cell instance sg13cmos5l_nand2_1_129 r0 *1 0,0
Xsg13cmos5l_nand2_1_129 \$2647 \$1929 VPWR VGND \$2648 sg13cmos5l_nand2_1
* cell instance sg13cmos5l_nand2_1_130 r0 *1 0,0
Xsg13cmos5l_nand2_1_130 \$107 \$39 VPWR VGND \$285 sg13cmos5l_nand2_1
* cell instance sg13cmos5l_nand2_1_131 r0 *1 0,0
Xsg13cmos5l_nand2_1_131 \$159 \$518 VPWR VGND \$541 sg13cmos5l_nand2_1
* cell instance sg13cmos5l_nand2_1_132 r0 *1 0,0
Xsg13cmos5l_nand2_1_132 \$1897 \$2125 VPWR VGND \$2197 sg13cmos5l_nand2_1
* cell instance sg13cmos5l_nand2_1_133 r0 *1 0,0
Xsg13cmos5l_nand2_1_133 \$804 \$793 VPWR VGND \$711 sg13cmos5l_nand2_1
* cell instance sg13cmos5l_nand2_1_134 r0 *1 0,0
Xsg13cmos5l_nand2_1_134 \$804 \$5 VPWR VGND \$20 sg13cmos5l_nand2_1
* cell instance sg13cmos5l_nand2_1_135 r0 *1 0,0
Xsg13cmos5l_nand2_1_135 \$42 \$97 VPWR VGND \$546 sg13cmos5l_nand2_1
* cell instance sg13cmos5l_nand2_1_136 r0 *1 0,0
Xsg13cmos5l_nand2_1_136 \$115 \$110 VPWR VGND \$383 sg13cmos5l_nand2_1
* cell instance sg13cmos5l_nand2_1_137 r0 *1 0,0
Xsg13cmos5l_nand2_1_137 \$302 \$632 VPWR VGND \$765 sg13cmos5l_nand2_1
* cell instance sg13cmos5l_nand2_1_138 r0 *1 0,0
Xsg13cmos5l_nand2_1_138 \$221 \$219 VPWR VGND \$220 sg13cmos5l_nand2_1
* cell instance sg13cmos5l_nand2_1_139 r0 *1 0,0
Xsg13cmos5l_nand2_1_139 \$591 \$100 VPWR VGND \$590 sg13cmos5l_nand2_1
* cell instance sg13cmos5l_nand2_1_140 r0 *1 0,0
Xsg13cmos5l_nand2_1_140 \$73 \$126 VPWR VGND \$221 sg13cmos5l_nand2_1
* cell instance sg13cmos5l_nand2_1_141 r0 *1 0,0
Xsg13cmos5l_nand2_1_141 \$504 \$752 VPWR VGND \$867 sg13cmos5l_nand2_1
* cell instance sg13cmos5l_nand2_1_142 r0 *1 0,0
Xsg13cmos5l_nand2_1_142 \$100 \$126 VPWR VGND \$1213 sg13cmos5l_nand2_1
* cell instance sg13cmos5l_nand2_1_143 r0 *1 0,0
Xsg13cmos5l_nand2_1_143 \$1701 \$2123 VPWR VGND \$2266 sg13cmos5l_nand2_1
* cell instance sg13cmos5l_nand2_1_144 r0 *1 0,0
Xsg13cmos5l_nand2_1_144 \$27 \$5 VPWR VGND \$16 sg13cmos5l_nand2_1
* cell instance sg13cmos5l_nand2_1_145 r0 *1 0,0
Xsg13cmos5l_nand2_1_145 \$2717 \$2785 VPWR VGND \$3799 sg13cmos5l_nand2_1
* cell instance sg13cmos5l_nand2_1_146 r0 *1 0,0
Xsg13cmos5l_nand2_1_146 \$2 \$898 VPWR VGND \$331 sg13cmos5l_nand2_1
* cell instance sg13cmos5l_nand2_1_147 r0 *1 0,0
Xsg13cmos5l_nand2_1_147 \$1701 \$1904 VPWR VGND \$2078 sg13cmos5l_nand2_1
* cell instance sg13cmos5l_nand2_1_148 r0 *1 0,0
Xsg13cmos5l_nand2_1_148 \$932 \$874 VPWR VGND \$931 sg13cmos5l_nand2_1
* cell instance sg13cmos5l_nand2_1_149 r0 *1 0,0
Xsg13cmos5l_nand2_1_149 \$27 \$922 VPWR VGND \$1205 sg13cmos5l_nand2_1
* cell instance sg13cmos5l_nand2_1_150 r0 *1 0,0
Xsg13cmos5l_nand2_1_150 \$2654 \$3234 VPWR VGND \$3360 sg13cmos5l_nand2_1
* cell instance sg13cmos5l_nand2_1_151 r0 *1 0,0
Xsg13cmos5l_nand2_1_151 \$97 \$73 VPWR VGND \$224 sg13cmos5l_nand2_1
* cell instance sg13cmos5l_nand2_1_152 r0 *1 0,0
Xsg13cmos5l_nand2_1_152 \$2935 \$3108 VPWR VGND \$3109 sg13cmos5l_nand2_1
* cell instance sg13cmos5l_nand2_1_153 r0 *1 0,0
Xsg13cmos5l_nand2_1_153 \$78 \$1111 VPWR VGND \$1011 sg13cmos5l_nand2_1
* cell instance sg13cmos5l_nand2_1_154 r0 *1 0,0
Xsg13cmos5l_nand2_1_154 \$42 \$41 VPWR VGND \$73 sg13cmos5l_nand2_1
* cell instance sg13cmos5l_nand2_1_155 r0 *1 0,0
Xsg13cmos5l_nand2_1_155 \$329 \$396 VPWR VGND \$551 sg13cmos5l_nand2_1
* cell instance sg13cmos5l_nand2_1_156 r0 *1 0,0
Xsg13cmos5l_nand2_1_156 \$12 \$27 VPWR VGND \$345 sg13cmos5l_nand2_1
* cell instance sg13cmos5l_nand2_1_157 r0 *1 0,0
Xsg13cmos5l_nand2_1_157 \$3815 \$3812 VPWR VGND \$3806 sg13cmos5l_nand2_1
* cell instance sg13cmos5l_nand2_1_158 r0 *1 0,0
Xsg13cmos5l_nand2_1_158 \$4006 \$3812 VPWR VGND \$3990 sg13cmos5l_nand2_1
* cell instance sg13cmos5l_nand2_1_159 r0 *1 0,0
Xsg13cmos5l_nand2_1_159 \$299 \$213 VPWR VGND \$230 sg13cmos5l_nand2_1
* cell instance sg13cmos5l_nand2_1_160 r0 *1 0,0
Xsg13cmos5l_nand2_1_160 \$4007 \$3812 VPWR VGND \$3994 sg13cmos5l_nand2_1
* cell instance sg13cmos5l_nand2_1_161 r0 *1 0,0
Xsg13cmos5l_nand2_1_161 \$518 \$711 VPWR VGND \$603 sg13cmos5l_nand2_1
* cell instance sg13cmos5l_nand2_1_162 r0 *1 0,0
Xsg13cmos5l_nand2_1_162 \$326 \$811 VPWR VGND \$142 sg13cmos5l_nand2_1
* cell instance sg13cmos5l_nand2_1_163 r0 *1 0,0
Xsg13cmos5l_nand2_1_163 \$41 \$3 VPWR VGND \$232 sg13cmos5l_nand2_1
* cell instance sg13cmos5l_nand2_1_164 r0 *1 0,0
Xsg13cmos5l_nand2_1_164 \$25 \$301 VPWR VGND \$293 sg13cmos5l_nand2_1
* cell instance sg13cmos5l_nand2_1_165 r0 *1 0,0
Xsg13cmos5l_nand2_1_165 \$2071 \$1738 VPWR VGND \$2794 sg13cmos5l_nand2_1
* cell instance sg13cmos5l_nand2_1_166 r0 *1 0,0
Xsg13cmos5l_nand2_1_166 \$182 \$300 VPWR VGND \$320 sg13cmos5l_nand2_1
* cell instance sg13cmos5l_nand2_1_167 r0 *1 0,0
Xsg13cmos5l_nand2_1_167 \$12 \$185 VPWR VGND \$595 sg13cmos5l_nand2_1
* cell instance sg13cmos5l_nand2_1_168 r0 *1 0,0
Xsg13cmos5l_nand2_1_168 \$822 \$606 VPWR VGND \$823 sg13cmos5l_nand2_1
* cell instance sg13cmos5l_nand2_1_169 r0 *1 0,0
Xsg13cmos5l_nand2_1_169 \$2788 \$2942 VPWR VGND \$3518 sg13cmos5l_nand2_1
* cell instance sg13cmos5l_nand2_1_170 r0 *1 0,0
Xsg13cmos5l_nand2_1_170 \$2071 \$1917 VPWR VGND \$2950 sg13cmos5l_nand2_1
* cell instance sg13cmos5l_nand2_1_171 r0 *1 0,0
Xsg13cmos5l_nand2_1_171 \$2351 \$2357 VPWR VGND \$2427 sg13cmos5l_nand2_1
* cell instance sg13cmos5l_nand2_1_172 r0 *1 0,0
Xsg13cmos5l_nand2_1_172 \$2209 \$2215 VPWR VGND \$1745 sg13cmos5l_nand2_1
* cell instance sg13cmos5l_nand2_1_173 r0 *1 0,0
Xsg13cmos5l_nand2_1_173 \$1743 \$1740 VPWR VGND \$2091 sg13cmos5l_nand2_1
* cell instance sg13cmos5l_nand2_1_174 r0 *1 0,0
Xsg13cmos5l_nand2_1_174 \$2209 \$2092 VPWR VGND \$1122 sg13cmos5l_nand2_1
* cell instance sg13cmos5l_nand2_1_175 r0 *1 0,0
Xsg13cmos5l_nand2_1_175 \$185 \$186 VPWR VGND \$225 sg13cmos5l_nand2_1
* cell instance sg13cmos5l_nand2_1_176 r0 *1 0,0
Xsg13cmos5l_nand2_1_176 \$41 \$185 VPWR VGND \$11 sg13cmos5l_nand2_1
* cell instance sg13cmos5l_nand2_1_177 r0 *1 0,0
Xsg13cmos5l_nand2_1_177 \$261 \$518 VPWR VGND \$401 sg13cmos5l_nand2_1
* cell instance sg13cmos5l_nand2_1_178 r0 *1 0,0
Xsg13cmos5l_nand2_1_178 \$115 \$313 VPWR VGND \$556 sg13cmos5l_nand2_1
* cell instance sg13cmos5l_nand2_1_179 r0 *1 0,0
Xsg13cmos5l_nand2_1_179 \$932 \$182 VPWR VGND \$756 sg13cmos5l_nand2_1
* cell instance sg13cmos5l_nand2_1_180 r0 *1 0,0
Xsg13cmos5l_nand2_1_180 \$176 \$648 VPWR VGND \$658 sg13cmos5l_nand2_1
* cell instance sg13cmos5l_nand2_1_181 r0 *1 0,0
Xsg13cmos5l_nand2_1_181 \$41 \$302 VPWR VGND \$313 sg13cmos5l_nand2_1
* cell instance sg13cmos5l_nand2_1_182 r0 *1 0,0
Xsg13cmos5l_nand2_1_182 \$41 \$188 VPWR VGND \$261 sg13cmos5l_nand2_1
* cell instance sg13cmos5l_nand2_1_183 r0 *1 0,0
Xsg13cmos5l_nand2_1_183 \$3834 \$4035 VPWR VGND \$3814 sg13cmos5l_nand2_1
* cell instance sg13cmos5l_nand2_1_184 r0 *1 0,0
Xsg13cmos5l_nand2_1_184 \$2220 \$1926 VPWR VGND \$2362 sg13cmos5l_nand2_1
* cell instance sg13cmos5l_nand2_1_185 r0 *1 0,0
Xsg13cmos5l_nand2_1_185 \$1564 \$1748 VPWR VGND \$1927 sg13cmos5l_nand2_1
* cell instance sg13cmos5l_nand2_1_186 r0 *1 0,0
Xsg13cmos5l_nand2_1_186 \$1748 \$1538 VPWR VGND \$2093 sg13cmos5l_nand2_1
* cell instance sg13cmos5l_nand2_1_187 r0 *1 0,0
Xsg13cmos5l_nand2_1_187 \$3246 \$2099 VPWR VGND \$3380 sg13cmos5l_nand2_1
* cell instance sg13cmos5l_nand2_1_188 r0 *1 0,0
Xsg13cmos5l_nand2_1_188 \$3380 \$2963 VPWR VGND \$3521 sg13cmos5l_nand2_1
* cell instance sg13cmos5l_nand2_1_189 r0 *1 0,0
Xsg13cmos5l_nand2_1_189 \$2384 \$2380 VPWR VGND \$2520 sg13cmos5l_nand2_1
* cell instance sg13cmos5l_nand2_1_190 r0 *1 0,0
Xsg13cmos5l_nand2_1_190 \$3839 \$4035 VPWR VGND \$3819 sg13cmos5l_nand2_1
* cell instance sg13cmos5l_nand2_1_191 r0 *1 0,0
Xsg13cmos5l_nand2_1_191 \$3382 \$3383 VPWR VGND \$899 sg13cmos5l_nand2_1
* cell instance sg13cmos5l_nand2_1_192 r0 *1 0,0
Xsg13cmos5l_nand2_1_192 \$2965 \$2106 VPWR VGND \$2964 sg13cmos5l_nand2_1
* cell instance sg13cmos5l_nand2_1_193 r0 *1 0,0
Xsg13cmos5l_nand2_1_193 \$1939 \$2105 VPWR VGND \$2104 sg13cmos5l_nand2_1
* cell instance sg13cmos5l_nand2_1_194 r0 *1 0,0
Xsg13cmos5l_nand2_1_194 \$3533 \$4035 VPWR VGND \$4241 sg13cmos5l_nand2_1
* cell instance sg13cmos5l_nand2_1_195 r0 *1 0,0
Xsg13cmos5l_nand2_1_195 \$2966 \$2818 VPWR VGND \$3382 sg13cmos5l_nand2_1
* cell instance sg13cmos5l_nand2_1_196 r0 *1 0,0
Xsg13cmos5l_nand2_1_196 \$2383 \$2106 VPWR VGND \$2384 sg13cmos5l_nand2_1
* cell instance sg13cmos5l_nand2_1_197 r0 *1 0,0
Xsg13cmos5l_nand2_1_197 \$3533 \$3839 VPWR VGND \$3841 sg13cmos5l_nand2_1
* cell instance sg13cmos5l_nand2_1_198 r0 *1 0,0
Xsg13cmos5l_nand2_1_198 \$3847 \$3544 VPWR VGND \$3846 sg13cmos5l_nand2_1
* cell instance sg13cmos5l_nand2_1_199 r0 *1 0,0
Xsg13cmos5l_nand2_1_199 \$4050 \$4515 VPWR VGND \$4049 sg13cmos5l_nand2_1
* cell instance sg13cmos5l_nand2_1_200 r0 *1 0,0
Xsg13cmos5l_nand2_1_200 \$3847 \$4051 VPWR VGND \$4245 sg13cmos5l_nand2_1
* cell instance sg13cmos5l_nand2_1_201 r0 *1 0,0
Xsg13cmos5l_nand2_1_201 \$3544 \$4051 VPWR VGND \$4039 sg13cmos5l_nand2_1
* cell instance sg13cmos5l_nand2_1_202 r0 *1 0,0
Xsg13cmos5l_nand2_1_202 \$3847 \$3688 VPWR VGND \$3547 sg13cmos5l_nand2_1
* cell instance sg13cmos5l_nand2_1_203 r0 *1 0,0
Xsg13cmos5l_nand2_1_203 \$3693 \$3694 VPWR VGND \$3690 sg13cmos5l_nand2_1
* cell instance sg13cmos5l_nand2b_1_0 r0 *1 0,0
Xsg13cmos5l_nand2b_1_0 \$2288 \$2435 VPWR VGND \$2294 sg13cmos5l_nand2b_1
* cell instance sg13cmos5l_nand2b_1_1 r0 *1 0,0
Xsg13cmos5l_nand2b_1_1 \$1838 \$1837 VPWR VGND \$1834 sg13cmos5l_nand2b_1
* cell instance sg13cmos5l_nand2b_1_2 r0 *1 0,0
Xsg13cmos5l_nand2b_1_2 \$46 \$153 VPWR VGND \$562 sg13cmos5l_nand2b_1
* cell instance sg13cmos5l_nand2b_1_3 r0 *1 0,0
Xsg13cmos5l_nand2b_1_3 \$3352 \$2849 VPWR VGND \$3355 sg13cmos5l_nand2b_1
* cell instance sg13cmos5l_nand2b_1_4 r0 *1 0,0
Xsg13cmos5l_nand2b_1_4 \$3216 \$3065 VPWR VGND \$3346 sg13cmos5l_nand2b_1
* cell instance sg13cmos5l_nand2b_1_5 r0 *1 0,0
Xsg13cmos5l_nand2b_1_5 \$1474 \$3205 VPWR VGND \$2047 sg13cmos5l_nand2b_1
* cell instance sg13cmos5l_nand2b_1_6 r0 *1 0,0
Xsg13cmos5l_nand2b_1_6 \$1724 \$2324 VPWR VGND \$2477 sg13cmos5l_nand2b_1
* cell instance sg13cmos5l_nand2b_1_7 r0 *1 0,0
Xsg13cmos5l_nand2b_1_7 \$3218 \$2068 VPWR VGND \$3209 sg13cmos5l_nand2b_1
* cell instance sg13cmos5l_nand2b_1_8 r0 *1 0,0
Xsg13cmos5l_nand2b_1_8 \$368 \$14 VPWR VGND \$806 sg13cmos5l_nand2b_1
* cell instance sg13cmos5l_nand2b_1_9 r0 *1 0,0
Xsg13cmos5l_nand2b_1_9 \$371 \$156 VPWR VGND \$418 sg13cmos5l_nand2b_1
* cell instance sg13cmos5l_nand2b_1_10 r0 *1 0,0
Xsg13cmos5l_nand2b_1_10 \$1095 \$752 VPWR VGND \$1203 sg13cmos5l_nand2b_1
* cell instance sg13cmos5l_nand2b_1_11 r0 *1 0,0
Xsg13cmos5l_nand2b_1_11 \$265 \$160 VPWR VGND \$175 sg13cmos5l_nand2b_1
* cell instance sg13cmos5l_nand2b_1_12 r0 *1 0,0
Xsg13cmos5l_nand2b_1_12 \$2335 \$2191 VPWR VGND \$2640 sg13cmos5l_nand2b_1
* cell instance sg13cmos5l_nand2b_1_13 r0 *1 0,0
Xsg13cmos5l_nand2b_1_13 \$100 \$102 VPWR VGND \$103 sg13cmos5l_nand2b_1
* cell instance sg13cmos5l_nand2b_1_14 r0 *1 0,0
Xsg13cmos5l_nand2b_1_14 \$643 \$669 VPWR VGND \$1085 sg13cmos5l_nand2b_1
* cell instance sg13cmos5l_nand2b_1_15 r0 *1 0,0
Xsg13cmos5l_nand2b_1_15 \$588 \$39 VPWR VGND \$644 sg13cmos5l_nand2b_1
* cell instance sg13cmos5l_nand2b_1_16 r0 *1 0,0
Xsg13cmos5l_nand2b_1_16 \$2218 \$2935 VPWR VGND \$2348 sg13cmos5l_nand2b_1
* cell instance sg13cmos5l_nand2b_1_17 r0 *1 0,0
Xsg13cmos5l_nand2b_1_17 \$2785 \$2717 VPWR VGND \$3802 sg13cmos5l_nand2b_1
* cell instance sg13cmos5l_nand2b_1_18 r0 *1 0,0
Xsg13cmos5l_nand2b_1_18 \$1905 \$1543 VPWR VGND \$2085 sg13cmos5l_nand2b_1
* cell instance sg13cmos5l_nand2b_1_19 r0 *1 0,0
Xsg13cmos5l_nand2b_1_19 \$1543 \$1905 VPWR VGND \$2087 sg13cmos5l_nand2b_1
* cell instance sg13cmos5l_nand2b_1_20 r0 *1 0,0
Xsg13cmos5l_nand2b_1_20 \$3371 \$3518 VPWR VGND \$3113 sg13cmos5l_nand2b_1
* cell instance sg13cmos5l_nand2b_1_21 r0 *1 0,0
Xsg13cmos5l_nand2b_1_21 \$2096 \$2090 VPWR VGND \$2094 sg13cmos5l_nand2b_1
* cell instance sg13cmos5l_nand2b_1_22 r0 *1 0,0
Xsg13cmos5l_nand2b_1_22 \$2219 \$2090 VPWR VGND \$2216 sg13cmos5l_nand2b_1
* cell instance sg13cmos5l_nand2b_1_23 r0 *1 0,0
Xsg13cmos5l_nand2b_1_23 \$2942 \$2788 VPWR VGND \$3522 sg13cmos5l_nand2b_1
* cell instance sg13cmos5l_nand2b_1_24 r0 *1 0,0
Xsg13cmos5l_nand2b_1_24 \$1753 \$2099 VPWR VGND \$2220 sg13cmos5l_nand2b_1
* cell instance sg13cmos5l_nand2b_1_25 r0 *1 0,0
Xsg13cmos5l_nand2b_1_25 \$1718 \$4254 VPWR VGND \$4255 sg13cmos5l_nand2b_1
* cell instance sg13cmos5l_nand2b_1_26 r0 *1 0,0
Xsg13cmos5l_nand2b_1_26 \$4498 \$4035 VPWR VGND \$4254 sg13cmos5l_nand2b_1
* cell instance sg13cmos5l_nand2b_1_27 r0 *1 0,0
Xsg13cmos5l_nand2b_1_27 \$3165 \$2099 VPWR VGND \$3383 sg13cmos5l_nand2b_1
* cell instance sg13cmos5l_nand2b_1_28 r0 *1 0,0
Xsg13cmos5l_nand2b_1_28 \$4515 \$4695 VPWR VGND \$4697 sg13cmos5l_nand2b_1
* cell instance sg13cmos5l_nand2b_1_29 r0 *1 0,0
Xsg13cmos5l_nand2b_1_29 \$3544 \$3547 VPWR VGND \$3403 sg13cmos5l_nand2b_1
* cell instance sg13cmos5l_nand2b_1_30 r0 *1 0,0
Xsg13cmos5l_nand2b_1_30 \$3691 \$3549 VPWR VGND \$3551 sg13cmos5l_nand2b_1
* cell instance sg13cmos5l_nand3_1_0 r0 *1 0,0
Xsg13cmos5l_nand3_1_0 \$1833 \$2283 \$2435 VPWR VGND \$2436 sg13cmos5l_nand3_1
* cell instance sg13cmos5l_nand3_1_1 r0 *1 0,0
Xsg13cmos5l_nand3_1_1 \$1300 \$1805 \$1644 VPWR VGND \$2 sg13cmos5l_nand3_1
* cell instance sg13cmos5l_nand3_1_2 r0 *1 0,0
Xsg13cmos5l_nand3_1_2 \$5119 \$5121 \$5192 VPWR VGND \$4077 sg13cmos5l_nand3_1
* cell instance sg13cmos5l_nand3_1_3 r0 *1 0,0
Xsg13cmos5l_nand3_1_3 \$7211 \$7640 \$7719 VPWR VGND \$7720 sg13cmos5l_nand3_1
* cell instance sg13cmos5l_nand3_1_4 r0 *1 0,0
Xsg13cmos5l_nand3_1_4 \$2161 \$3192 \$3193 VPWR VGND \$3338 sg13cmos5l_nand3_1
* cell instance sg13cmos5l_nand3_1_5 r0 *1 0,0
Xsg13cmos5l_nand3_1_5 \$7209 \$7554 \$7585 VPWR VGND \$7555 sg13cmos5l_nand3_1
* cell instance sg13cmos5l_nand3_1_6 r0 *1 0,0
Xsg13cmos5l_nand3_1_6 \$1287 \$937 \$1645 VPWR VGND \$1967 sg13cmos5l_nand3_1
* cell instance sg13cmos5l_nand3_1_7 r0 *1 0,0
Xsg13cmos5l_nand3_1_7 \$2161 \$3192 \$3197 VPWR VGND \$3341 sg13cmos5l_nand3_1
* cell instance sg13cmos5l_nand3_1_8 r0 *1 0,0
Xsg13cmos5l_nand3_1_8 \$1303 \$2451 \$2450 VPWR VGND \$2614 sg13cmos5l_nand3_1
* cell instance sg13cmos5l_nand3_1_9 r0 *1 0,0
Xsg13cmos5l_nand3_1_9 \$6977 \$7641 \$7656 VPWR VGND \$7558 sg13cmos5l_nand3_1
* cell instance sg13cmos5l_nand3_1_10 r0 *1 0,0
Xsg13cmos5l_nand3_1_10 \$4597 \$4596 \$4361 VPWR VGND \$4359 sg13cmos5l_nand3_1
* cell instance sg13cmos5l_nand3_1_11 r0 *1 0,0
Xsg13cmos5l_nand3_1_11 \$2161 \$3193 \$3053 VPWR VGND \$2750 sg13cmos5l_nand3_1
* cell instance sg13cmos5l_nand3_1_12 r0 *1 0,0
Xsg13cmos5l_nand3_1_12 \$2161 \$2319 \$2464 VPWR VGND \$3343 sg13cmos5l_nand3_1
* cell instance sg13cmos5l_nand3_1_13 r0 *1 0,0
Xsg13cmos5l_nand3_1_13 \$4143 \$4598 \$4358 VPWR VGND \$4363 sg13cmos5l_nand3_1
* cell instance sg13cmos5l_nand3_1_14 r0 *1 0,0
Xsg13cmos5l_nand3_1_14 \$1193 \$1062 \$1307 VPWR VGND \$1851 sg13cmos5l_nand3_1
* cell instance sg13cmos5l_nand3_1_15 r0 *1 0,0
Xsg13cmos5l_nand3_1_15 \$148 \$153 \$3 VPWR VGND \$735 sg13cmos5l_nand3_1
* cell instance sg13cmos5l_nand3_1_16 r0 *1 0,0
Xsg13cmos5l_nand3_1_16 \$588 \$735 \$730 VPWR VGND \$736 sg13cmos5l_nand3_1
* cell instance sg13cmos5l_nand3_1_17 r0 *1 0,0
Xsg13cmos5l_nand3_1_17 \$48 \$153 \$246 VPWR VGND \$588 sg13cmos5l_nand3_1
* cell instance sg13cmos5l_nand3_1_18 r0 *1 0,0
Xsg13cmos5l_nand3_1_18 \$130 \$737 \$742 VPWR VGND \$740 sg13cmos5l_nand3_1
* cell instance sg13cmos5l_nand3_1_19 r0 *1 0,0
Xsg13cmos5l_nand3_1_19 \$156 \$157 \$158 VPWR VGND \$61 sg13cmos5l_nand3_1
* cell instance sg13cmos5l_nand3_1_20 r0 *1 0,0
Xsg13cmos5l_nand3_1_20 \$2439 \$1303 \$2123 VPWR VGND \$1992 sg13cmos5l_nand3_1
* cell instance sg13cmos5l_nand3_1_21 r0 *1 0,0
Xsg13cmos5l_nand3_1_21 \$155 \$159 \$34 VPWR VGND \$158 sg13cmos5l_nand3_1
* cell instance sg13cmos5l_nand3_1_22 r0 *1 0,0
Xsg13cmos5l_nand3_1_22 \$2439 \$2123 \$3215 VPWR VGND \$2475 sg13cmos5l_nand3_1
* cell instance sg13cmos5l_nand3_1_23 r0 *1 0,0
Xsg13cmos5l_nand3_1_23 \$2325 \$2475 \$2266 VPWR VGND \$2324 sg13cmos5l_nand3_1
* cell instance sg13cmos5l_nand3_1_24 r0 *1 0,0
Xsg13cmos5l_nand3_1_24 \$207 \$157 \$208 VPWR VGND \$28 sg13cmos5l_nand3_1
* cell instance sg13cmos5l_nand3_1_25 r0 *1 0,0
Xsg13cmos5l_nand3_1_25 \$3054 \$2925 \$2124 VPWR VGND \$2906 sg13cmos5l_nand3_1
* cell instance sg13cmos5l_nand3_1_26 r0 *1 0,0
Xsg13cmos5l_nand3_1_26 \$804 \$147 \$166 VPWR VGND \$368 sg13cmos5l_nand3_1
* cell instance sg13cmos5l_nand3_1_27 r0 *1 0,0
Xsg13cmos5l_nand3_1_27 \$162 \$588 \$522 VPWR VGND \$682 sg13cmos5l_nand3_1
* cell instance sg13cmos5l_nand3_1_28 r0 *1 0,0
Xsg13cmos5l_nand3_1_28 \$130 \$368 \$742 VPWR VGND \$681 sg13cmos5l_nand3_1
* cell instance sg13cmos5l_nand3_1_29 r0 *1 0,0
Xsg13cmos5l_nand3_1_29 \$128 \$681 \$682 VPWR VGND \$679 sg13cmos5l_nand3_1
* cell instance sg13cmos5l_nand3_1_30 r0 *1 0,0
Xsg13cmos5l_nand3_1_30 \$14 \$166 \$268 VPWR VGND \$985 sg13cmos5l_nand3_1
* cell instance sg13cmos5l_nand3_1_31 r0 *1 0,0
Xsg13cmos5l_nand3_1_31 \$151 \$471 \$316 VPWR VGND \$742 sg13cmos5l_nand3_1
* cell instance sg13cmos5l_nand3_1_32 r0 *1 0,0
Xsg13cmos5l_nand3_1_32 \$522 \$160 \$866 VPWR VGND \$920 sg13cmos5l_nand3_1
* cell instance sg13cmos5l_nand3_1_33 r0 *1 0,0
Xsg13cmos5l_nand3_1_33 \$214 \$1203 \$1330 VPWR VGND \$1334 sg13cmos5l_nand3_1
* cell instance sg13cmos5l_nand3_1_34 r0 *1 0,0
Xsg13cmos5l_nand3_1_34 \$88 \$86 \$85 VPWR VGND \$87 sg13cmos5l_nand3_1
* cell instance sg13cmos5l_nand3_1_35 r0 *1 0,0
Xsg13cmos5l_nand3_1_35 \$154 \$299 \$213 VPWR VGND \$212 sg13cmos5l_nand3_1
* cell instance sg13cmos5l_nand3_1_36 r0 *1 0,0
Xsg13cmos5l_nand3_1_36 \$176 \$323 \$215 VPWR VGND \$214 sg13cmos5l_nand3_1
* cell instance sg13cmos5l_nand3_1_37 r0 *1 0,0
Xsg13cmos5l_nand3_1_37 \$697 \$187 \$632 VPWR VGND \$696 sg13cmos5l_nand3_1
* cell instance sg13cmos5l_nand3_1_38 r0 *1 0,0
Xsg13cmos5l_nand3_1_38 \$2332 \$2649 \$3370 VPWR VGND \$3228 sg13cmos5l_nand3_1
* cell instance sg13cmos5l_nand3_1_39 r0 *1 0,0
Xsg13cmos5l_nand3_1_39 \$16 \$292 \$293 VPWR VGND \$219 sg13cmos5l_nand3_1
* cell instance sg13cmos5l_nand3_1_40 r0 *1 0,0
Xsg13cmos5l_nand3_1_40 \$110 \$330 \$329 VPWR VGND \$332 sg13cmos5l_nand3_1
* cell instance sg13cmos5l_nand3_1_41 r0 *1 0,0
Xsg13cmos5l_nand3_1_41 \$595 \$752 \$590 VPWR VGND \$491 sg13cmos5l_nand3_1
* cell instance sg13cmos5l_nand3_1_42 r0 *1 0,0
Xsg13cmos5l_nand3_1_42 \$489 \$483 \$493 VPWR VGND \$494 sg13cmos5l_nand3_1
* cell instance sg13cmos5l_nand3_1_43 r0 *1 0,0
Xsg13cmos5l_nand3_1_43 \$3106 \$2937 \$2787 VPWR VGND \$3095 sg13cmos5l_nand3_1
* cell instance sg13cmos5l_nand3_1_44 r0 *1 0,0
Xsg13cmos5l_nand3_1_44 \$225 \$224 \$223 VPWR VGND \$222 sg13cmos5l_nand3_1
* cell instance sg13cmos5l_nand3_1_45 r0 *1 0,0
Xsg13cmos5l_nand3_1_45 \$12 \$42 \$41 VPWR VGND \$284 sg13cmos5l_nand3_1
* cell instance sg13cmos5l_nand3_1_46 r0 *1 0,0
Xsg13cmos5l_nand3_1_46 \$2564 \$2658 \$2790 VPWR VGND \$2789 sg13cmos5l_nand3_1
* cell instance sg13cmos5l_nand3_1_47 r0 *1 0,0
Xsg13cmos5l_nand3_1_47 \$2943 \$2941 \$3109 VPWR VGND \$3110 sg13cmos5l_nand3_1
* cell instance sg13cmos5l_nand3_1_48 r0 *1 0,0
Xsg13cmos5l_nand3_1_48 \$2351 \$2935 \$2357 VPWR VGND \$2356 sg13cmos5l_nand3_1
* cell instance sg13cmos5l_nand3_1_49 r0 *1 0,0
Xsg13cmos5l_nand3_1_49 \$811 \$36 \$1012 VPWR VGND \$822 sg13cmos5l_nand3_1
* cell instance sg13cmos5l_nand3_1_50 r0 *1 0,0
Xsg13cmos5l_nand3_1_50 \$345 \$820 \$293 VPWR VGND \$440 sg13cmos5l_nand3_1
* cell instance sg13cmos5l_nand3_1_51 r0 *1 0,0
Xsg13cmos5l_nand3_1_51 \$25 \$115 \$302 VPWR VGND \$205 sg13cmos5l_nand3_1
* cell instance sg13cmos5l_nand3_1_52 r0 *1 0,0
Xsg13cmos5l_nand3_1_52 \$2209 \$2216 \$2208 VPWR VGND \$1285 sg13cmos5l_nand3_1
* cell instance sg13cmos5l_nand3_1_53 r0 *1 0,0
Xsg13cmos5l_nand3_1_53 \$182 \$11 \$225 VPWR VGND \$236 sg13cmos5l_nand3_1
* cell instance sg13cmos5l_nand3_1_54 r0 *1 0,0
Xsg13cmos5l_nand3_1_54 \$2209 \$2094 \$2089 VPWR VGND \$1402 sg13cmos5l_nand3_1
* cell instance sg13cmos5l_nand3_1_55 r0 *1 0,0
Xsg13cmos5l_nand3_1_55 \$2423 \$2953 \$3113 VPWR VGND \$3114 sg13cmos5l_nand3_1
* cell instance sg13cmos5l_nand3_1_56 r0 *1 0,0
Xsg13cmos5l_nand3_1_56 \$4006 \$4007 \$3832 VPWR VGND \$3823 sg13cmos5l_nand3_1
* cell instance sg13cmos5l_nand3_1_57 r0 *1 0,0
Xsg13cmos5l_nand3_1_57 \$2220 \$1926 \$2352 VPWR VGND \$2218 sg13cmos5l_nand3_1
* cell instance sg13cmos5l_nand3_1_58 r0 *1 0,0
Xsg13cmos5l_nand3_1_58 \$1928 \$1927 \$1749 VPWR VGND \$1926 sg13cmos5l_nand3_1
* cell instance sg13cmos5l_nand3_1_59 r0 *1 0,0
Xsg13cmos5l_nand3_1_59 \$1118 \$1743 \$1740 VPWR VGND \$1928 sg13cmos5l_nand3_1
* cell instance sg13cmos5l_nand3_1_60 r0 *1 0,0
Xsg13cmos5l_nand3_1_60 \$2093 \$2964 \$2962 VPWR VGND \$2963 sg13cmos5l_nand3_1
* cell instance sg13cmos5l_nand3_1_61 r0 *1 0,0
Xsg13cmos5l_nand3_1_61 \$3693 \$3692 \$4052 VPWR VGND \$3549 sg13cmos5l_nand3_1
* cell instance sg13cmos5l_nand3_1_62 r0 *1 0,0
Xsg13cmos5l_nand3_1_62 \$4059 \$4281 \$4521 VPWR VGND \$4530 sg13cmos5l_nand3_1
* cell instance sg13cmos5l_nand3b_1_0 r0 *1 0,0
Xsg13cmos5l_nand3b_1_0 \$1831 \$2438 \$2598 VPWR VGND \$2600 sg13cmos5l_nand3b_1
* cell instance sg13cmos5l_nand3b_1_1 r0 *1 0,0
Xsg13cmos5l_nand3b_1_1 \$316 \$471 \$166 VPWR VGND \$866 sg13cmos5l_nand3b_1
* cell instance sg13cmos5l_nand3b_1_2 r0 *1 0,0
Xsg13cmos5l_nand3b_1_2 \$300 \$401 \$935 VPWR VGND \$403 sg13cmos5l_nand3b_1
* cell instance sg13cmos5l_nand3b_1_3 r0 *1 0,0
Xsg13cmos5l_nand3b_1_3 \$3195 \$4254 \$4500 VPWR VGND \$4501 sg13cmos5l_nand3b_1
* cell instance sg13cmos5l_nand4_1_0 r0 *1 0,0
Xsg13cmos5l_nand4_1_0 \$1833 \$1819 \$2283 \$2435 VPWR VGND \$2001
+ sg13cmos5l_nand4_1
* cell instance sg13cmos5l_nand4_1_1 r0 *1 0,0
Xsg13cmos5l_nand4_1_1 \$7219 \$7557 \$7336 \$7218 VPWR VGND \$7337
+ sg13cmos5l_nand4_1
* cell instance sg13cmos5l_nand4_1_2 r0 *1 0,0
Xsg13cmos5l_nand4_1_2 \$3739 \$3734 \$3435 \$3913 VPWR VGND \$3911
+ sg13cmos5l_nand4_1
* cell instance sg13cmos5l_nand4_1_3 r0 *1 0,0
Xsg13cmos5l_nand4_1_3 \$3751 \$3734 \$3912 \$3913 VPWR VGND \$3910
+ sg13cmos5l_nand4_1
* cell instance sg13cmos5l_nand4_1_4 r0 *1 0,0
Xsg13cmos5l_nand4_1_4 \$2161 \$3193 \$3053 \$2331 VPWR VGND \$3054
+ sg13cmos5l_nand4_1
* cell instance sg13cmos5l_nand4_1_5 r0 *1 0,0
Xsg13cmos5l_nand4_1_5 \$3218 \$7446 \$6972 \$4156 VPWR VGND \$7269
+ sg13cmos5l_nand4_1
* cell instance sg13cmos5l_nand4_1_6 r0 *1 0,0
Xsg13cmos5l_nand4_1_6 \$148 \$49 \$130 \$305 VPWR VGND \$349 sg13cmos5l_nand4_1
* cell instance sg13cmos5l_nand4_1_7 r0 *1 0,0
Xsg13cmos5l_nand4_1_7 \$2621 \$3203 \$2319 \$3197 VPWR VGND \$3202
+ sg13cmos5l_nand4_1
* cell instance sg13cmos5l_nand4_1_8 r0 *1 0,0
Xsg13cmos5l_nand4_1_8 \$2606 \$2123 \$2889 \$3210 VPWR VGND \$2624
+ sg13cmos5l_nand4_1
* cell instance sg13cmos5l_nand4_1_9 r0 *1 0,0
Xsg13cmos5l_nand4_1_9 \$631 \$305 \$85 \$632 VPWR VGND \$571 sg13cmos5l_nand4_1
* cell instance sg13cmos5l_nand4_1_10 r0 *1 0,0
Xsg13cmos5l_nand4_1_10 \$2849 \$2908 \$3598 \$3474 VPWR VGND \$3904
+ sg13cmos5l_nand4_1
* cell instance sg13cmos5l_nand4_1_11 r0 *1 0,0
Xsg13cmos5l_nand4_1_11 \$144 \$785 \$167 \$511 VPWR VGND \$1089
+ sg13cmos5l_nand4_1
* cell instance sg13cmos5l_nand4_1_12 r0 *1 0,0
Xsg13cmos5l_nand4_1_12 \$861 \$612 \$368 \$857 VPWR VGND \$860
+ sg13cmos5l_nand4_1
* cell instance sg13cmos5l_nand4_1_13 r0 *1 0,0
Xsg13cmos5l_nand4_1_13 \$1880 \$1870 \$1897 \$2125 VPWR VGND \$3156
+ sg13cmos5l_nand4_1
* cell instance sg13cmos5l_nand4_1_14 r0 *1 0,0
Xsg13cmos5l_nand4_1_14 \$2060 \$2645 \$2778 \$2929 VPWR VGND \$2765
+ sg13cmos5l_nand4_1
* cell instance sg13cmos5l_nand4_1_15 r0 *1 0,0
Xsg13cmos5l_nand4_1_15 \$1880 \$1870 \$2057 \$2055 VPWR VGND \$2058
+ sg13cmos5l_nand4_1
* cell instance sg13cmos5l_nand4_1_16 r0 *1 0,0
Xsg13cmos5l_nand4_1_16 \$176 \$175 \$94 \$87 VPWR VGND \$4 sg13cmos5l_nand4_1
* cell instance sg13cmos5l_nand4_1_17 r0 *1 0,0
Xsg13cmos5l_nand4_1_17 \$3096 \$3160 \$2772 \$3367 VPWR VGND \$3094
+ sg13cmos5l_nand4_1
* cell instance sg13cmos5l_nand4_1_18 r0 *1 0,0
Xsg13cmos5l_nand4_1_18 \$2652 \$2854 \$2783 \$3004 VPWR VGND \$2782
+ sg13cmos5l_nand4_1
* cell instance sg13cmos5l_nand4_1_19 r0 *1 0,0
Xsg13cmos5l_nand4_1_19 \$2637 \$2348 \$2349 \$2350 VPWR VGND \$2200
+ sg13cmos5l_nand4_1
* cell instance sg13cmos5l_nand4_1_20 r0 *1 0,0
Xsg13cmos5l_nand4_1_20 \$2218 \$2494 \$2427 \$2654 VPWR VGND \$2655
+ sg13cmos5l_nand4_1
* cell instance sg13cmos5l_nand4_1_21 r0 *1 0,0
Xsg13cmos5l_nand4_1_21 \$2071 \$1543 \$1905 \$2123 VPWR VGND \$2083
+ sg13cmos5l_nand4_1
* cell instance sg13cmos5l_nand4_1_22 r0 *1 0,0
Xsg13cmos5l_nand4_1_22 \$2504 \$2505 \$2358 \$2356 VPWR VGND \$2507
+ sg13cmos5l_nand4_1
* cell instance sg13cmos5l_nand4_1_23 r0 *1 0,0
Xsg13cmos5l_nand4_1_23 \$4006 \$3834 \$4007 \$3815 VPWR VGND \$4028
+ sg13cmos5l_nand4_1
* cell instance sg13cmos5l_nand4_1_24 r0 *1 0,0
Xsg13cmos5l_nand4_1_24 \$3693 \$4522 \$4515 \$4523 VPWR VGND \$4407
+ sg13cmos5l_nand4_1
* cell instance sg13cmos5l_nor2_1_0 r0 *1 0,0
Xsg13cmos5l_nor2_1_0 \$2270 \$2284 VPWR VGND \$2283 sg13cmos5l_nor2_1
* cell instance sg13cmos5l_nor2_1_1 r0 *1 0,0
Xsg13cmos5l_nor2_1_1 \$9358 \$8320 VPWR VGND \$9275 sg13cmos5l_nor2_1
* cell instance sg13cmos5l_nor2_1_2 r0 *1 0,0
Xsg13cmos5l_nor2_1_2 \$10703 \$9804 VPWR VGND \$10704 sg13cmos5l_nor2_1
* cell instance sg13cmos5l_nor2_1_3 r0 *1 0,0
Xsg13cmos5l_nor2_1_3 \$1819 \$1638 VPWR VGND \$1820 sg13cmos5l_nor2_1
* cell instance sg13cmos5l_nor2_1_4 r0 *1 0,0
Xsg13cmos5l_nor2_1_4 \$3423 \$1817 VPWR VGND \$3172 sg13cmos5l_nor2_1
* cell instance sg13cmos5l_nor2_1_5 r0 *1 0,0
Xsg13cmos5l_nor2_1_5 \$8174 \$8320 VPWR VGND \$8175 sg13cmos5l_nor2_1
* cell instance sg13cmos5l_nor2_1_6 r0 *1 0,0
Xsg13cmos5l_nor2_1_6 \$13835 \$9804 VPWR VGND \$12872 sg13cmos5l_nor2_1
* cell instance sg13cmos5l_nor2_1_7 r0 *1 0,0
Xsg13cmos5l_nor2_1_7 \$9502 \$7584 VPWR VGND \$12640 sg13cmos5l_nor2_1
* cell instance sg13cmos5l_nor2_1_8 r0 *1 0,0
Xsg13cmos5l_nor2_1_8 \$1640 \$1638 VPWR VGND \$1639 sg13cmos5l_nor2_1
* cell instance sg13cmos5l_nor2_1_9 r0 *1 0,0
Xsg13cmos5l_nor2_1_9 \$10873 \$7801 VPWR VGND \$11162 sg13cmos5l_nor2_1
* cell instance sg13cmos5l_nor2_1_10 r0 *1 0,0
Xsg13cmos5l_nor2_1_10 \$2439 \$2438 VPWR VGND \$2149 sg13cmos5l_nor2_1
* cell instance sg13cmos5l_nor2_1_11 r0 *1 0,0
Xsg13cmos5l_nor2_1_11 \$9957 \$9804 VPWR VGND \$9785 sg13cmos5l_nor2_1
* cell instance sg13cmos5l_nor2_1_12 r0 *1 0,0
Xsg13cmos5l_nor2_1_12 \$2150 \$2149 VPWR VGND \$1638 sg13cmos5l_nor2_1
* cell instance sg13cmos5l_nor2_1_13 r0 *1 0,0
Xsg13cmos5l_nor2_1_13 \$3323 \$1817 VPWR VGND \$3322 sg13cmos5l_nor2_1
* cell instance sg13cmos5l_nor2_1_14 r0 *1 0,0
Xsg13cmos5l_nor2_1_14 \$2439 \$2597 VPWR VGND \$3028 sg13cmos5l_nor2_1
* cell instance sg13cmos5l_nor2_1_15 r0 *1 0,0
Xsg13cmos5l_nor2_1_15 \$9352 \$8320 VPWR VGND \$8322 sg13cmos5l_nor2_1
* cell instance sg13cmos5l_nor2_1_16 r0 *1 0,0
Xsg13cmos5l_nor2_1_16 \$1833 \$2151 VPWR VGND \$2260 sg13cmos5l_nor2_1
* cell instance sg13cmos5l_nor2_1_17 r0 *1 0,0
Xsg13cmos5l_nor2_1_17 \$9363 \$5116 VPWR VGND \$9364 sg13cmos5l_nor2_1
* cell instance sg13cmos5l_nor2_1_18 r0 *1 0,0
Xsg13cmos5l_nor2_1_18 \$2439 \$2733 VPWR VGND \$1991 sg13cmos5l_nor2_1
* cell instance sg13cmos5l_nor2_1_19 r0 *1 0,0
Xsg13cmos5l_nor2_1_19 \$1650 \$2739 VPWR VGND \$2736 sg13cmos5l_nor2_1
* cell instance sg13cmos5l_nor2_1_20 r0 *1 0,0
Xsg13cmos5l_nor2_1_20 \$7332 \$10172 VPWR VGND \$14695 sg13cmos5l_nor2_1
* cell instance sg13cmos5l_nor2_1_21 r0 *1 0,0
Xsg13cmos5l_nor2_1_21 \$11314 \$7888 VPWR VGND \$11171 sg13cmos5l_nor2_1
* cell instance sg13cmos5l_nor2_1_22 r0 *1 0,0
Xsg13cmos5l_nor2_1_22 \$7586 \$9794 VPWR VGND \$16329 sg13cmos5l_nor2_1
* cell instance sg13cmos5l_nor2_1_23 r0 *1 0,0
Xsg13cmos5l_nor2_1_23 \$11899 \$11895 VPWR VGND \$11749 sg13cmos5l_nor2_1
* cell instance sg13cmos5l_nor2_1_24 r0 *1 0,0
Xsg13cmos5l_nor2_1_24 \$8923 \$8922 VPWR VGND \$8777 sg13cmos5l_nor2_1
* cell instance sg13cmos5l_nor2_1_25 r0 *1 0,0
Xsg13cmos5l_nor2_1_25 \$2739 \$3203 VPWR VGND \$3192 sg13cmos5l_nor2_1
* cell instance sg13cmos5l_nor2_1_26 r0 *1 0,0
Xsg13cmos5l_nor2_1_26 \$1299 \$1436 VPWR VGND \$2742 sg13cmos5l_nor2_1
* cell instance sg13cmos5l_nor2_1_27 r0 *1 0,0
Xsg13cmos5l_nor2_1_27 \$3339 \$3575 VPWR VGND \$3710 sg13cmos5l_nor2_1
* cell instance sg13cmos5l_nor2_1_28 r0 *1 0,0
Xsg13cmos5l_nor2_1_28 \$2319 \$3197 VPWR VGND \$3193 sg13cmos5l_nor2_1
* cell instance sg13cmos5l_nor2_1_29 r0 *1 0,0
Xsg13cmos5l_nor2_1_29 \$12874 \$9804 VPWR VGND \$12651 sg13cmos5l_nor2_1
* cell instance sg13cmos5l_nor2_1_30 r0 *1 0,0
Xsg13cmos5l_nor2_1_30 \$13362 \$11895 VPWR VGND \$13361 sg13cmos5l_nor2_1
* cell instance sg13cmos5l_nor2_1_31 r0 *1 0,0
Xsg13cmos5l_nor2_1_31 \$2319 \$3341 VPWR VGND \$3448 sg13cmos5l_nor2_1
* cell instance sg13cmos5l_nor2_1_32 r0 *1 0,0
Xsg13cmos5l_nor2_1_32 \$3350 \$3341 VPWR VGND \$4141 sg13cmos5l_nor2_1
* cell instance sg13cmos5l_nor2_1_33 r0 *1 0,0
Xsg13cmos5l_nor2_1_33 \$3904 \$3710 VPWR VGND \$3728 sg13cmos5l_nor2_1
* cell instance sg13cmos5l_nor2_1_34 r0 *1 0,0
Xsg13cmos5l_nor2_1_34 \$3733 \$3911 VPWR VGND \$3909 sg13cmos5l_nor2_1
* cell instance sg13cmos5l_nor2_1_35 r0 *1 0,0
Xsg13cmos5l_nor2_1_35 \$9368 \$8320 VPWR VGND \$8324 sg13cmos5l_nor2_1
* cell instance sg13cmos5l_nor2_1_36 r0 *1 0,0
Xsg13cmos5l_nor2_1_36 \$3419 \$6211 VPWR VGND \$16598 sg13cmos5l_nor2_1
* cell instance sg13cmos5l_nor2_1_37 r0 *1 0,0
Xsg13cmos5l_nor2_1_37 \$3449 \$3343 VPWR VGND \$3450 sg13cmos5l_nor2_1
* cell instance sg13cmos5l_nor2_1_38 r0 *1 0,0
Xsg13cmos5l_nor2_1_38 \$3196 \$3341 VPWR VGND \$5122 sg13cmos5l_nor2_1
* cell instance sg13cmos5l_nor2_1_39 r0 *1 0,0
Xsg13cmos5l_nor2_1_39 \$145 \$715 VPWR VGND \$716 sg13cmos5l_nor2_1
* cell instance sg13cmos5l_nor2_1_40 r0 *1 0,0
Xsg13cmos5l_nor2_1_40 \$3449 \$3342 VPWR VGND \$3451 sg13cmos5l_nor2_1
* cell instance sg13cmos5l_nor2_1_41 r0 *1 0,0
Xsg13cmos5l_nor2_1_41 \$10289 \$8922 VPWR VGND \$9370 sg13cmos5l_nor2_1
* cell instance sg13cmos5l_nor2_1_42 r0 *1 0,0
Xsg13cmos5l_nor2_1_42 \$3343 \$3453 VPWR VGND \$3735 sg13cmos5l_nor2_1
* cell instance sg13cmos5l_nor2_1_43 r0 *1 0,0
Xsg13cmos5l_nor2_1_43 \$3350 \$2750 VPWR VGND \$7725 sg13cmos5l_nor2_1
* cell instance sg13cmos5l_nor2_1_44 r0 *1 0,0
Xsg13cmos5l_nor2_1_44 \$2739 \$2851 VPWR VGND \$3053 sg13cmos5l_nor2_1
* cell instance sg13cmos5l_nor2_1_45 r0 *1 0,0
Xsg13cmos5l_nor2_1_45 \$3904 \$3737 VPWR VGND \$3914 sg13cmos5l_nor2_1
* cell instance sg13cmos5l_nor2_1_46 r0 *1 0,0
Xsg13cmos5l_nor2_1_46 \$6408 \$4362 VPWR VGND \$13092 sg13cmos5l_nor2_1
* cell instance sg13cmos5l_nor2_1_47 r0 *1 0,0
Xsg13cmos5l_nor2_1_47 \$152 \$566 VPWR VGND \$615 sg13cmos5l_nor2_1
* cell instance sg13cmos5l_nor2_1_48 r0 *1 0,0
Xsg13cmos5l_nor2_1_48 \$1850 \$1851 VPWR VGND \$1645 sg13cmos5l_nor2_1
* cell instance sg13cmos5l_nor2_1_49 r0 *1 0,0
Xsg13cmos5l_nor2_1_49 \$3734 \$3914 VPWR VGND \$3736 sg13cmos5l_nor2_1
* cell instance sg13cmos5l_nor2_1_50 r0 *1 0,0
Xsg13cmos5l_nor2_1_50 \$244 \$243 VPWR VGND \$242 sg13cmos5l_nor2_1
* cell instance sg13cmos5l_nor2_1_51 r0 *1 0,0
Xsg13cmos5l_nor2_1_51 \$54 \$130 VPWR VGND \$450 sg13cmos5l_nor2_1
* cell instance sg13cmos5l_nor2_1_52 r0 *1 0,0
Xsg13cmos5l_nor2_1_52 \$621 \$187 VPWR VGND \$614 sg13cmos5l_nor2_1
* cell instance sg13cmos5l_nor2_1_53 r0 *1 0,0
Xsg13cmos5l_nor2_1_53 \$47 \$54 VPWR VGND \$10 sg13cmos5l_nor2_1
* cell instance sg13cmos5l_nor2_1_54 r0 *1 0,0
Xsg13cmos5l_nor2_1_54 \$47 \$187 VPWR VGND \$454 sg13cmos5l_nor2_1
* cell instance sg13cmos5l_nor2_1_55 r0 *1 0,0
Xsg13cmos5l_nor2_1_55 \$48 \$49 VPWR VGND \$6 sg13cmos5l_nor2_1
* cell instance sg13cmos5l_nor2_1_56 r0 *1 0,0
Xsg13cmos5l_nor2_1_56 \$48 \$153 VPWR VGND \$886 sg13cmos5l_nor2_1
* cell instance sg13cmos5l_nor2_1_57 r0 *1 0,0
Xsg13cmos5l_nor2_1_57 \$2458 \$2459 VPWR VGND \$2156 sg13cmos5l_nor2_1
* cell instance sg13cmos5l_nor2_1_58 r0 *1 0,0
Xsg13cmos5l_nor2_1_58 \$243 \$201 VPWR VGND \$249 sg13cmos5l_nor2_1
* cell instance sg13cmos5l_nor2_1_59 r0 *1 0,0
Xsg13cmos5l_nor2_1_59 \$54 \$238 VPWR VGND \$250 sg13cmos5l_nor2_1
* cell instance sg13cmos5l_nor2_1_60 r0 *1 0,0
Xsg13cmos5l_nor2_1_60 \$243 \$461 VPWR VGND \$521 sg13cmos5l_nor2_1
* cell instance sg13cmos5l_nor2_1_61 r0 *1 0,0
Xsg13cmos5l_nor2_1_61 \$735 \$243 VPWR VGND \$354 sg13cmos5l_nor2_1
* cell instance sg13cmos5l_nor2_1_62 r0 *1 0,0
Xsg13cmos5l_nor2_1_62 \$145 \$201 VPWR VGND \$203 sg13cmos5l_nor2_1
* cell instance sg13cmos5l_nor2_1_63 r0 *1 0,0
Xsg13cmos5l_nor2_1_63 \$1461 \$1451 VPWR VGND \$2123 sg13cmos5l_nor2_1
* cell instance sg13cmos5l_nor2_1_64 r0 *1 0,0
Xsg13cmos5l_nor2_1_64 \$3752 \$3471 VPWR VGND \$3754 sg13cmos5l_nor2_1
* cell instance sg13cmos5l_nor2_1_65 r0 *1 0,0
Xsg13cmos5l_nor2_1_65 \$2190 \$2465 VPWR VGND \$1849 sg13cmos5l_nor2_1
* cell instance sg13cmos5l_nor2_1_66 r0 *1 0,0
Xsg13cmos5l_nor2_1_66 \$152 \$128 VPWR VGND \$155 sg13cmos5l_nor2_1
* cell instance sg13cmos5l_nor2_1_67 r0 *1 0,0
Xsg13cmos5l_nor2_1_67 \$24 \$238 VPWR VGND \$912 sg13cmos5l_nor2_1
* cell instance sg13cmos5l_nor2_1_68 r0 *1 0,0
Xsg13cmos5l_nor2_1_68 \$405 \$806 VPWR VGND \$968 sg13cmos5l_nor2_1
* cell instance sg13cmos5l_nor2_1_69 r0 *1 0,0
Xsg13cmos5l_nor2_1_69 \$49 \$511 VPWR VGND \$524 sg13cmos5l_nor2_1
* cell instance sg13cmos5l_nor2_1_70 r0 *1 0,0
Xsg13cmos5l_nor2_1_70 \$3156 \$3209 VPWR VGND \$3212 sg13cmos5l_nor2_1
* cell instance sg13cmos5l_nor2_1_71 r0 *1 0,0
Xsg13cmos5l_nor2_1_71 \$1303 \$2626 VPWR VGND \$1970 sg13cmos5l_nor2_1
* cell instance sg13cmos5l_nor2_1_72 r0 *1 0,0
Xsg13cmos5l_nor2_1_72 \$3491 \$3947 VPWR VGND \$4161 sg13cmos5l_nor2_1
* cell instance sg13cmos5l_nor2_1_73 r0 *1 0,0
Xsg13cmos5l_nor2_1_73 \$3759 \$3579 VPWR VGND \$3758 sg13cmos5l_nor2_1
* cell instance sg13cmos5l_nor2_1_74 r0 *1 0,0
Xsg13cmos5l_nor2_1_74 \$471 \$59 VPWR VGND \$413 sg13cmos5l_nor2_1
* cell instance sg13cmos5l_nor2_1_75 r0 *1 0,0
Xsg13cmos5l_nor2_1_75 \$3555 \$3579 VPWR VGND \$3476 sg13cmos5l_nor2_1
* cell instance sg13cmos5l_nor2_1_76 r0 *1 0,0
Xsg13cmos5l_nor2_1_76 \$162 \$457 VPWR VGND \$1200 sg13cmos5l_nor2_1
* cell instance sg13cmos5l_nor2_1_77 r0 *1 0,0
Xsg13cmos5l_nor2_1_77 \$1992 \$3156 VPWR VGND \$3065 sg13cmos5l_nor2_1
* cell instance sg13cmos5l_nor2_1_78 r0 *1 0,0
Xsg13cmos5l_nor2_1_78 \$360 \$511 VPWR VGND \$451 sg13cmos5l_nor2_1
* cell instance sg13cmos5l_nor2_1_79 r0 *1 0,0
Xsg13cmos5l_nor2_1_79 \$2177 \$3202 VPWR VGND \$3217 sg13cmos5l_nor2_1
* cell instance sg13cmos5l_nor2_1_80 r0 *1 0,0
Xsg13cmos5l_nor2_1_80 \$310 \$154 VPWR VGND \$360 sg13cmos5l_nor2_1
* cell instance sg13cmos5l_nor2_1_81 r0 *1 0,0
Xsg13cmos5l_nor2_1_81 \$54 \$145 VPWR VGND \$259 sg13cmos5l_nor2_1
* cell instance sg13cmos5l_nor2_1_82 r0 *1 0,0
Xsg13cmos5l_nor2_1_82 \$65 \$344 VPWR VGND \$414 sg13cmos5l_nor2_1
* cell instance sg13cmos5l_nor2_1_83 r0 *1 0,0
Xsg13cmos5l_nor2_1_83 \$2335 \$2458 VPWR VGND \$2752 sg13cmos5l_nor2_1
* cell instance sg13cmos5l_nor2_1_84 r0 *1 0,0
Xsg13cmos5l_nor2_1_84 \$669 \$414 VPWR VGND \$633 sg13cmos5l_nor2_1
* cell instance sg13cmos5l_nor2_1_85 r0 *1 0,0
Xsg13cmos5l_nor2_1_85 \$915 \$1085 VPWR VGND \$1081 sg13cmos5l_nor2_1
* cell instance sg13cmos5l_nor2_1_86 r0 *1 0,0
Xsg13cmos5l_nor2_1_86 \$151 \$159 VPWR VGND \$566 sg13cmos5l_nor2_1
* cell instance sg13cmos5l_nor2_1_87 r0 *1 0,0
Xsg13cmos5l_nor2_1_87 \$69 \$59 VPWR VGND \$260 sg13cmos5l_nor2_1
* cell instance sg13cmos5l_nor2_1_88 r0 *1 0,0
Xsg13cmos5l_nor2_1_88 \$290 \$622 VPWR VGND \$634 sg13cmos5l_nor2_1
* cell instance sg13cmos5l_nor2_1_89 r0 *1 0,0
Xsg13cmos5l_nor2_1_89 \$152 \$144 VPWR VGND \$160 sg13cmos5l_nor2_1
* cell instance sg13cmos5l_nor2_1_90 r0 *1 0,0
Xsg13cmos5l_nor2_1_90 \$59 \$261 VPWR VGND \$465 sg13cmos5l_nor2_1
* cell instance sg13cmos5l_nor2_1_91 r0 *1 0,0
Xsg13cmos5l_nor2_1_91 \$3156 \$3002 VPWR VGND \$3220 sg13cmos5l_nor2_1
* cell instance sg13cmos5l_nor2_1_92 r0 *1 0,0
Xsg13cmos5l_nor2_1_92 \$3555 \$3491 VPWR VGND \$3490 sg13cmos5l_nor2_1
* cell instance sg13cmos5l_nor2_1_93 r0 *1 0,0
Xsg13cmos5l_nor2_1_93 \$3218 \$2068 VPWR VGND \$3292 sg13cmos5l_nor2_1
* cell instance sg13cmos5l_nor2_1_94 r0 *1 0,0
Xsg13cmos5l_nor2_1_94 \$151 \$69 VPWR VGND \$72 sg13cmos5l_nor2_1
* cell instance sg13cmos5l_nor2_1_95 r0 *1 0,0
Xsg13cmos5l_nor2_1_95 \$52 \$367 VPWR VGND \$369 sg13cmos5l_nor2_1
* cell instance sg13cmos5l_nor2_1_96 r0 *1 0,0
Xsg13cmos5l_nor2_1_96 \$166 \$16 VPWR VGND \$76 sg13cmos5l_nor2_1
* cell instance sg13cmos5l_nor2_1_97 r0 *1 0,0
Xsg13cmos5l_nor2_1_97 \$315 \$1328 VPWR VGND \$1326 sg13cmos5l_nor2_1
* cell instance sg13cmos5l_nor2_1_98 r0 *1 0,0
Xsg13cmos5l_nor2_1_98 \$210 \$57 VPWR VGND \$209 sg13cmos5l_nor2_1
* cell instance sg13cmos5l_nor2_1_99 r0 *1 0,0
Xsg13cmos5l_nor2_1_99 \$151 \$210 VPWR VGND \$531 sg13cmos5l_nor2_1
* cell instance sg13cmos5l_nor2_1_100 r0 *1 0,0
Xsg13cmos5l_nor2_1_100 \$3961 \$3772 VPWR VGND \$3960 sg13cmos5l_nor2_1
* cell instance sg13cmos5l_nor2_1_101 r0 *1 0,0
Xsg13cmos5l_nor2_1_101 \$90 \$612 VPWR VGND \$636 sg13cmos5l_nor2_1
* cell instance sg13cmos5l_nor2_1_102 r0 *1 0,0
Xsg13cmos5l_nor2_1_102 \$3612 \$3772 VPWR VGND \$3773 sg13cmos5l_nor2_1
* cell instance sg13cmos5l_nor2_1_103 r0 *1 0,0
Xsg13cmos5l_nor2_1_103 \$302 \$59 VPWR VGND \$372 sg13cmos5l_nor2_1
* cell instance sg13cmos5l_nor2_1_104 r0 *1 0,0
Xsg13cmos5l_nor2_1_104 \$2335 \$2332 VPWR VGND \$3085 sg13cmos5l_nor2_1
* cell instance sg13cmos5l_nor2_1_105 r0 *1 0,0
Xsg13cmos5l_nor2_1_105 \$2333 \$2125 VPWR VGND \$2489 sg13cmos5l_nor2_1
* cell instance sg13cmos5l_nor2_1_106 r0 *1 0,0
Xsg13cmos5l_nor2_1_106 \$387 \$641 VPWR VGND \$640 sg13cmos5l_nor2_1
* cell instance sg13cmos5l_nor2_1_107 r0 *1 0,0
Xsg13cmos5l_nor2_1_107 \$90 \$268 VPWR VGND \$378 sg13cmos5l_nor2_1
* cell instance sg13cmos5l_nor2_1_108 r0 *1 0,0
Xsg13cmos5l_nor2_1_108 \$1880 \$2189 VPWR VGND \$2191 sg13cmos5l_nor2_1
* cell instance sg13cmos5l_nor2_1_109 r0 *1 0,0
Xsg13cmos5l_nor2_1_109 \$3491 \$3350 VPWR VGND \$4197 sg13cmos5l_nor2_1
* cell instance sg13cmos5l_nor2_1_110 r0 *1 0,0
Xsg13cmos5l_nor2_1_110 \$52 \$26 VPWR VGND \$35 sg13cmos5l_nor2_1
* cell instance sg13cmos5l_nor2_1_111 r0 *1 0,0
Xsg13cmos5l_nor2_1_111 \$669 \$690 VPWR VGND \$757 sg13cmos5l_nor2_1
* cell instance sg13cmos5l_nor2_1_112 r0 *1 0,0
Xsg13cmos5l_nor2_1_112 \$107 \$1102 VPWR VGND \$923 sg13cmos5l_nor2_1
* cell instance sg13cmos5l_nor2_1_113 r0 *1 0,0
Xsg13cmos5l_nor2_1_113 \$2265 \$2332 VPWR VGND \$2781 sg13cmos5l_nor2_1
* cell instance sg13cmos5l_nor2_1_114 r0 *1 0,0
Xsg13cmos5l_nor2_1_114 \$2333 \$2492 VPWR VGND \$3084 sg13cmos5l_nor2_1
* cell instance sg13cmos5l_nor2_1_115 r0 *1 0,0
Xsg13cmos5l_nor2_1_115 \$3521 \$3098 VPWR VGND \$3797 sg13cmos5l_nor2_1
* cell instance sg13cmos5l_nor2_1_116 r0 *1 0,0
Xsg13cmos5l_nor2_1_116 \$107 \$171 VPWR VGND \$167 sg13cmos5l_nor2_1
* cell instance sg13cmos5l_nor2_1_117 r0 *1 0,0
Xsg13cmos5l_nor2_1_117 \$3299 \$2063 VPWR VGND \$2064 sg13cmos5l_nor2_1
* cell instance sg13cmos5l_nor2_1_118 r0 *1 0,0
Xsg13cmos5l_nor2_1_118 \$498 \$7 VPWR VGND \$482 sg13cmos5l_nor2_1
* cell instance sg13cmos5l_nor2_1_119 r0 *1 0,0
Xsg13cmos5l_nor2_1_119 \$756 \$70 VPWR VGND \$873 sg13cmos5l_nor2_1
* cell instance sg13cmos5l_nor2_1_120 r0 *1 0,0
Xsg13cmos5l_nor2_1_120 \$1001 \$1205 VPWR VGND \$576 sg13cmos5l_nor2_1
* cell instance sg13cmos5l_nor2_1_121 r0 *1 0,0
Xsg13cmos5l_nor2_1_121 \$172 \$96 VPWR VGND \$216 sg13cmos5l_nor2_1
* cell instance sg13cmos5l_nor2_1_122 r0 *1 0,0
Xsg13cmos5l_nor2_1_122 \$3505 \$3368 VPWR VGND \$3502 sg13cmos5l_nor2_1
* cell instance sg13cmos5l_nor2_1_123 r0 *1 0,0
Xsg13cmos5l_nor2_1_123 \$383 \$299 VPWR VGND \$382 sg13cmos5l_nor2_1
* cell instance sg13cmos5l_nor2_1_124 r0 *1 0,0
Xsg13cmos5l_nor2_1_124 \$100 \$383 VPWR VGND \$377 sg13cmos5l_nor2_1
* cell instance sg13cmos5l_nor2_1_125 r0 *1 0,0
Xsg13cmos5l_nor2_1_125 \$2619 \$3098 VPWR VGND \$3368 sg13cmos5l_nor2_1
* cell instance sg13cmos5l_nor2_1_126 r0 *1 0,0
Xsg13cmos5l_nor2_1_126 \$2492 \$2332 VPWR VGND \$2494 sg13cmos5l_nor2_1
* cell instance sg13cmos5l_nor2_1_127 r0 *1 0,0
Xsg13cmos5l_nor2_1_127 \$1897 \$2125 VPWR VGND \$2067 sg13cmos5l_nor2_1
* cell instance sg13cmos5l_nor2_1_128 r0 *1 0,0
Xsg13cmos5l_nor2_1_128 \$326 \$874 VPWR VGND \$587 sg13cmos5l_nor2_1
* cell instance sg13cmos5l_nor2_1_129 r0 *1 0,0
Xsg13cmos5l_nor2_1_129 \$589 \$997 VPWR VGND \$996 sg13cmos5l_nor2_1
* cell instance sg13cmos5l_nor2_1_130 r0 *1 0,0
Xsg13cmos5l_nor2_1_130 \$2197 \$2332 VPWR VGND \$2346 sg13cmos5l_nor2_1
* cell instance sg13cmos5l_nor2_1_131 r0 *1 0,0
Xsg13cmos5l_nor2_1_131 \$11 \$187 VPWR VGND \$180 sg13cmos5l_nor2_1
* cell instance sg13cmos5l_nor2_1_132 r0 *1 0,0
Xsg13cmos5l_nor2_1_132 \$804 \$27 VPWR VGND \$874 sg13cmos5l_nor2_1
* cell instance sg13cmos5l_nor2_1_133 r0 *1 0,0
Xsg13cmos5l_nor2_1_133 \$3103 \$3506 VPWR VGND \$3504 sg13cmos5l_nor2_1
* cell instance sg13cmos5l_nor2_1_134 r0 *1 0,0
Xsg13cmos5l_nor2_1_134 \$12 \$25 VPWR VGND \$425 sg13cmos5l_nor2_1
* cell instance sg13cmos5l_nor2_1_135 r0 *1 0,0
Xsg13cmos5l_nor2_1_135 \$2717 \$2785 VPWR VGND \$3506 sg13cmos5l_nor2_1
* cell instance sg13cmos5l_nor2_1_136 r0 *1 0,0
Xsg13cmos5l_nor2_1_136 \$426 \$491 VPWR VGND \$490 sg13cmos5l_nor2_1
* cell instance sg13cmos5l_nor2_1_137 r0 *1 0,0
Xsg13cmos5l_nor2_1_137 \$185 \$100 VPWR VGND \$700 sg13cmos5l_nor2_1
* cell instance sg13cmos5l_nor2_1_138 r0 *1 0,0
Xsg13cmos5l_nor2_1_138 \$78 \$176 VPWR VGND \$752 sg13cmos5l_nor2_1
* cell instance sg13cmos5l_nor2_1_139 r0 *1 0,0
Xsg13cmos5l_nor2_1_139 \$1283 \$1201 VPWR VGND \$1723 sg13cmos5l_nor2_1
* cell instance sg13cmos5l_nor2_1_140 r0 *1 0,0
Xsg13cmos5l_nor2_1_140 \$2569 \$2669 VPWR VGND \$3508 sg13cmos5l_nor2_1
* cell instance sg13cmos5l_nor2_1_141 r0 *1 0,0
Xsg13cmos5l_nor2_1_141 \$756 \$284 VPWR VGND \$703 sg13cmos5l_nor2_1
* cell instance sg13cmos5l_nor2_1_142 r0 *1 0,0
Xsg13cmos5l_nor2_1_142 \$592 \$596 VPWR VGND \$597 sg13cmos5l_nor2_1
* cell instance sg13cmos5l_nor2_1_143 r0 *1 0,0
Xsg13cmos5l_nor2_1_143 \$393 \$274 VPWR VGND \$346 sg13cmos5l_nor2_1
* cell instance sg13cmos5l_nor2_1_144 r0 *1 0,0
Xsg13cmos5l_nor2_1_144 \$182 \$457 VPWR VGND \$223 sg13cmos5l_nor2_1
* cell instance sg13cmos5l_nor2_1_145 r0 *1 0,0
Xsg13cmos5l_nor2_1_145 \$504 \$100 VPWR VGND \$707 sg13cmos5l_nor2_1
* cell instance sg13cmos5l_nor2_1_146 r0 *1 0,0
Xsg13cmos5l_nor2_1_146 \$1725 \$1724 VPWR VGND \$1534 sg13cmos5l_nor2_1
* cell instance sg13cmos5l_nor2_1_147 r0 *1 0,0
Xsg13cmos5l_nor2_1_147 \$2082 \$1724 VPWR VGND \$2081 sg13cmos5l_nor2_1
* cell instance sg13cmos5l_nor2_1_148 r0 *1 0,0
Xsg13cmos5l_nor2_1_148 \$4224 \$2669 VPWR VGND \$3510 sg13cmos5l_nor2_1
* cell instance sg13cmos5l_nor2_1_149 r0 *1 0,0
Xsg13cmos5l_nor2_1_149 \$3632 \$3772 VPWR VGND \$3631 sg13cmos5l_nor2_1
* cell instance sg13cmos5l_nor2_1_150 r0 *1 0,0
Xsg13cmos5l_nor2_1_150 \$3371 \$3516 VPWR VGND \$3634 sg13cmos5l_nor2_1
* cell instance sg13cmos5l_nor2_1_151 r0 *1 0,0
Xsg13cmos5l_nor2_1_151 \$182 \$78 VPWR VGND \$93 sg13cmos5l_nor2_1
* cell instance sg13cmos5l_nor2_1_152 r0 *1 0,0
Xsg13cmos5l_nor2_1_152 \$185 \$188 VPWR VGND \$34 sg13cmos5l_nor2_1
* cell instance sg13cmos5l_nor2_1_153 r0 *1 0,0
Xsg13cmos5l_nor2_1_153 \$12 \$115 VPWR VGND \$126 sg13cmos5l_nor2_1
* cell instance sg13cmos5l_nor2_1_154 r0 *1 0,0
Xsg13cmos5l_nor2_1_154 \$3 \$188 VPWR VGND \$302 sg13cmos5l_nor2_1
* cell instance sg13cmos5l_nor2_1_155 r0 *1 0,0
Xsg13cmos5l_nor2_1_155 \$12 \$5 VPWR VGND \$999 sg13cmos5l_nor2_1
* cell instance sg13cmos5l_nor2_1_156 r0 *1 0,0
Xsg13cmos5l_nor2_1_156 \$115 \$57 VPWR VGND \$86 sg13cmos5l_nor2_1
* cell instance sg13cmos5l_nor2_1_157 r0 *1 0,0
Xsg13cmos5l_nor2_1_157 \$86 \$608 VPWR VGND \$712 sg13cmos5l_nor2_1
* cell instance sg13cmos5l_nor2_1_158 r0 *1 0,0
Xsg13cmos5l_nor2_1_158 \$2788 \$2942 VPWR VGND \$3371 sg13cmos5l_nor2_1
* cell instance sg13cmos5l_nor2_1_159 r0 *1 0,0
Xsg13cmos5l_nor2_1_159 \$2795 \$2659 VPWR VGND \$2796 sg13cmos5l_nor2_1
* cell instance sg13cmos5l_nor2_1_160 r0 *1 0,0
Xsg13cmos5l_nor2_1_160 \$4675 \$3772 VPWR VGND \$4247 sg13cmos5l_nor2_1
* cell instance sg13cmos5l_nor2_1_161 r0 *1 0,0
Xsg13cmos5l_nor2_1_161 \$11 \$302 VPWR VGND \$300 sg13cmos5l_nor2_1
* cell instance sg13cmos5l_nor2_1_162 r0 *1 0,0
Xsg13cmos5l_nor2_1_162 \$2426 \$3114 VPWR VGND \$3164 sg13cmos5l_nor2_1
* cell instance sg13cmos5l_nor2_1_163 r0 *1 0,0
Xsg13cmos5l_nor2_1_163 \$609 \$236 VPWR VGND \$560 sg13cmos5l_nor2_1
* cell instance sg13cmos5l_nor2_1_164 r0 *1 0,0
Xsg13cmos5l_nor2_1_164 \$326 \$176 VPWR VGND \$660 sg13cmos5l_nor2_1
* cell instance sg13cmos5l_nor2_1_165 r0 *1 0,0
Xsg13cmos5l_nor2_1_165 \$1566 \$1739 VPWR VGND \$2568 sg13cmos5l_nor2_1
* cell instance sg13cmos5l_nor2_1_166 r0 *1 0,0
Xsg13cmos5l_nor2_1_166 \$1920 \$1811 VPWR VGND \$3117 sg13cmos5l_nor2_1
* cell instance sg13cmos5l_nor2_1_167 r0 *1 0,0
Xsg13cmos5l_nor2_1_167 \$3532 \$3529 VPWR VGND \$3531 sg13cmos5l_nor2_1
* cell instance sg13cmos5l_nor2_1_168 r0 *1 0,0
Xsg13cmos5l_nor2_1_168 \$1743 \$1538 VPWR VGND \$2096 sg13cmos5l_nor2_1
* cell instance sg13cmos5l_nor2_1_169 r0 *1 0,0
Xsg13cmos5l_nor2_1_169 \$1748 \$1538 VPWR VGND \$2106 sg13cmos5l_nor2_1
* cell instance sg13cmos5l_nor2_1_170 r0 *1 0,0
Xsg13cmos5l_nor2_1_170 \$1566 \$1357 VPWR VGND \$1635 sg13cmos5l_nor2_1
* cell instance sg13cmos5l_nor2_1_171 r0 *1 0,0
Xsg13cmos5l_nor2_1_171 \$1748 \$1740 VPWR VGND \$2219 sg13cmos5l_nor2_1
* cell instance sg13cmos5l_nor2_1_172 r0 *1 0,0
Xsg13cmos5l_nor2_1_172 \$1743 \$1740 VPWR VGND \$2099 sg13cmos5l_nor2_1
* cell instance sg13cmos5l_nor2_1_173 r0 *1 0,0
Xsg13cmos5l_nor2_1_173 \$1745 \$3124 VPWR VGND \$3262 sg13cmos5l_nor2_1
* cell instance sg13cmos5l_nor2_1_174 r0 *1 0,0
Xsg13cmos5l_nor2_1_174 \$3847 \$3688 VPWR VGND \$3545 sg13cmos5l_nor2_1
* cell instance sg13cmos5l_nor2_1_175 r0 *1 0,0
Xsg13cmos5l_nor2_1_175 \$3544 \$3547 VPWR VGND \$3546 sg13cmos5l_nor2_1
* cell instance sg13cmos5l_nor2_1_176 r0 *1 0,0
Xsg13cmos5l_nor2_1_176 \$3545 \$3546 VPWR VGND \$3548 sg13cmos5l_nor2_1
* cell instance sg13cmos5l_nor2_1_177 r0 *1 0,0
Xsg13cmos5l_nor2_1_177 \$5589 \$3638 VPWR VGND \$5541 sg13cmos5l_nor2_1
* cell instance sg13cmos5l_nor2_1_178 r0 *1 0,0
Xsg13cmos5l_nor2_1_178 \$5834 \$3638 VPWR VGND \$6038 sg13cmos5l_nor2_1
* cell instance sg13cmos5l_nor2b_1_0 r0 *1 0,0
Xsg13cmos5l_nor2b_1_0 \$2599 \$2597 VPWR VGND \$2435 sg13cmos5l_nor2b_1
* cell instance sg13cmos5l_nor2b_1_1 r0 *1 0,0
Xsg13cmos5l_nor2b_1_1 \$4141 \$4592 VPWR VGND \$4593 sg13cmos5l_nor2b_1
* cell instance sg13cmos5l_nor2b_1_2 r0 *1 0,0
Xsg13cmos5l_nor2b_1_2 \$3350 \$3450 VPWR VGND \$7722 sg13cmos5l_nor2b_1
* cell instance sg13cmos5l_nor2b_1_3 r0 *1 0,0
Xsg13cmos5l_nor2b_1_3 \$459 \$464 VPWR VGND \$462 sg13cmos5l_nor2b_1
* cell instance sg13cmos5l_nor2b_1_4 r0 *1 0,0
Xsg13cmos5l_nor2b_1_4 \$595 \$73 VPWR VGND \$71 sg13cmos5l_nor2b_1
* cell instance sg13cmos5l_nor2b_1_5 r0 *1 0,0
Xsg13cmos5l_nor2b_1_5 \$3350 \$3217 VPWR VGND \$3496 sg13cmos5l_nor2b_1
* cell instance sg13cmos5l_nor2b_1_6 r0 *1 0,0
Xsg13cmos5l_nor2b_1_6 \$2335 \$2191 VPWR VGND \$3089 sg13cmos5l_nor2b_1
* cell instance sg13cmos5l_nor2b_1_7 r0 *1 0,0
Xsg13cmos5l_nor2b_1_7 \$2197 \$2191 VPWR VGND \$2345 sg13cmos5l_nor2b_1
* cell instance sg13cmos5l_nor2b_1_8 r0 *1 0,0
Xsg13cmos5l_nor2b_1_8 \$2423 \$2338 VPWR VGND \$2199 sg13cmos5l_nor2b_1
* cell instance sg13cmos5l_nor2b_1_9 r0 *1 0,0
Xsg13cmos5l_nor2b_1_9 \$2717 \$2785 VPWR VGND \$3627 sg13cmos5l_nor2b_1
* cell instance sg13cmos5l_nor2b_1_10 r0 *1 0,0
Xsg13cmos5l_nor2b_1_10 \$820 \$707 VPWR VGND \$656 sg13cmos5l_nor2b_1
* cell instance sg13cmos5l_nor2b_1_11 r0 *1 0,0
Xsg13cmos5l_nor2b_1_11 \$609 \$676 VPWR VGND \$601 sg13cmos5l_nor2b_1
* cell instance sg13cmos5l_nor2b_1_12 r0 *1 0,0
Xsg13cmos5l_nor2b_1_12 \$3830 \$3823 VPWR VGND \$3829 sg13cmos5l_nor2b_1
* cell instance sg13cmos5l_nor2b_1_13 r0 *1 0,0
Xsg13cmos5l_nor2b_1_13 \$2357 \$2351 VPWR VGND \$2518 sg13cmos5l_nor2b_1
* cell instance sg13cmos5l_nor2b_1_14 r0 *1 0,0
Xsg13cmos5l_nor2b_1_14 \$2659 \$2795 VPWR VGND \$2799 sg13cmos5l_nor2b_1
* cell instance sg13cmos5l_nor2b_1_15 r0 *1 0,0
Xsg13cmos5l_nor2b_1_15 \$3841 \$3535 VPWR VGND \$3529 sg13cmos5l_nor2b_1
* cell instance sg13cmos5l_nor2b_1_16 r0 *1 0,0
Xsg13cmos5l_nor2b_1_16 \$3691 \$4059 VPWR VGND \$4522 sg13cmos5l_nor2b_1
* cell instance sg13cmos5l_nor3_1_0 r0 *1 0,0
Xsg13cmos5l_nor3_1_0 \$2270 \$2591 \$1819 VPWR VGND \$2438 sg13cmos5l_nor3_1
* cell instance sg13cmos5l_nor3_1_1 r0 *1 0,0
Xsg13cmos5l_nor3_1_1 \$2598 \$2732 \$3025 VPWR VGND \$2597 sg13cmos5l_nor3_1
* cell instance sg13cmos5l_nor3_1_2 r0 *1 0,0
Xsg13cmos5l_nor3_1_2 \$2439 \$1436 \$2733 VPWR VGND \$2440 sg13cmos5l_nor3_1
* cell instance sg13cmos5l_nor3_1_3 r0 *1 0,0
Xsg13cmos5l_nor3_1_3 \$832 \$831 \$128 VPWR VGND \$85 sg13cmos5l_nor3_1
* cell instance sg13cmos5l_nor3_1_4 r0 *1 0,0
Xsg13cmos5l_nor3_1_4 \$665 \$667 \$616 VPWR VGND \$668 sg13cmos5l_nor3_1
* cell instance sg13cmos5l_nor3_1_5 r0 *1 0,0
Xsg13cmos5l_nor3_1_5 \$2621 \$2851 \$3342 VPWR VGND \$3454 sg13cmos5l_nor3_1
* cell instance sg13cmos5l_nor3_1_6 r0 *1 0,0
Xsg13cmos5l_nor3_1_6 \$2177 \$3196 \$3197 VPWR VGND \$2889 sg13cmos5l_nor3_1
* cell instance sg13cmos5l_nor3_1_7 r0 *1 0,0
Xsg13cmos5l_nor3_1_7 \$2621 \$2458 \$2459 VPWR VGND \$2315 sg13cmos5l_nor3_1
* cell instance sg13cmos5l_nor3_1_8 r0 *1 0,0
Xsg13cmos5l_nor3_1_8 \$240 \$405 \$917 VPWR VGND \$837 sg13cmos5l_nor3_1
* cell instance sg13cmos5l_nor3_1_9 r0 *1 0,0
Xsg13cmos5l_nor3_1_9 \$145 \$1 \$194 VPWR VGND \$195 sg13cmos5l_nor3_1
* cell instance sg13cmos5l_nor3_1_10 r0 *1 0,0
Xsg13cmos5l_nor3_1_10 \$3203 \$2458 \$2459 VPWR VGND \$2033 sg13cmos5l_nor3_1
* cell instance sg13cmos5l_nor3_1_11 r0 *1 0,0
Xsg13cmos5l_nor3_1_11 \$305 \$11 \$32 VPWR VGND \$307 sg13cmos5l_nor3_1
* cell instance sg13cmos5l_nor3_1_12 r0 *1 0,0
Xsg13cmos5l_nor3_1_12 \$1650 \$1643 \$2877 VPWR VGND \$2849 sg13cmos5l_nor3_1
* cell instance sg13cmos5l_nor3_1_13 r0 *1 0,0
Xsg13cmos5l_nor3_1_13 \$3339 \$4155 \$3913 VPWR VGND \$4154 sg13cmos5l_nor3_1
* cell instance sg13cmos5l_nor3_1_14 r0 *1 0,0
Xsg13cmos5l_nor3_1_14 \$525 \$795 \$567 VPWR VGND \$794 sg13cmos5l_nor3_1
* cell instance sg13cmos5l_nor3_1_15 r0 *1 0,0
Xsg13cmos5l_nor3_1_15 \$2464 \$2458 \$2459 VPWR VGND \$2173 sg13cmos5l_nor3_1
* cell instance sg13cmos5l_nor3_1_16 r0 *1 0,0
Xsg13cmos5l_nor3_1_16 \$145 \$154 \$1 VPWR VGND \$357 sg13cmos5l_nor3_1
* cell instance sg13cmos5l_nor3_1_17 r0 *1 0,0
Xsg13cmos5l_nor3_1_17 \$49 \$345 \$32 VPWR VGND \$352 sg13cmos5l_nor3_1
* cell instance sg13cmos5l_nor3_1_18 r0 *1 0,0
Xsg13cmos5l_nor3_1_18 \$256 \$629 \$630 VPWR VGND \$610 sg13cmos5l_nor3_1
* cell instance sg13cmos5l_nor3_1_19 r0 *1 0,0
Xsg13cmos5l_nor3_1_19 \$145 \$631 \$267 VPWR VGND \$630 sg13cmos5l_nor3_1
* cell instance sg13cmos5l_nor3_1_20 r0 *1 0,0
Xsg13cmos5l_nor3_1_20 \$151 \$471 \$867 VPWR VGND \$915 sg13cmos5l_nor3_1
* cell instance sg13cmos5l_nor3_1_21 r0 *1 0,0
Xsg13cmos5l_nor3_1_21 \$50 \$32 \$857 VPWR VGND \$856 sg13cmos5l_nor3_1
* cell instance sg13cmos5l_nor3_1_22 r0 *1 0,0
Xsg13cmos5l_nor3_1_22 \$856 \$465 \$854 VPWR VGND \$855 sg13cmos5l_nor3_1
* cell instance sg13cmos5l_nor3_1_23 r0 *1 0,0
Xsg13cmos5l_nor3_1_23 \$172 \$86 \$264 VPWR VGND \$263 sg13cmos5l_nor3_1
* cell instance sg13cmos5l_nor3_1_24 r0 *1 0,0
Xsg13cmos5l_nor3_1_24 \$147 \$166 \$187 VPWR VGND \$165 sg13cmos5l_nor3_1
* cell instance sg13cmos5l_nor3_1_25 r0 *1 0,0
Xsg13cmos5l_nor3_1_25 \$304 \$498 \$248 VPWR VGND \$469 sg13cmos5l_nor3_1
* cell instance sg13cmos5l_nor3_1_26 r0 *1 0,0
Xsg13cmos5l_nor3_1_26 \$2056 \$1870 \$2055 VPWR VGND \$2054 sg13cmos5l_nor3_1
* cell instance sg13cmos5l_nor3_1_27 r0 *1 0,0
Xsg13cmos5l_nor3_1_27 \$2335 \$2332 \$3360 VPWR VGND \$3359 sg13cmos5l_nor3_1
* cell instance sg13cmos5l_nor3_1_28 r0 *1 0,0
Xsg13cmos5l_nor3_1_28 \$918 \$919 \$889 VPWR VGND \$916 sg13cmos5l_nor3_1
* cell instance sg13cmos5l_nor3_1_29 r0 *1 0,0
Xsg13cmos5l_nor3_1_29 \$2639 \$2202 \$2489 VPWR VGND \$2500 sg13cmos5l_nor3_1
* cell instance sg13cmos5l_nor3_1_30 r0 *1 0,0
Xsg13cmos5l_nor3_1_30 \$3361 \$3095 \$3359 VPWR VGND \$3362 sg13cmos5l_nor3_1
* cell instance sg13cmos5l_nor3_1_31 r0 *1 0,0
Xsg13cmos5l_nor3_1_31 \$756 \$299 \$290 VPWR VGND \$889 sg13cmos5l_nor3_1
* cell instance sg13cmos5l_nor3_1_32 r0 *1 0,0
Xsg13cmos5l_nor3_1_32 \$4567 \$4197 \$3616 VPWR VGND \$4408 sg13cmos5l_nor3_1
* cell instance sg13cmos5l_nor3_1_33 r0 *1 0,0
Xsg13cmos5l_nor3_1_33 \$489 \$686 \$1337 VPWR VGND \$1336 sg13cmos5l_nor3_1
* cell instance sg13cmos5l_nor3_1_34 r0 *1 0,0
Xsg13cmos5l_nor3_1_34 \$804 \$580 \$52 VPWR VGND \$581 sg13cmos5l_nor3_1
* cell instance sg13cmos5l_nor3_1_35 r0 *1 0,0
Xsg13cmos5l_nor3_1_35 \$2333 \$2068 \$2265 VPWR VGND \$2493 sg13cmos5l_nor3_1
* cell instance sg13cmos5l_nor3_1_36 r0 *1 0,0
Xsg13cmos5l_nor3_1_36 \$2333 \$1633 \$2265 VPWR VGND \$2501 sg13cmos5l_nor3_1
* cell instance sg13cmos5l_nor3_1_37 r0 *1 0,0
Xsg13cmos5l_nor3_1_37 \$542 \$70 \$285 VPWR VGND \$643 sg13cmos5l_nor3_1
* cell instance sg13cmos5l_nor3_1_38 r0 *1 0,0
Xsg13cmos5l_nor3_1_38 \$1701 \$2064 \$2065 VPWR VGND \$2090 sg13cmos5l_nor3_1
* cell instance sg13cmos5l_nor3_1_39 r0 *1 0,0
Xsg13cmos5l_nor3_1_39 \$91 \$210 \$188 VPWR VGND \$213 sg13cmos5l_nor3_1
* cell instance sg13cmos5l_nor3_1_40 r0 *1 0,0
Xsg13cmos5l_nor3_1_40 \$326 \$383 \$299 VPWR VGND \$424 sg13cmos5l_nor3_1
* cell instance sg13cmos5l_nor3_1_41 r0 *1 0,0
Xsg13cmos5l_nor3_1_41 \$2198 \$2199 \$2200 VPWR VGND \$2076 sg13cmos5l_nor3_1
* cell instance sg13cmos5l_nor3_1_42 r0 *1 0,0
Xsg13cmos5l_nor3_1_42 \$7 \$425 \$383 VPWR VGND \$426 sg13cmos5l_nor3_1
* cell instance sg13cmos5l_nor3_1_43 r0 *1 0,0
Xsg13cmos5l_nor3_1_43 \$90 \$329 \$383 VPWR VGND \$390 sg13cmos5l_nor3_1
* cell instance sg13cmos5l_nor3_1_44 r0 *1 0,0
Xsg13cmos5l_nor3_1_44 \$811 \$346 \$226 VPWR VGND \$394 sg13cmos5l_nor3_1
* cell instance sg13cmos5l_nor3_1_45 r0 *1 0,0
Xsg13cmos5l_nor3_1_45 \$542 \$654 \$656 VPWR VGND \$598 sg13cmos5l_nor3_1
* cell instance sg13cmos5l_nor3_1_46 r0 *1 0,0
Xsg13cmos5l_nor3_1_46 \$489 \$599 \$598 VPWR VGND \$550 sg13cmos5l_nor3_1
* cell instance sg13cmos5l_nor3_1_47 r0 *1 0,0
Xsg13cmos5l_nor3_1_47 \$3633 \$3634 \$3110 VPWR VGND \$3515 sg13cmos5l_nor3_1
* cell instance sg13cmos5l_nor3_1_48 r0 *1 0,0
Xsg13cmos5l_nor3_1_48 \$589 \$600 \$601 VPWR VGND \$599 sg13cmos5l_nor3_1
* cell instance sg13cmos5l_nor3_1_49 r0 *1 0,0
Xsg13cmos5l_nor3_1_49 \$922 \$591 \$7 VPWR VGND \$609 sg13cmos5l_nor3_1
* cell instance sg13cmos5l_nor3_1_50 r0 *1 0,0
Xsg13cmos5l_nor3_1_50 \$4028 \$3841 \$3846 VPWR VGND \$4052 sg13cmos5l_nor3_1
* cell instance sg13cmos5l_nor3_1_51 r0 *1 0,0
Xsg13cmos5l_nor3_1_51 \$3691 \$3690 \$4052 VPWR VGND \$3689 sg13cmos5l_nor3_1
* cell instance sg13cmos5l_nor4_1_0 r0 *1 0,0
Xsg13cmos5l_nor4_1_0 \$2732 \$3022 \$2731 \$2600 VPWR VGND \$2733
+ sg13cmos5l_nor4_1
* cell instance sg13cmos5l_nor4_1_1 r0 *1 0,0
Xsg13cmos5l_nor4_1_1 \$1643 \$2877 \$1837 \$2741 VPWR VGND \$2865
+ sg13cmos5l_nor4_1
* cell instance sg13cmos5l_nor4_1_2 r0 *1 0,0
Xsg13cmos5l_nor4_1_2 \$2155 \$2151 \$2017 \$2000 VPWR VGND \$2161
+ sg13cmos5l_nor4_1
* cell instance sg13cmos5l_nor4_1_3 r0 *1 0,0
Xsg13cmos5l_nor4_1_3 \$669 \$722 \$620 \$723 VPWR VGND \$720 sg13cmos5l_nor4_1
* cell instance sg13cmos5l_nor4_1_4 r0 *1 0,0
Xsg13cmos5l_nor4_1_4 \$669 \$722 \$829 \$837 VPWR VGND \$838 sg13cmos5l_nor4_1
* cell instance sg13cmos5l_nor4_1_5 r0 *1 0,0
Xsg13cmos5l_nor4_1_5 \$2177 \$2319 \$2464 \$3449 VPWR VGND \$3345
+ sg13cmos5l_nor4_1
* cell instance sg13cmos5l_nor4_1_6 r0 *1 0,0
Xsg13cmos5l_nor4_1_6 \$354 \$195 \$352 \$307 VPWR VGND \$351 sg13cmos5l_nor4_1
* cell instance sg13cmos5l_nor4_1_7 r0 *1 0,0
Xsg13cmos5l_nor4_1_7 \$2739 \$3203 \$3156 \$3209 VPWR VGND \$3210
+ sg13cmos5l_nor4_1
* cell instance sg13cmos5l_nor4_1_8 r0 *1 0,0
Xsg13cmos5l_nor4_1_8 \$240 \$352 \$413 \$357 VPWR VGND \$412 sg13cmos5l_nor4_1
* cell instance sg13cmos5l_nor4_1_9 r0 *1 0,0
Xsg13cmos5l_nor4_1_9 \$2177 \$3202 \$3299 \$3216 VPWR VGND \$3215
+ sg13cmos5l_nor4_1
* cell instance sg13cmos5l_nor4_1_10 r0 *1 0,0
Xsg13cmos5l_nor4_1_10 \$1283 \$1201 \$1969 \$1724 VPWR VGND \$2758
+ sg13cmos5l_nor4_1
* cell instance sg13cmos5l_nor4_1_11 r0 *1 0,0
Xsg13cmos5l_nor4_1_11 \$2056 \$1870 \$2057 \$2055 VPWR VGND \$2330
+ sg13cmos5l_nor4_1
* cell instance sg13cmos5l_nor4_1_12 r0 *1 0,0
Xsg13cmos5l_nor4_1_12 \$147 \$151 \$3 \$186 VPWR VGND \$264 sg13cmos5l_nor4_1
* cell instance sg13cmos5l_nor4_1_13 r0 *1 0,0
Xsg13cmos5l_nor4_1_13 \$78 \$76 \$75 \$79 VPWR VGND \$80 sg13cmos5l_nor4_1
* cell instance sg13cmos5l_nor4_1_14 r0 *1 0,0
Xsg13cmos5l_nor4_1_14 \$3083 \$3226 \$3227 \$3107 VPWR VGND \$3082
+ sg13cmos5l_nor4_1
* cell instance sg13cmos5l_nor4_1_15 r0 *1 0,0
Xsg13cmos5l_nor4_1_15 \$2056 \$2189 \$1897 \$2055 VPWR VGND \$2331
+ sg13cmos5l_nor4_1
* cell instance sg13cmos5l_nor4_1_16 r0 *1 0,0
Xsg13cmos5l_nor4_1_16 \$35 \$83 \$80 \$81 VPWR VGND \$82 sg13cmos5l_nor4_1
* cell instance sg13cmos5l_nor4_1_17 r0 *1 0,0
Xsg13cmos5l_nor4_1_17 \$3159 \$3163 \$3229 \$3228 VPWR VGND \$3226
+ sg13cmos5l_nor4_1
* cell instance sg13cmos5l_nor4_1_18 r0 *1 0,0
Xsg13cmos5l_nor4_1_18 \$2337 \$2779 \$2932 \$3364 VPWR VGND \$3363
+ sg13cmos5l_nor4_1
* cell instance sg13cmos5l_nor4_1_19 r0 *1 0,0
Xsg13cmos5l_nor4_1_19 \$27 \$811 \$268 \$32 VPWR VGND \$869 sg13cmos5l_nor4_1
* cell instance sg13cmos5l_nor4_1_20 r0 *1 0,0
Xsg13cmos5l_nor4_1_20 \$3504 \$3502 \$3099 \$3503 VPWR VGND \$3365
+ sg13cmos5l_nor4_1
* cell instance sg13cmos5l_nor4_1_21 r0 *1 0,0
Xsg13cmos5l_nor4_1_21 \$697 \$210 \$330 \$425 VPWR VGND \$695 sg13cmos5l_nor4_1
* cell instance sg13cmos5l_nor4_1_22 r0 *1 0,0
Xsg13cmos5l_nor4_1_22 \$289 \$485 \$424 \$486 VPWR VGND \$487 sg13cmos5l_nor4_1
* cell instance sg13cmos5l_nor4_1_23 r0 *1 0,0
Xsg13cmos5l_nor4_1_23 \$3234 \$3233 \$3231 \$2774 VPWR VGND \$3232
+ sg13cmos5l_nor4_1
* cell instance sg13cmos5l_nor4_1_24 r0 *1 0,0
Xsg13cmos5l_nor4_1_24 \$2797 \$3108 \$3104 \$2655 VPWR VGND \$3107
+ sg13cmos5l_nor4_1
* cell instance sg13cmos5l_nor4_1_25 r0 *1 0,0
Xsg13cmos5l_nor4_1_25 \$3691 \$3690 \$4028 \$3841 VPWR VGND \$3688
+ sg13cmos5l_nor4_1
* cell instance sg13cmos5l_o21ai_1_0 r0 *1 0,0
Xsg13cmos5l_o21ai_1_0 \$5905 \$5698 \$5904 VPWR VGND \$5863 sg13cmos5l_o21ai_1
* cell instance sg13cmos5l_o21ai_1_1 r0 *1 0,0
Xsg13cmos5l_o21ai_1_1 \$4592 \$5237 \$5235 VPWR VGND \$5482 sg13cmos5l_o21ai_1
* cell instance sg13cmos5l_o21ai_1_2 r0 *1 0,0
Xsg13cmos5l_o21ai_1_2 \$5905 \$6356 \$6559 VPWR VGND \$6495 sg13cmos5l_o21ai_1
* cell instance sg13cmos5l_o21ai_1_3 r0 *1 0,0
Xsg13cmos5l_o21ai_1_3 \$5905 \$6959 \$7308 VPWR VGND \$7612 sg13cmos5l_o21ai_1
* cell instance sg13cmos5l_o21ai_1_4 r0 *1 0,0
Xsg13cmos5l_o21ai_1_4 \$5905 \$7009 \$7306 VPWR VGND \$7259 sg13cmos5l_o21ai_1
* cell instance sg13cmos5l_o21ai_1_5 r0 *1 0,0
Xsg13cmos5l_o21ai_1_5 \$5905 \$6963 \$7199 VPWR VGND \$7315 sg13cmos5l_o21ai_1
* cell instance sg13cmos5l_o21ai_1_6 r0 *1 0,0
Xsg13cmos5l_o21ai_1_6 \$1833 \$2000 \$2001 VPWR VGND \$1815 sg13cmos5l_o21ai_1
* cell instance sg13cmos5l_o21ai_1_7 r0 *1 0,0
Xsg13cmos5l_o21ai_1_7 \$1833 \$1180 \$2436 VPWR VGND \$2437 sg13cmos5l_o21ai_1
* cell instance sg13cmos5l_o21ai_1_8 r0 *1 0,0
Xsg13cmos5l_o21ai_1_8 \$7009 \$7011 \$4406 VPWR VGND \$6701 sg13cmos5l_o21ai_1
* cell instance sg13cmos5l_o21ai_1_9 r0 *1 0,0
Xsg13cmos5l_o21ai_1_9 \$3883 \$3521 \$4578 VPWR VGND \$4577 sg13cmos5l_o21ai_1
* cell instance sg13cmos5l_o21ai_1_10 r0 *1 0,0
Xsg13cmos5l_o21ai_1_10 \$5905 \$5702 \$7316 VPWR VGND \$7885 sg13cmos5l_o21ai_1
* cell instance sg13cmos5l_o21ai_1_11 r0 *1 0,0
Xsg13cmos5l_o21ai_1_11 \$3521 \$11737 \$11738 VPWR VGND \$11896
+ sg13cmos5l_o21ai_1
* cell instance sg13cmos5l_o21ai_1_12 r0 *1 0,0
Xsg13cmos5l_o21ai_1_12 \$2446 \$14111 \$14261 VPWR VGND \$14177
+ sg13cmos5l_o21ai_1
* cell instance sg13cmos5l_o21ai_1_13 r0 *1 0,0
Xsg13cmos5l_o21ai_1_13 \$2598 \$3423 \$2604 VPWR VGND \$3317 sg13cmos5l_o21ai_1
* cell instance sg13cmos5l_o21ai_1_14 r0 *1 0,0
Xsg13cmos5l_o21ai_1_14 \$2598 \$2732 \$3025 VPWR VGND \$3026 sg13cmos5l_o21ai_1
* cell instance sg13cmos5l_o21ai_1_15 r0 *1 0,0
Xsg13cmos5l_o21ai_1_15 \$2604 \$3197 \$3177 VPWR VGND \$3170 sg13cmos5l_o21ai_1
* cell instance sg13cmos5l_o21ai_1_16 r0 *1 0,0
Xsg13cmos5l_o21ai_1_16 \$3883 \$2446 \$4328 VPWR VGND \$4327 sg13cmos5l_o21ai_1
* cell instance sg13cmos5l_o21ai_1_17 r0 *1 0,0
Xsg13cmos5l_o21ai_1_17 \$3886 \$4224 \$5104 VPWR VGND \$5176 sg13cmos5l_o21ai_1
* cell instance sg13cmos5l_o21ai_1_18 r0 *1 0,0
Xsg13cmos5l_o21ai_1_18 \$2439 \$2435 \$1817 VPWR VGND \$2150 sg13cmos5l_o21ai_1
* cell instance sg13cmos5l_o21ai_1_19 r0 *1 0,0
Xsg13cmos5l_o21ai_1_19 \$5905 \$7540 \$7322 VPWR VGND \$7541 sg13cmos5l_o21ai_1
* cell instance sg13cmos5l_o21ai_1_20 r0 *1 0,0
Xsg13cmos5l_o21ai_1_20 \$4592 \$5586 \$5703 VPWR VGND \$5605 sg13cmos5l_o21ai_1
* cell instance sg13cmos5l_o21ai_1_21 r0 *1 0,0
Xsg13cmos5l_o21ai_1_21 \$899 \$11737 \$11745 VPWR VGND \$12347
+ sg13cmos5l_o21ai_1
* cell instance sg13cmos5l_o21ai_1_22 r0 *1 0,0
Xsg13cmos5l_o21ai_1_22 \$2150 \$2736 \$2737 VPWR VGND \$2846 sg13cmos5l_o21ai_1
* cell instance sg13cmos5l_o21ai_1_23 r0 *1 0,0
Xsg13cmos5l_o21ai_1_23 \$2735 \$3028 \$2599 VPWR VGND \$2734 sg13cmos5l_o21ai_1
* cell instance sg13cmos5l_o21ai_1_24 r0 *1 0,0
Xsg13cmos5l_o21ai_1_24 \$4592 \$7324 \$7327 VPWR VGND \$7543 sg13cmos5l_o21ai_1
* cell instance sg13cmos5l_o21ai_1_25 r0 *1 0,0
Xsg13cmos5l_o21ai_1_25 \$4224 \$11737 \$10874 VPWR VGND \$10696
+ sg13cmos5l_o21ai_1
* cell instance sg13cmos5l_o21ai_1_26 r0 *1 0,0
Xsg13cmos5l_o21ai_1_26 \$3883 \$899 \$5254 VPWR VGND \$5256 sg13cmos5l_o21ai_1
* cell instance sg13cmos5l_o21ai_1_27 r0 *1 0,0
Xsg13cmos5l_o21ai_1_27 \$1833 \$2017 \$1832 VPWR VGND \$1822 sg13cmos5l_o21ai_1
* cell instance sg13cmos5l_o21ai_1_28 r0 *1 0,0
Xsg13cmos5l_o21ai_1_28 \$2446 \$13940 \$13836 VPWR VGND \$13670
+ sg13cmos5l_o21ai_1
* cell instance sg13cmos5l_o21ai_1_29 r0 *1 0,0
Xsg13cmos5l_o21ai_1_29 \$4592 \$6705 \$6779 VPWR VGND \$6708 sg13cmos5l_o21ai_1
* cell instance sg13cmos5l_o21ai_1_30 r0 *1 0,0
Xsg13cmos5l_o21ai_1_30 \$5905 \$6192 \$5876 VPWR VGND \$6373 sg13cmos5l_o21ai_1
* cell instance sg13cmos5l_o21ai_1_31 r0 *1 0,0
Xsg13cmos5l_o21ai_1_31 \$4224 \$10283 \$10284 VPWR VGND \$10177
+ sg13cmos5l_o21ai_1
* cell instance sg13cmos5l_o21ai_1_32 r0 *1 0,0
Xsg13cmos5l_o21ai_1_32 \$3886 \$2176 \$5334 VPWR VGND \$5612 sg13cmos5l_o21ai_1
* cell instance sg13cmos5l_o21ai_1_33 r0 *1 0,0
Xsg13cmos5l_o21ai_1_33 \$2018 \$1835 \$1839 VPWR VGND \$1805 sg13cmos5l_o21ai_1
* cell instance sg13cmos5l_o21ai_1_34 r0 *1 0,0
Xsg13cmos5l_o21ai_1_34 \$2153 \$2319 \$3189 VPWR VGND \$3180 sg13cmos5l_o21ai_1
* cell instance sg13cmos5l_o21ai_1_35 r0 *1 0,0
Xsg13cmos5l_o21ai_1_35 \$1643 \$2877 \$2153 VPWR VGND \$2875 sg13cmos5l_o21ai_1
* cell instance sg13cmos5l_o21ai_1_36 r0 *1 0,0
Xsg13cmos5l_o21ai_1_36 \$3446 \$3436 \$3444 VPWR VGND \$3440 sg13cmos5l_o21ai_1
* cell instance sg13cmos5l_o21ai_1_37 r0 *1 0,0
Xsg13cmos5l_o21ai_1_37 \$2176 \$13940 \$14268 VPWR VGND \$14847
+ sg13cmos5l_o21ai_1
* cell instance sg13cmos5l_o21ai_1_38 r0 *1 0,0
Xsg13cmos5l_o21ai_1_38 \$3904 \$3710 \$3733 VPWR VGND \$3903 sg13cmos5l_o21ai_1
* cell instance sg13cmos5l_o21ai_1_39 r0 *1 0,0
Xsg13cmos5l_o21ai_1_39 \$3521 \$3435 \$3447 VPWR VGND \$3725 sg13cmos5l_o21ai_1
* cell instance sg13cmos5l_o21ai_1_40 r0 *1 0,0
Xsg13cmos5l_o21ai_1_40 \$4592 \$6507 \$6512 VPWR VGND \$6714 sg13cmos5l_o21ai_1
* cell instance sg13cmos5l_o21ai_1_41 r0 *1 0,0
Xsg13cmos5l_o21ai_1_41 \$3904 \$3907 \$3905 VPWR VGND \$3906 sg13cmos5l_o21ai_1
* cell instance sg13cmos5l_o21ai_1_42 r0 *1 0,0
Xsg13cmos5l_o21ai_1_42 \$3521 \$10283 \$10880 VPWR VGND \$10698
+ sg13cmos5l_o21ai_1
* cell instance sg13cmos5l_o21ai_1_43 r0 *1 0,0
Xsg13cmos5l_o21ai_1_43 \$899 \$10283 \$11900 VPWR VGND \$11735
+ sg13cmos5l_o21ai_1
* cell instance sg13cmos5l_o21ai_1_44 r0 *1 0,0
Xsg13cmos5l_o21ai_1_44 \$1299 \$1287 \$1300 VPWR VGND \$831 sg13cmos5l_o21ai_1
* cell instance sg13cmos5l_o21ai_1_45 r0 *1 0,0
Xsg13cmos5l_o21ai_1_45 \$4567 \$1658 \$5198 VPWR VGND \$5199 sg13cmos5l_o21ai_1
* cell instance sg13cmos5l_o21ai_1_46 r0 *1 0,0
Xsg13cmos5l_o21ai_1_46 \$1650 \$1844 \$1845 VPWR VGND \$1301 sg13cmos5l_o21ai_1
* cell instance sg13cmos5l_o21ai_1_47 r0 *1 0,0
Xsg13cmos5l_o21ai_1_47 \$1658 \$14111 \$16817 VPWR VGND \$16599
+ sg13cmos5l_o21ai_1
* cell instance sg13cmos5l_o21ai_1_48 r0 *1 0,0
Xsg13cmos5l_o21ai_1_48 \$1299 \$1154 \$1300 VPWR VGND \$2613 sg13cmos5l_o21ai_1
* cell instance sg13cmos5l_o21ai_1_49 r0 *1 0,0
Xsg13cmos5l_o21ai_1_49 \$832 \$831 \$144 VPWR VGND \$784 sg13cmos5l_o21ai_1
* cell instance sg13cmos5l_o21ai_1_50 r0 *1 0,0
Xsg13cmos5l_o21ai_1_50 \$1658 \$10283 \$16294 VPWR VGND \$15862
+ sg13cmos5l_o21ai_1
* cell instance sg13cmos5l_o21ai_1_51 r0 *1 0,0
Xsg13cmos5l_o21ai_1_51 \$3419 \$2739 \$3203 VPWR VGND \$3453 sg13cmos5l_o21ai_1
* cell instance sg13cmos5l_o21ai_1_52 r0 *1 0,0
Xsg13cmos5l_o21ai_1_52 \$2306 \$2452 \$2307 VPWR VGND \$2451 sg13cmos5l_o21ai_1
* cell instance sg13cmos5l_o21ai_1_53 r0 *1 0,0
Xsg13cmos5l_o21ai_1_53 \$2569 \$3435 \$3911 VPWR VGND \$3578 sg13cmos5l_o21ai_1
* cell instance sg13cmos5l_o21ai_1_54 r0 *1 0,0
Xsg13cmos5l_o21ai_1_54 \$716 \$721 \$240 VPWR VGND \$717 sg13cmos5l_o21ai_1
* cell instance sg13cmos5l_o21ai_1_55 r0 *1 0,0
Xsg13cmos5l_o21ai_1_55 \$2176 \$14111 \$13677 VPWR VGND \$14190
+ sg13cmos5l_o21ai_1
* cell instance sg13cmos5l_o21ai_1_56 r0 *1 0,0
Xsg13cmos5l_o21ai_1_56 \$3339 \$3913 \$3579 VPWR VGND \$3915 sg13cmos5l_o21ai_1
* cell instance sg13cmos5l_o21ai_1_57 r0 *1 0,0
Xsg13cmos5l_o21ai_1_57 \$242 \$28 \$240 VPWR VGND \$239 sg13cmos5l_o21ai_1
* cell instance sg13cmos5l_o21ai_1_58 r0 *1 0,0
Xsg13cmos5l_o21ai_1_58 \$347 \$4 \$192 VPWR VGND \$191 sg13cmos5l_o21ai_1
* cell instance sg13cmos5l_o21ai_1_59 r0 *1 0,0
Xsg13cmos5l_o21ai_1_59 \$1299 \$1307 \$1300 VPWR VGND \$1305 sg13cmos5l_o21ai_1
* cell instance sg13cmos5l_o21ai_1_60 r0 *1 0,0
Xsg13cmos5l_o21ai_1_60 \$1650 \$1651 \$1652 VPWR VGND \$1624 sg13cmos5l_o21ai_1
* cell instance sg13cmos5l_o21ai_1_61 r0 *1 0,0
Xsg13cmos5l_o21ai_1_61 \$454 \$511 \$450 VPWR VGND \$512 sg13cmos5l_o21ai_1
* cell instance sg13cmos5l_o21ai_1_62 r0 *1 0,0
Xsg13cmos5l_o21ai_1_62 \$405 \$456 \$785 VPWR VGND \$459 sg13cmos5l_o21ai_1
* cell instance sg13cmos5l_o21ai_1_63 r0 *1 0,0
Xsg13cmos5l_o21ai_1_63 \$1650 \$2313 \$2457 VPWR VGND \$2312 sg13cmos5l_o21ai_1
* cell instance sg13cmos5l_o21ai_1_64 r0 *1 0,0
Xsg13cmos5l_o21ai_1_64 \$48 \$148 \$50 VPWR VGND \$46 sg13cmos5l_o21ai_1
* cell instance sg13cmos5l_o21ai_1_65 r0 *1 0,0
Xsg13cmos5l_o21ai_1_65 \$3206 \$3205 \$3155 VPWR VGND \$2621 sg13cmos5l_o21ai_1
* cell instance sg13cmos5l_o21ai_1_66 r0 *1 0,0
Xsg13cmos5l_o21ai_1_66 \$405 \$404 \$351 VPWR VGND \$448 sg13cmos5l_o21ai_1
* cell instance sg13cmos5l_o21ai_1_67 r0 *1 0,0
Xsg13cmos5l_o21ai_1_67 \$243 \$515 \$517 VPWR VGND \$516 sg13cmos5l_o21ai_1
* cell instance sg13cmos5l_o21ai_1_68 r0 *1 0,0
Xsg13cmos5l_o21ai_1_68 \$1657 \$1655 \$1653 VPWR VGND \$1654 sg13cmos5l_o21ai_1
* cell instance sg13cmos5l_o21ai_1_69 r0 *1 0,0
Xsg13cmos5l_o21ai_1_69 \$3 \$186 \$148 VPWR VGND \$409 sg13cmos5l_o21ai_1
* cell instance sg13cmos5l_o21ai_1_70 r0 *1 0,0
Xsg13cmos5l_o21ai_1_70 \$1650 \$2317 \$2036 VPWR VGND \$1661 sg13cmos5l_o21ai_1
* cell instance sg13cmos5l_o21ai_1_71 r0 *1 0,0
Xsg13cmos5l_o21ai_1_71 \$1650 \$2042 \$2037 VPWR VGND \$1667 sg13cmos5l_o21ai_1
* cell instance sg13cmos5l_o21ai_1_72 r0 *1 0,0
Xsg13cmos5l_o21ai_1_72 \$521 \$850 \$65 VPWR VGND \$911 sg13cmos5l_o21ai_1
* cell instance sg13cmos5l_o21ai_1_73 r0 *1 0,0
Xsg13cmos5l_o21ai_1_73 \$246 \$57 \$250 VPWR VGND \$522 sg13cmos5l_o21ai_1
* cell instance sg13cmos5l_o21ai_1_74 r0 *1 0,0
Xsg13cmos5l_o21ai_1_74 \$3470 \$3205 \$3349 VPWR VGND \$3203 sg13cmos5l_o21ai_1
* cell instance sg13cmos5l_o21ai_1_75 r0 *1 0,0
Xsg13cmos5l_o21ai_1_75 \$673 \$462 \$665 VPWR VGND \$674 sg13cmos5l_o21ai_1
* cell instance sg13cmos5l_o21ai_1_76 r0 *1 0,0
Xsg13cmos5l_o21ai_1_76 \$16 \$59 \$240 VPWR VGND \$256 sg13cmos5l_o21ai_1
* cell instance sg13cmos5l_o21ai_1_77 r0 *1 0,0
Xsg13cmos5l_o21ai_1_77 \$1992 \$2462 \$2904 VPWR VGND \$2909 sg13cmos5l_o21ai_1
* cell instance sg13cmos5l_o21ai_1_78 r0 *1 0,0
Xsg13cmos5l_o21ai_1_78 \$246 \$57 \$259 VPWR VGND \$157 sg13cmos5l_o21ai_1
* cell instance sg13cmos5l_o21ai_1_79 r0 *1 0,0
Xsg13cmos5l_o21ai_1_79 \$936 \$1083 \$1081 VPWR VGND \$1199 sg13cmos5l_o21ai_1
* cell instance sg13cmos5l_o21ai_1_80 r0 *1 0,0
Xsg13cmos5l_o21ai_1_80 \$172 \$848 \$785 VPWR VGND \$854 sg13cmos5l_o21ai_1
* cell instance sg13cmos5l_o21ai_1_81 r0 *1 0,0
Xsg13cmos5l_o21ai_1_81 \$2030 \$2182 \$2047 VPWR VGND \$1180 sg13cmos5l_o21ai_1
* cell instance sg13cmos5l_o21ai_1_82 r0 *1 0,0
Xsg13cmos5l_o21ai_1_82 \$3734 \$3601 \$3600 VPWR VGND \$3603 sg13cmos5l_o21ai_1
* cell instance sg13cmos5l_o21ai_1_83 r0 *1 0,0
Xsg13cmos5l_o21ai_1_83 \$18 \$66 \$65 VPWR VGND \$67 sg13cmos5l_o21ai_1
* cell instance sg13cmos5l_o21ai_1_84 r0 *1 0,0
Xsg13cmos5l_o21ai_1_84 \$867 \$744 \$669 VPWR VGND \$799 sg13cmos5l_o21ai_1
* cell instance sg13cmos5l_o21ai_1_85 r0 *1 0,0
Xsg13cmos5l_o21ai_1_85 \$3733 \$3601 \$3764 VPWR VGND \$3954 sg13cmos5l_o21ai_1
* cell instance sg13cmos5l_o21ai_1_86 r0 *1 0,0
Xsg13cmos5l_o21ai_1_86 \$3739 \$3601 \$3608 VPWR VGND \$3766 sg13cmos5l_o21ai_1
* cell instance sg13cmos5l_o21ai_1_87 r0 *1 0,0
Xsg13cmos5l_o21ai_1_87 \$24 \$14 \$147 VPWR VGND \$69 sg13cmos5l_o21ai_1
* cell instance sg13cmos5l_o21ai_1_88 r0 *1 0,0
Xsg13cmos5l_o21ai_1_88 \$3752 \$3355 \$3767 VPWR VGND \$3955 sg13cmos5l_o21ai_1
* cell instance sg13cmos5l_o21ai_1_89 r0 *1 0,0
Xsg13cmos5l_o21ai_1_89 \$59 \$409 \$156 VPWR VGND \$416 sg13cmos5l_o21ai_1
* cell instance sg13cmos5l_o21ai_1_90 r0 *1 0,0
Xsg13cmos5l_o21ai_1_90 \$3759 \$3358 \$3768 VPWR VGND \$3956 sg13cmos5l_o21ai_1
* cell instance sg13cmos5l_o21ai_1_91 r0 *1 0,0
Xsg13cmos5l_o21ai_1_91 \$72 \$165 \$160 VPWR VGND \$163 sg13cmos5l_o21ai_1
* cell instance sg13cmos5l_o21ai_1_92 r0 *1 0,0
Xsg13cmos5l_o21ai_1_92 \$3437 \$3358 \$3489 VPWR VGND \$3609 sg13cmos5l_o21ai_1
* cell instance sg13cmos5l_o21ai_1_93 r0 *1 0,0
Xsg13cmos5l_o21ai_1_93 \$3726 \$3601 \$3357 VPWR VGND \$3957 sg13cmos5l_o21ai_1
* cell instance sg13cmos5l_o21ai_1_94 r0 *1 0,0
Xsg13cmos5l_o21ai_1_94 \$72 \$71 \$160 VPWR VGND \$207 sg13cmos5l_o21ai_1
* cell instance sg13cmos5l_o21ai_1_95 r0 *1 0,0
Xsg13cmos5l_o21ai_1_95 \$2488 \$2055 \$2487 VPWR VGND \$2459 sg13cmos5l_o21ai_1
* cell instance sg13cmos5l_o21ai_1_96 r0 *1 0,0
Xsg13cmos5l_o21ai_1_96 \$3555 \$3358 \$3610 VPWR VGND \$3770 sg13cmos5l_o21ai_1
* cell instance sg13cmos5l_o21ai_1_97 r0 *1 0,0
Xsg13cmos5l_o21ai_1_97 \$2926 \$2761 \$2759 VPWR VGND \$2762 sg13cmos5l_o21ai_1
* cell instance sg13cmos5l_o21ai_1_98 r0 *1 0,0
Xsg13cmos5l_o21ai_1_98 \$498 \$595 \$368 VPWR VGND \$575 sg13cmos5l_o21ai_1
* cell instance sg13cmos5l_o21ai_1_99 r0 *1 0,0
Xsg13cmos5l_o21ai_1_99 \$279 \$1091 \$1089 VPWR VGND \$1079 sg13cmos5l_o21ai_1
* cell instance sg13cmos5l_o21ai_1_100 r0 *1 0,0
Xsg13cmos5l_o21ai_1_100 \$1327 \$290 \$665 VPWR VGND \$1328 sg13cmos5l_o21ai_1
* cell instance sg13cmos5l_o21ai_1_101 r0 *1 0,0
Xsg13cmos5l_o21ai_1_101 \$2000 \$2060 \$2190 VPWR VGND \$2636 sg13cmos5l_o21ai_1
* cell instance sg13cmos5l_o21ai_1_102 r0 *1 0,0
Xsg13cmos5l_o21ai_1_102 \$2851 \$2060 \$2190 VPWR VGND \$2764 sg13cmos5l_o21ai_1
* cell instance sg13cmos5l_o21ai_1_103 r0 *1 0,0
Xsg13cmos5l_o21ai_1_103 \$2739 \$2060 \$2190 VPWR VGND \$2928 sg13cmos5l_o21ai_1
* cell instance sg13cmos5l_o21ai_1_104 r0 *1 0,0
Xsg13cmos5l_o21ai_1_104 \$70 \$59 \$65 VPWR VGND \$81 sg13cmos5l_o21ai_1
* cell instance sg13cmos5l_o21ai_1_105 r0 *1 0,0
Xsg13cmos5l_o21ai_1_105 \$1808 \$2182 \$1697 VPWR VGND \$2056 sg13cmos5l_o21ai_1
* cell instance sg13cmos5l_o21ai_1_106 r0 *1 0,0
Xsg13cmos5l_o21ai_1_106 \$3058 \$2060 \$2190 VPWR VGND \$1879 sg13cmos5l_o21ai_1
* cell instance sg13cmos5l_o21ai_1_107 r0 *1 0,0
Xsg13cmos5l_o21ai_1_107 \$1283 \$1201 \$1808 VPWR VGND \$1874 sg13cmos5l_o21ai_1
* cell instance sg13cmos5l_o21ai_1_108 r0 *1 0,0
Xsg13cmos5l_o21ai_1_108 \$353 \$3 \$107 VPWR VGND \$276 sg13cmos5l_o21ai_1
* cell instance sg13cmos5l_o21ai_1_109 r0 *1 0,0
Xsg13cmos5l_o21ai_1_109 \$489 \$1098 \$1334 VPWR VGND \$1499 sg13cmos5l_o21ai_1
* cell instance sg13cmos5l_o21ai_1_110 r0 *1 0,0
Xsg13cmos5l_o21ai_1_110 \$2337 \$3501 \$3362 VPWR VGND \$3087 sg13cmos5l_o21ai_1
* cell instance sg13cmos5l_o21ai_1_111 r0 *1 0,0
Xsg13cmos5l_o21ai_1_111 \$2017 \$2060 \$1700 VPWR VGND \$2061 sg13cmos5l_o21ai_1
* cell instance sg13cmos5l_o21ai_1_112 r0 *1 0,0
Xsg13cmos5l_o21ai_1_112 \$1880 \$2335 \$2337 VPWR VGND \$2338 sg13cmos5l_o21ai_1
* cell instance sg13cmos5l_o21ai_1_113 r0 *1 0,0
Xsg13cmos5l_o21ai_1_113 \$756 \$284 \$683 VPWR VGND \$754 sg13cmos5l_o21ai_1
* cell instance sg13cmos5l_o21ai_1_114 r0 *1 0,0
Xsg13cmos5l_o21ai_1_114 \$981 \$268 \$279 VPWR VGND \$1096 sg13cmos5l_o21ai_1
* cell instance sg13cmos5l_o21ai_1_115 r0 *1 0,0
Xsg13cmos5l_o21ai_1_115 \$542 \$536 \$475 VPWR VGND \$641 sg13cmos5l_o21ai_1
* cell instance sg13cmos5l_o21ai_1_116 r0 *1 0,0
Xsg13cmos5l_o21ai_1_116 \$378 \$474 \$420 VPWR VGND \$475 sg13cmos5l_o21ai_1
* cell instance sg13cmos5l_o21ai_1_117 r0 *1 0,0
Xsg13cmos5l_o21ai_1_117 \$1883 \$2061 \$1885 VPWR VGND \$1746 sg13cmos5l_o21ai_1
* cell instance sg13cmos5l_o21ai_1_118 r0 *1 0,0
Xsg13cmos5l_o21ai_1_118 \$2151 \$2060 \$2190 VPWR VGND \$2340 sg13cmos5l_o21ai_1
* cell instance sg13cmos5l_o21ai_1_119 r0 *1 0,0
Xsg13cmos5l_o21ai_1_119 \$3491 \$3350 \$4407 VPWR VGND \$4406 sg13cmos5l_o21ai_1
* cell instance sg13cmos5l_o21ai_1_120 r0 *1 0,0
Xsg13cmos5l_o21ai_1_120 \$2334 \$2340 \$2342 VPWR VGND \$1739 sg13cmos5l_o21ai_1
* cell instance sg13cmos5l_o21ai_1_121 r0 *1 0,0
Xsg13cmos5l_o21ai_1_121 \$2190 \$2644 \$2762 VPWR VGND \$2243 sg13cmos5l_o21ai_1
* cell instance sg13cmos5l_o21ai_1_122 r0 *1 0,0
Xsg13cmos5l_o21ai_1_122 \$91 \$88 \$39 VPWR VGND \$474 sg13cmos5l_o21ai_1
* cell instance sg13cmos5l_o21ai_1_123 r0 *1 0,0
Xsg13cmos5l_o21ai_1_123 \$107 \$88 \$85 VPWR VGND \$92 sg13cmos5l_o21ai_1
* cell instance sg13cmos5l_o21ai_1_124 r0 *1 0,0
Xsg13cmos5l_o21ai_1_124 \$172 \$72 \$92 VPWR VGND \$178 sg13cmos5l_o21ai_1
* cell instance sg13cmos5l_o21ai_1_125 r0 *1 0,0
Xsg13cmos5l_o21ai_1_125 \$688 \$636 \$93 VPWR VGND \$689 sg13cmos5l_o21ai_1
* cell instance sg13cmos5l_o21ai_1_126 r0 *1 0,0
Xsg13cmos5l_o21ai_1_126 \$2767 \$2636 \$2766 VPWR VGND \$3124 sg13cmos5l_o21ai_1
* cell instance sg13cmos5l_o21ai_1_127 r0 *1 0,0
Xsg13cmos5l_o21ai_1_127 \$1886 \$1884 \$1702 VPWR VGND \$1870 sg13cmos5l_o21ai_1
* cell instance sg13cmos5l_o21ai_1_128 r0 *1 0,0
Xsg13cmos5l_o21ai_1_128 \$171 \$409 \$78 VPWR VGND \$381 sg13cmos5l_o21ai_1
* cell instance sg13cmos5l_o21ai_1_129 r0 *1 0,0
Xsg13cmos5l_o21ai_1_129 \$3363 \$3365 \$3164 VPWR VGND \$3081 sg13cmos5l_o21ai_1
* cell instance sg13cmos5l_o21ai_1_130 r0 *1 0,0
Xsg13cmos5l_o21ai_1_130 \$756 \$261 \$326 VPWR VGND \$477 sg13cmos5l_o21ai_1
* cell instance sg13cmos5l_o21ai_1_131 r0 *1 0,0
Xsg13cmos5l_o21ai_1_131 \$3970 \$3957 \$3972 VPWR VGND \$3971 sg13cmos5l_o21ai_1
* cell instance sg13cmos5l_o21ai_1_132 r0 *1 0,0
Xsg13cmos5l_o21ai_1_132 \$96 \$95 \$93 VPWR VGND \$94 sg13cmos5l_o21ai_1
* cell instance sg13cmos5l_o21ai_1_133 r0 *1 0,0
Xsg13cmos5l_o21ai_1_133 \$3970 \$3609 \$3974 VPWR VGND \$3973 sg13cmos5l_o21ai_1
* cell instance sg13cmos5l_o21ai_1_134 r0 *1 0,0
Xsg13cmos5l_o21ai_1_134 \$1633 \$3217 \$3218 VPWR VGND \$2063 sg13cmos5l_o21ai_1
* cell instance sg13cmos5l_o21ai_1_135 r0 *1 0,0
Xsg13cmos5l_o21ai_1_135 \$380 \$381 \$325 VPWR VGND \$323 sg13cmos5l_o21ai_1
* cell instance sg13cmos5l_o21ai_1_136 r0 *1 0,0
Xsg13cmos5l_o21ai_1_136 \$382 \$477 \$381 VPWR VGND \$464 sg13cmos5l_o21ai_1
* cell instance sg13cmos5l_o21ai_1_137 r0 *1 0,0
Xsg13cmos5l_o21ai_1_137 \$325 \$382 \$176 VPWR VGND \$321 sg13cmos5l_o21ai_1
* cell instance sg13cmos5l_o21ai_1_138 r0 *1 0,0
Xsg13cmos5l_o21ai_1_138 \$3970 \$3956 \$3976 VPWR VGND \$3975 sg13cmos5l_o21ai_1
* cell instance sg13cmos5l_o21ai_1_139 r0 *1 0,0
Xsg13cmos5l_o21ai_1_139 \$285 \$284 \$326 VPWR VGND \$325 sg13cmos5l_o21ai_1
* cell instance sg13cmos5l_o21ai_1_140 r0 *1 0,0
Xsg13cmos5l_o21ai_1_140 \$285 \$482 \$478 VPWR VGND \$483 sg13cmos5l_o21ai_1
* cell instance sg13cmos5l_o21ai_1_141 r0 *1 0,0
Xsg13cmos5l_o21ai_1_141 \$102 \$981 \$1208 VPWR VGND \$1206 sg13cmos5l_o21ai_1
* cell instance sg13cmos5l_o21ai_1_142 r0 *1 0,0
Xsg13cmos5l_o21ai_1_142 \$3970 \$3770 \$3714 VPWR VGND \$3977 sg13cmos5l_o21ai_1
* cell instance sg13cmos5l_o21ai_1_143 r0 *1 0,0
Xsg13cmos5l_o21ai_1_143 \$95 \$180 \$93 VPWR VGND \$215 sg13cmos5l_o21ai_1
* cell instance sg13cmos5l_o21ai_1_144 r0 *1 0,0
Xsg13cmos5l_o21ai_1_144 \$3970 \$3766 \$3979 VPWR VGND \$3978 sg13cmos5l_o21ai_1
* cell instance sg13cmos5l_o21ai_1_145 r0 *1 0,0
Xsg13cmos5l_o21ai_1_145 \$1896 \$1884 \$1717 VPWR VGND \$1897 sg13cmos5l_o21ai_1
* cell instance sg13cmos5l_o21ai_1_146 r0 *1 0,0
Xsg13cmos5l_o21ai_1_146 \$3970 \$3955 \$3809 VPWR VGND \$3980 sg13cmos5l_o21ai_1
* cell instance sg13cmos5l_o21ai_1_147 r0 *1 0,0
Xsg13cmos5l_o21ai_1_147 \$107 \$37 \$110 VPWR VGND \$79 sg13cmos5l_o21ai_1
* cell instance sg13cmos5l_o21ai_1_148 r0 *1 0,0
Xsg13cmos5l_o21ai_1_148 \$85 \$762 \$815 VPWR VGND \$814 sg13cmos5l_o21ai_1
* cell instance sg13cmos5l_o21ai_1_149 r0 *1 0,0
Xsg13cmos5l_o21ai_1_149 \$3970 \$3954 \$3982 VPWR VGND \$3981 sg13cmos5l_o21ai_1
* cell instance sg13cmos5l_o21ai_1_150 r0 *1 0,0
Xsg13cmos5l_o21ai_1_150 \$180 \$79 \$108 VPWR VGND \$139 sg13cmos5l_o21ai_1
* cell instance sg13cmos5l_o21ai_1_151 r0 *1 0,0
Xsg13cmos5l_o21ai_1_151 \$644 \$589 \$387 VPWR VGND \$486 sg13cmos5l_o21ai_1
* cell instance sg13cmos5l_o21ai_1_152 r0 *1 0,0
Xsg13cmos5l_o21ai_1_152 \$3970 \$3603 \$3984 VPWR VGND \$3983 sg13cmos5l_o21ai_1
* cell instance sg13cmos5l_o21ai_1_153 r0 *1 0,0
Xsg13cmos5l_o21ai_1_153 \$1899 \$1721 \$1898 VPWR VGND \$2055 sg13cmos5l_o21ai_1
* cell instance sg13cmos5l_o21ai_1_154 r0 *1 0,0
Xsg13cmos5l_o21ai_1_154 \$3506 \$3624 \$3799 VPWR VGND \$3795 sg13cmos5l_o21ai_1
* cell instance sg13cmos5l_o21ai_1_155 r0 *1 0,0
Xsg13cmos5l_o21ai_1_155 \$16 \$756 \$490 VPWR VGND \$493 sg13cmos5l_o21ai_1
* cell instance sg13cmos5l_o21ai_1_156 r0 *1 0,0
Xsg13cmos5l_o21ai_1_156 \$2076 \$1879 \$2078 VPWR VGND \$1381 sg13cmos5l_o21ai_1
* cell instance sg13cmos5l_o21ai_1_157 r0 *1 0,0
Xsg13cmos5l_o21ai_1_157 \$334 \$390 \$326 VPWR VGND \$392 sg13cmos5l_o21ai_1
* cell instance sg13cmos5l_o21ai_1_158 r0 *1 0,0
Xsg13cmos5l_o21ai_1_158 \$1904 \$1721 \$1720 VPWR VGND \$2068 sg13cmos5l_o21ai_1
* cell instance sg13cmos5l_o21ai_1_159 r0 *1 0,0
Xsg13cmos5l_o21ai_1_159 \$2502 \$2352 \$2354 VPWR VGND \$2349 sg13cmos5l_o21ai_1
* cell instance sg13cmos5l_o21ai_1_160 r0 *1 0,0
Xsg13cmos5l_o21ai_1_160 \$874 \$863 \$935 VPWR VGND \$877 sg13cmos5l_o21ai_1
* cell instance sg13cmos5l_o21ai_1_161 r0 *1 0,0
Xsg13cmos5l_o21ai_1_161 \$932 \$159 \$655 VPWR VGND \$768 sg13cmos5l_o21ai_1
* cell instance sg13cmos5l_o21ai_1_162 r0 *1 0,0
Xsg13cmos5l_o21ai_1_162 \$110 \$496 \$295 VPWR VGND \$497 sg13cmos5l_o21ai_1
* cell instance sg13cmos5l_o21ai_1_163 r0 *1 0,0
Xsg13cmos5l_o21ai_1_163 \$542 \$705 \$769 VPWR VGND \$596 sg13cmos5l_o21ai_1
* cell instance sg13cmos5l_o21ai_1_164 r0 *1 0,0
Xsg13cmos5l_o21ai_1_164 \$102 \$580 \$932 VPWR VGND \$863 sg13cmos5l_o21ai_1
* cell instance sg13cmos5l_o21ai_1_165 r0 *1 0,0
Xsg13cmos5l_o21ai_1_165 \$394 \$494 \$429 VPWR VGND \$428 sg13cmos5l_o21ai_1
* cell instance sg13cmos5l_o21ai_1_166 r0 *1 0,0
Xsg13cmos5l_o21ai_1_166 \$331 \$336 \$120 VPWR VGND \$337 sg13cmos5l_o21ai_1
* cell instance sg13cmos5l_o21ai_1_167 r0 *1 0,0
Xsg13cmos5l_o21ai_1_167 \$431 \$337 \$387 VPWR VGND \$429 sg13cmos5l_o21ai_1
* cell instance sg13cmos5l_o21ai_1_168 r0 *1 0,0
Xsg13cmos5l_o21ai_1_168 \$248 \$7 \$1001 VPWR VGND \$1112 sg13cmos5l_o21ai_1
* cell instance sg13cmos5l_o21ai_1_169 r0 *1 0,0
Xsg13cmos5l_o21ai_1_169 \$820 \$880 \$655 VPWR VGND \$755 sg13cmos5l_o21ai_1
* cell instance sg13cmos5l_o21ai_1_170 r0 *1 0,0
Xsg13cmos5l_o21ai_1_170 \$2351 \$2357 \$2354 VPWR VGND \$2358 sg13cmos5l_o21ai_1
* cell instance sg13cmos5l_o21ai_1_171 r0 *1 0,0
Xsg13cmos5l_o21ai_1_171 \$880 \$608 \$655 VPWR VGND \$1034 sg13cmos5l_o21ai_1
* cell instance sg13cmos5l_o21ai_1_172 r0 *1 0,0
Xsg13cmos5l_o21ai_1_172 \$2640 \$2511 \$2565 VPWR VGND \$2761 sg13cmos5l_o21ai_1
* cell instance sg13cmos5l_o21ai_1_173 r0 *1 0,0
Xsg13cmos5l_o21ai_1_173 \$2640 \$3241 \$3238 VPWR VGND \$3239 sg13cmos5l_o21ai_1
* cell instance sg13cmos5l_o21ai_1_174 r0 *1 0,0
Xsg13cmos5l_o21ai_1_174 \$2640 \$3375 \$3515 VPWR VGND \$3374 sg13cmos5l_o21ai_1
* cell instance sg13cmos5l_o21ai_1_175 r0 *1 0,0
Xsg13cmos5l_o21ai_1_175 \$2266 \$2087 \$1992 VPWR VGND \$2208 sg13cmos5l_o21ai_1
* cell instance sg13cmos5l_o21ai_1_176 r0 *1 0,0
Xsg13cmos5l_o21ai_1_176 \$1116 \$608 \$93 VPWR VGND \$1012 sg13cmos5l_o21ai_1
* cell instance sg13cmos5l_o21ai_1_177 r0 *1 0,0
Xsg13cmos5l_o21ai_1_177 \$2793 \$2764 \$2794 VPWR VGND \$1599 sg13cmos5l_o21ai_1
* cell instance sg13cmos5l_o21ai_1_178 r0 *1 0,0
Xsg13cmos5l_o21ai_1_178 \$1738 \$1721 \$1545 VPWR VGND \$1538 sg13cmos5l_o21ai_1
* cell instance sg13cmos5l_o21ai_1_179 r0 *1 0,0
Xsg13cmos5l_o21ai_1_179 \$2266 \$2085 \$1992 VPWR VGND \$2089 sg13cmos5l_o21ai_1
* cell instance sg13cmos5l_o21ai_1_180 r0 *1 0,0
Xsg13cmos5l_o21ai_1_180 \$2945 \$2928 \$2950 VPWR VGND \$2949 sg13cmos5l_o21ai_1
* cell instance sg13cmos5l_o21ai_1_181 r0 *1 0,0
Xsg13cmos5l_o21ai_1_181 \$655 \$605 \$553 VPWR VGND \$606 sg13cmos5l_o21ai_1
* cell instance sg13cmos5l_o21ai_1_182 r0 *1 0,0
Xsg13cmos5l_o21ai_1_182 \$1917 \$1884 \$1548 VPWR VGND \$1918 sg13cmos5l_o21ai_1
* cell instance sg13cmos5l_o21ai_1_183 r0 *1 0,0
Xsg13cmos5l_o21ai_1_183 \$867 \$712 \$773 VPWR VGND \$774 sg13cmos5l_o21ai_1
* cell instance sg13cmos5l_o21ai_1_184 r0 *1 0,0
Xsg13cmos5l_o21ai_1_184 \$2218 \$2513 \$2427 VPWR VGND \$2661 sg13cmos5l_o21ai_1
* cell instance sg13cmos5l_o21ai_1_185 r0 *1 0,0
Xsg13cmos5l_o21ai_1_185 \$3371 \$3112 \$3518 VPWR VGND \$3499 sg13cmos5l_o21ai_1
* cell instance sg13cmos5l_o21ai_1_186 r0 *1 0,0
Xsg13cmos5l_o21ai_1_186 \$999 \$756 \$811 VPWR VGND \$883 sg13cmos5l_o21ai_1
* cell instance sg13cmos5l_o21ai_1_187 r0 *1 0,0
Xsg13cmos5l_o21ai_1_187 \$557 \$658 \$659 VPWR VGND \$826 sg13cmos5l_o21ai_1
* cell instance sg13cmos5l_o21ai_1_188 r0 *1 0,0
Xsg13cmos5l_o21ai_1_188 \$1229 \$1748 \$1538 VPWR VGND \$1749 sg13cmos5l_o21ai_1
* cell instance sg13cmos5l_o21ai_1_189 r0 *1 0,0
Xsg13cmos5l_o21ai_1_189 \$2509 \$2221 \$2665 VPWR VGND \$2664 sg13cmos5l_o21ai_1
* cell instance sg13cmos5l_o21ai_1_190 r0 *1 0,0
Xsg13cmos5l_o21ai_1_190 \$660 \$828 \$586 VPWR VGND \$659 sg13cmos5l_o21ai_1
* cell instance sg13cmos5l_o21ai_1_191 r0 *1 0,0
Xsg13cmos5l_o21ai_1_191 \$3524 \$3116 \$3522 VPWR VGND \$3512 sg13cmos5l_o21ai_1
* cell instance sg13cmos5l_o21ai_1_192 r0 *1 0,0
Xsg13cmos5l_o21ai_1_192 \$1757 \$2093 \$2104 VPWR VGND \$2103 sg13cmos5l_o21ai_1
* cell instance sg13cmos5l_o21ai_1_193 r0 *1 0,0
Xsg13cmos5l_o21ai_1_193 \$2680 \$2093 \$2520 VPWR VGND \$4224 sg13cmos5l_o21ai_1
* cell instance sg13cmos5l_o21ai_1_194 r0 *1 0,0
Xsg13cmos5l_o21ai_1_194 \$1400 \$1918 \$1538 VPWR VGND \$1939 sg13cmos5l_o21ai_1
* cell instance sg13cmos5l_o21ai_1_195 r0 *1 0,0
Xsg13cmos5l_o21ai_1_195 \$4051 \$4498 \$4048 VPWR VGND \$4695 sg13cmos5l_o21ai_1
* cell instance sg13cmos5l_o21ai_1_196 r0 *1 0,0
Xsg13cmos5l_o21ai_1_196 \$1270 \$1538 \$1748 VPWR VGND \$1940 sg13cmos5l_o21ai_1
* cell instance sg13cmos5l_or2_1_0 r0 *1 0,0
Xsg13cmos5l_or2_1_0 \$1643 \$2555 VPWR VGND \$2445 sg13cmos5l_or2_1
* cell instance sg13cmos5l_or2_1_1 r0 *1 0,0
Xsg13cmos5l_or2_1_1 \$2160 \$1967 VPWR VGND \$2159 sg13cmos5l_or2_1
* cell instance sg13cmos5l_or2_1_2 r0 *1 0,0
Xsg13cmos5l_or2_1_2 \$49 \$409 VPWR VGND \$363 sg13cmos5l_or2_1
* cell instance sg13cmos5l_or2_1_3 r0 *1 0,0
Xsg13cmos5l_or2_1_3 \$785 \$794 VPWR VGND \$845 sg13cmos5l_or2_1
* cell instance sg13cmos5l_or2_1_4 r0 *1 0,0
Xsg13cmos5l_or2_1_4 \$3 \$186 VPWR VGND \$187 sg13cmos5l_or2_1
* cell instance sg13cmos5l_or2_1_5 r0 *1 0,0
Xsg13cmos5l_or2_1_5 \$851 \$796 VPWR VGND \$850 sg13cmos5l_or2_1
* cell instance sg13cmos5l_or2_1_6 r0 *1 0,0
Xsg13cmos5l_or2_1_6 \$354 \$968 VPWR VGND \$970 sg13cmos5l_or2_1
* cell instance sg13cmos5l_or2_1_7 r0 *1 0,0
Xsg13cmos5l_or2_1_7 \$531 \$396 VPWR VGND \$857 sg13cmos5l_or2_1
* cell instance sg13cmos5l_or2_1_8 r0 *1 0,0
Xsg13cmos5l_or2_1_8 \$82 \$43 VPWR VGND \$134 sg13cmos5l_or2_1
* cell instance sg13cmos5l_or2_1_9 r0 *1 0,0
Xsg13cmos5l_or2_1_9 \$2265 \$2332 VPWR VGND \$2337 sg13cmos5l_or2_1
* cell instance sg13cmos5l_or2_1_10 r0 *1 0,0
Xsg13cmos5l_or2_1_10 \$4410 \$4626 VPWR VGND \$4635 sg13cmos5l_or2_1
* cell instance sg13cmos5l_or2_1_11 r0 *1 0,0
Xsg13cmos5l_or2_1_11 \$2647 \$1929 VPWR VGND \$2774 sg13cmos5l_or2_1
* cell instance sg13cmos5l_or2_1_12 r0 *1 0,0
Xsg13cmos5l_or2_1_12 \$285 \$284 VPWR VGND \$287 sg13cmos5l_or2_1
* cell instance sg13cmos5l_or2_1_13 r0 *1 0,0
Xsg13cmos5l_or2_1_13 \$2640 \$2649 VPWR VGND \$2651 sg13cmos5l_or2_1
* cell instance sg13cmos5l_or2_1_14 r0 *1 0,0
Xsg13cmos5l_or2_1_14 \$73 \$595 VPWR VGND \$122 sg13cmos5l_or2_1
* cell instance sg13cmos5l_or2_1_15 r0 *1 0,0
Xsg13cmos5l_or2_1_15 \$110 \$501 VPWR VGND \$502 sg13cmos5l_or2_1
* cell instance sg13cmos5l_or2_1_16 r0 *1 0,0
Xsg13cmos5l_or2_1_16 \$2797 \$2796 VPWR VGND \$2953 sg13cmos5l_or2_1
* cell instance sg13cmos5l_or2_1_17 r0 *1 0,0
Xsg13cmos5l_or2_1_17 \$4512 \$4498 VPWR VGND \$4500 sg13cmos5l_or2_1
* cell instance sg13cmos5l_or3_1_0 r0 *1 0,0
Xsg13cmos5l_or3_1_0 \$1451 \$2608 \$2742 VPWR VGND \$2611 sg13cmos5l_or3_1
* cell instance sg13cmos5l_or3_1_1 r0 *1 0,0
Xsg13cmos5l_or3_1_1 \$1487 \$1283 \$1201 VPWR VGND \$3155 sg13cmos5l_or3_1
* cell instance sg13cmos5l_or3_1_2 r0 *1 0,0
Xsg13cmos5l_or3_1_2 \$3467 \$1283 \$1201 VPWR VGND \$3349 sg13cmos5l_or3_1
* cell instance sg13cmos5l_or3_1_3 r0 *1 0,0
Xsg13cmos5l_or3_1_3 \$1869 \$2054 \$1871 VPWR VGND \$2124 sg13cmos5l_or3_1
* cell instance sg13cmos5l_or3_1_4 r0 *1 0,0
Xsg13cmos5l_or3_1_4 \$2639 \$2202 \$2489 VPWR VGND \$2637 sg13cmos5l_or3_1
* cell instance sg13cmos5l_or3_1_5 r0 *1 0,0
Xsg13cmos5l_or3_1_5 \$1696 \$1283 \$1201 VPWR VGND \$1697 sg13cmos5l_or3_1
* cell instance sg13cmos5l_or3_1_6 r0 *1 0,0
Xsg13cmos5l_or3_1_6 \$1512 \$1718 \$1704 VPWR VGND \$1702 sg13cmos5l_or3_1
* cell instance sg13cmos5l_or3_1_7 r0 *1 0,0
Xsg13cmos5l_or3_1_7 \$1629 \$1718 \$1704 VPWR VGND \$1717 sg13cmos5l_or3_1
* cell instance sg13cmos5l_or3_1_8 r0 *1 0,0
Xsg13cmos5l_or3_1_8 \$3103 \$3505 \$2776 VPWR VGND \$3104 sg13cmos5l_or3_1
* cell instance sg13cmos5l_or3_1_9 r0 *1 0,0
Xsg13cmos5l_or3_1_9 \$1023 \$1718 \$1704 VPWR VGND \$1898 sg13cmos5l_or3_1
* cell instance sg13cmos5l_or3_1_10 r0 *1 0,0
Xsg13cmos5l_or3_1_10 \$1356 \$1718 \$1704 VPWR VGND \$1720 sg13cmos5l_or3_1
* cell instance sg13cmos5l_or3_1_11 r0 *1 0,0
Xsg13cmos5l_or3_1_11 \$542 \$23 \$141 VPWR VGND \$120 sg13cmos5l_or3_1
* cell instance sg13cmos5l_or3_1_12 r0 *1 0,0
Xsg13cmos5l_or3_1_12 \$1543 \$2082 \$2266 VPWR VGND \$2207 sg13cmos5l_or3_1
* cell instance sg13cmos5l_or3_1_13 r0 *1 0,0
Xsg13cmos5l_or3_1_13 \$1718 \$1704 \$1368 VPWR VGND \$1545 sg13cmos5l_or3_1
* cell instance sg13cmos5l_or3_1_14 r0 *1 0,0
Xsg13cmos5l_or3_1_14 \$1547 \$1283 \$1201 VPWR VGND \$1548 sg13cmos5l_or3_1
* cell instance sg13cmos5l_or4_1_0 r0 *1 0,0
Xsg13cmos5l_or4_1_0 \$2155 \$2151 \$2017 \$2000 VPWR VGND \$2177
+ sg13cmos5l_or4_1
* cell instance sg13cmos5l_tiehi_0 r0 *1 0,0
Xsg13cmos5l_tiehi_0 \$4615 VPWR VGND sg13cmos5l_tiehi
* cell instance sg13cmos5l_tiehi_1 r0 *1 0,0
Xsg13cmos5l_tiehi_1 \$4819 VPWR VGND sg13cmos5l_tiehi
* cell instance sg13cmos5l_tiehi_2 r0 *1 0,0
Xsg13cmos5l_tiehi_2 \$4831 VPWR VGND sg13cmos5l_tiehi
* cell instance sg13cmos5l_tiehi_3 r0 *1 0,0
Xsg13cmos5l_tiehi_3 \$4847 VPWR VGND sg13cmos5l_tiehi
* cell instance sg13cmos5l_tiehi_4 r0 *1 0,0
Xsg13cmos5l_tiehi_4 \$4859 VPWR VGND sg13cmos5l_tiehi
* cell instance sg13cmos5l_tiehi_5 r0 *1 0,0
Xsg13cmos5l_tiehi_5 \$4871 VPWR VGND sg13cmos5l_tiehi
* cell instance sg13cmos5l_tiehi_6 r0 *1 0,0
Xsg13cmos5l_tiehi_6 \$4883 VPWR VGND sg13cmos5l_tiehi
* cell instance sg13cmos5l_tiehi_7 r0 *1 0,0
Xsg13cmos5l_tiehi_7 \$4896 VPWR VGND sg13cmos5l_tiehi
* cell instance sg13cmos5l_tiehi_8 r0 *1 0,0
Xsg13cmos5l_tiehi_8 \$4924 VPWR VGND sg13cmos5l_tiehi
* cell instance sg13cmos5l_tiehi_9 r0 *1 0,0
Xsg13cmos5l_tiehi_9 \$4933 VPWR VGND sg13cmos5l_tiehi
* cell instance sg13cmos5l_tiehi_10 r0 *1 0,0
Xsg13cmos5l_tiehi_10 \$4945 VPWR VGND sg13cmos5l_tiehi
* cell instance sg13cmos5l_tiehi_11 r0 *1 0,0
Xsg13cmos5l_tiehi_11 \$4963 VPWR VGND sg13cmos5l_tiehi
* cell instance sg13cmos5l_tiehi_12 r0 *1 0,0
Xsg13cmos5l_tiehi_12 \$4979 VPWR VGND sg13cmos5l_tiehi
* cell instance sg13cmos5l_tiehi_13 r0 *1 0,0
Xsg13cmos5l_tiehi_13 \$4992 VPWR VGND sg13cmos5l_tiehi
* cell instance sg13cmos5l_tiehi_14 r0 *1 0,0
Xsg13cmos5l_tiehi_14 \$5010 VPWR VGND sg13cmos5l_tiehi
* cell instance sg13cmos5l_tiehi_15 r0 *1 0,0
Xsg13cmos5l_tiehi_15 \$5023 VPWR VGND sg13cmos5l_tiehi
* cell instance sg13cmos5l_tiehi_16 r0 *1 0,0
Xsg13cmos5l_tiehi_16 \$4041 VPWR VGND sg13cmos5l_tiehi
* cell instance sg13cmos5l_tiehi_17 r0 *1 0,0
Xsg13cmos5l_tiehi_17 \$5041 VPWR VGND sg13cmos5l_tiehi
* cell instance sg13cmos5l_tielo_0 r0 *1 0,0
Xsg13cmos5l_tielo_0 \$5311 VPWR VGND sg13cmos5l_tielo
* cell instance sg13cmos5l_tielo_1 r0 *1 0,0
Xsg13cmos5l_tielo_1 \$4611 VPWR VGND sg13cmos5l_tielo
* cell instance sg13cmos5l_tielo_2 r0 *1 0,0
Xsg13cmos5l_tielo_2 \$4808 VPWR VGND sg13cmos5l_tielo
* cell instance sg13cmos5l_tielo_3 r0 *1 0,0
Xsg13cmos5l_tielo_3 \$4814 VPWR VGND sg13cmos5l_tielo
* cell instance sg13cmos5l_tielo_4 r0 *1 0,0
Xsg13cmos5l_tielo_4 \$4822 VPWR VGND sg13cmos5l_tielo
* cell instance sg13cmos5l_tielo_5 r0 *1 0,0
Xsg13cmos5l_tielo_5 \$4826 VPWR VGND sg13cmos5l_tielo
* cell instance sg13cmos5l_tielo_6 r0 *1 0,0
Xsg13cmos5l_tielo_6 \$4836 VPWR VGND sg13cmos5l_tielo
* cell instance sg13cmos5l_tielo_7 r0 *1 0,0
Xsg13cmos5l_tielo_7 \$4842 VPWR VGND sg13cmos5l_tielo
* cell instance sg13cmos5l_tielo_8 r0 *1 0,0
Xsg13cmos5l_tielo_8 \$4850 VPWR VGND sg13cmos5l_tielo
* cell instance sg13cmos5l_tielo_9 r0 *1 0,0
Xsg13cmos5l_tielo_9 \$4854 VPWR VGND sg13cmos5l_tielo
* cell instance sg13cmos5l_tielo_10 r0 *1 0,0
Xsg13cmos5l_tielo_10 \$4862 VPWR VGND sg13cmos5l_tielo
* cell instance sg13cmos5l_tielo_11 r0 *1 0,0
Xsg13cmos5l_tielo_11 \$4866 VPWR VGND sg13cmos5l_tielo
* cell instance sg13cmos5l_tielo_12 r0 *1 0,0
Xsg13cmos5l_tielo_12 \$4874 VPWR VGND sg13cmos5l_tielo
* cell instance sg13cmos5l_tielo_13 r0 *1 0,0
Xsg13cmos5l_tielo_13 \$4878 VPWR VGND sg13cmos5l_tielo
* cell instance sg13cmos5l_tielo_14 r0 *1 0,0
Xsg13cmos5l_tielo_14 \$4892 VPWR VGND sg13cmos5l_tielo
* cell instance sg13cmos5l_tielo_15 r0 *1 0,0
Xsg13cmos5l_tielo_15 \$4886 VPWR VGND sg13cmos5l_tielo
* cell instance sg13cmos5l_tielo_16 r0 *1 0,0
Xsg13cmos5l_tielo_16 \$4554 VPWR VGND sg13cmos5l_tielo
* cell instance sg13cmos5l_tielo_17 r0 *1 0,0
Xsg13cmos5l_tielo_17 \$4555 VPWR VGND sg13cmos5l_tielo
* cell instance sg13cmos5l_tielo_18 r0 *1 0,0
Xsg13cmos5l_tielo_18 \$4556 VPWR VGND sg13cmos5l_tielo
* cell instance sg13cmos5l_tielo_19 r0 *1 0,0
Xsg13cmos5l_tielo_19 \$4202 VPWR VGND sg13cmos5l_tielo
* cell instance sg13cmos5l_tielo_20 r0 *1 0,0
Xsg13cmos5l_tielo_20 \$4557 VPWR VGND sg13cmos5l_tielo
* cell instance sg13cmos5l_tielo_21 r0 *1 0,0
Xsg13cmos5l_tielo_21 \$4910 VPWR VGND sg13cmos5l_tielo
* cell instance sg13cmos5l_tielo_22 r0 *1 0,0
Xsg13cmos5l_tielo_22 \$4210 VPWR VGND sg13cmos5l_tielo
* cell instance sg13cmos5l_tielo_23 r0 *1 0,0
Xsg13cmos5l_tielo_23 \$4641 VPWR VGND sg13cmos5l_tielo
* cell instance sg13cmos5l_tielo_24 r0 *1 0,0
Xsg13cmos5l_tielo_24 \$4214 VPWR VGND sg13cmos5l_tielo
* cell instance sg13cmos5l_tielo_25 r0 *1 0,0
Xsg13cmos5l_tielo_25 \$5631 VPWR VGND sg13cmos5l_tielo
* cell instance sg13cmos5l_tielo_26 r0 *1 0,0
Xsg13cmos5l_tielo_26 \$4558 VPWR VGND sg13cmos5l_tielo
* cell instance sg13cmos5l_tielo_27 r0 *1 0,0
Xsg13cmos5l_tielo_27 \$4559 VPWR VGND sg13cmos5l_tielo
* cell instance sg13cmos5l_tielo_28 r0 *1 0,0
Xsg13cmos5l_tielo_28 \$4925 VPWR VGND sg13cmos5l_tielo
* cell instance sg13cmos5l_tielo_29 r0 *1 0,0
Xsg13cmos5l_tielo_29 \$4936 VPWR VGND sg13cmos5l_tielo
* cell instance sg13cmos5l_tielo_30 r0 *1 0,0
Xsg13cmos5l_tielo_30 \$4940 VPWR VGND sg13cmos5l_tielo
* cell instance sg13cmos5l_tielo_31 r0 *1 0,0
Xsg13cmos5l_tielo_31 \$4948 VPWR VGND sg13cmos5l_tielo
* cell instance sg13cmos5l_tielo_32 r0 *1 0,0
Xsg13cmos5l_tielo_32 \$4956 VPWR VGND sg13cmos5l_tielo
* cell instance sg13cmos5l_tielo_33 r0 *1 0,0
Xsg13cmos5l_tielo_33 \$4966 VPWR VGND sg13cmos5l_tielo
* cell instance sg13cmos5l_tielo_34 r0 *1 0,0
Xsg13cmos5l_tielo_34 \$4972 VPWR VGND sg13cmos5l_tielo
* cell instance sg13cmos5l_tielo_35 r0 *1 0,0
Xsg13cmos5l_tielo_35 \$4982 VPWR VGND sg13cmos5l_tielo
* cell instance sg13cmos5l_tielo_36 r0 *1 0,0
Xsg13cmos5l_tielo_36 \$4986 VPWR VGND sg13cmos5l_tielo
* cell instance sg13cmos5l_tielo_37 r0 *1 0,0
Xsg13cmos5l_tielo_37 \$5002 VPWR VGND sg13cmos5l_tielo
* cell instance sg13cmos5l_tielo_38 r0 *1 0,0
Xsg13cmos5l_tielo_38 \$5000 VPWR VGND sg13cmos5l_tielo
* cell instance sg13cmos5l_tielo_39 r0 *1 0,0
Xsg13cmos5l_tielo_39 \$5013 VPWR VGND sg13cmos5l_tielo
* cell instance sg13cmos5l_tielo_40 r0 *1 0,0
Xsg13cmos5l_tielo_40 \$5017 VPWR VGND sg13cmos5l_tielo
* cell instance sg13cmos5l_tielo_41 r0 *1 0,0
Xsg13cmos5l_tielo_41 \$5026 VPWR VGND sg13cmos5l_tielo
* cell instance sg13cmos5l_tielo_42 r0 *1 0,0
Xsg13cmos5l_tielo_42 \$5030 VPWR VGND sg13cmos5l_tielo
* cell instance sg13cmos5l_tielo_43 r0 *1 0,0
Xsg13cmos5l_tielo_43 \$5045 VPWR VGND sg13cmos5l_tielo
* cell instance sg13cmos5l_tielo_44 r0 *1 0,0
Xsg13cmos5l_tielo_44 \$5285 VPWR VGND sg13cmos5l_tielo
* cell instance sg13cmos5l_xnor2_1_0 r0 *1 0,0
Xsg13cmos5l_xnor2_1_0 \$5698 \$5697 VPWR VGND \$5237 sg13cmos5l_xnor2_1
* cell instance sg13cmos5l_xnor2_1_1 r0 *1 0,0
Xsg13cmos5l_xnor2_1_1 \$7009 \$5699 VPWR VGND \$6959 sg13cmos5l_xnor2_1
* cell instance sg13cmos5l_xnor2_1_2 r0 *1 0,0
Xsg13cmos5l_xnor2_1_2 \$5700 \$5699 VPWR VGND \$5697 sg13cmos5l_xnor2_1
* cell instance sg13cmos5l_xnor2_1_3 r0 *1 0,0
Xsg13cmos5l_xnor2_1_3 \$7010 \$6702 VPWR VGND \$7009 sg13cmos5l_xnor2_1
* cell instance sg13cmos5l_xnor2_1_4 r0 *1 0,0
Xsg13cmos5l_xnor2_1_4 \$6238 \$6186 VPWR VGND \$5698 sg13cmos5l_xnor2_1
* cell instance sg13cmos5l_xnor2_1_5 r0 *1 0,0
Xsg13cmos5l_xnor2_1_5 \$6240 \$6239 VPWR VGND \$6241 sg13cmos5l_xnor2_1
* cell instance sg13cmos5l_xnor2_1_6 r0 *1 0,0
Xsg13cmos5l_xnor2_1_6 \$6562 \$6561 VPWR VGND \$6498 sg13cmos5l_xnor2_1
* cell instance sg13cmos5l_xnor2_1_7 r0 *1 0,0
Xsg13cmos5l_xnor2_1_7 \$5250 \$6498 VPWR VGND \$6702 sg13cmos5l_xnor2_1
* cell instance sg13cmos5l_xnor2_1_8 r0 *1 0,0
Xsg13cmos5l_xnor2_1_8 \$6429 \$7010 VPWR VGND \$6705 sg13cmos5l_xnor2_1
* cell instance sg13cmos5l_xnor2_1_9 r0 *1 0,0
Xsg13cmos5l_xnor2_1_9 \$7254 \$7253 VPWR VGND \$7012 sg13cmos5l_xnor2_1
* cell instance sg13cmos5l_xnor2_1_10 r0 *1 0,0
Xsg13cmos5l_xnor2_1_10 \$6564 \$7253 VPWR VGND \$7580 sg13cmos5l_xnor2_1
* cell instance sg13cmos5l_xnor2_1_11 r0 *1 0,0
Xsg13cmos5l_xnor2_1_11 \$5702 \$7580 VPWR VGND \$7540 sg13cmos5l_xnor2_1
* cell instance sg13cmos5l_xnor2_1_12 r0 *1 0,0
Xsg13cmos5l_xnor2_1_12 \$6240 \$5702 VPWR VGND \$5586 sg13cmos5l_xnor2_1
* cell instance sg13cmos5l_xnor2_1_13 r0 *1 0,0
Xsg13cmos5l_xnor2_1_13 \$6564 \$6974 VPWR VGND \$6429 sg13cmos5l_xnor2_1
* cell instance sg13cmos5l_xnor2_1_14 r0 *1 0,0
Xsg13cmos5l_xnor2_1_14 \$4577 \$7012 VPWR VGND \$7010 sg13cmos5l_xnor2_1
* cell instance sg13cmos5l_xnor2_1_15 r0 *1 0,0
Xsg13cmos5l_xnor2_1_15 \$7529 \$6429 VPWR VGND \$5909 sg13cmos5l_xnor2_1
* cell instance sg13cmos5l_xnor2_1_16 r0 *1 0,0
Xsg13cmos5l_xnor2_1_16 \$5199 \$6369 VPWR VGND \$6186 sg13cmos5l_xnor2_1
* cell instance sg13cmos5l_xnor2_1_17 r0 *1 0,0
Xsg13cmos5l_xnor2_1_17 \$5699 \$6767 VPWR VGND \$5702 sg13cmos5l_xnor2_1
* cell instance sg13cmos5l_xnor2_1_18 r0 *1 0,0
Xsg13cmos5l_xnor2_1_18 \$7651 \$7013 VPWR VGND \$7203 sg13cmos5l_xnor2_1
* cell instance sg13cmos5l_xnor2_1_19 r0 *1 0,0
Xsg13cmos5l_xnor2_1_19 \$7255 \$5833 VPWR VGND \$6564 sg13cmos5l_xnor2_1
* cell instance sg13cmos5l_xnor2_1_20 r0 *1 0,0
Xsg13cmos5l_xnor2_1_20 \$4327 \$5909 VPWR VGND \$5699 sg13cmos5l_xnor2_1
* cell instance sg13cmos5l_xnor2_1_21 r0 *1 0,0
Xsg13cmos5l_xnor2_1_21 \$5176 \$6241 VPWR VGND \$6238 sg13cmos5l_xnor2_1
* cell instance sg13cmos5l_xnor2_1_22 r0 *1 0,0
Xsg13cmos5l_xnor2_1_22 \$5602 \$5700 VPWR VGND \$5705 sg13cmos5l_xnor2_1
* cell instance sg13cmos5l_xnor2_1_23 r0 *1 0,0
Xsg13cmos5l_xnor2_1_23 \$6372 \$7013 VPWR VGND \$7011 sg13cmos5l_xnor2_1
* cell instance sg13cmos5l_xnor2_1_24 r0 *1 0,0
Xsg13cmos5l_xnor2_1_24 \$7013 \$7204 VPWR VGND \$7253 sg13cmos5l_xnor2_1
* cell instance sg13cmos5l_xnor2_1_25 r0 *1 0,0
Xsg13cmos5l_xnor2_1_25 \$6067 \$6566 VPWR VGND \$6507 sg13cmos5l_xnor2_1
* cell instance sg13cmos5l_xnor2_1_26 r0 *1 0,0
Xsg13cmos5l_xnor2_1_26 \$5256 \$7203 VPWR VGND \$6767 sg13cmos5l_xnor2_1
* cell instance sg13cmos5l_xnor2_1_27 r0 *1 0,0
Xsg13cmos5l_xnor2_1_27 \$5612 \$5705 VPWR VGND \$5613 sg13cmos5l_xnor2_1
* cell instance sg13cmos5l_xnor2_1_28 r0 *1 0,0
Xsg13cmos5l_xnor2_1_28 \$5700 \$5257 VPWR VGND \$6240 sg13cmos5l_xnor2_1
* cell instance sg13cmos5l_xnor2_1_29 r0 *1 0,0
Xsg13cmos5l_xnor2_1_29 \$7262 \$7256 VPWR VGND \$7013 sg13cmos5l_xnor2_1
* cell instance sg13cmos5l_xnor2_1_30 r0 *1 0,0
Xsg13cmos5l_xnor2_1_30 \$4130 \$6565 VPWR VGND \$6236 sg13cmos5l_xnor2_1
* cell instance sg13cmos5l_xnor2_1_31 r0 *1 0,0
Xsg13cmos5l_xnor2_1_31 \$5308 \$4398 VPWR VGND \$5257 sg13cmos5l_xnor2_1
* cell instance sg13cmos5l_xnor2_1_32 r0 *1 0,0
Xsg13cmos5l_xnor2_1_32 \$5548 \$4679 VPWR VGND \$5700 sg13cmos5l_xnor2_1
* cell instance sg13cmos5l_xnor2_1_33 r0 *1 0,0
Xsg13cmos5l_xnor2_1_33 \$6236 \$5613 VPWR VGND \$6067 sg13cmos5l_xnor2_1
* cell instance sg13cmos5l_xnor2_1_34 r0 *1 0,0
Xsg13cmos5l_xnor2_1_34 \$7014 \$5078 VPWR VGND \$7204 sg13cmos5l_xnor2_1
* cell instance sg13cmos5l_xnor2_1_35 r0 *1 0,0
Xsg13cmos5l_xnor2_1_35 \$2160 \$1967 VPWR VGND \$2306 sg13cmos5l_xnor2_1
* cell instance sg13cmos5l_xnor2_1_36 r0 *1 0,0
Xsg13cmos5l_xnor2_1_36 \$6561 \$6208 VPWR VGND \$6372 sg13cmos5l_xnor2_1
* cell instance sg13cmos5l_xnor2_1_37 r0 *1 0,0
Xsg13cmos5l_xnor2_1_37 \$6204 \$3962 VPWR VGND \$6208 sg13cmos5l_xnor2_1
* cell instance sg13cmos5l_xnor2_1_38 r0 *1 0,0
Xsg13cmos5l_xnor2_1_38 \$6713 \$5130 VPWR VGND \$6974 sg13cmos5l_xnor2_1
* cell instance sg13cmos5l_xnor2_1_39 r0 *1 0,0
Xsg13cmos5l_xnor2_1_39 \$1449 \$1645 VPWR VGND \$1646 sg13cmos5l_xnor2_1
* cell instance sg13cmos5l_xnor2_1_40 r0 *1 0,0
Xsg13cmos5l_xnor2_1_40 \$6572 \$5207 VPWR VGND \$6561 sg13cmos5l_xnor2_1
* cell instance sg13cmos5l_xnor2_1_41 r0 *1 0,0
Xsg13cmos5l_xnor2_1_41 \$1166 \$1851 VPWR VGND \$2168 sg13cmos5l_xnor2_1
* cell instance sg13cmos5l_xnor2_1_42 r0 *1 0,0
Xsg13cmos5l_xnor2_1_42 \$54 \$210 VPWR VGND \$201 sg13cmos5l_xnor2_1
* cell instance sg13cmos5l_xnor2_1_43 r0 *1 0,0
Xsg13cmos5l_xnor2_1_43 \$3605 \$3759 VPWR VGND \$3947 sg13cmos5l_xnor2_1
* cell instance sg13cmos5l_xnor2_1_44 r0 *1 0,0
Xsg13cmos5l_xnor2_1_44 \$147 \$186 VPWR VGND \$316 sg13cmos5l_xnor2_1
* cell instance sg13cmos5l_xnor2_1_45 r0 *1 0,0
Xsg13cmos5l_xnor2_1_45 \$3360 \$3499 VPWR VGND \$3159 sg13cmos5l_xnor2_1
* cell instance sg13cmos5l_xnor2_1_46 r0 *1 0,0
Xsg13cmos5l_xnor2_1_46 \$3099 \$3618 VPWR VGND \$3229 sg13cmos5l_xnor2_1
* cell instance sg13cmos5l_xnor2_1_47 r0 *1 0,0
Xsg13cmos5l_xnor2_1_47 \$3792 \$3790 VPWR VGND \$3090 sg13cmos5l_xnor2_1
* cell instance sg13cmos5l_xnor2_1_48 r0 *1 0,0
Xsg13cmos5l_xnor2_1_48 \$3792 \$3795 VPWR VGND \$3163 sg13cmos5l_xnor2_1
* cell instance sg13cmos5l_xnor2_1_49 r0 *1 0,0
Xsg13cmos5l_xnor2_1_49 \$804 \$5 VPWR VGND \$927 sg13cmos5l_xnor2_1
* cell instance sg13cmos5l_xnor2_1_50 r0 *1 0,0
Xsg13cmos5l_xnor2_1_50 \$12 \$5 VPWR VGND \$37 sg13cmos5l_xnor2_1
* cell instance sg13cmos5l_xnor2_1_51 r0 *1 0,0
Xsg13cmos5l_xnor2_1_51 \$3360 \$3512 VPWR VGND \$3501 sg13cmos5l_xnor2_1
* cell instance sg13cmos5l_xnor2_1_52 r0 *1 0,0
Xsg13cmos5l_xnor2_1_52 \$27 \$5 VPWR VGND \$580 sg13cmos5l_xnor2_1
* cell instance sg13cmos5l_xnor2_1_53 r0 *1 0,0
Xsg13cmos5l_xnor2_1_53 \$3815 \$3823 VPWR VGND \$3820 sg13cmos5l_xnor2_1
* cell instance sg13cmos5l_xnor2_1_54 r0 *1 0,0
Xsg13cmos5l_xnor2_1_54 \$2218 \$2513 VPWR VGND \$2511 sg13cmos5l_xnor2_1
* cell instance sg13cmos5l_xnor2_1_55 r0 *1 0,0
Xsg13cmos5l_xnor2_1_55 \$42 \$41 VPWR VGND \$498 sg13cmos5l_xnor2_1
* cell instance sg13cmos5l_xnor2_1_56 r0 *1 0,0
Xsg13cmos5l_xnor2_1_56 \$3006 \$2661 VPWR VGND \$3241 sg13cmos5l_xnor2_1
* cell instance sg13cmos5l_xnor2_1_57 r0 *1 0,0
Xsg13cmos5l_xnor2_1_57 \$2513 \$2221 VPWR VGND \$2426 sg13cmos5l_xnor2_1
* cell instance sg13cmos5l_xnor2_1_58 r0 *1 0,0
Xsg13cmos5l_xnor2_1_58 \$3113 \$3112 VPWR VGND \$3375 sg13cmos5l_xnor2_1
* cell instance sg13cmos5l_xnor2_1_59 r0 *1 0,0
Xsg13cmos5l_xnor2_1_59 \$3006 \$2664 VPWR VGND \$2951 sg13cmos5l_xnor2_1
* cell instance sg13cmos5l_xnor2_1_60 r0 *1 0,0
Xsg13cmos5l_xnor2_1_60 \$3113 \$3116 VPWR VGND \$2947 sg13cmos5l_xnor2_1
* cell instance sg13cmos5l_xnor2_1_61 r0 *1 0,0
Xsg13cmos5l_xnor2_1_61 \$2362 \$2365 VPWR VGND \$2423 sg13cmos5l_xnor2_1
* cell instance sg13cmos5l_xnor2_1_62 r0 *1 0,0
Xsg13cmos5l_xnor2_1_62 \$4069 \$4530 VPWR VGND \$4287 sg13cmos5l_xnor2_1
* cell instance sg13cmos5l_xnor2_1_63 r0 *1 0,0
Xsg13cmos5l_xnor2_1_63 \$4059 \$4049 VPWR VGND \$4715 sg13cmos5l_xnor2_1
* cell instance sg13cmos5l_xor2_1_0 r0 *1 0,0
Xsg13cmos5l_xor2_1_0 \$5698 \$6236 VPWR VGND \$6356 sg13cmos5l_xor2_1
* cell instance sg13cmos5l_xor2_1_1 r0 *1 0,0
Xsg13cmos5l_xor2_1_1 \$6067 \$7010 VPWR VGND \$6963 sg13cmos5l_xor2_1
* cell instance sg13cmos5l_xor2_1_2 r0 *1 0,0
Xsg13cmos5l_xor2_1_2 \$6365 \$6564 VPWR VGND \$6239 sg13cmos5l_xor2_1
* cell instance sg13cmos5l_xor2_1_3 r0 *1 0,0
Xsg13cmos5l_xor2_1_3 \$6178 \$6429 VPWR VGND \$6369 sg13cmos5l_xor2_1
* cell instance sg13cmos5l_xor2_1_4 r0 *1 0,0
Xsg13cmos5l_xor2_1_4 \$6697 \$6372 VPWR VGND \$6565 sg13cmos5l_xor2_1
* cell instance sg13cmos5l_xor2_1_5 r0 *1 0,0
Xsg13cmos5l_xor2_1_5 \$6238 \$6372 VPWR VGND \$6192 sg13cmos5l_xor2_1
* cell instance sg13cmos5l_xor2_1_6 r0 *1 0,0
Xsg13cmos5l_xor2_1_6 \$6236 \$7253 VPWR VGND \$7324 sg13cmos5l_xor2_1
* cell instance sg13cmos5l_xor2_1_7 r0 *1 0,0
Xsg13cmos5l_xor2_1_7 \$6240 \$6561 VPWR VGND \$6566 sg13cmos5l_xor2_1
* cell instance sg13cmos5l_xor2_1_8 r0 *1 0,0
Xsg13cmos5l_xor2_1_8 \$1436 \$2159 VPWR VGND \$2443 sg13cmos5l_xor2_1
* cell instance sg13cmos5l_xor2_1_9 r0 *1 0,0
Xsg13cmos5l_xor2_1_9 \$1193 \$1062 VPWR VGND \$2039 sg13cmos5l_xor2_1
* cell instance sg13cmos5l_xor2_1_10 r0 *1 0,0
Xsg13cmos5l_xor2_1_10 \$3099 \$3788 VPWR VGND \$2932 sg13cmos5l_xor2_1
* cell instance sg13cmos5l_xor2_1_11 r0 *1 0,0
Xsg13cmos5l_xor2_1_11 \$3504 \$3624 VPWR VGND \$2649 sg13cmos5l_xor2_1
* cell instance sg13cmos5l_xor2_1_12 r0 *1 0,0
Xsg13cmos5l_xor2_1_12 \$3504 \$3509 VPWR VGND \$2779 sg13cmos5l_xor2_1
* cell instance sg13cmos5l_xor2_1_13 r0 *1 0,0
Xsg13cmos5l_xor2_1_13 \$4006 \$3832 VPWR VGND \$3639 sg13cmos5l_xor2_1
* cell instance sg13cmos5l_xor2_1_14 r0 *1 0,0
Xsg13cmos5l_xor2_1_14 \$2351 \$2357 VPWR VGND \$2509 sg13cmos5l_xor2_1
* cell instance sg13cmos5l_xor2_1_15 r0 *1 0,0
Xsg13cmos5l_xor2_1_15 \$3834 \$3529 VPWR VGND \$3530 sg13cmos5l_xor2_1
* cell instance sg13cmos5l_xor2_1_16 r0 *1 0,0
Xsg13cmos5l_xor2_1_16 \$3839 \$3535 VPWR VGND \$3540 sg13cmos5l_xor2_1
* cell instance sg13cmos5l_xor2_1_17 r0 *1 0,0
Xsg13cmos5l_xor2_1_17 \$3693 \$3694 VPWR VGND \$3865 sg13cmos5l_xor2_1
.ENDS tt_um_2amlogic_protocol_emulator

* cell sg13cmos5l_xor2_1
* pin A
* pin B
* pin VDD
* pin VSS
* pin X
.SUBCKT sg13cmos5l_xor2_1 A B VDD VSS X
.ENDS sg13cmos5l_xor2_1

* cell sg13cmos5l_xnor2_1
* pin A
* pin B
* pin VDD
* pin VSS
* pin Y
.SUBCKT sg13cmos5l_xnor2_1 A B VDD VSS Y
.ENDS sg13cmos5l_xnor2_1

* cell sg13cmos5l_tielo
* pin L_LO
* pin VDD
* pin VSS
.SUBCKT sg13cmos5l_tielo L_LO VDD VSS
.ENDS sg13cmos5l_tielo

* cell sg13cmos5l_tiehi
* pin L_HI
* pin VDD
* pin VSS
.SUBCKT sg13cmos5l_tiehi L_HI VDD VSS
.ENDS sg13cmos5l_tiehi

* cell sg13cmos5l_or4_1
* pin A
* pin B
* pin C
* pin D
* pin VDD
* pin VSS
* pin X
.SUBCKT sg13cmos5l_or4_1 A B C D VDD VSS X
.ENDS sg13cmos5l_or4_1

* cell sg13cmos5l_or3_1
* pin A
* pin B
* pin C
* pin VDD
* pin VSS
* pin X
.SUBCKT sg13cmos5l_or3_1 A B C VDD VSS X
.ENDS sg13cmos5l_or3_1

* cell sg13cmos5l_or2_1
* pin A
* pin B
* pin VDD
* pin VSS
* pin X
.SUBCKT sg13cmos5l_or2_1 A B VDD VSS X
.ENDS sg13cmos5l_or2_1

* cell sg13cmos5l_o21ai_1
* pin A1
* pin A2
* pin B1
* pin VDD
* pin VSS
* pin Y
.SUBCKT sg13cmos5l_o21ai_1 A1 A2 B1 VDD VSS Y
.ENDS sg13cmos5l_o21ai_1

* cell sg13cmos5l_nor4_1
* pin A
* pin B
* pin C
* pin D
* pin VDD
* pin VSS
* pin Y
.SUBCKT sg13cmos5l_nor4_1 A B C D VDD VSS Y
.ENDS sg13cmos5l_nor4_1

* cell sg13cmos5l_nor3_1
* pin A
* pin B
* pin C
* pin VDD
* pin VSS
* pin Y
.SUBCKT sg13cmos5l_nor3_1 A B C VDD VSS Y
.ENDS sg13cmos5l_nor3_1

* cell sg13cmos5l_nor2b_1
* pin A
* pin B_N
* pin VDD
* pin VSS
* pin Y
.SUBCKT sg13cmos5l_nor2b_1 A B_N VDD VSS Y
.ENDS sg13cmos5l_nor2b_1

* cell sg13cmos5l_nor2_1
* pin A
* pin B
* pin VDD
* pin VSS
* pin Y
.SUBCKT sg13cmos5l_nor2_1 A B VDD VSS Y
.ENDS sg13cmos5l_nor2_1

* cell sg13cmos5l_nand4_1
* pin A
* pin B
* pin C
* pin D
* pin VDD
* pin VSS
* pin Y
.SUBCKT sg13cmos5l_nand4_1 A B C D VDD VSS Y
.ENDS sg13cmos5l_nand4_1

* cell sg13cmos5l_nand3b_1
* pin A_N
* pin B
* pin C
* pin VDD
* pin VSS
* pin Y
.SUBCKT sg13cmos5l_nand3b_1 A_N B C VDD VSS Y
.ENDS sg13cmos5l_nand3b_1

* cell sg13cmos5l_nand3_1
* pin A
* pin B
* pin C
* pin VDD
* pin VSS
* pin Y
.SUBCKT sg13cmos5l_nand3_1 A B C VDD VSS Y
.ENDS sg13cmos5l_nand3_1

* cell sg13cmos5l_nand2b_1
* pin A_N
* pin B
* pin VDD
* pin VSS
* pin Y
.SUBCKT sg13cmos5l_nand2b_1 A_N B VDD VSS Y
.ENDS sg13cmos5l_nand2b_1

* cell sg13cmos5l_nand2_1
* pin A
* pin B
* pin VDD
* pin VSS
* pin Y
.SUBCKT sg13cmos5l_nand2_1 A B VDD VSS Y
.ENDS sg13cmos5l_nand2_1

* cell sg13cmos5l_mux4_1
* pin A0
* pin A1
* pin A2
* pin A3
* pin S0
* pin S1
* pin VDD
* pin VSS
* pin X
.SUBCKT sg13cmos5l_mux4_1 A0 A1 A2 A3 S0 S1 VDD VSS X
.ENDS sg13cmos5l_mux4_1

* cell sg13cmos5l_mux2_1
* pin A0
* pin A1
* pin S
* pin VDD
* pin VSS
* pin X
.SUBCKT sg13cmos5l_mux2_1 A0 A1 S VDD VSS X
.ENDS sg13cmos5l_mux2_1

* cell sg13cmos5l_inv_1
* pin A
* pin VDD
* pin VSS
* pin Y
.SUBCKT sg13cmos5l_inv_1 A VDD VSS Y
.ENDS sg13cmos5l_inv_1

* cell sg13cmos5l_fill_2
* pin VDD
* pin VSS
.SUBCKT sg13cmos5l_fill_2 VDD VSS
.ENDS sg13cmos5l_fill_2

* cell sg13cmos5l_fill_1
* pin VDD
* pin VSS
.SUBCKT sg13cmos5l_fill_1 VDD VSS
.ENDS sg13cmos5l_fill_1

* cell sg13cmos5l_dlygate4sd3_1
* pin A
* pin VDD
* pin VSS
* pin X
.SUBCKT sg13cmos5l_dlygate4sd3_1 A VDD VSS X
.ENDS sg13cmos5l_dlygate4sd3_1

* cell sg13cmos5l_dfrbpq_1
* pin CLK
* pin D
* pin Q
* pin RESET_B
* pin VDD
* pin VSS
.SUBCKT sg13cmos5l_dfrbpq_1 CLK D Q RESET_B VDD VSS
.ENDS sg13cmos5l_dfrbpq_1

* cell sg13cmos5l_decap_8
* pin VDD
* pin VSS
.SUBCKT sg13cmos5l_decap_8 VDD VSS
.ENDS sg13cmos5l_decap_8

* cell sg13cmos5l_decap_4
* pin VDD
* pin VSS
.SUBCKT sg13cmos5l_decap_4 VDD VSS
.ENDS sg13cmos5l_decap_4

* cell sg13cmos5l_buf_8
* pin A
* pin VDD
* pin VSS
* pin X
.SUBCKT sg13cmos5l_buf_8 A VDD VSS X
.ENDS sg13cmos5l_buf_8

* cell sg13cmos5l_buf_4
* pin A
* pin VDD
* pin VSS
* pin X
.SUBCKT sg13cmos5l_buf_4 A VDD VSS X
.ENDS sg13cmos5l_buf_4

* cell sg13cmos5l_buf_1
* pin A
* pin VDD
* pin VSS
* pin X
.SUBCKT sg13cmos5l_buf_1 A VDD VSS X
.ENDS sg13cmos5l_buf_1

* cell sg13cmos5l_antennanp
* pin A
* pin VDD
* pin VSS
.SUBCKT sg13cmos5l_antennanp A VDD VSS
.ENDS sg13cmos5l_antennanp

* cell sg13cmos5l_and4_1
* pin A
* pin B
* pin C
* pin D
* pin VDD
* pin VSS
* pin X
.SUBCKT sg13cmos5l_and4_1 A B C D VDD VSS X
.ENDS sg13cmos5l_and4_1

* cell sg13cmos5l_and3_1
* pin A
* pin B
* pin C
* pin VDD
* pin VSS
* pin X
.SUBCKT sg13cmos5l_and3_1 A B C VDD VSS X
.ENDS sg13cmos5l_and3_1

* cell sg13cmos5l_and2_1
* pin A
* pin B
* pin VDD
* pin VSS
* pin X
.SUBCKT sg13cmos5l_and2_1 A B VDD VSS X
.ENDS sg13cmos5l_and2_1

* cell sg13cmos5l_a22oi_1
* pin A1
* pin A2
* pin B1
* pin B2
* pin VDD
* pin VSS
* pin Y
.SUBCKT sg13cmos5l_a22oi_1 A1 A2 B1 B2 VDD VSS Y
.ENDS sg13cmos5l_a22oi_1

* cell sg13cmos5l_a221oi_1
* pin A1
* pin A2
* pin B1
* pin B2
* pin C1
* pin VDD
* pin VSS
* pin Y
.SUBCKT sg13cmos5l_a221oi_1 A1 A2 B1 B2 C1 VDD VSS Y
.ENDS sg13cmos5l_a221oi_1

* cell sg13cmos5l_a21oi_1
* pin A1
* pin A2
* pin B1
* pin VDD
* pin VSS
* pin Y
.SUBCKT sg13cmos5l_a21oi_1 A1 A2 B1 VDD VSS Y
.ENDS sg13cmos5l_a21oi_1

* cell sg13cmos5l_a21o_1
* pin A1
* pin A2
* pin B1
* pin VDD
* pin VSS
* pin X
.SUBCKT sg13cmos5l_a21o_1 A1 A2 B1 VDD VSS X
.ENDS sg13cmos5l_a21o_1

* cell RM_IHPSG13_1P_256x16_c2_bm_bist
* pin A_ADDR<0>
* pin A_ADDR<1>
* pin A_ADDR<2>
* pin A_ADDR<3>
* pin A_ADDR<4>
* pin A_ADDR<5>
* pin A_ADDR<6>
* pin A_ADDR<7>
* pin A_BIST_ADDR<0>
* pin A_BIST_ADDR<1>
* pin A_BIST_ADDR<2>
* pin A_BIST_ADDR<3>
* pin A_BIST_ADDR<4>
* pin A_BIST_ADDR<5>
* pin A_BIST_ADDR<6>
* pin A_BIST_ADDR<7>
* pin A_BIST_BM<0>
* pin A_BIST_BM<10>
* pin A_BIST_BM<11>
* pin A_BIST_BM<12>
* pin A_BIST_BM<13>
* pin A_BIST_BM<14>
* pin A_BIST_BM<15>
* pin A_BIST_BM<1>
* pin A_BIST_BM<2>
* pin A_BIST_BM<3>
* pin A_BIST_BM<4>
* pin A_BIST_BM<5>
* pin A_BIST_BM<6>
* pin A_BIST_BM<7>
* pin A_BIST_BM<8>
* pin A_BIST_BM<9>
* pin A_BIST_CLK
* pin A_BIST_DIN<0>
* pin A_BIST_DIN<10>
* pin A_BIST_DIN<11>
* pin A_BIST_DIN<12>
* pin A_BIST_DIN<13>
* pin A_BIST_DIN<14>
* pin A_BIST_DIN<15>
* pin A_BIST_DIN<1>
* pin A_BIST_DIN<2>
* pin A_BIST_DIN<3>
* pin A_BIST_DIN<4>
* pin A_BIST_DIN<5>
* pin A_BIST_DIN<6>
* pin A_BIST_DIN<7>
* pin A_BIST_DIN<8>
* pin A_BIST_DIN<9>
* pin A_BIST_EN
* pin A_BIST_MEN
* pin A_BIST_REN
* pin A_BIST_WEN
* pin A_BM<0>
* pin A_BM<10>
* pin A_BM<11>
* pin A_BM<12>
* pin A_BM<13>
* pin A_BM<14>
* pin A_BM<15>
* pin A_BM<1>
* pin A_BM<2>
* pin A_BM<3>
* pin A_BM<4>
* pin A_BM<5>
* pin A_BM<6>
* pin A_BM<7>
* pin A_BM<8>
* pin A_BM<9>
* pin A_CLK
* pin A_DIN<0>
* pin A_DIN<10>
* pin A_DIN<11>
* pin A_DIN<12>
* pin A_DIN<13>
* pin A_DIN<14>
* pin A_DIN<15>
* pin A_DIN<1>
* pin A_DIN<2>
* pin A_DIN<3>
* pin A_DIN<4>
* pin A_DIN<5>
* pin A_DIN<6>
* pin A_DIN<7>
* pin A_DIN<8>
* pin A_DIN<9>
* pin A_DLY
* pin A_DOUT<0>
* pin A_DOUT<10>
* pin A_DOUT<11>
* pin A_DOUT<12>
* pin A_DOUT<13>
* pin A_DOUT<14>
* pin A_DOUT<15>
* pin A_DOUT<1>
* pin A_DOUT<2>
* pin A_DOUT<3>
* pin A_DOUT<4>
* pin A_DOUT<5>
* pin A_DOUT<6>
* pin A_DOUT<7>
* pin A_DOUT<8>
* pin A_DOUT<9>
* pin A_MEN
* pin A_REN
* pin A_WEN
* pin VDD!
* pin VDDARRAY!
* pin VSS!
.SUBCKT RM_IHPSG13_1P_256x16_c2_bm_bist A_ADDR<0> A_ADDR<1> A_ADDR<2> A_ADDR<3>
+ A_ADDR<4> A_ADDR<5> A_ADDR<6> A_ADDR<7> A_BIST_ADDR<0> A_BIST_ADDR<1>
+ A_BIST_ADDR<2> A_BIST_ADDR<3> A_BIST_ADDR<4> A_BIST_ADDR<5> A_BIST_ADDR<6>
+ A_BIST_ADDR<7> A_BIST_BM<0> A_BIST_BM<10> A_BIST_BM<11> A_BIST_BM<12>
+ A_BIST_BM<13> A_BIST_BM<14> A_BIST_BM<15> A_BIST_BM<1> A_BIST_BM<2>
+ A_BIST_BM<3> A_BIST_BM<4> A_BIST_BM<5> A_BIST_BM<6> A_BIST_BM<7> A_BIST_BM<8>
+ A_BIST_BM<9> A_BIST_CLK A_BIST_DIN<0> A_BIST_DIN<10> A_BIST_DIN<11>
+ A_BIST_DIN<12> A_BIST_DIN<13> A_BIST_DIN<14> A_BIST_DIN<15> A_BIST_DIN<1>
+ A_BIST_DIN<2> A_BIST_DIN<3> A_BIST_DIN<4> A_BIST_DIN<5> A_BIST_DIN<6>
+ A_BIST_DIN<7> A_BIST_DIN<8> A_BIST_DIN<9> A_BIST_EN A_BIST_MEN A_BIST_REN
+ A_BIST_WEN A_BM<0> A_BM<10> A_BM<11> A_BM<12> A_BM<13> A_BM<14> A_BM<15>
+ A_BM<1> A_BM<2> A_BM<3> A_BM<4> A_BM<5> A_BM<6> A_BM<7> A_BM<8> A_BM<9> A_CLK
+ A_DIN<0> A_DIN<10> A_DIN<11> A_DIN<12> A_DIN<13> A_DIN<14> A_DIN<15> A_DIN<1>
+ A_DIN<2> A_DIN<3> A_DIN<4> A_DIN<5> A_DIN<6> A_DIN<7> A_DIN<8> A_DIN<9> A_DLY
+ A_DOUT<0> A_DOUT<10> A_DOUT<11> A_DOUT<12> A_DOUT<13> A_DOUT<14> A_DOUT<15>
+ A_DOUT<1> A_DOUT<2> A_DOUT<3> A_DOUT<4> A_DOUT<5> A_DOUT<6> A_DOUT<7>
+ A_DOUT<8> A_DOUT<9> A_MEN A_REN A_WEN VDD! VDDARRAY! VSS!
.ENDS RM_IHPSG13_1P_256x16_c2_bm_bist
