* extracted by klt extract --deck sg13cmos5l

* cell tt_um_2amlogic_protocol_emulator
.SUBCKT tt_um_2amlogic_protocol_emulator
* cell instance RM_IHPSG13_1P_256x16_c2_bm_bist_0 r0 *1 0,0
XRM_IHPSG13_1P_256x16_c2_bm_bist_0 \$2 \$2 \$2 \$2 \$2 \$2 \$2 \$2 \$2 \$2 \$2
+ \$2 \$2 \$2 \$2 \$2 \$2 \$2 \$2 \$2 \$2 \$2 \$2 \$2 \$2 \$2 \$2 \$2 \$2 \$2
+ \$2 \$2 \$2 \$2 \$2 \$2 \$2 \$2 \$2 \$2 \$2 \$2 \$2 \$2 \$2 \$2 \$2 \$2 \$2
+ \$2 \$2 \$2 \$2 \$2 \$2 \$2 \$2 \$2 \$2 \$2 \$2 \$2 \$2 \$2 \$2 \$2 \$2 \$2
+ \$2 \$2 \$2 \$2 \$2 \$2 \$2 \$2 \$2 \$2 \$2 \$2 \$2 \$2 \$2 \$2 \$2 \$2 \$2
+ \$2 \$2 \$2 \$2 \$2 \$2 \$2 \$2 \$2 \$2 \$2 \$2 \$2 \$2 \$2 \$2 \$2 \$2 \$2
+ \$3917 \$2 \$1 RM_IHPSG13_1P_256x16_c2_bm_bist
* cell instance sg13cmos5l_a21o_1_0 r0 *1 0,0
Xsg13cmos5l_a21o_1_0 \$4613 \$3513 \$4081 \$2 \$1 \$5137 sg13cmos5l_a21o_1
* cell instance sg13cmos5l_a21o_1_1 r0 *1 0,0
Xsg13cmos5l_a21o_1_1 \$391 \$87 \$206 \$2 \$1 \$200 sg13cmos5l_a21o_1
* cell instance sg13cmos5l_a21o_1_2 r0 *1 0,0
Xsg13cmos5l_a21o_1_2 \$3018 \$3020 \$2921 \$2 \$1 \$2888 sg13cmos5l_a21o_1
* cell instance sg13cmos5l_a21o_1_3 r0 *1 0,0
Xsg13cmos5l_a21o_1_3 \$854 \$859 \$560 \$2 \$1 \$1088 sg13cmos5l_a21o_1
* cell instance sg13cmos5l_a21o_1_4 r0 *1 0,0
Xsg13cmos5l_a21o_1_4 \$391 \$875 \$365 \$2 \$1 \$1093 sg13cmos5l_a21o_1
* cell instance sg13cmos5l_a21o_1_5 r0 *1 0,0
Xsg13cmos5l_a21o_1_5 \$4046 \$7109 \$7275 \$2 \$1 \$7113 sg13cmos5l_a21o_1
* cell instance sg13cmos5l_a21o_1_6 r0 *1 0,0
Xsg13cmos5l_a21o_1_6 \$1336 \$1545 \$690 \$2 \$1 \$1096 sg13cmos5l_a21o_1
* cell instance sg13cmos5l_a21o_1_7 r0 *1 0,0
Xsg13cmos5l_a21o_1_7 \$260 \$255 \$256 \$2 \$1 \$257 sg13cmos5l_a21o_1
* cell instance sg13cmos5l_a21o_1_8 r0 *1 0,0
Xsg13cmos5l_a21o_1_8 \$455 \$448 \$142 \$2 \$1 \$452 sg13cmos5l_a21o_1
* cell instance sg13cmos5l_a21o_1_9 r0 *1 0,0
Xsg13cmos5l_a21o_1_9 \$506 \$180 \$662 \$2 \$1 \$660 sg13cmos5l_a21o_1
* cell instance sg13cmos5l_a21oi_1_0 r0 *1 0,0
Xsg13cmos5l_a21oi_1_0 \$5137 \$5140 \$6676 \$2 \$1 \$7106 sg13cmos5l_a21oi_1
* cell instance sg13cmos5l_a21oi_1_1 r0 *1 0,0
Xsg13cmos5l_a21oi_1_1 \$3517 \$3826 \$3790 \$2 \$1 \$4019 sg13cmos5l_a21oi_1
* cell instance sg13cmos5l_a21oi_1_2 r0 *1 0,0
Xsg13cmos5l_a21oi_1_2 \$5137 \$2921 \$7775 \$2 \$1 \$7627 sg13cmos5l_a21oi_1
* cell instance sg13cmos5l_a21oi_1_3 r0 *1 0,0
Xsg13cmos5l_a21oi_1_3 \$1544 \$2084 \$2943 \$2 \$1 \$2749 sg13cmos5l_a21oi_1
* cell instance sg13cmos5l_a21oi_1_4 r0 *1 0,0
Xsg13cmos5l_a21oi_1_4 \$5137 \$5140 \$4766 \$2 \$1 \$6577 sg13cmos5l_a21oi_1
* cell instance sg13cmos5l_a21oi_1_5 r0 *1 0,0
Xsg13cmos5l_a21oi_1_5 \$3068 \$3071 \$3274 \$2 \$1 \$3493 sg13cmos5l_a21oi_1
* cell instance sg13cmos5l_a21oi_1_6 r0 *1 0,0
Xsg13cmos5l_a21oi_1_6 \$3491 \$3520 \$4097 \$2 \$1 \$3830 sg13cmos5l_a21oi_1
* cell instance sg13cmos5l_a21oi_1_7 r0 *1 0,0
Xsg13cmos5l_a21oi_1_7 \$396 \$397 \$394 \$2 \$1 \$393 sg13cmos5l_a21oi_1
* cell instance sg13cmos5l_a21oi_1_8 r0 *1 0,0
Xsg13cmos5l_a21oi_1_8 \$1564 \$2084 \$1905 \$2 \$1 \$1888 sg13cmos5l_a21oi_1
* cell instance sg13cmos5l_a21oi_1_9 r0 *1 0,0
Xsg13cmos5l_a21oi_1_9 \$3491 \$3520 \$4157 \$2 \$1 \$4158 sg13cmos5l_a21oi_1
* cell instance sg13cmos5l_a21oi_1_10 r0 *1 0,0
Xsg13cmos5l_a21oi_1_10 \$1565 \$2084 \$2083 \$2 \$1 \$1934 sg13cmos5l_a21oi_1
* cell instance sg13cmos5l_a21oi_1_11 r0 *1 0,0
Xsg13cmos5l_a21oi_1_11 \$412 \$567 \$568 \$2 \$1 \$397 sg13cmos5l_a21oi_1
* cell instance sg13cmos5l_a21oi_1_12 r0 *1 0,0
Xsg13cmos5l_a21oi_1_12 \$3097 \$2921 \$3075 \$2 \$1 \$2083 sg13cmos5l_a21oi_1
* cell instance sg13cmos5l_a21oi_1_13 r0 *1 0,0
Xsg13cmos5l_a21oi_1_13 \$3833 \$5145 \$4767 \$2 \$1 \$5725 sg13cmos5l_a21oi_1
* cell instance sg13cmos5l_a21oi_1_14 r0 *1 0,0
Xsg13cmos5l_a21oi_1_14 \$365 \$571 \$409 \$2 \$1 \$95 sg13cmos5l_a21oi_1
* cell instance sg13cmos5l_a21oi_1_15 r0 *1 0,0
Xsg13cmos5l_a21oi_1_15 \$7705 \$2436 \$8720 \$2 \$1 \$8721 sg13cmos5l_a21oi_1
* cell instance sg13cmos5l_a21oi_1_16 r0 *1 0,0
Xsg13cmos5l_a21oi_1_16 \$412 \$239 \$410 \$2 \$1 \$238 sg13cmos5l_a21oi_1
* cell instance sg13cmos5l_a21oi_1_17 r0 *1 0,0
Xsg13cmos5l_a21oi_1_17 \$412 \$574 \$572 \$2 \$1 \$571 sg13cmos5l_a21oi_1
* cell instance sg13cmos5l_a21oi_1_18 r0 *1 0,0
Xsg13cmos5l_a21oi_1_18 \$2893 \$3495 \$2084 \$2 \$1 \$3270 sg13cmos5l_a21oi_1
* cell instance sg13cmos5l_a21oi_1_19 r0 *1 0,0
Xsg13cmos5l_a21oi_1_19 \$365 \$238 \$90 \$2 \$1 \$240 sg13cmos5l_a21oi_1
* cell instance sg13cmos5l_a21oi_1_20 r0 *1 0,0
Xsg13cmos5l_a21oi_1_20 \$2416 \$9624 \$2084 \$2 \$1 \$9184 sg13cmos5l_a21oi_1
* cell instance sg13cmos5l_a21oi_1_21 r0 *1 0,0
Xsg13cmos5l_a21oi_1_21 \$1575 \$1568 \$863 \$2 \$1 \$1108 sg13cmos5l_a21oi_1
* cell instance sg13cmos5l_a21oi_1_22 r0 *1 0,0
Xsg13cmos5l_a21oi_1_22 \$582 \$403 \$417 \$2 \$1 \$580 sg13cmos5l_a21oi_1
* cell instance sg13cmos5l_a21oi_1_23 r0 *1 0,0
Xsg13cmos5l_a21oi_1_23 \$247 \$403 \$417 \$2 \$1 \$418 sg13cmos5l_a21oi_1
* cell instance sg13cmos5l_a21oi_1_24 r0 *1 0,0
Xsg13cmos5l_a21oi_1_24 \$247 \$880 \$706 \$2 \$1 \$711 sg13cmos5l_a21oi_1
* cell instance sg13cmos5l_a21oi_1_25 r0 *1 0,0
Xsg13cmos5l_a21oi_1_25 \$589 \$572 \$718 \$2 \$1 \$872 sg13cmos5l_a21oi_1
* cell instance sg13cmos5l_a21oi_1_26 r0 *1 0,0
Xsg13cmos5l_a21oi_1_26 \$537 \$266 \$265 \$2 \$1 \$602 sg13cmos5l_a21oi_1
* cell instance sg13cmos5l_a21oi_1_27 r0 *1 0,0
Xsg13cmos5l_a21oi_1_27 \$133 \$284 \$139 \$2 \$1 \$282 sg13cmos5l_a21oi_1
* cell instance sg13cmos5l_a21oi_1_28 r0 *1 0,0
Xsg13cmos5l_a21oi_1_28 \$612 \$613 \$139 \$2 \$1 \$610 sg13cmos5l_a21oi_1
* cell instance sg13cmos5l_a21oi_1_29 r0 *1 0,0
Xsg13cmos5l_a21oi_1_29 \$132 \$606 \$139 \$2 \$1 \$140 sg13cmos5l_a21oi_1
* cell instance sg13cmos5l_a21oi_1_30 r0 *1 0,0
Xsg13cmos5l_a21oi_1_30 \$508 \$931 \$929 \$2 \$1 \$636 sg13cmos5l_a21oi_1
* cell instance sg13cmos5l_a21oi_1_31 r0 *1 0,0
Xsg13cmos5l_a21oi_1_31 \$931 \$1411 \$1406 \$2 \$1 \$1186 sg13cmos5l_a21oi_1
* cell instance sg13cmos5l_a21oi_1_32 r0 *1 0,0
Xsg13cmos5l_a21oi_1_32 \$22 \$20 \$21 \$2 \$1 \$61 sg13cmos5l_a21oi_1
* cell instance sg13cmos5l_a21oi_1_33 r0 *1 0,0
Xsg13cmos5l_a21oi_1_33 \$348 \$181 \$513 \$2 \$1 \$183 sg13cmos5l_a21oi_1
* cell instance sg13cmos5l_a221oi_1_0 r0 *1 0,0
Xsg13cmos5l_a221oi_1_0 \$5719 \$7272 \$6577 \$4076 \$7106 \$2 \$1 \$7109
+ sg13cmos5l_a221oi_1
* cell instance sg13cmos5l_a221oi_1_1 r0 *1 0,0
Xsg13cmos5l_a221oi_1_1 \$2762 \$3737 \$3501 \$3923 \$3828 \$2 \$1 \$2943
+ sg13cmos5l_a221oi_1
* cell instance sg13cmos5l_a221oi_1_2 r0 *1 0,0
Xsg13cmos5l_a221oi_1_2 \$2762 \$5361 \$3020 \$5359 \$5360 \$2 \$1 \$4762
+ sg13cmos5l_a221oi_1
* cell instance sg13cmos5l_a221oi_1_3 r0 *1 0,0
Xsg13cmos5l_a221oi_1_3 \$4081 \$2760 \$2893 \$8716 \$4763 \$2 \$1 \$8577
+ sg13cmos5l_a221oi_1
* cell instance sg13cmos5l_a221oi_1_4 r0 *1 0,0
Xsg13cmos5l_a221oi_1_4 \$2762 \$4098 \$3020 \$4766 \$6679 \$2 \$1 \$6578
+ sg13cmos5l_a221oi_1
* cell instance sg13cmos5l_a221oi_1_5 r0 *1 0,0
Xsg13cmos5l_a221oi_1_5 \$2762 \$3073 \$3501 \$3072 \$2891 \$2 \$1 \$1905
+ sg13cmos5l_a221oi_1
* cell instance sg13cmos5l_a221oi_1_6 r0 *1 0,0
Xsg13cmos5l_a221oi_1_6 \$3257 \$2759 \$9182 \$2893 \$4763 \$2 \$1 \$8717
+ sg13cmos5l_a221oi_1
* cell instance sg13cmos5l_a221oi_1_7 r0 *1 0,0
Xsg13cmos5l_a221oi_1_7 \$2762 \$3832 \$3020 \$3491 \$4045 \$2 \$1 \$3924
+ sg13cmos5l_a221oi_1
* cell instance sg13cmos5l_a221oi_1_8 r0 *1 0,0
Xsg13cmos5l_a221oi_1_8 \$4091 \$2759 \$9622 \$2893 \$4763 \$2 \$1 \$4428
+ sg13cmos5l_a221oi_1
* cell instance sg13cmos5l_a221oi_1_9 r0 *1 0,0
Xsg13cmos5l_a221oi_1_9 \$2731 \$5799 \$3020 \$4046 \$6681 \$2 \$1 \$6579
+ sg13cmos5l_a221oi_1
* cell instance sg13cmos5l_a221oi_1_10 r0 *1 0,0
Xsg13cmos5l_a221oi_1_10 \$4091 \$2945 \$9029 \$2893 \$4763 \$2 \$1 \$2944
+ sg13cmos5l_a221oi_1
* cell instance sg13cmos5l_a221oi_1_11 r0 *1 0,0
Xsg13cmos5l_a221oi_1_11 \$4767 \$2729 \$7277 \$2897 \$7276 \$2 \$1 \$6680
+ sg13cmos5l_a221oi_1
* cell instance sg13cmos5l_a221oi_1_12 r0 *1 0,0
Xsg13cmos5l_a221oi_1_12 \$4093 \$2760 \$2893 \$4768 \$4763 \$2 \$1 \$4324
+ sg13cmos5l_a221oi_1
* cell instance sg13cmos5l_a221oi_1_13 r0 *1 0,0
Xsg13cmos5l_a221oi_1_13 \$9183 \$2760 \$2893 \$9623 \$2730 \$2 \$1 \$9529
+ sg13cmos5l_a221oi_1
* cell instance sg13cmos5l_a221oi_1_14 r0 *1 0,0
Xsg13cmos5l_a221oi_1_14 \$579 \$418 \$577 \$585 \$583 \$2 \$1 \$245
+ sg13cmos5l_a221oi_1
* cell instance sg13cmos5l_a221oi_1_15 r0 *1 0,0
Xsg13cmos5l_a221oi_1_15 \$256 \$587 \$576 \$589 \$690 \$2 \$1 \$425
+ sg13cmos5l_a221oi_1
* cell instance sg13cmos5l_a221oi_1_16 r0 *1 0,0
Xsg13cmos5l_a221oi_1_16 \$427 \$428 \$253 \$425 \$139 \$2 \$1 \$423
+ sg13cmos5l_a221oi_1
* cell instance sg13cmos5l_a221oi_1_17 r0 *1 0,0
Xsg13cmos5l_a221oi_1_17 \$427 \$264 \$263 \$437 \$139 \$2 \$1 \$435
+ sg13cmos5l_a221oi_1
* cell instance sg13cmos5l_a221oi_1_18 r0 *1 0,0
Xsg13cmos5l_a221oi_1_18 \$266 \$587 \$410 \$589 \$690 \$2 \$1 \$437
+ sg13cmos5l_a221oi_1
* cell instance sg13cmos5l_a221oi_1_19 r0 *1 0,0
Xsg13cmos5l_a221oi_1_19 \$265 \$587 \$568 \$589 \$427 \$2 \$1 \$595
+ sg13cmos5l_a221oi_1
* cell instance sg13cmos5l_a221oi_1_20 r0 *1 0,0
Xsg13cmos5l_a221oi_1_20 \$427 \$267 \$373 \$595 \$139 \$2 \$1 \$441
+ sg13cmos5l_a221oi_1
* cell instance sg13cmos5l_a22oi_1_0 r0 *1 0,0
Xsg13cmos5l_a22oi_1_0 \$1863 \$4763 \$4761 \$4762 \$2 \$1 \$3740
+ sg13cmos5l_a22oi_1
* cell instance sg13cmos5l_a22oi_1_1 r0 *1 0,0
Xsg13cmos5l_a22oi_1_1 \$4236 \$2921 \$3269 \$4235 \$2 \$1 \$4154
+ sg13cmos5l_a22oi_1
* cell instance sg13cmos5l_a22oi_1_2 r0 *1 0,0
Xsg13cmos5l_a22oi_1_2 \$846 \$206 \$851 \$365 \$2 \$1 \$852 sg13cmos5l_a22oi_1
* cell instance sg13cmos5l_a22oi_1_3 r0 *1 0,0
Xsg13cmos5l_a22oi_1_3 \$3017 \$2760 \$2945 \$4764 \$2 \$1 \$4322
+ sg13cmos5l_a22oi_1
* cell instance sg13cmos5l_a22oi_1_4 r0 *1 0,0
Xsg13cmos5l_a22oi_1_4 \$1092 \$4763 \$6428 \$6578 \$2 \$1 \$8711
+ sg13cmos5l_a22oi_1
* cell instance sg13cmos5l_a22oi_1_5 r0 *1 0,0
Xsg13cmos5l_a22oi_1_5 \$8282 \$2760 \$2945 \$5719 \$2 \$1 \$8715
+ sg13cmos5l_a22oi_1
* cell instance sg13cmos5l_a22oi_1_6 r0 *1 0,0
Xsg13cmos5l_a22oi_1_6 \$9181 \$2945 \$2759 \$4764 \$2 \$1 \$8283
+ sg13cmos5l_a22oi_1
* cell instance sg13cmos5l_a22oi_1_7 r0 *1 0,0
Xsg13cmos5l_a22oi_1_7 \$7273 \$2921 \$3269 \$5793 \$2 \$1 \$8144
+ sg13cmos5l_a22oi_1
* cell instance sg13cmos5l_a22oi_1_8 r0 *1 0,0
Xsg13cmos5l_a22oi_1_8 \$1931 \$2760 \$2759 \$2434 \$2 \$1 \$2728
+ sg13cmos5l_a22oi_1
* cell instance sg13cmos5l_a22oi_1_9 r0 *1 0,0
Xsg13cmos5l_a22oi_1_9 \$1845 \$2084 \$3519 \$3924 \$2 \$1 \$4756
+ sg13cmos5l_a22oi_1
* cell instance sg13cmos5l_a22oi_1_10 r0 *1 0,0
Xsg13cmos5l_a22oi_1_10 \$3257 \$2945 \$2759 \$2174 \$2 \$1 \$4161
+ sg13cmos5l_a22oi_1
* cell instance sg13cmos5l_a22oi_1_11 r0 *1 0,0
Xsg13cmos5l_a22oi_1_11 \$2274 \$4763 \$6215 \$6680 \$2 \$1 \$6653
+ sg13cmos5l_a22oi_1
* cell instance sg13cmos5l_a22oi_1_12 r0 *1 0,0
Xsg13cmos5l_a22oi_1_12 \$9527 \$2945 \$2759 \$5719 \$2 \$1 \$8857
+ sg13cmos5l_a22oi_1
* cell instance sg13cmos5l_a22oi_1_13 r0 *1 0,0
Xsg13cmos5l_a22oi_1_13 \$2138 \$2760 \$2945 \$2174 \$2 \$1 \$3074
+ sg13cmos5l_a22oi_1
* cell instance sg13cmos5l_a22oi_1_14 r0 *1 0,0
Xsg13cmos5l_a22oi_1_14 \$7706 \$2921 \$3269 \$8789 \$2 \$1 \$8578
+ sg13cmos5l_a22oi_1
* cell instance sg13cmos5l_a22oi_1_15 r0 *1 0,0
Xsg13cmos5l_a22oi_1_15 \$1854 \$2730 \$7113 \$6579 \$2 \$1 \$7632
+ sg13cmos5l_a22oi_1
* cell instance sg13cmos5l_a22oi_1_16 r0 *1 0,0
Xsg13cmos5l_a22oi_1_16 \$3796 \$3451 \$3925 \$3926 \$2 \$1 \$3746
+ sg13cmos5l_a22oi_1
* cell instance sg13cmos5l_a22oi_1_17 r0 *1 0,0
Xsg13cmos5l_a22oi_1_17 \$8718 \$3077 \$2759 \$9181 \$2 \$1 \$9032
+ sg13cmos5l_a22oi_1
* cell instance sg13cmos5l_a22oi_1_18 r0 *1 0,0
Xsg13cmos5l_a22oi_1_18 \$860 \$589 \$1111 \$247 \$2 \$1 \$869 sg13cmos5l_a22oi_1
* cell instance sg13cmos5l_a22oi_1_19 r0 *1 0,0
Xsg13cmos5l_a22oi_1_19 \$392 \$604 \$684 \$456 \$2 \$1 \$284 sg13cmos5l_a22oi_1
* cell instance sg13cmos5l_a22oi_1_20 r0 *1 0,0
Xsg13cmos5l_a22oi_1_20 \$605 \$607 \$604 \$1563 \$2 \$1 \$606 sg13cmos5l_a22oi_1
* cell instance sg13cmos5l_a22oi_1_21 r0 *1 0,0
Xsg13cmos5l_a22oi_1_21 \$142 \$728 \$604 \$1562 \$2 \$1 \$613 sg13cmos5l_a22oi_1
* cell instance sg13cmos5l_and2_1_0 r0 *1 0,0
Xsg13cmos5l_and2_1_0 \$4613 \$3513 \$2 \$1 \$5719 sg13cmos5l_and2_1
* cell instance sg13cmos5l_and2_1_1 r0 *1 0,0
Xsg13cmos5l_and2_1_1 \$3257 \$3017 \$2 \$1 \$4235 sg13cmos5l_and2_1
* cell instance sg13cmos5l_and2_1_2 r0 *1 0,0
Xsg13cmos5l_and2_1_2 \$4764 \$8282 \$2 \$1 \$5793 sg13cmos5l_and2_1
* cell instance sg13cmos5l_and2_1_3 r0 *1 0,0
Xsg13cmos5l_and2_1_3 \$5137 \$5140 \$2 \$1 \$5359 sg13cmos5l_and2_1
* cell instance sg13cmos5l_and2_1_4 r0 *1 0,0
Xsg13cmos5l_and2_1_4 \$4091 \$4093 \$2 \$1 \$4097 sg13cmos5l_and2_1
* cell instance sg13cmos5l_and2_1_5 r0 *1 0,0
Xsg13cmos5l_and2_1_5 \$5137 \$5221 \$2 \$1 \$5224 sg13cmos5l_and2_1
* cell instance sg13cmos5l_and2_1_6 r0 *1 0,0
Xsg13cmos5l_and2_1_6 \$7705 \$7274 \$2 \$1 \$4767 sg13cmos5l_and2_1
* cell instance sg13cmos5l_and2_1_7 r0 *1 0,0
Xsg13cmos5l_and2_1_7 \$3833 \$7706 \$2 \$1 \$4046 sg13cmos5l_and2_1
* cell instance sg13cmos5l_and2_1_8 r0 *1 0,0
Xsg13cmos5l_and2_1_8 \$1846 \$1852 \$2 \$1 \$1572 sg13cmos5l_and2_1
* cell instance sg13cmos5l_and2_1_9 r0 *1 0,0
Xsg13cmos5l_and2_1_9 \$706 \$865 \$2 \$1 \$396 sg13cmos5l_and2_1
* cell instance sg13cmos5l_and2_1_10 r0 *1 0,0
Xsg13cmos5l_and2_1_10 \$868 \$869 \$2 \$1 \$585 sg13cmos5l_and2_1
* cell instance sg13cmos5l_and2_1_11 r0 *1 0,0
Xsg13cmos5l_and2_1_11 \$589 \$868 \$2 \$1 \$604 sg13cmos5l_and2_1
* cell instance sg13cmos5l_and2_1_12 r0 *1 0,0
Xsg13cmos5l_and2_1_12 \$301 \$143 \$2 \$1 \$880 sg13cmos5l_and2_1
* cell instance sg13cmos5l_and2_1_13 r0 *1 0,0
Xsg13cmos5l_and2_1_13 \$515 \$517 \$2 \$1 \$181 sg13cmos5l_and2_1
* cell instance sg13cmos5l_and3_1_0 r0 *1 0,0
Xsg13cmos5l_and3_1_0 \$4767 \$3833 \$5145 \$2 \$1 \$5800 sg13cmos5l_and3_1
* cell instance sg13cmos5l_and3_1_1 r0 *1 0,0
Xsg13cmos5l_and3_1_1 \$537 \$266 \$265 \$2 \$1 \$448 sg13cmos5l_and3_1
* cell instance sg13cmos5l_and3_1_2 r0 *1 0,0
Xsg13cmos5l_and3_1_2 \$1405 \$931 \$929 \$2 \$1 \$779 sg13cmos5l_and3_1
* cell instance sg13cmos5l_and3_1_3 r0 *1 0,0
Xsg13cmos5l_and3_1_3 \$348 \$513 \$181 \$2 \$1 \$20 sg13cmos5l_and3_1
* cell instance sg13cmos5l_antennanp_0 r0 *1 0,0
Xsg13cmos5l_antennanp_0 \$933 \$2 \$1 sg13cmos5l_antennanp
* cell instance sg13cmos5l_buf_1_0 r0 *1 0,0
Xsg13cmos5l_buf_1_0 \$9320 \$2 \$1 \$4233 sg13cmos5l_buf_1
* cell instance sg13cmos5l_buf_1_1 r0 *1 0,0
Xsg13cmos5l_buf_1_1 \$1305 \$2 \$1 \$2073 sg13cmos5l_buf_1
* cell instance sg13cmos5l_buf_1_2 r0 *1 0,0
Xsg13cmos5l_buf_1_2 \$2272 \$2 \$1 \$2208 sg13cmos5l_buf_1
* cell instance sg13cmos5l_buf_1_3 r0 *1 0,0
Xsg13cmos5l_buf_1_3 \$12148 \$2 \$1 \$11237 sg13cmos5l_buf_1
* cell instance sg13cmos5l_buf_1_4 r0 *1 0,0
Xsg13cmos5l_buf_1_4 \$12148 \$2 \$1 \$12712 sg13cmos5l_buf_1
* cell instance sg13cmos5l_buf_1_5 r0 *1 0,0
Xsg13cmos5l_buf_1_5 \$1305 \$2 \$1 \$37 sg13cmos5l_buf_1
* cell instance sg13cmos5l_buf_1_6 r0 *1 0,0
Xsg13cmos5l_buf_1_6 \$1448 \$2 \$1 \$2271 sg13cmos5l_buf_1
* cell instance sg13cmos5l_buf_1_7 r0 *1 0,0
Xsg13cmos5l_buf_1_7 \$37 \$2 \$1 \$77 sg13cmos5l_buf_1
* cell instance sg13cmos5l_buf_1_8 r0 *1 0,0
Xsg13cmos5l_buf_1_8 \$2416 \$2 \$1 \$2893 sg13cmos5l_buf_1
* cell instance sg13cmos5l_buf_1_9 r0 *1 0,0
Xsg13cmos5l_buf_1_9 \$2895 \$2 \$1 \$2078 sg13cmos5l_buf_1
* cell instance sg13cmos5l_buf_1_10 r0 *1 0,0
Xsg13cmos5l_buf_1_10 \$1912 \$2 \$1 \$2082 sg13cmos5l_buf_1
* cell instance sg13cmos5l_buf_1_11 r0 *1 0,0
Xsg13cmos5l_buf_1_11 \$1843 \$2 \$1 \$391 sg13cmos5l_buf_1
* cell instance sg13cmos5l_buf_1_12 r0 *1 0,0
Xsg13cmos5l_buf_1_12 \$2761 \$2 \$1 \$3269 sg13cmos5l_buf_1
* cell instance sg13cmos5l_buf_1_13 r0 *1 0,0
Xsg13cmos5l_buf_1_13 \$2729 \$2 \$1 \$3020 sg13cmos5l_buf_1
* cell instance sg13cmos5l_buf_1_14 r0 *1 0,0
Xsg13cmos5l_buf_1_14 \$2897 \$2 \$1 \$3501 sg13cmos5l_buf_1
* cell instance sg13cmos5l_buf_1_15 r0 *1 0,0
Xsg13cmos5l_buf_1_15 \$863 \$2 \$1 \$412 sg13cmos5l_buf_1
* cell instance sg13cmos5l_buf_1_16 r0 *1 0,0
Xsg13cmos5l_buf_1_16 \$2730 \$2 \$1 \$2084 sg13cmos5l_buf_1
* cell instance sg13cmos5l_buf_1_17 r0 *1 0,0
Xsg13cmos5l_buf_1_17 \$391 \$2 \$1 \$863 sg13cmos5l_buf_1
* cell instance sg13cmos5l_buf_1_18 r0 *1 0,0
Xsg13cmos5l_buf_1_18 \$3077 \$2 \$1 \$2760 sg13cmos5l_buf_1
* cell instance sg13cmos5l_buf_1_19 r0 *1 0,0
Xsg13cmos5l_buf_1_19 \$2084 \$2 \$1 \$4763 sg13cmos5l_buf_1
* cell instance sg13cmos5l_buf_1_20 r0 *1 0,0
Xsg13cmos5l_buf_1_20 \$1569 \$2 \$1 \$690 sg13cmos5l_buf_1
* cell instance sg13cmos5l_buf_1_21 r0 *1 0,0
Xsg13cmos5l_buf_1_21 \$2436 \$2 \$1 \$2921 sg13cmos5l_buf_1
* cell instance sg13cmos5l_buf_1_22 r0 *1 0,0
Xsg13cmos5l_buf_1_22 \$396 \$2 \$1 \$365 sg13cmos5l_buf_1
* cell instance sg13cmos5l_buf_1_23 r0 *1 0,0
Xsg13cmos5l_buf_1_23 \$536 \$2 \$1 \$1305 sg13cmos5l_buf_1
* cell instance sg13cmos5l_buf_1_24 r0 *1 0,0
Xsg13cmos5l_buf_1_24 \$2731 \$2 \$1 \$2762 sg13cmos5l_buf_1
* cell instance sg13cmos5l_buf_1_25 r0 *1 0,0
Xsg13cmos5l_buf_1_25 \$536 \$2 \$1 \$9320 sg13cmos5l_buf_1
* cell instance sg13cmos5l_buf_1_26 r0 *1 0,0
Xsg13cmos5l_buf_1_26 \$12148 \$2 \$1 \$11238 sg13cmos5l_buf_1
* cell instance sg13cmos5l_buf_1_27 r0 *1 0,0
Xsg13cmos5l_buf_1_27 \$933 \$2 \$1 \$536 sg13cmos5l_buf_1
* cell instance sg13cmos5l_buf_1_28 r0 *1 0,0
Xsg13cmos5l_buf_1_28 \$591 \$2 \$1 \$427 sg13cmos5l_buf_1
* cell instance sg13cmos5l_buf_1_29 r0 *1 0,0
Xsg13cmos5l_buf_1_29 \$9320 \$2 \$1 \$12148 sg13cmos5l_buf_1
* cell instance sg13cmos5l_buf_1_30 r0 *1 0,0
Xsg13cmos5l_buf_1_30 \$13887 \$2 \$1 \$13888 sg13cmos5l_buf_1
* cell instance sg13cmos5l_buf_1_31 r0 *1 0,0
Xsg13cmos5l_buf_1_31 \$13890 \$2 \$1 \$13891 sg13cmos5l_buf_1
* cell instance sg13cmos5l_buf_1_32 r0 *1 0,0
Xsg13cmos5l_buf_1_32 \$13893 \$2 \$1 \$13894 sg13cmos5l_buf_1
* cell instance sg13cmos5l_buf_1_33 r0 *1 0,0
Xsg13cmos5l_buf_1_33 \$13896 \$2 \$1 \$13819 sg13cmos5l_buf_1
* cell instance sg13cmos5l_buf_1_34 r0 *1 0,0
Xsg13cmos5l_buf_1_34 \$13898 \$2 \$1 \$13899 sg13cmos5l_buf_1
* cell instance sg13cmos5l_buf_1_35 r0 *1 0,0
Xsg13cmos5l_buf_1_35 \$536 \$2 \$1 \$50 sg13cmos5l_buf_1
* cell instance sg13cmos5l_buf_1_36 r0 *1 0,0
Xsg13cmos5l_buf_1_36 \$536 \$2 \$1 \$272 sg13cmos5l_buf_1
* cell instance sg13cmos5l_buf_1_37 r0 *1 0,0
Xsg13cmos5l_buf_1_37 \$13925 \$2 \$1 \$929 sg13cmos5l_buf_1
* cell instance sg13cmos5l_buf_1_38 r0 *1 0,0
Xsg13cmos5l_buf_1_38 \$13950 \$2 \$1 \$13919 sg13cmos5l_buf_1
* cell instance sg13cmos5l_buf_1_39 r0 *1 0,0
Xsg13cmos5l_buf_1_39 \$13927 \$2 \$1 \$13905 sg13cmos5l_buf_1
* cell instance sg13cmos5l_buf_1_40 r0 *1 0,0
Xsg13cmos5l_buf_1_40 \$13949 \$2 \$1 \$13923 sg13cmos5l_buf_1
* cell instance sg13cmos5l_buf_1_41 r0 *1 0,0
Xsg13cmos5l_buf_1_41 \$13951 \$2 \$1 \$13908 sg13cmos5l_buf_1
* cell instance sg13cmos5l_buf_1_42 r0 *1 0,0
Xsg13cmos5l_buf_1_42 \$13948 \$2 \$1 \$13815 sg13cmos5l_buf_1
* cell instance sg13cmos5l_buf_1_43 r0 *1 0,0
Xsg13cmos5l_buf_1_43 \$13952 \$2 \$1 \$13820 sg13cmos5l_buf_1
* cell instance sg13cmos5l_buf_1_44 r0 *1 0,0
Xsg13cmos5l_buf_1_44 \$766 \$2 \$1 \$1367 sg13cmos5l_buf_1
* cell instance sg13cmos5l_buf_1_45 r0 *1 0,0
Xsg13cmos5l_buf_1_45 \$13933 \$2 \$1 \$13913 sg13cmos5l_buf_1
* cell instance sg13cmos5l_buf_1_46 r0 *1 0,0
Xsg13cmos5l_buf_1_46 \$13935 \$2 \$1 \$13916 sg13cmos5l_buf_1
* cell instance sg13cmos5l_buf_1_47 r0 *1 0,0
Xsg13cmos5l_buf_1_47 \$773 \$2 \$1 \$315 sg13cmos5l_buf_1
* cell instance sg13cmos5l_buf_1_48 r0 *1 0,0
Xsg13cmos5l_buf_1_48 \$13938 \$2 \$1 \$13922 sg13cmos5l_buf_1
* cell instance sg13cmos5l_buf_1_49 r0 *1 0,0
Xsg13cmos5l_buf_1_49 \$13953 \$2 \$1 \$1119 sg13cmos5l_buf_1
* cell instance sg13cmos5l_buf_1_50 r0 *1 0,0
Xsg13cmos5l_buf_1_50 \$933 \$2 \$1 \$773 sg13cmos5l_buf_1
* cell instance sg13cmos5l_buf_1_51 r0 *1 0,0
Xsg13cmos5l_buf_1_51 \$13940 \$2 \$1 \$933 sg13cmos5l_buf_1
* cell instance sg13cmos5l_buf_1_52 r0 *1 0,0
Xsg13cmos5l_buf_1_52 \$773 \$2 \$1 \$163 sg13cmos5l_buf_1
* cell instance sg13cmos5l_buf_1_53 r0 *1 0,0
Xsg13cmos5l_buf_1_53 \$651 \$2 \$1 \$508 sg13cmos5l_buf_1
* cell instance sg13cmos5l_buf_1_54 r0 *1 0,0
Xsg13cmos5l_buf_1_54 \$773 \$2 \$1 \$1242 sg13cmos5l_buf_1
* cell instance sg13cmos5l_buf_1_55 r0 *1 0,0
Xsg13cmos5l_buf_1_55 \$766 \$2 \$1 \$1472 sg13cmos5l_buf_1
* cell instance sg13cmos5l_buf_4_0 r0 *1 0,0
Xsg13cmos5l_buf_4_0 \$1914 \$2 \$1 \$2272 sg13cmos5l_buf_4
* cell instance sg13cmos5l_buf_4_1 r0 *1 0,0
Xsg13cmos5l_buf_4_1 \$1450 \$2 \$1 \$1448 sg13cmos5l_buf_4
* cell instance sg13cmos5l_buf_4_2 r0 *1 0,0
Xsg13cmos5l_buf_4_2 \$1693 \$2 \$1 \$1691 sg13cmos5l_buf_4
* cell instance sg13cmos5l_buf_4_3 r0 *1 0,0
Xsg13cmos5l_buf_4_3 \$826 \$2 \$1 \$824 sg13cmos5l_buf_4
* cell instance sg13cmos5l_buf_8_0 r0 *1 0,0
Xsg13cmos5l_buf_8_0 \$701 \$2 \$1 \$1860 sg13cmos5l_buf_8
* cell instance sg13cmos5l_buf_8_1 r0 *1 0,0
Xsg13cmos5l_buf_8_1 \$701 \$2 \$1 \$2210 sg13cmos5l_buf_8
* cell instance sg13cmos5l_buf_8_2 r0 *1 0,0
Xsg13cmos5l_buf_8_2 \$701 \$2 \$1 \$1316 sg13cmos5l_buf_8
* cell instance sg13cmos5l_buf_8_3 r0 *1 0,0
Xsg13cmos5l_buf_8_3 \$701 \$2 \$1 \$4616 sg13cmos5l_buf_8
* cell instance sg13cmos5l_buf_8_4 r0 *1 0,0
Xsg13cmos5l_buf_8_4 \$701 \$2 \$1 \$7271 sg13cmos5l_buf_8
* cell instance sg13cmos5l_buf_8_5 r0 *1 0,0
Xsg13cmos5l_buf_8_5 \$701 \$2 \$1 \$6581 sg13cmos5l_buf_8
* cell instance sg13cmos5l_buf_8_6 r0 *1 0,0
Xsg13cmos5l_buf_8_6 \$701 \$2 \$1 \$7119 sg13cmos5l_buf_8
* cell instance sg13cmos5l_buf_8_7 r0 *1 0,0
Xsg13cmos5l_buf_8_7 \$701 \$2 \$1 \$7861 sg13cmos5l_buf_8
* cell instance sg13cmos5l_buf_8_8 r0 *1 0,0
Xsg13cmos5l_buf_8_8 \$701 \$2 \$1 \$92 sg13cmos5l_buf_8
* cell instance sg13cmos5l_buf_8_9 r0 *1 0,0
Xsg13cmos5l_buf_8_9 \$701 \$2 \$1 \$551 sg13cmos5l_buf_8
* cell instance sg13cmos5l_buf_8_10 r0 *1 0,0
Xsg13cmos5l_buf_8_10 \$701 \$2 \$1 \$759 sg13cmos5l_buf_8
* cell instance sg13cmos5l_buf_8_11 r0 *1 0,0
Xsg13cmos5l_buf_8_11 \$701 \$2 \$1 \$277 sg13cmos5l_buf_8
* cell instance sg13cmos5l_buf_8_12 r0 *1 0,0
Xsg13cmos5l_buf_8_12 \$1397 \$2 \$1 \$701 sg13cmos5l_buf_8
* cell instance sg13cmos5l_buf_8_13 r0 *1 0,0
Xsg13cmos5l_buf_8_13 \$1343 \$2 \$1 \$1397 sg13cmos5l_buf_8
* cell instance sg13cmos5l_buf_8_14 r0 *1 0,0
Xsg13cmos5l_buf_8_14 \$701 \$2 \$1 \$320 sg13cmos5l_buf_8
* cell instance sg13cmos5l_buf_8_15 r0 *1 0,0
Xsg13cmos5l_buf_8_15 \$1665 \$2 \$1 \$1666 sg13cmos5l_buf_8
* cell instance sg13cmos5l_buf_8_16 r0 *1 0,0
Xsg13cmos5l_buf_8_16 \$1343 \$2 \$1 \$13943 sg13cmos5l_buf_8
* cell instance sg13cmos5l_buf_8_17 r0 *1 0,0
Xsg13cmos5l_buf_8_17 \$701 \$2 \$1 \$326 sg13cmos5l_buf_8
* cell instance sg13cmos5l_buf_8_18 r0 *1 0,0
Xsg13cmos5l_buf_8_18 \$13943 \$2 \$1 \$13945 sg13cmos5l_buf_8
* cell instance sg13cmos5l_buf_8_19 r0 *1 0,0
Xsg13cmos5l_buf_8_19 \$13945 \$2 \$1 \$1670 sg13cmos5l_buf_8
* cell instance sg13cmos5l_buf_8_20 r0 *1 0,0
Xsg13cmos5l_buf_8_20 \$1670 \$2 \$1 \$1665 sg13cmos5l_buf_8
* cell instance sg13cmos5l_buf_8_21 r0 *1 0,0
Xsg13cmos5l_buf_8_21 \$701 \$2 \$1 \$1216 sg13cmos5l_buf_8
* cell instance sg13cmos5l_buf_8_22 r0 *1 0,0
Xsg13cmos5l_buf_8_22 \$701 \$2 \$1 \$819 sg13cmos5l_buf_8
* cell instance sg13cmos5l_decap_4_0 r0 *1 0,0
Xsg13cmos5l_decap_4_0 \$2 \$1 sg13cmos5l_decap_4
* cell instance sg13cmos5l_decap_4_1 r0 *1 0,0
Xsg13cmos5l_decap_4_1 \$2 \$1 sg13cmos5l_decap_4
* cell instance sg13cmos5l_decap_4_2 r0 *1 0,0
Xsg13cmos5l_decap_4_2 \$2 \$1 sg13cmos5l_decap_4
* cell instance sg13cmos5l_decap_4_3 r0 *1 0,0
Xsg13cmos5l_decap_4_3 \$2 \$1 sg13cmos5l_decap_4
* cell instance sg13cmos5l_decap_4_4 r0 *1 0,0
Xsg13cmos5l_decap_4_4 \$2 \$1 sg13cmos5l_decap_4
* cell instance sg13cmos5l_decap_4_5 r0 *1 0,0
Xsg13cmos5l_decap_4_5 \$2 \$1 sg13cmos5l_decap_4
* cell instance sg13cmos5l_decap_4_6 r0 *1 0,0
Xsg13cmos5l_decap_4_6 \$2 \$1 sg13cmos5l_decap_4
* cell instance sg13cmos5l_decap_4_7 r0 *1 0,0
Xsg13cmos5l_decap_4_7 \$2 \$1 sg13cmos5l_decap_4
* cell instance sg13cmos5l_decap_4_8 r0 *1 0,0
Xsg13cmos5l_decap_4_8 \$2 \$1 sg13cmos5l_decap_4
* cell instance sg13cmos5l_decap_4_9 r0 *1 0,0
Xsg13cmos5l_decap_4_9 \$2 \$1 sg13cmos5l_decap_4
* cell instance sg13cmos5l_decap_4_10 r0 *1 0,0
Xsg13cmos5l_decap_4_10 \$2 \$1 sg13cmos5l_decap_4
* cell instance sg13cmos5l_decap_4_11 r0 *1 0,0
Xsg13cmos5l_decap_4_11 \$2 \$1 sg13cmos5l_decap_4
* cell instance sg13cmos5l_decap_4_12 r0 *1 0,0
Xsg13cmos5l_decap_4_12 \$2 \$1 sg13cmos5l_decap_4
* cell instance sg13cmos5l_decap_4_13 r0 *1 0,0
Xsg13cmos5l_decap_4_13 \$2 \$1 sg13cmos5l_decap_4
* cell instance sg13cmos5l_decap_4_14 r0 *1 0,0
Xsg13cmos5l_decap_4_14 \$2 \$1 sg13cmos5l_decap_4
* cell instance sg13cmos5l_decap_4_15 r0 *1 0,0
Xsg13cmos5l_decap_4_15 \$2 \$1 sg13cmos5l_decap_4
* cell instance sg13cmos5l_decap_4_16 r0 *1 0,0
Xsg13cmos5l_decap_4_16 \$2 \$1 sg13cmos5l_decap_4
* cell instance sg13cmos5l_decap_4_17 r0 *1 0,0
Xsg13cmos5l_decap_4_17 \$2 \$1 sg13cmos5l_decap_4
* cell instance sg13cmos5l_decap_4_18 r0 *1 0,0
Xsg13cmos5l_decap_4_18 \$2 \$1 sg13cmos5l_decap_4
* cell instance sg13cmos5l_decap_4_19 r0 *1 0,0
Xsg13cmos5l_decap_4_19 \$2 \$1 sg13cmos5l_decap_4
* cell instance sg13cmos5l_decap_4_20 r0 *1 0,0
Xsg13cmos5l_decap_4_20 \$2 \$1 sg13cmos5l_decap_4
* cell instance sg13cmos5l_decap_4_21 r0 *1 0,0
Xsg13cmos5l_decap_4_21 \$2 \$1 sg13cmos5l_decap_4
* cell instance sg13cmos5l_decap_4_22 r0 *1 0,0
Xsg13cmos5l_decap_4_22 \$2 \$1 sg13cmos5l_decap_4
* cell instance sg13cmos5l_decap_4_23 r0 *1 0,0
Xsg13cmos5l_decap_4_23 \$2 \$1 sg13cmos5l_decap_4
* cell instance sg13cmos5l_decap_4_24 r0 *1 0,0
Xsg13cmos5l_decap_4_24 \$2 \$1 sg13cmos5l_decap_4
* cell instance sg13cmos5l_decap_4_25 r0 *1 0,0
Xsg13cmos5l_decap_4_25 \$2 \$1 sg13cmos5l_decap_4
* cell instance sg13cmos5l_decap_4_26 r0 *1 0,0
Xsg13cmos5l_decap_4_26 \$2 \$1 sg13cmos5l_decap_4
* cell instance sg13cmos5l_decap_4_27 r0 *1 0,0
Xsg13cmos5l_decap_4_27 \$2 \$1 sg13cmos5l_decap_4
* cell instance sg13cmos5l_decap_4_28 r0 *1 0,0
Xsg13cmos5l_decap_4_28 \$2 \$1 sg13cmos5l_decap_4
* cell instance sg13cmos5l_decap_4_29 r0 *1 0,0
Xsg13cmos5l_decap_4_29 \$2 \$1 sg13cmos5l_decap_4
* cell instance sg13cmos5l_decap_4_30 r0 *1 0,0
Xsg13cmos5l_decap_4_30 \$2 \$1 sg13cmos5l_decap_4
* cell instance sg13cmos5l_decap_4_31 r0 *1 0,0
Xsg13cmos5l_decap_4_31 \$2 \$1 sg13cmos5l_decap_4
* cell instance sg13cmos5l_decap_4_32 r0 *1 0,0
Xsg13cmos5l_decap_4_32 \$2 \$1 sg13cmos5l_decap_4
* cell instance sg13cmos5l_decap_4_33 r0 *1 0,0
Xsg13cmos5l_decap_4_33 \$2 \$1 sg13cmos5l_decap_4
* cell instance sg13cmos5l_decap_4_34 r0 *1 0,0
Xsg13cmos5l_decap_4_34 \$2 \$1 sg13cmos5l_decap_4
* cell instance sg13cmos5l_decap_4_35 r0 *1 0,0
Xsg13cmos5l_decap_4_35 \$2 \$1 sg13cmos5l_decap_4
* cell instance sg13cmos5l_decap_4_36 r0 *1 0,0
Xsg13cmos5l_decap_4_36 \$2 \$1 sg13cmos5l_decap_4
* cell instance sg13cmos5l_decap_4_37 r0 *1 0,0
Xsg13cmos5l_decap_4_37 \$2 \$1 sg13cmos5l_decap_4
* cell instance sg13cmos5l_decap_4_38 r0 *1 0,0
Xsg13cmos5l_decap_4_38 \$2 \$1 sg13cmos5l_decap_4
* cell instance sg13cmos5l_decap_4_39 r0 *1 0,0
Xsg13cmos5l_decap_4_39 \$2 \$1 sg13cmos5l_decap_4
* cell instance sg13cmos5l_decap_4_40 r0 *1 0,0
Xsg13cmos5l_decap_4_40 \$2 \$1 sg13cmos5l_decap_4
* cell instance sg13cmos5l_decap_4_41 r0 *1 0,0
Xsg13cmos5l_decap_4_41 \$2 \$1 sg13cmos5l_decap_4
* cell instance sg13cmos5l_decap_4_42 r0 *1 0,0
Xsg13cmos5l_decap_4_42 \$2 \$1 sg13cmos5l_decap_4
* cell instance sg13cmos5l_decap_4_43 r0 *1 0,0
Xsg13cmos5l_decap_4_43 \$2 \$1 sg13cmos5l_decap_4
* cell instance sg13cmos5l_decap_4_44 r0 *1 0,0
Xsg13cmos5l_decap_4_44 \$2 \$1 sg13cmos5l_decap_4
* cell instance sg13cmos5l_decap_4_45 r0 *1 0,0
Xsg13cmos5l_decap_4_45 \$2 \$1 sg13cmos5l_decap_4
* cell instance sg13cmos5l_decap_4_46 r0 *1 0,0
Xsg13cmos5l_decap_4_46 \$2 \$1 sg13cmos5l_decap_4
* cell instance sg13cmos5l_decap_4_47 r0 *1 0,0
Xsg13cmos5l_decap_4_47 \$2 \$1 sg13cmos5l_decap_4
* cell instance sg13cmos5l_decap_4_48 r0 *1 0,0
Xsg13cmos5l_decap_4_48 \$2 \$1 sg13cmos5l_decap_4
* cell instance sg13cmos5l_decap_4_49 r0 *1 0,0
Xsg13cmos5l_decap_4_49 \$2 \$1 sg13cmos5l_decap_4
* cell instance sg13cmos5l_decap_4_50 r0 *1 0,0
Xsg13cmos5l_decap_4_50 \$2 \$1 sg13cmos5l_decap_4
* cell instance sg13cmos5l_decap_4_51 r0 *1 0,0
Xsg13cmos5l_decap_4_51 \$2 \$1 sg13cmos5l_decap_4
* cell instance sg13cmos5l_decap_4_52 r0 *1 0,0
Xsg13cmos5l_decap_4_52 \$2 \$1 sg13cmos5l_decap_4
* cell instance sg13cmos5l_decap_4_53 r0 *1 0,0
Xsg13cmos5l_decap_4_53 \$2 \$1 sg13cmos5l_decap_4
* cell instance sg13cmos5l_decap_4_54 r0 *1 0,0
Xsg13cmos5l_decap_4_54 \$2 \$1 sg13cmos5l_decap_4
* cell instance sg13cmos5l_decap_4_55 r0 *1 0,0
Xsg13cmos5l_decap_4_55 \$2 \$1 sg13cmos5l_decap_4
* cell instance sg13cmos5l_decap_4_56 r0 *1 0,0
Xsg13cmos5l_decap_4_56 \$2 \$1 sg13cmos5l_decap_4
* cell instance sg13cmos5l_decap_4_57 r0 *1 0,0
Xsg13cmos5l_decap_4_57 \$2 \$1 sg13cmos5l_decap_4
* cell instance sg13cmos5l_decap_4_58 r0 *1 0,0
Xsg13cmos5l_decap_4_58 \$2 \$1 sg13cmos5l_decap_4
* cell instance sg13cmos5l_decap_4_59 r0 *1 0,0
Xsg13cmos5l_decap_4_59 \$2 \$1 sg13cmos5l_decap_4
* cell instance sg13cmos5l_decap_4_60 r0 *1 0,0
Xsg13cmos5l_decap_4_60 \$2 \$1 sg13cmos5l_decap_4
* cell instance sg13cmos5l_decap_4_61 r0 *1 0,0
Xsg13cmos5l_decap_4_61 \$2 \$1 sg13cmos5l_decap_4
* cell instance sg13cmos5l_decap_4_62 r0 *1 0,0
Xsg13cmos5l_decap_4_62 \$2 \$1 sg13cmos5l_decap_4
* cell instance sg13cmos5l_decap_4_63 r0 *1 0,0
Xsg13cmos5l_decap_4_63 \$2 \$1 sg13cmos5l_decap_4
* cell instance sg13cmos5l_decap_4_64 r0 *1 0,0
Xsg13cmos5l_decap_4_64 \$2 \$1 sg13cmos5l_decap_4
* cell instance sg13cmos5l_decap_4_65 r0 *1 0,0
Xsg13cmos5l_decap_4_65 \$2 \$1 sg13cmos5l_decap_4
* cell instance sg13cmos5l_decap_4_66 r0 *1 0,0
Xsg13cmos5l_decap_4_66 \$2 \$1 sg13cmos5l_decap_4
* cell instance sg13cmos5l_decap_4_67 r0 *1 0,0
Xsg13cmos5l_decap_4_67 \$2 \$1 sg13cmos5l_decap_4
* cell instance sg13cmos5l_decap_4_68 r0 *1 0,0
Xsg13cmos5l_decap_4_68 \$2 \$1 sg13cmos5l_decap_4
* cell instance sg13cmos5l_decap_4_69 r0 *1 0,0
Xsg13cmos5l_decap_4_69 \$2 \$1 sg13cmos5l_decap_4
* cell instance sg13cmos5l_decap_4_70 r0 *1 0,0
Xsg13cmos5l_decap_4_70 \$2 \$1 sg13cmos5l_decap_4
* cell instance sg13cmos5l_decap_4_71 r0 *1 0,0
Xsg13cmos5l_decap_4_71 \$2 \$1 sg13cmos5l_decap_4
* cell instance sg13cmos5l_decap_4_72 r0 *1 0,0
Xsg13cmos5l_decap_4_72 \$2 \$1 sg13cmos5l_decap_4
* cell instance sg13cmos5l_decap_4_73 r0 *1 0,0
Xsg13cmos5l_decap_4_73 \$2 \$1 sg13cmos5l_decap_4
* cell instance sg13cmos5l_decap_4_74 r0 *1 0,0
Xsg13cmos5l_decap_4_74 \$2 \$1 sg13cmos5l_decap_4
* cell instance sg13cmos5l_decap_4_75 r0 *1 0,0
Xsg13cmos5l_decap_4_75 \$2 \$1 sg13cmos5l_decap_4
* cell instance sg13cmos5l_decap_4_76 r0 *1 0,0
Xsg13cmos5l_decap_4_76 \$2 \$1 sg13cmos5l_decap_4
* cell instance sg13cmos5l_decap_4_77 r0 *1 0,0
Xsg13cmos5l_decap_4_77 \$2 \$1 sg13cmos5l_decap_4
* cell instance sg13cmos5l_decap_4_78 r0 *1 0,0
Xsg13cmos5l_decap_4_78 \$2 \$1 sg13cmos5l_decap_4
* cell instance sg13cmos5l_decap_4_79 r0 *1 0,0
Xsg13cmos5l_decap_4_79 \$2 \$1 sg13cmos5l_decap_4
* cell instance sg13cmos5l_decap_4_80 r0 *1 0,0
Xsg13cmos5l_decap_4_80 \$2 \$1 sg13cmos5l_decap_4
* cell instance sg13cmos5l_decap_4_81 r0 *1 0,0
Xsg13cmos5l_decap_4_81 \$2 \$1 sg13cmos5l_decap_4
* cell instance sg13cmos5l_decap_4_82 r0 *1 0,0
Xsg13cmos5l_decap_4_82 \$2 \$1 sg13cmos5l_decap_4
* cell instance sg13cmos5l_decap_4_83 r0 *1 0,0
Xsg13cmos5l_decap_4_83 \$2 \$1 sg13cmos5l_decap_4
* cell instance sg13cmos5l_decap_4_84 r0 *1 0,0
Xsg13cmos5l_decap_4_84 \$2 \$1 sg13cmos5l_decap_4
* cell instance sg13cmos5l_decap_4_85 r0 *1 0,0
Xsg13cmos5l_decap_4_85 \$2 \$1 sg13cmos5l_decap_4
* cell instance sg13cmos5l_decap_4_86 r0 *1 0,0
Xsg13cmos5l_decap_4_86 \$2 \$1 sg13cmos5l_decap_4
* cell instance sg13cmos5l_decap_4_87 r0 *1 0,0
Xsg13cmos5l_decap_4_87 \$2 \$1 sg13cmos5l_decap_4
* cell instance sg13cmos5l_decap_4_88 r0 *1 0,0
Xsg13cmos5l_decap_4_88 \$2 \$1 sg13cmos5l_decap_4
* cell instance sg13cmos5l_decap_4_89 r0 *1 0,0
Xsg13cmos5l_decap_4_89 \$2 \$1 sg13cmos5l_decap_4
* cell instance sg13cmos5l_decap_4_90 r0 *1 0,0
Xsg13cmos5l_decap_4_90 \$2 \$1 sg13cmos5l_decap_4
* cell instance sg13cmos5l_decap_4_91 r0 *1 0,0
Xsg13cmos5l_decap_4_91 \$2 \$1 sg13cmos5l_decap_4
* cell instance sg13cmos5l_decap_4_92 r0 *1 0,0
Xsg13cmos5l_decap_4_92 \$2 \$1 sg13cmos5l_decap_4
* cell instance sg13cmos5l_decap_4_93 r0 *1 0,0
Xsg13cmos5l_decap_4_93 \$2 \$1 sg13cmos5l_decap_4
* cell instance sg13cmos5l_decap_4_94 r0 *1 0,0
Xsg13cmos5l_decap_4_94 \$2 \$1 sg13cmos5l_decap_4
* cell instance sg13cmos5l_decap_4_95 r0 *1 0,0
Xsg13cmos5l_decap_4_95 \$2 \$1 sg13cmos5l_decap_4
* cell instance sg13cmos5l_decap_4_96 r0 *1 0,0
Xsg13cmos5l_decap_4_96 \$2 \$1 sg13cmos5l_decap_4
* cell instance sg13cmos5l_decap_4_97 r0 *1 0,0
Xsg13cmos5l_decap_4_97 \$2 \$1 sg13cmos5l_decap_4
* cell instance sg13cmos5l_decap_4_98 r0 *1 0,0
Xsg13cmos5l_decap_4_98 \$2 \$1 sg13cmos5l_decap_4
* cell instance sg13cmos5l_decap_4_99 r0 *1 0,0
Xsg13cmos5l_decap_4_99 \$2 \$1 sg13cmos5l_decap_4
* cell instance sg13cmos5l_decap_4_100 r0 *1 0,0
Xsg13cmos5l_decap_4_100 \$2 \$1 sg13cmos5l_decap_4
* cell instance sg13cmos5l_decap_4_101 r0 *1 0,0
Xsg13cmos5l_decap_4_101 \$2 \$1 sg13cmos5l_decap_4
* cell instance sg13cmos5l_decap_4_102 r0 *1 0,0
Xsg13cmos5l_decap_4_102 \$2 \$1 sg13cmos5l_decap_4
* cell instance sg13cmos5l_decap_4_103 r0 *1 0,0
Xsg13cmos5l_decap_4_103 \$2 \$1 sg13cmos5l_decap_4
* cell instance sg13cmos5l_decap_4_104 r0 *1 0,0
Xsg13cmos5l_decap_4_104 \$2 \$1 sg13cmos5l_decap_4
* cell instance sg13cmos5l_decap_4_105 r0 *1 0,0
Xsg13cmos5l_decap_4_105 \$2 \$1 sg13cmos5l_decap_4
* cell instance sg13cmos5l_decap_4_106 r0 *1 0,0
Xsg13cmos5l_decap_4_106 \$2 \$1 sg13cmos5l_decap_4
* cell instance sg13cmos5l_decap_8_0 r0 *1 0,0
Xsg13cmos5l_decap_8_0 \$2 \$1 sg13cmos5l_decap_8
* cell instance sg13cmos5l_decap_8_1 r0 *1 0,0
Xsg13cmos5l_decap_8_1 \$2 \$1 sg13cmos5l_decap_8
* cell instance sg13cmos5l_decap_8_2 r0 *1 0,0
Xsg13cmos5l_decap_8_2 \$2 \$1 sg13cmos5l_decap_8
* cell instance sg13cmos5l_decap_8_3 r0 *1 0,0
Xsg13cmos5l_decap_8_3 \$2 \$1 sg13cmos5l_decap_8
* cell instance sg13cmos5l_decap_8_4 r0 *1 0,0
Xsg13cmos5l_decap_8_4 \$2 \$1 sg13cmos5l_decap_8
* cell instance sg13cmos5l_decap_8_5 r0 *1 0,0
Xsg13cmos5l_decap_8_5 \$2 \$1 sg13cmos5l_decap_8
* cell instance sg13cmos5l_decap_8_6 r0 *1 0,0
Xsg13cmos5l_decap_8_6 \$2 \$1 sg13cmos5l_decap_8
* cell instance sg13cmos5l_decap_8_7 r0 *1 0,0
Xsg13cmos5l_decap_8_7 \$2 \$1 sg13cmos5l_decap_8
* cell instance sg13cmos5l_decap_8_8 r0 *1 0,0
Xsg13cmos5l_decap_8_8 \$2 \$1 sg13cmos5l_decap_8
* cell instance sg13cmos5l_decap_8_9 r0 *1 0,0
Xsg13cmos5l_decap_8_9 \$2 \$1 sg13cmos5l_decap_8
* cell instance sg13cmos5l_decap_8_10 r0 *1 0,0
Xsg13cmos5l_decap_8_10 \$2 \$1 sg13cmos5l_decap_8
* cell instance sg13cmos5l_decap_8_11 r0 *1 0,0
Xsg13cmos5l_decap_8_11 \$2 \$1 sg13cmos5l_decap_8
* cell instance sg13cmos5l_decap_8_12 r0 *1 0,0
Xsg13cmos5l_decap_8_12 \$2 \$1 sg13cmos5l_decap_8
* cell instance sg13cmos5l_decap_8_13 r0 *1 0,0
Xsg13cmos5l_decap_8_13 \$2 \$1 sg13cmos5l_decap_8
* cell instance sg13cmos5l_decap_8_14 r0 *1 0,0
Xsg13cmos5l_decap_8_14 \$2 \$1 sg13cmos5l_decap_8
* cell instance sg13cmos5l_decap_8_15 r0 *1 0,0
Xsg13cmos5l_decap_8_15 \$2 \$1 sg13cmos5l_decap_8
* cell instance sg13cmos5l_decap_8_16 r0 *1 0,0
Xsg13cmos5l_decap_8_16 \$2 \$1 sg13cmos5l_decap_8
* cell instance sg13cmos5l_decap_8_17 r0 *1 0,0
Xsg13cmos5l_decap_8_17 \$2 \$1 sg13cmos5l_decap_8
* cell instance sg13cmos5l_decap_8_18 r0 *1 0,0
Xsg13cmos5l_decap_8_18 \$2 \$1 sg13cmos5l_decap_8
* cell instance sg13cmos5l_decap_8_19 r0 *1 0,0
Xsg13cmos5l_decap_8_19 \$2 \$1 sg13cmos5l_decap_8
* cell instance sg13cmos5l_decap_8_20 r0 *1 0,0
Xsg13cmos5l_decap_8_20 \$2 \$1 sg13cmos5l_decap_8
* cell instance sg13cmos5l_decap_8_21 r0 *1 0,0
Xsg13cmos5l_decap_8_21 \$2 \$1 sg13cmos5l_decap_8
* cell instance sg13cmos5l_decap_8_22 r0 *1 0,0
Xsg13cmos5l_decap_8_22 \$2 \$1 sg13cmos5l_decap_8
* cell instance sg13cmos5l_decap_8_23 r0 *1 0,0
Xsg13cmos5l_decap_8_23 \$2 \$1 sg13cmos5l_decap_8
* cell instance sg13cmos5l_decap_8_24 r0 *1 0,0
Xsg13cmos5l_decap_8_24 \$2 \$1 sg13cmos5l_decap_8
* cell instance sg13cmos5l_decap_8_25 r0 *1 0,0
Xsg13cmos5l_decap_8_25 \$2 \$1 sg13cmos5l_decap_8
* cell instance sg13cmos5l_decap_8_26 r0 *1 0,0
Xsg13cmos5l_decap_8_26 \$2 \$1 sg13cmos5l_decap_8
* cell instance sg13cmos5l_decap_8_27 r0 *1 0,0
Xsg13cmos5l_decap_8_27 \$2 \$1 sg13cmos5l_decap_8
* cell instance sg13cmos5l_decap_8_28 r0 *1 0,0
Xsg13cmos5l_decap_8_28 \$2 \$1 sg13cmos5l_decap_8
* cell instance sg13cmos5l_decap_8_29 r0 *1 0,0
Xsg13cmos5l_decap_8_29 \$2 \$1 sg13cmos5l_decap_8
* cell instance sg13cmos5l_decap_8_30 r0 *1 0,0
Xsg13cmos5l_decap_8_30 \$2 \$1 sg13cmos5l_decap_8
* cell instance sg13cmos5l_decap_8_31 r0 *1 0,0
Xsg13cmos5l_decap_8_31 \$2 \$1 sg13cmos5l_decap_8
* cell instance sg13cmos5l_decap_8_32 r0 *1 0,0
Xsg13cmos5l_decap_8_32 \$2 \$1 sg13cmos5l_decap_8
* cell instance sg13cmos5l_decap_8_33 r0 *1 0,0
Xsg13cmos5l_decap_8_33 \$2 \$1 sg13cmos5l_decap_8
* cell instance sg13cmos5l_decap_8_34 r0 *1 0,0
Xsg13cmos5l_decap_8_34 \$2 \$1 sg13cmos5l_decap_8
* cell instance sg13cmos5l_decap_8_35 r0 *1 0,0
Xsg13cmos5l_decap_8_35 \$2 \$1 sg13cmos5l_decap_8
* cell instance sg13cmos5l_decap_8_36 r0 *1 0,0
Xsg13cmos5l_decap_8_36 \$2 \$1 sg13cmos5l_decap_8
* cell instance sg13cmos5l_decap_8_37 r0 *1 0,0
Xsg13cmos5l_decap_8_37 \$2 \$1 sg13cmos5l_decap_8
* cell instance sg13cmos5l_decap_8_38 r0 *1 0,0
Xsg13cmos5l_decap_8_38 \$2 \$1 sg13cmos5l_decap_8
* cell instance sg13cmos5l_decap_8_39 r0 *1 0,0
Xsg13cmos5l_decap_8_39 \$2 \$1 sg13cmos5l_decap_8
* cell instance sg13cmos5l_decap_8_40 r0 *1 0,0
Xsg13cmos5l_decap_8_40 \$2 \$1 sg13cmos5l_decap_8
* cell instance sg13cmos5l_decap_8_41 r0 *1 0,0
Xsg13cmos5l_decap_8_41 \$2 \$1 sg13cmos5l_decap_8
* cell instance sg13cmos5l_decap_8_42 r0 *1 0,0
Xsg13cmos5l_decap_8_42 \$2 \$1 sg13cmos5l_decap_8
* cell instance sg13cmos5l_decap_8_43 r0 *1 0,0
Xsg13cmos5l_decap_8_43 \$2 \$1 sg13cmos5l_decap_8
* cell instance sg13cmos5l_decap_8_44 r0 *1 0,0
Xsg13cmos5l_decap_8_44 \$2 \$1 sg13cmos5l_decap_8
* cell instance sg13cmos5l_decap_8_45 r0 *1 0,0
Xsg13cmos5l_decap_8_45 \$2 \$1 sg13cmos5l_decap_8
* cell instance sg13cmos5l_decap_8_46 r0 *1 0,0
Xsg13cmos5l_decap_8_46 \$2 \$1 sg13cmos5l_decap_8
* cell instance sg13cmos5l_decap_8_47 r0 *1 0,0
Xsg13cmos5l_decap_8_47 \$2 \$1 sg13cmos5l_decap_8
* cell instance sg13cmos5l_decap_8_48 r0 *1 0,0
Xsg13cmos5l_decap_8_48 \$2 \$1 sg13cmos5l_decap_8
* cell instance sg13cmos5l_decap_8_49 r0 *1 0,0
Xsg13cmos5l_decap_8_49 \$2 \$1 sg13cmos5l_decap_8
* cell instance sg13cmos5l_decap_8_50 r0 *1 0,0
Xsg13cmos5l_decap_8_50 \$2 \$1 sg13cmos5l_decap_8
* cell instance sg13cmos5l_decap_8_51 r0 *1 0,0
Xsg13cmos5l_decap_8_51 \$2 \$1 sg13cmos5l_decap_8
* cell instance sg13cmos5l_decap_8_52 r0 *1 0,0
Xsg13cmos5l_decap_8_52 \$2 \$1 sg13cmos5l_decap_8
* cell instance sg13cmos5l_decap_8_53 r0 *1 0,0
Xsg13cmos5l_decap_8_53 \$2 \$1 sg13cmos5l_decap_8
* cell instance sg13cmos5l_decap_8_54 r0 *1 0,0
Xsg13cmos5l_decap_8_54 \$2 \$1 sg13cmos5l_decap_8
* cell instance sg13cmos5l_decap_8_55 r0 *1 0,0
Xsg13cmos5l_decap_8_55 \$2 \$1 sg13cmos5l_decap_8
* cell instance sg13cmos5l_decap_8_56 r0 *1 0,0
Xsg13cmos5l_decap_8_56 \$2 \$1 sg13cmos5l_decap_8
* cell instance sg13cmos5l_decap_8_57 r0 *1 0,0
Xsg13cmos5l_decap_8_57 \$2 \$1 sg13cmos5l_decap_8
* cell instance sg13cmos5l_decap_8_58 r0 *1 0,0
Xsg13cmos5l_decap_8_58 \$2 \$1 sg13cmos5l_decap_8
* cell instance sg13cmos5l_decap_8_59 r0 *1 0,0
Xsg13cmos5l_decap_8_59 \$2 \$1 sg13cmos5l_decap_8
* cell instance sg13cmos5l_decap_8_60 r0 *1 0,0
Xsg13cmos5l_decap_8_60 \$2 \$1 sg13cmos5l_decap_8
* cell instance sg13cmos5l_decap_8_61 r0 *1 0,0
Xsg13cmos5l_decap_8_61 \$2 \$1 sg13cmos5l_decap_8
* cell instance sg13cmos5l_decap_8_62 r0 *1 0,0
Xsg13cmos5l_decap_8_62 \$2 \$1 sg13cmos5l_decap_8
* cell instance sg13cmos5l_decap_8_63 r0 *1 0,0
Xsg13cmos5l_decap_8_63 \$2 \$1 sg13cmos5l_decap_8
* cell instance sg13cmos5l_decap_8_64 r0 *1 0,0
Xsg13cmos5l_decap_8_64 \$2 \$1 sg13cmos5l_decap_8
* cell instance sg13cmos5l_decap_8_65 r0 *1 0,0
Xsg13cmos5l_decap_8_65 \$2 \$1 sg13cmos5l_decap_8
* cell instance sg13cmos5l_decap_8_66 r0 *1 0,0
Xsg13cmos5l_decap_8_66 \$2 \$1 sg13cmos5l_decap_8
* cell instance sg13cmos5l_decap_8_67 r0 *1 0,0
Xsg13cmos5l_decap_8_67 \$2 \$1 sg13cmos5l_decap_8
* cell instance sg13cmos5l_decap_8_68 r0 *1 0,0
Xsg13cmos5l_decap_8_68 \$2 \$1 sg13cmos5l_decap_8
* cell instance sg13cmos5l_decap_8_69 r0 *1 0,0
Xsg13cmos5l_decap_8_69 \$2 \$1 sg13cmos5l_decap_8
* cell instance sg13cmos5l_decap_8_70 r0 *1 0,0
Xsg13cmos5l_decap_8_70 \$2 \$1 sg13cmos5l_decap_8
* cell instance sg13cmos5l_decap_8_71 r0 *1 0,0
Xsg13cmos5l_decap_8_71 \$2 \$1 sg13cmos5l_decap_8
* cell instance sg13cmos5l_decap_8_72 r0 *1 0,0
Xsg13cmos5l_decap_8_72 \$2 \$1 sg13cmos5l_decap_8
* cell instance sg13cmos5l_decap_8_73 r0 *1 0,0
Xsg13cmos5l_decap_8_73 \$2 \$1 sg13cmos5l_decap_8
* cell instance sg13cmos5l_decap_8_74 r0 *1 0,0
Xsg13cmos5l_decap_8_74 \$2 \$1 sg13cmos5l_decap_8
* cell instance sg13cmos5l_decap_8_75 r0 *1 0,0
Xsg13cmos5l_decap_8_75 \$2 \$1 sg13cmos5l_decap_8
* cell instance sg13cmos5l_decap_8_76 r0 *1 0,0
Xsg13cmos5l_decap_8_76 \$2 \$1 sg13cmos5l_decap_8
* cell instance sg13cmos5l_decap_8_77 r0 *1 0,0
Xsg13cmos5l_decap_8_77 \$2 \$1 sg13cmos5l_decap_8
* cell instance sg13cmos5l_decap_8_78 r0 *1 0,0
Xsg13cmos5l_decap_8_78 \$2 \$1 sg13cmos5l_decap_8
* cell instance sg13cmos5l_decap_8_79 r0 *1 0,0
Xsg13cmos5l_decap_8_79 \$2 \$1 sg13cmos5l_decap_8
* cell instance sg13cmos5l_decap_8_80 r0 *1 0,0
Xsg13cmos5l_decap_8_80 \$2 \$1 sg13cmos5l_decap_8
* cell instance sg13cmos5l_decap_8_81 r0 *1 0,0
Xsg13cmos5l_decap_8_81 \$2 \$1 sg13cmos5l_decap_8
* cell instance sg13cmos5l_decap_8_82 r0 *1 0,0
Xsg13cmos5l_decap_8_82 \$2 \$1 sg13cmos5l_decap_8
* cell instance sg13cmos5l_decap_8_83 r0 *1 0,0
Xsg13cmos5l_decap_8_83 \$2 \$1 sg13cmos5l_decap_8
* cell instance sg13cmos5l_decap_8_84 r0 *1 0,0
Xsg13cmos5l_decap_8_84 \$2 \$1 sg13cmos5l_decap_8
* cell instance sg13cmos5l_decap_8_85 r0 *1 0,0
Xsg13cmos5l_decap_8_85 \$2 \$1 sg13cmos5l_decap_8
* cell instance sg13cmos5l_decap_8_86 r0 *1 0,0
Xsg13cmos5l_decap_8_86 \$2 \$1 sg13cmos5l_decap_8
* cell instance sg13cmos5l_decap_8_87 r0 *1 0,0
Xsg13cmos5l_decap_8_87 \$2 \$1 sg13cmos5l_decap_8
* cell instance sg13cmos5l_decap_8_88 r0 *1 0,0
Xsg13cmos5l_decap_8_88 \$2 \$1 sg13cmos5l_decap_8
* cell instance sg13cmos5l_decap_8_89 r0 *1 0,0
Xsg13cmos5l_decap_8_89 \$2 \$1 sg13cmos5l_decap_8
* cell instance sg13cmos5l_decap_8_90 r0 *1 0,0
Xsg13cmos5l_decap_8_90 \$2 \$1 sg13cmos5l_decap_8
* cell instance sg13cmos5l_decap_8_91 r0 *1 0,0
Xsg13cmos5l_decap_8_91 \$2 \$1 sg13cmos5l_decap_8
* cell instance sg13cmos5l_decap_8_92 r0 *1 0,0
Xsg13cmos5l_decap_8_92 \$2 \$1 sg13cmos5l_decap_8
* cell instance sg13cmos5l_decap_8_93 r0 *1 0,0
Xsg13cmos5l_decap_8_93 \$2 \$1 sg13cmos5l_decap_8
* cell instance sg13cmos5l_decap_8_94 r0 *1 0,0
Xsg13cmos5l_decap_8_94 \$2 \$1 sg13cmos5l_decap_8
* cell instance sg13cmos5l_decap_8_95 r0 *1 0,0
Xsg13cmos5l_decap_8_95 \$2 \$1 sg13cmos5l_decap_8
* cell instance sg13cmos5l_decap_8_96 r0 *1 0,0
Xsg13cmos5l_decap_8_96 \$2 \$1 sg13cmos5l_decap_8
* cell instance sg13cmos5l_decap_8_97 r0 *1 0,0
Xsg13cmos5l_decap_8_97 \$2 \$1 sg13cmos5l_decap_8
* cell instance sg13cmos5l_decap_8_98 r0 *1 0,0
Xsg13cmos5l_decap_8_98 \$2 \$1 sg13cmos5l_decap_8
* cell instance sg13cmos5l_decap_8_99 r0 *1 0,0
Xsg13cmos5l_decap_8_99 \$2 \$1 sg13cmos5l_decap_8
* cell instance sg13cmos5l_decap_8_100 r0 *1 0,0
Xsg13cmos5l_decap_8_100 \$2 \$1 sg13cmos5l_decap_8
* cell instance sg13cmos5l_decap_8_101 r0 *1 0,0
Xsg13cmos5l_decap_8_101 \$2 \$1 sg13cmos5l_decap_8
* cell instance sg13cmos5l_decap_8_102 r0 *1 0,0
Xsg13cmos5l_decap_8_102 \$2 \$1 sg13cmos5l_decap_8
* cell instance sg13cmos5l_decap_8_103 r0 *1 0,0
Xsg13cmos5l_decap_8_103 \$2 \$1 sg13cmos5l_decap_8
* cell instance sg13cmos5l_decap_8_104 r0 *1 0,0
Xsg13cmos5l_decap_8_104 \$2 \$1 sg13cmos5l_decap_8
* cell instance sg13cmos5l_decap_8_105 r0 *1 0,0
Xsg13cmos5l_decap_8_105 \$2 \$1 sg13cmos5l_decap_8
* cell instance sg13cmos5l_decap_8_106 r0 *1 0,0
Xsg13cmos5l_decap_8_106 \$2 \$1 sg13cmos5l_decap_8
* cell instance sg13cmos5l_decap_8_107 r0 *1 0,0
Xsg13cmos5l_decap_8_107 \$2 \$1 sg13cmos5l_decap_8
* cell instance sg13cmos5l_decap_8_108 r0 *1 0,0
Xsg13cmos5l_decap_8_108 \$2 \$1 sg13cmos5l_decap_8
* cell instance sg13cmos5l_decap_8_109 r0 *1 0,0
Xsg13cmos5l_decap_8_109 \$2 \$1 sg13cmos5l_decap_8
* cell instance sg13cmos5l_decap_8_110 r0 *1 0,0
Xsg13cmos5l_decap_8_110 \$2 \$1 sg13cmos5l_decap_8
* cell instance sg13cmos5l_decap_8_111 r0 *1 0,0
Xsg13cmos5l_decap_8_111 \$2 \$1 sg13cmos5l_decap_8
* cell instance sg13cmos5l_decap_8_112 r0 *1 0,0
Xsg13cmos5l_decap_8_112 \$2 \$1 sg13cmos5l_decap_8
* cell instance sg13cmos5l_decap_8_113 r0 *1 0,0
Xsg13cmos5l_decap_8_113 \$2 \$1 sg13cmos5l_decap_8
* cell instance sg13cmos5l_decap_8_114 r0 *1 0,0
Xsg13cmos5l_decap_8_114 \$2 \$1 sg13cmos5l_decap_8
* cell instance sg13cmos5l_decap_8_115 r0 *1 0,0
Xsg13cmos5l_decap_8_115 \$2 \$1 sg13cmos5l_decap_8
* cell instance sg13cmos5l_decap_8_116 r0 *1 0,0
Xsg13cmos5l_decap_8_116 \$2 \$1 sg13cmos5l_decap_8
* cell instance sg13cmos5l_decap_8_117 r0 *1 0,0
Xsg13cmos5l_decap_8_117 \$2 \$1 sg13cmos5l_decap_8
* cell instance sg13cmos5l_decap_8_118 r0 *1 0,0
Xsg13cmos5l_decap_8_118 \$2 \$1 sg13cmos5l_decap_8
* cell instance sg13cmos5l_decap_8_119 r0 *1 0,0
Xsg13cmos5l_decap_8_119 \$2 \$1 sg13cmos5l_decap_8
* cell instance sg13cmos5l_decap_8_120 r0 *1 0,0
Xsg13cmos5l_decap_8_120 \$2 \$1 sg13cmos5l_decap_8
* cell instance sg13cmos5l_decap_8_121 r0 *1 0,0
Xsg13cmos5l_decap_8_121 \$2 \$1 sg13cmos5l_decap_8
* cell instance sg13cmos5l_decap_8_122 r0 *1 0,0
Xsg13cmos5l_decap_8_122 \$2 \$1 sg13cmos5l_decap_8
* cell instance sg13cmos5l_decap_8_123 r0 *1 0,0
Xsg13cmos5l_decap_8_123 \$2 \$1 sg13cmos5l_decap_8
* cell instance sg13cmos5l_decap_8_124 r0 *1 0,0
Xsg13cmos5l_decap_8_124 \$2 \$1 sg13cmos5l_decap_8
* cell instance sg13cmos5l_decap_8_125 r0 *1 0,0
Xsg13cmos5l_decap_8_125 \$2 \$1 sg13cmos5l_decap_8
* cell instance sg13cmos5l_decap_8_126 r0 *1 0,0
Xsg13cmos5l_decap_8_126 \$2 \$1 sg13cmos5l_decap_8
* cell instance sg13cmos5l_decap_8_127 r0 *1 0,0
Xsg13cmos5l_decap_8_127 \$2 \$1 sg13cmos5l_decap_8
* cell instance sg13cmos5l_decap_8_128 r0 *1 0,0
Xsg13cmos5l_decap_8_128 \$2 \$1 sg13cmos5l_decap_8
* cell instance sg13cmos5l_decap_8_129 r0 *1 0,0
Xsg13cmos5l_decap_8_129 \$2 \$1 sg13cmos5l_decap_8
* cell instance sg13cmos5l_decap_8_130 r0 *1 0,0
Xsg13cmos5l_decap_8_130 \$2 \$1 sg13cmos5l_decap_8
* cell instance sg13cmos5l_decap_8_131 r0 *1 0,0
Xsg13cmos5l_decap_8_131 \$2 \$1 sg13cmos5l_decap_8
* cell instance sg13cmos5l_decap_8_132 r0 *1 0,0
Xsg13cmos5l_decap_8_132 \$2 \$1 sg13cmos5l_decap_8
* cell instance sg13cmos5l_decap_8_133 r0 *1 0,0
Xsg13cmos5l_decap_8_133 \$2 \$1 sg13cmos5l_decap_8
* cell instance sg13cmos5l_decap_8_134 r0 *1 0,0
Xsg13cmos5l_decap_8_134 \$2 \$1 sg13cmos5l_decap_8
* cell instance sg13cmos5l_decap_8_135 r0 *1 0,0
Xsg13cmos5l_decap_8_135 \$2 \$1 sg13cmos5l_decap_8
* cell instance sg13cmos5l_decap_8_136 r0 *1 0,0
Xsg13cmos5l_decap_8_136 \$2 \$1 sg13cmos5l_decap_8
* cell instance sg13cmos5l_decap_8_137 r0 *1 0,0
Xsg13cmos5l_decap_8_137 \$2 \$1 sg13cmos5l_decap_8
* cell instance sg13cmos5l_decap_8_138 r0 *1 0,0
Xsg13cmos5l_decap_8_138 \$2 \$1 sg13cmos5l_decap_8
* cell instance sg13cmos5l_decap_8_139 r0 *1 0,0
Xsg13cmos5l_decap_8_139 \$2 \$1 sg13cmos5l_decap_8
* cell instance sg13cmos5l_decap_8_140 r0 *1 0,0
Xsg13cmos5l_decap_8_140 \$2 \$1 sg13cmos5l_decap_8
* cell instance sg13cmos5l_decap_8_141 r0 *1 0,0
Xsg13cmos5l_decap_8_141 \$2 \$1 sg13cmos5l_decap_8
* cell instance sg13cmos5l_decap_8_142 r0 *1 0,0
Xsg13cmos5l_decap_8_142 \$2 \$1 sg13cmos5l_decap_8
* cell instance sg13cmos5l_decap_8_143 r0 *1 0,0
Xsg13cmos5l_decap_8_143 \$2 \$1 sg13cmos5l_decap_8
* cell instance sg13cmos5l_decap_8_144 r0 *1 0,0
Xsg13cmos5l_decap_8_144 \$2 \$1 sg13cmos5l_decap_8
* cell instance sg13cmos5l_decap_8_145 r0 *1 0,0
Xsg13cmos5l_decap_8_145 \$2 \$1 sg13cmos5l_decap_8
* cell instance sg13cmos5l_decap_8_146 r0 *1 0,0
Xsg13cmos5l_decap_8_146 \$2 \$1 sg13cmos5l_decap_8
* cell instance sg13cmos5l_decap_8_147 r0 *1 0,0
Xsg13cmos5l_decap_8_147 \$2 \$1 sg13cmos5l_decap_8
* cell instance sg13cmos5l_decap_8_148 r0 *1 0,0
Xsg13cmos5l_decap_8_148 \$2 \$1 sg13cmos5l_decap_8
* cell instance sg13cmos5l_decap_8_149 r0 *1 0,0
Xsg13cmos5l_decap_8_149 \$2 \$1 sg13cmos5l_decap_8
* cell instance sg13cmos5l_decap_8_150 r0 *1 0,0
Xsg13cmos5l_decap_8_150 \$2 \$1 sg13cmos5l_decap_8
* cell instance sg13cmos5l_decap_8_151 r0 *1 0,0
Xsg13cmos5l_decap_8_151 \$2 \$1 sg13cmos5l_decap_8
* cell instance sg13cmos5l_decap_8_152 r0 *1 0,0
Xsg13cmos5l_decap_8_152 \$2 \$1 sg13cmos5l_decap_8
* cell instance sg13cmos5l_decap_8_153 r0 *1 0,0
Xsg13cmos5l_decap_8_153 \$2 \$1 sg13cmos5l_decap_8
* cell instance sg13cmos5l_decap_8_154 r0 *1 0,0
Xsg13cmos5l_decap_8_154 \$2 \$1 sg13cmos5l_decap_8
* cell instance sg13cmos5l_decap_8_155 r0 *1 0,0
Xsg13cmos5l_decap_8_155 \$2 \$1 sg13cmos5l_decap_8
* cell instance sg13cmos5l_decap_8_156 r0 *1 0,0
Xsg13cmos5l_decap_8_156 \$2 \$1 sg13cmos5l_decap_8
* cell instance sg13cmos5l_decap_8_157 r0 *1 0,0
Xsg13cmos5l_decap_8_157 \$2 \$1 sg13cmos5l_decap_8
* cell instance sg13cmos5l_decap_8_158 r0 *1 0,0
Xsg13cmos5l_decap_8_158 \$2 \$1 sg13cmos5l_decap_8
* cell instance sg13cmos5l_decap_8_159 r0 *1 0,0
Xsg13cmos5l_decap_8_159 \$2 \$1 sg13cmos5l_decap_8
* cell instance sg13cmos5l_decap_8_160 r0 *1 0,0
Xsg13cmos5l_decap_8_160 \$2 \$1 sg13cmos5l_decap_8
* cell instance sg13cmos5l_decap_8_161 r0 *1 0,0
Xsg13cmos5l_decap_8_161 \$2 \$1 sg13cmos5l_decap_8
* cell instance sg13cmos5l_decap_8_162 r0 *1 0,0
Xsg13cmos5l_decap_8_162 \$2 \$1 sg13cmos5l_decap_8
* cell instance sg13cmos5l_decap_8_163 r0 *1 0,0
Xsg13cmos5l_decap_8_163 \$2 \$1 sg13cmos5l_decap_8
* cell instance sg13cmos5l_decap_8_164 r0 *1 0,0
Xsg13cmos5l_decap_8_164 \$2 \$1 sg13cmos5l_decap_8
* cell instance sg13cmos5l_decap_8_165 r0 *1 0,0
Xsg13cmos5l_decap_8_165 \$2 \$1 sg13cmos5l_decap_8
* cell instance sg13cmos5l_decap_8_166 r0 *1 0,0
Xsg13cmos5l_decap_8_166 \$2 \$1 sg13cmos5l_decap_8
* cell instance sg13cmos5l_decap_8_167 r0 *1 0,0
Xsg13cmos5l_decap_8_167 \$2 \$1 sg13cmos5l_decap_8
* cell instance sg13cmos5l_decap_8_168 r0 *1 0,0
Xsg13cmos5l_decap_8_168 \$2 \$1 sg13cmos5l_decap_8
* cell instance sg13cmos5l_decap_8_169 r0 *1 0,0
Xsg13cmos5l_decap_8_169 \$2 \$1 sg13cmos5l_decap_8
* cell instance sg13cmos5l_decap_8_170 r0 *1 0,0
Xsg13cmos5l_decap_8_170 \$2 \$1 sg13cmos5l_decap_8
* cell instance sg13cmos5l_decap_8_171 r0 *1 0,0
Xsg13cmos5l_decap_8_171 \$2 \$1 sg13cmos5l_decap_8
* cell instance sg13cmos5l_decap_8_172 r0 *1 0,0
Xsg13cmos5l_decap_8_172 \$2 \$1 sg13cmos5l_decap_8
* cell instance sg13cmos5l_decap_8_173 r0 *1 0,0
Xsg13cmos5l_decap_8_173 \$2 \$1 sg13cmos5l_decap_8
* cell instance sg13cmos5l_decap_8_174 r0 *1 0,0
Xsg13cmos5l_decap_8_174 \$2 \$1 sg13cmos5l_decap_8
* cell instance sg13cmos5l_decap_8_175 r0 *1 0,0
Xsg13cmos5l_decap_8_175 \$2 \$1 sg13cmos5l_decap_8
* cell instance sg13cmos5l_decap_8_176 r0 *1 0,0
Xsg13cmos5l_decap_8_176 \$2 \$1 sg13cmos5l_decap_8
* cell instance sg13cmos5l_decap_8_177 r0 *1 0,0
Xsg13cmos5l_decap_8_177 \$2 \$1 sg13cmos5l_decap_8
* cell instance sg13cmos5l_decap_8_178 r0 *1 0,0
Xsg13cmos5l_decap_8_178 \$2 \$1 sg13cmos5l_decap_8
* cell instance sg13cmos5l_decap_8_179 r0 *1 0,0
Xsg13cmos5l_decap_8_179 \$2 \$1 sg13cmos5l_decap_8
* cell instance sg13cmos5l_decap_8_180 r0 *1 0,0
Xsg13cmos5l_decap_8_180 \$2 \$1 sg13cmos5l_decap_8
* cell instance sg13cmos5l_decap_8_181 r0 *1 0,0
Xsg13cmos5l_decap_8_181 \$2 \$1 sg13cmos5l_decap_8
* cell instance sg13cmos5l_decap_8_182 r0 *1 0,0
Xsg13cmos5l_decap_8_182 \$2 \$1 sg13cmos5l_decap_8
* cell instance sg13cmos5l_decap_8_183 r0 *1 0,0
Xsg13cmos5l_decap_8_183 \$2 \$1 sg13cmos5l_decap_8
* cell instance sg13cmos5l_decap_8_184 r0 *1 0,0
Xsg13cmos5l_decap_8_184 \$2 \$1 sg13cmos5l_decap_8
* cell instance sg13cmos5l_decap_8_185 r0 *1 0,0
Xsg13cmos5l_decap_8_185 \$2 \$1 sg13cmos5l_decap_8
* cell instance sg13cmos5l_decap_8_186 r0 *1 0,0
Xsg13cmos5l_decap_8_186 \$2 \$1 sg13cmos5l_decap_8
* cell instance sg13cmos5l_decap_8_187 r0 *1 0,0
Xsg13cmos5l_decap_8_187 \$2 \$1 sg13cmos5l_decap_8
* cell instance sg13cmos5l_decap_8_188 r0 *1 0,0
Xsg13cmos5l_decap_8_188 \$2 \$1 sg13cmos5l_decap_8
* cell instance sg13cmos5l_decap_8_189 r0 *1 0,0
Xsg13cmos5l_decap_8_189 \$2 \$1 sg13cmos5l_decap_8
* cell instance sg13cmos5l_decap_8_190 r0 *1 0,0
Xsg13cmos5l_decap_8_190 \$2 \$1 sg13cmos5l_decap_8
* cell instance sg13cmos5l_decap_8_191 r0 *1 0,0
Xsg13cmos5l_decap_8_191 \$2 \$1 sg13cmos5l_decap_8
* cell instance sg13cmos5l_decap_8_192 r0 *1 0,0
Xsg13cmos5l_decap_8_192 \$2 \$1 sg13cmos5l_decap_8
* cell instance sg13cmos5l_decap_8_193 r0 *1 0,0
Xsg13cmos5l_decap_8_193 \$2 \$1 sg13cmos5l_decap_8
* cell instance sg13cmos5l_decap_8_194 r0 *1 0,0
Xsg13cmos5l_decap_8_194 \$2 \$1 sg13cmos5l_decap_8
* cell instance sg13cmos5l_decap_8_195 r0 *1 0,0
Xsg13cmos5l_decap_8_195 \$2 \$1 sg13cmos5l_decap_8
* cell instance sg13cmos5l_decap_8_196 r0 *1 0,0
Xsg13cmos5l_decap_8_196 \$2 \$1 sg13cmos5l_decap_8
* cell instance sg13cmos5l_decap_8_197 r0 *1 0,0
Xsg13cmos5l_decap_8_197 \$2 \$1 sg13cmos5l_decap_8
* cell instance sg13cmos5l_decap_8_198 r0 *1 0,0
Xsg13cmos5l_decap_8_198 \$2 \$1 sg13cmos5l_decap_8
* cell instance sg13cmos5l_decap_8_199 r0 *1 0,0
Xsg13cmos5l_decap_8_199 \$2 \$1 sg13cmos5l_decap_8
* cell instance sg13cmos5l_decap_8_200 r0 *1 0,0
Xsg13cmos5l_decap_8_200 \$2 \$1 sg13cmos5l_decap_8
* cell instance sg13cmos5l_decap_8_201 r0 *1 0,0
Xsg13cmos5l_decap_8_201 \$2 \$1 sg13cmos5l_decap_8
* cell instance sg13cmos5l_decap_8_202 r0 *1 0,0
Xsg13cmos5l_decap_8_202 \$2 \$1 sg13cmos5l_decap_8
* cell instance sg13cmos5l_decap_8_203 r0 *1 0,0
Xsg13cmos5l_decap_8_203 \$2 \$1 sg13cmos5l_decap_8
* cell instance sg13cmos5l_decap_8_204 r0 *1 0,0
Xsg13cmos5l_decap_8_204 \$2 \$1 sg13cmos5l_decap_8
* cell instance sg13cmos5l_decap_8_205 r0 *1 0,0
Xsg13cmos5l_decap_8_205 \$2 \$1 sg13cmos5l_decap_8
* cell instance sg13cmos5l_decap_8_206 r0 *1 0,0
Xsg13cmos5l_decap_8_206 \$2 \$1 sg13cmos5l_decap_8
* cell instance sg13cmos5l_decap_8_207 r0 *1 0,0
Xsg13cmos5l_decap_8_207 \$2 \$1 sg13cmos5l_decap_8
* cell instance sg13cmos5l_decap_8_208 r0 *1 0,0
Xsg13cmos5l_decap_8_208 \$2 \$1 sg13cmos5l_decap_8
* cell instance sg13cmos5l_decap_8_209 r0 *1 0,0
Xsg13cmos5l_decap_8_209 \$2 \$1 sg13cmos5l_decap_8
* cell instance sg13cmos5l_decap_8_210 r0 *1 0,0
Xsg13cmos5l_decap_8_210 \$2 \$1 sg13cmos5l_decap_8
* cell instance sg13cmos5l_decap_8_211 r0 *1 0,0
Xsg13cmos5l_decap_8_211 \$2 \$1 sg13cmos5l_decap_8
* cell instance sg13cmos5l_decap_8_212 r0 *1 0,0
Xsg13cmos5l_decap_8_212 \$2 \$1 sg13cmos5l_decap_8
* cell instance sg13cmos5l_decap_8_213 r0 *1 0,0
Xsg13cmos5l_decap_8_213 \$2 \$1 sg13cmos5l_decap_8
* cell instance sg13cmos5l_decap_8_214 r0 *1 0,0
Xsg13cmos5l_decap_8_214 \$2 \$1 sg13cmos5l_decap_8
* cell instance sg13cmos5l_decap_8_215 r0 *1 0,0
Xsg13cmos5l_decap_8_215 \$2 \$1 sg13cmos5l_decap_8
* cell instance sg13cmos5l_decap_8_216 r0 *1 0,0
Xsg13cmos5l_decap_8_216 \$2 \$1 sg13cmos5l_decap_8
* cell instance sg13cmos5l_decap_8_217 r0 *1 0,0
Xsg13cmos5l_decap_8_217 \$2 \$1 sg13cmos5l_decap_8
* cell instance sg13cmos5l_decap_8_218 r0 *1 0,0
Xsg13cmos5l_decap_8_218 \$2 \$1 sg13cmos5l_decap_8
* cell instance sg13cmos5l_decap_8_219 r0 *1 0,0
Xsg13cmos5l_decap_8_219 \$2 \$1 sg13cmos5l_decap_8
* cell instance sg13cmos5l_decap_8_220 r0 *1 0,0
Xsg13cmos5l_decap_8_220 \$2 \$1 sg13cmos5l_decap_8
* cell instance sg13cmos5l_decap_8_221 r0 *1 0,0
Xsg13cmos5l_decap_8_221 \$2 \$1 sg13cmos5l_decap_8
* cell instance sg13cmos5l_decap_8_222 r0 *1 0,0
Xsg13cmos5l_decap_8_222 \$2 \$1 sg13cmos5l_decap_8
* cell instance sg13cmos5l_decap_8_223 r0 *1 0,0
Xsg13cmos5l_decap_8_223 \$2 \$1 sg13cmos5l_decap_8
* cell instance sg13cmos5l_decap_8_224 r0 *1 0,0
Xsg13cmos5l_decap_8_224 \$2 \$1 sg13cmos5l_decap_8
* cell instance sg13cmos5l_decap_8_225 r0 *1 0,0
Xsg13cmos5l_decap_8_225 \$2 \$1 sg13cmos5l_decap_8
* cell instance sg13cmos5l_decap_8_226 r0 *1 0,0
Xsg13cmos5l_decap_8_226 \$2 \$1 sg13cmos5l_decap_8
* cell instance sg13cmos5l_decap_8_227 r0 *1 0,0
Xsg13cmos5l_decap_8_227 \$2 \$1 sg13cmos5l_decap_8
* cell instance sg13cmos5l_decap_8_228 r0 *1 0,0
Xsg13cmos5l_decap_8_228 \$2 \$1 sg13cmos5l_decap_8
* cell instance sg13cmos5l_decap_8_229 r0 *1 0,0
Xsg13cmos5l_decap_8_229 \$2 \$1 sg13cmos5l_decap_8
* cell instance sg13cmos5l_decap_8_230 r0 *1 0,0
Xsg13cmos5l_decap_8_230 \$2 \$1 sg13cmos5l_decap_8
* cell instance sg13cmos5l_decap_8_231 r0 *1 0,0
Xsg13cmos5l_decap_8_231 \$2 \$1 sg13cmos5l_decap_8
* cell instance sg13cmos5l_decap_8_232 r0 *1 0,0
Xsg13cmos5l_decap_8_232 \$2 \$1 sg13cmos5l_decap_8
* cell instance sg13cmos5l_decap_8_233 r0 *1 0,0
Xsg13cmos5l_decap_8_233 \$2 \$1 sg13cmos5l_decap_8
* cell instance sg13cmos5l_decap_8_234 r0 *1 0,0
Xsg13cmos5l_decap_8_234 \$2 \$1 sg13cmos5l_decap_8
* cell instance sg13cmos5l_decap_8_235 r0 *1 0,0
Xsg13cmos5l_decap_8_235 \$2 \$1 sg13cmos5l_decap_8
* cell instance sg13cmos5l_decap_8_236 r0 *1 0,0
Xsg13cmos5l_decap_8_236 \$2 \$1 sg13cmos5l_decap_8
* cell instance sg13cmos5l_decap_8_237 r0 *1 0,0
Xsg13cmos5l_decap_8_237 \$2 \$1 sg13cmos5l_decap_8
* cell instance sg13cmos5l_decap_8_238 r0 *1 0,0
Xsg13cmos5l_decap_8_238 \$2 \$1 sg13cmos5l_decap_8
* cell instance sg13cmos5l_decap_8_239 r0 *1 0,0
Xsg13cmos5l_decap_8_239 \$2 \$1 sg13cmos5l_decap_8
* cell instance sg13cmos5l_decap_8_240 r0 *1 0,0
Xsg13cmos5l_decap_8_240 \$2 \$1 sg13cmos5l_decap_8
* cell instance sg13cmos5l_decap_8_241 r0 *1 0,0
Xsg13cmos5l_decap_8_241 \$2 \$1 sg13cmos5l_decap_8
* cell instance sg13cmos5l_decap_8_242 r0 *1 0,0
Xsg13cmos5l_decap_8_242 \$2 \$1 sg13cmos5l_decap_8
* cell instance sg13cmos5l_decap_8_243 r0 *1 0,0
Xsg13cmos5l_decap_8_243 \$2 \$1 sg13cmos5l_decap_8
* cell instance sg13cmos5l_decap_8_244 r0 *1 0,0
Xsg13cmos5l_decap_8_244 \$2 \$1 sg13cmos5l_decap_8
* cell instance sg13cmos5l_decap_8_245 r0 *1 0,0
Xsg13cmos5l_decap_8_245 \$2 \$1 sg13cmos5l_decap_8
* cell instance sg13cmos5l_decap_8_246 r0 *1 0,0
Xsg13cmos5l_decap_8_246 \$2 \$1 sg13cmos5l_decap_8
* cell instance sg13cmos5l_decap_8_247 r0 *1 0,0
Xsg13cmos5l_decap_8_247 \$2 \$1 sg13cmos5l_decap_8
* cell instance sg13cmos5l_decap_8_248 r0 *1 0,0
Xsg13cmos5l_decap_8_248 \$2 \$1 sg13cmos5l_decap_8
* cell instance sg13cmos5l_decap_8_249 r0 *1 0,0
Xsg13cmos5l_decap_8_249 \$2 \$1 sg13cmos5l_decap_8
* cell instance sg13cmos5l_decap_8_250 r0 *1 0,0
Xsg13cmos5l_decap_8_250 \$2 \$1 sg13cmos5l_decap_8
* cell instance sg13cmos5l_decap_8_251 r0 *1 0,0
Xsg13cmos5l_decap_8_251 \$2 \$1 sg13cmos5l_decap_8
* cell instance sg13cmos5l_decap_8_252 r0 *1 0,0
Xsg13cmos5l_decap_8_252 \$2 \$1 sg13cmos5l_decap_8
* cell instance sg13cmos5l_decap_8_253 r0 *1 0,0
Xsg13cmos5l_decap_8_253 \$2 \$1 sg13cmos5l_decap_8
* cell instance sg13cmos5l_decap_8_254 r0 *1 0,0
Xsg13cmos5l_decap_8_254 \$2 \$1 sg13cmos5l_decap_8
* cell instance sg13cmos5l_decap_8_255 r0 *1 0,0
Xsg13cmos5l_decap_8_255 \$2 \$1 sg13cmos5l_decap_8
* cell instance sg13cmos5l_decap_8_256 r0 *1 0,0
Xsg13cmos5l_decap_8_256 \$2 \$1 sg13cmos5l_decap_8
* cell instance sg13cmos5l_decap_8_257 r0 *1 0,0
Xsg13cmos5l_decap_8_257 \$2 \$1 sg13cmos5l_decap_8
* cell instance sg13cmos5l_decap_8_258 r0 *1 0,0
Xsg13cmos5l_decap_8_258 \$2 \$1 sg13cmos5l_decap_8
* cell instance sg13cmos5l_decap_8_259 r0 *1 0,0
Xsg13cmos5l_decap_8_259 \$2 \$1 sg13cmos5l_decap_8
* cell instance sg13cmos5l_decap_8_260 r0 *1 0,0
Xsg13cmos5l_decap_8_260 \$2 \$1 sg13cmos5l_decap_8
* cell instance sg13cmos5l_decap_8_261 r0 *1 0,0
Xsg13cmos5l_decap_8_261 \$2 \$1 sg13cmos5l_decap_8
* cell instance sg13cmos5l_decap_8_262 r0 *1 0,0
Xsg13cmos5l_decap_8_262 \$2 \$1 sg13cmos5l_decap_8
* cell instance sg13cmos5l_decap_8_263 r0 *1 0,0
Xsg13cmos5l_decap_8_263 \$2 \$1 sg13cmos5l_decap_8
* cell instance sg13cmos5l_decap_8_264 r0 *1 0,0
Xsg13cmos5l_decap_8_264 \$2 \$1 sg13cmos5l_decap_8
* cell instance sg13cmos5l_decap_8_265 r0 *1 0,0
Xsg13cmos5l_decap_8_265 \$2 \$1 sg13cmos5l_decap_8
* cell instance sg13cmos5l_decap_8_266 r0 *1 0,0
Xsg13cmos5l_decap_8_266 \$2 \$1 sg13cmos5l_decap_8
* cell instance sg13cmos5l_decap_8_267 r0 *1 0,0
Xsg13cmos5l_decap_8_267 \$2 \$1 sg13cmos5l_decap_8
* cell instance sg13cmos5l_decap_8_268 r0 *1 0,0
Xsg13cmos5l_decap_8_268 \$2 \$1 sg13cmos5l_decap_8
* cell instance sg13cmos5l_decap_8_269 r0 *1 0,0
Xsg13cmos5l_decap_8_269 \$2 \$1 sg13cmos5l_decap_8
* cell instance sg13cmos5l_decap_8_270 r0 *1 0,0
Xsg13cmos5l_decap_8_270 \$2 \$1 sg13cmos5l_decap_8
* cell instance sg13cmos5l_decap_8_271 r0 *1 0,0
Xsg13cmos5l_decap_8_271 \$2 \$1 sg13cmos5l_decap_8
* cell instance sg13cmos5l_decap_8_272 r0 *1 0,0
Xsg13cmos5l_decap_8_272 \$2 \$1 sg13cmos5l_decap_8
* cell instance sg13cmos5l_decap_8_273 r0 *1 0,0
Xsg13cmos5l_decap_8_273 \$2 \$1 sg13cmos5l_decap_8
* cell instance sg13cmos5l_decap_8_274 r0 *1 0,0
Xsg13cmos5l_decap_8_274 \$2 \$1 sg13cmos5l_decap_8
* cell instance sg13cmos5l_decap_8_275 r0 *1 0,0
Xsg13cmos5l_decap_8_275 \$2 \$1 sg13cmos5l_decap_8
* cell instance sg13cmos5l_decap_8_276 r0 *1 0,0
Xsg13cmos5l_decap_8_276 \$2 \$1 sg13cmos5l_decap_8
* cell instance sg13cmos5l_decap_8_277 r0 *1 0,0
Xsg13cmos5l_decap_8_277 \$2 \$1 sg13cmos5l_decap_8
* cell instance sg13cmos5l_decap_8_278 r0 *1 0,0
Xsg13cmos5l_decap_8_278 \$2 \$1 sg13cmos5l_decap_8
* cell instance sg13cmos5l_decap_8_279 r0 *1 0,0
Xsg13cmos5l_decap_8_279 \$2 \$1 sg13cmos5l_decap_8
* cell instance sg13cmos5l_decap_8_280 r0 *1 0,0
Xsg13cmos5l_decap_8_280 \$2 \$1 sg13cmos5l_decap_8
* cell instance sg13cmos5l_decap_8_281 r0 *1 0,0
Xsg13cmos5l_decap_8_281 \$2 \$1 sg13cmos5l_decap_8
* cell instance sg13cmos5l_decap_8_282 r0 *1 0,0
Xsg13cmos5l_decap_8_282 \$2 \$1 sg13cmos5l_decap_8
* cell instance sg13cmos5l_decap_8_283 r0 *1 0,0
Xsg13cmos5l_decap_8_283 \$2 \$1 sg13cmos5l_decap_8
* cell instance sg13cmos5l_decap_8_284 r0 *1 0,0
Xsg13cmos5l_decap_8_284 \$2 \$1 sg13cmos5l_decap_8
* cell instance sg13cmos5l_decap_8_285 r0 *1 0,0
Xsg13cmos5l_decap_8_285 \$2 \$1 sg13cmos5l_decap_8
* cell instance sg13cmos5l_decap_8_286 r0 *1 0,0
Xsg13cmos5l_decap_8_286 \$2 \$1 sg13cmos5l_decap_8
* cell instance sg13cmos5l_decap_8_287 r0 *1 0,0
Xsg13cmos5l_decap_8_287 \$2 \$1 sg13cmos5l_decap_8
* cell instance sg13cmos5l_decap_8_288 r0 *1 0,0
Xsg13cmos5l_decap_8_288 \$2 \$1 sg13cmos5l_decap_8
* cell instance sg13cmos5l_decap_8_289 r0 *1 0,0
Xsg13cmos5l_decap_8_289 \$2 \$1 sg13cmos5l_decap_8
* cell instance sg13cmos5l_decap_8_290 r0 *1 0,0
Xsg13cmos5l_decap_8_290 \$2 \$1 sg13cmos5l_decap_8
* cell instance sg13cmos5l_decap_8_291 r0 *1 0,0
Xsg13cmos5l_decap_8_291 \$2 \$1 sg13cmos5l_decap_8
* cell instance sg13cmos5l_decap_8_292 r0 *1 0,0
Xsg13cmos5l_decap_8_292 \$2 \$1 sg13cmos5l_decap_8
* cell instance sg13cmos5l_decap_8_293 r0 *1 0,0
Xsg13cmos5l_decap_8_293 \$2 \$1 sg13cmos5l_decap_8
* cell instance sg13cmos5l_decap_8_294 r0 *1 0,0
Xsg13cmos5l_decap_8_294 \$2 \$1 sg13cmos5l_decap_8
* cell instance sg13cmos5l_decap_8_295 r0 *1 0,0
Xsg13cmos5l_decap_8_295 \$2 \$1 sg13cmos5l_decap_8
* cell instance sg13cmos5l_decap_8_296 r0 *1 0,0
Xsg13cmos5l_decap_8_296 \$2 \$1 sg13cmos5l_decap_8
* cell instance sg13cmos5l_decap_8_297 r0 *1 0,0
Xsg13cmos5l_decap_8_297 \$2 \$1 sg13cmos5l_decap_8
* cell instance sg13cmos5l_decap_8_298 r0 *1 0,0
Xsg13cmos5l_decap_8_298 \$2 \$1 sg13cmos5l_decap_8
* cell instance sg13cmos5l_decap_8_299 r0 *1 0,0
Xsg13cmos5l_decap_8_299 \$2 \$1 sg13cmos5l_decap_8
* cell instance sg13cmos5l_decap_8_300 r0 *1 0,0
Xsg13cmos5l_decap_8_300 \$2 \$1 sg13cmos5l_decap_8
* cell instance sg13cmos5l_decap_8_301 r0 *1 0,0
Xsg13cmos5l_decap_8_301 \$2 \$1 sg13cmos5l_decap_8
* cell instance sg13cmos5l_decap_8_302 r0 *1 0,0
Xsg13cmos5l_decap_8_302 \$2 \$1 sg13cmos5l_decap_8
* cell instance sg13cmos5l_decap_8_303 r0 *1 0,0
Xsg13cmos5l_decap_8_303 \$2 \$1 sg13cmos5l_decap_8
* cell instance sg13cmos5l_decap_8_304 r0 *1 0,0
Xsg13cmos5l_decap_8_304 \$2 \$1 sg13cmos5l_decap_8
* cell instance sg13cmos5l_decap_8_305 r0 *1 0,0
Xsg13cmos5l_decap_8_305 \$2 \$1 sg13cmos5l_decap_8
* cell instance sg13cmos5l_decap_8_306 r0 *1 0,0
Xsg13cmos5l_decap_8_306 \$2 \$1 sg13cmos5l_decap_8
* cell instance sg13cmos5l_decap_8_307 r0 *1 0,0
Xsg13cmos5l_decap_8_307 \$2 \$1 sg13cmos5l_decap_8
* cell instance sg13cmos5l_decap_8_308 r0 *1 0,0
Xsg13cmos5l_decap_8_308 \$2 \$1 sg13cmos5l_decap_8
* cell instance sg13cmos5l_decap_8_309 r0 *1 0,0
Xsg13cmos5l_decap_8_309 \$2 \$1 sg13cmos5l_decap_8
* cell instance sg13cmos5l_decap_8_310 r0 *1 0,0
Xsg13cmos5l_decap_8_310 \$2 \$1 sg13cmos5l_decap_8
* cell instance sg13cmos5l_decap_8_311 r0 *1 0,0
Xsg13cmos5l_decap_8_311 \$2 \$1 sg13cmos5l_decap_8
* cell instance sg13cmos5l_decap_8_312 r0 *1 0,0
Xsg13cmos5l_decap_8_312 \$2 \$1 sg13cmos5l_decap_8
* cell instance sg13cmos5l_decap_8_313 r0 *1 0,0
Xsg13cmos5l_decap_8_313 \$2 \$1 sg13cmos5l_decap_8
* cell instance sg13cmos5l_decap_8_314 r0 *1 0,0
Xsg13cmos5l_decap_8_314 \$2 \$1 sg13cmos5l_decap_8
* cell instance sg13cmos5l_decap_8_315 r0 *1 0,0
Xsg13cmos5l_decap_8_315 \$2 \$1 sg13cmos5l_decap_8
* cell instance sg13cmos5l_decap_8_316 r0 *1 0,0
Xsg13cmos5l_decap_8_316 \$2 \$1 sg13cmos5l_decap_8
* cell instance sg13cmos5l_decap_8_317 r0 *1 0,0
Xsg13cmos5l_decap_8_317 \$2 \$1 sg13cmos5l_decap_8
* cell instance sg13cmos5l_decap_8_318 r0 *1 0,0
Xsg13cmos5l_decap_8_318 \$2 \$1 sg13cmos5l_decap_8
* cell instance sg13cmos5l_decap_8_319 r0 *1 0,0
Xsg13cmos5l_decap_8_319 \$2 \$1 sg13cmos5l_decap_8
* cell instance sg13cmos5l_decap_8_320 r0 *1 0,0
Xsg13cmos5l_decap_8_320 \$2 \$1 sg13cmos5l_decap_8
* cell instance sg13cmos5l_decap_8_321 r0 *1 0,0
Xsg13cmos5l_decap_8_321 \$2 \$1 sg13cmos5l_decap_8
* cell instance sg13cmos5l_decap_8_322 r0 *1 0,0
Xsg13cmos5l_decap_8_322 \$2 \$1 sg13cmos5l_decap_8
* cell instance sg13cmos5l_decap_8_323 r0 *1 0,0
Xsg13cmos5l_decap_8_323 \$2 \$1 sg13cmos5l_decap_8
* cell instance sg13cmos5l_decap_8_324 r0 *1 0,0
Xsg13cmos5l_decap_8_324 \$2 \$1 sg13cmos5l_decap_8
* cell instance sg13cmos5l_decap_8_325 r0 *1 0,0
Xsg13cmos5l_decap_8_325 \$2 \$1 sg13cmos5l_decap_8
* cell instance sg13cmos5l_decap_8_326 r0 *1 0,0
Xsg13cmos5l_decap_8_326 \$2 \$1 sg13cmos5l_decap_8
* cell instance sg13cmos5l_decap_8_327 r0 *1 0,0
Xsg13cmos5l_decap_8_327 \$2 \$1 sg13cmos5l_decap_8
* cell instance sg13cmos5l_decap_8_328 r0 *1 0,0
Xsg13cmos5l_decap_8_328 \$2 \$1 sg13cmos5l_decap_8
* cell instance sg13cmos5l_decap_8_329 r0 *1 0,0
Xsg13cmos5l_decap_8_329 \$2 \$1 sg13cmos5l_decap_8
* cell instance sg13cmos5l_decap_8_330 r0 *1 0,0
Xsg13cmos5l_decap_8_330 \$2 \$1 sg13cmos5l_decap_8
* cell instance sg13cmos5l_decap_8_331 r0 *1 0,0
Xsg13cmos5l_decap_8_331 \$2 \$1 sg13cmos5l_decap_8
* cell instance sg13cmos5l_decap_8_332 r0 *1 0,0
Xsg13cmos5l_decap_8_332 \$2 \$1 sg13cmos5l_decap_8
* cell instance sg13cmos5l_decap_8_333 r0 *1 0,0
Xsg13cmos5l_decap_8_333 \$2 \$1 sg13cmos5l_decap_8
* cell instance sg13cmos5l_decap_8_334 r0 *1 0,0
Xsg13cmos5l_decap_8_334 \$2 \$1 sg13cmos5l_decap_8
* cell instance sg13cmos5l_decap_8_335 r0 *1 0,0
Xsg13cmos5l_decap_8_335 \$2 \$1 sg13cmos5l_decap_8
* cell instance sg13cmos5l_decap_8_336 r0 *1 0,0
Xsg13cmos5l_decap_8_336 \$2 \$1 sg13cmos5l_decap_8
* cell instance sg13cmos5l_decap_8_337 r0 *1 0,0
Xsg13cmos5l_decap_8_337 \$2 \$1 sg13cmos5l_decap_8
* cell instance sg13cmos5l_decap_8_338 r0 *1 0,0
Xsg13cmos5l_decap_8_338 \$2 \$1 sg13cmos5l_decap_8
* cell instance sg13cmos5l_decap_8_339 r0 *1 0,0
Xsg13cmos5l_decap_8_339 \$2 \$1 sg13cmos5l_decap_8
* cell instance sg13cmos5l_decap_8_340 r0 *1 0,0
Xsg13cmos5l_decap_8_340 \$2 \$1 sg13cmos5l_decap_8
* cell instance sg13cmos5l_decap_8_341 r0 *1 0,0
Xsg13cmos5l_decap_8_341 \$2 \$1 sg13cmos5l_decap_8
* cell instance sg13cmos5l_decap_8_342 r0 *1 0,0
Xsg13cmos5l_decap_8_342 \$2 \$1 sg13cmos5l_decap_8
* cell instance sg13cmos5l_decap_8_343 r0 *1 0,0
Xsg13cmos5l_decap_8_343 \$2 \$1 sg13cmos5l_decap_8
* cell instance sg13cmos5l_decap_8_344 r0 *1 0,0
Xsg13cmos5l_decap_8_344 \$2 \$1 sg13cmos5l_decap_8
* cell instance sg13cmos5l_decap_8_345 r0 *1 0,0
Xsg13cmos5l_decap_8_345 \$2 \$1 sg13cmos5l_decap_8
* cell instance sg13cmos5l_decap_8_346 r0 *1 0,0
Xsg13cmos5l_decap_8_346 \$2 \$1 sg13cmos5l_decap_8
* cell instance sg13cmos5l_decap_8_347 r0 *1 0,0
Xsg13cmos5l_decap_8_347 \$2 \$1 sg13cmos5l_decap_8
* cell instance sg13cmos5l_decap_8_348 r0 *1 0,0
Xsg13cmos5l_decap_8_348 \$2 \$1 sg13cmos5l_decap_8
* cell instance sg13cmos5l_decap_8_349 r0 *1 0,0
Xsg13cmos5l_decap_8_349 \$2 \$1 sg13cmos5l_decap_8
* cell instance sg13cmos5l_decap_8_350 r0 *1 0,0
Xsg13cmos5l_decap_8_350 \$2 \$1 sg13cmos5l_decap_8
* cell instance sg13cmos5l_decap_8_351 r0 *1 0,0
Xsg13cmos5l_decap_8_351 \$2 \$1 sg13cmos5l_decap_8
* cell instance sg13cmos5l_decap_8_352 r0 *1 0,0
Xsg13cmos5l_decap_8_352 \$2 \$1 sg13cmos5l_decap_8
* cell instance sg13cmos5l_decap_8_353 r0 *1 0,0
Xsg13cmos5l_decap_8_353 \$2 \$1 sg13cmos5l_decap_8
* cell instance sg13cmos5l_decap_8_354 r0 *1 0,0
Xsg13cmos5l_decap_8_354 \$2 \$1 sg13cmos5l_decap_8
* cell instance sg13cmos5l_decap_8_355 r0 *1 0,0
Xsg13cmos5l_decap_8_355 \$2 \$1 sg13cmos5l_decap_8
* cell instance sg13cmos5l_decap_8_356 r0 *1 0,0
Xsg13cmos5l_decap_8_356 \$2 \$1 sg13cmos5l_decap_8
* cell instance sg13cmos5l_decap_8_357 r0 *1 0,0
Xsg13cmos5l_decap_8_357 \$2 \$1 sg13cmos5l_decap_8
* cell instance sg13cmos5l_decap_8_358 r0 *1 0,0
Xsg13cmos5l_decap_8_358 \$2 \$1 sg13cmos5l_decap_8
* cell instance sg13cmos5l_decap_8_359 r0 *1 0,0
Xsg13cmos5l_decap_8_359 \$2 \$1 sg13cmos5l_decap_8
* cell instance sg13cmos5l_decap_8_360 r0 *1 0,0
Xsg13cmos5l_decap_8_360 \$2 \$1 sg13cmos5l_decap_8
* cell instance sg13cmos5l_decap_8_361 r0 *1 0,0
Xsg13cmos5l_decap_8_361 \$2 \$1 sg13cmos5l_decap_8
* cell instance sg13cmos5l_decap_8_362 r0 *1 0,0
Xsg13cmos5l_decap_8_362 \$2 \$1 sg13cmos5l_decap_8
* cell instance sg13cmos5l_decap_8_363 r0 *1 0,0
Xsg13cmos5l_decap_8_363 \$2 \$1 sg13cmos5l_decap_8
* cell instance sg13cmos5l_decap_8_364 r0 *1 0,0
Xsg13cmos5l_decap_8_364 \$2 \$1 sg13cmos5l_decap_8
* cell instance sg13cmos5l_decap_8_365 r0 *1 0,0
Xsg13cmos5l_decap_8_365 \$2 \$1 sg13cmos5l_decap_8
* cell instance sg13cmos5l_decap_8_366 r0 *1 0,0
Xsg13cmos5l_decap_8_366 \$2 \$1 sg13cmos5l_decap_8
* cell instance sg13cmos5l_decap_8_367 r0 *1 0,0
Xsg13cmos5l_decap_8_367 \$2 \$1 sg13cmos5l_decap_8
* cell instance sg13cmos5l_decap_8_368 r0 *1 0,0
Xsg13cmos5l_decap_8_368 \$2 \$1 sg13cmos5l_decap_8
* cell instance sg13cmos5l_decap_8_369 r0 *1 0,0
Xsg13cmos5l_decap_8_369 \$2 \$1 sg13cmos5l_decap_8
* cell instance sg13cmos5l_decap_8_370 r0 *1 0,0
Xsg13cmos5l_decap_8_370 \$2 \$1 sg13cmos5l_decap_8
* cell instance sg13cmos5l_decap_8_371 r0 *1 0,0
Xsg13cmos5l_decap_8_371 \$2 \$1 sg13cmos5l_decap_8
* cell instance sg13cmos5l_decap_8_372 r0 *1 0,0
Xsg13cmos5l_decap_8_372 \$2 \$1 sg13cmos5l_decap_8
* cell instance sg13cmos5l_decap_8_373 r0 *1 0,0
Xsg13cmos5l_decap_8_373 \$2 \$1 sg13cmos5l_decap_8
* cell instance sg13cmos5l_decap_8_374 r0 *1 0,0
Xsg13cmos5l_decap_8_374 \$2 \$1 sg13cmos5l_decap_8
* cell instance sg13cmos5l_decap_8_375 r0 *1 0,0
Xsg13cmos5l_decap_8_375 \$2 \$1 sg13cmos5l_decap_8
* cell instance sg13cmos5l_decap_8_376 r0 *1 0,0
Xsg13cmos5l_decap_8_376 \$2 \$1 sg13cmos5l_decap_8
* cell instance sg13cmos5l_decap_8_377 r0 *1 0,0
Xsg13cmos5l_decap_8_377 \$2 \$1 sg13cmos5l_decap_8
* cell instance sg13cmos5l_decap_8_378 r0 *1 0,0
Xsg13cmos5l_decap_8_378 \$2 \$1 sg13cmos5l_decap_8
* cell instance sg13cmos5l_decap_8_379 r0 *1 0,0
Xsg13cmos5l_decap_8_379 \$2 \$1 sg13cmos5l_decap_8
* cell instance sg13cmos5l_decap_8_380 r0 *1 0,0
Xsg13cmos5l_decap_8_380 \$2 \$1 sg13cmos5l_decap_8
* cell instance sg13cmos5l_decap_8_381 r0 *1 0,0
Xsg13cmos5l_decap_8_381 \$2 \$1 sg13cmos5l_decap_8
* cell instance sg13cmos5l_decap_8_382 r0 *1 0,0
Xsg13cmos5l_decap_8_382 \$2 \$1 sg13cmos5l_decap_8
* cell instance sg13cmos5l_decap_8_383 r0 *1 0,0
Xsg13cmos5l_decap_8_383 \$2 \$1 sg13cmos5l_decap_8
* cell instance sg13cmos5l_decap_8_384 r0 *1 0,0
Xsg13cmos5l_decap_8_384 \$2 \$1 sg13cmos5l_decap_8
* cell instance sg13cmos5l_decap_8_385 r0 *1 0,0
Xsg13cmos5l_decap_8_385 \$2 \$1 sg13cmos5l_decap_8
* cell instance sg13cmos5l_decap_8_386 r0 *1 0,0
Xsg13cmos5l_decap_8_386 \$2 \$1 sg13cmos5l_decap_8
* cell instance sg13cmos5l_decap_8_387 r0 *1 0,0
Xsg13cmos5l_decap_8_387 \$2 \$1 sg13cmos5l_decap_8
* cell instance sg13cmos5l_decap_8_388 r0 *1 0,0
Xsg13cmos5l_decap_8_388 \$2 \$1 sg13cmos5l_decap_8
* cell instance sg13cmos5l_decap_8_389 r0 *1 0,0
Xsg13cmos5l_decap_8_389 \$2 \$1 sg13cmos5l_decap_8
* cell instance sg13cmos5l_decap_8_390 r0 *1 0,0
Xsg13cmos5l_decap_8_390 \$2 \$1 sg13cmos5l_decap_8
* cell instance sg13cmos5l_decap_8_391 r0 *1 0,0
Xsg13cmos5l_decap_8_391 \$2 \$1 sg13cmos5l_decap_8
* cell instance sg13cmos5l_decap_8_392 r0 *1 0,0
Xsg13cmos5l_decap_8_392 \$2 \$1 sg13cmos5l_decap_8
* cell instance sg13cmos5l_decap_8_393 r0 *1 0,0
Xsg13cmos5l_decap_8_393 \$2 \$1 sg13cmos5l_decap_8
* cell instance sg13cmos5l_decap_8_394 r0 *1 0,0
Xsg13cmos5l_decap_8_394 \$2 \$1 sg13cmos5l_decap_8
* cell instance sg13cmos5l_decap_8_395 r0 *1 0,0
Xsg13cmos5l_decap_8_395 \$2 \$1 sg13cmos5l_decap_8
* cell instance sg13cmos5l_decap_8_396 r0 *1 0,0
Xsg13cmos5l_decap_8_396 \$2 \$1 sg13cmos5l_decap_8
* cell instance sg13cmos5l_decap_8_397 r0 *1 0,0
Xsg13cmos5l_decap_8_397 \$2 \$1 sg13cmos5l_decap_8
* cell instance sg13cmos5l_decap_8_398 r0 *1 0,0
Xsg13cmos5l_decap_8_398 \$2 \$1 sg13cmos5l_decap_8
* cell instance sg13cmos5l_decap_8_399 r0 *1 0,0
Xsg13cmos5l_decap_8_399 \$2 \$1 sg13cmos5l_decap_8
* cell instance sg13cmos5l_decap_8_400 r0 *1 0,0
Xsg13cmos5l_decap_8_400 \$2 \$1 sg13cmos5l_decap_8
* cell instance sg13cmos5l_decap_8_401 r0 *1 0,0
Xsg13cmos5l_decap_8_401 \$2 \$1 sg13cmos5l_decap_8
* cell instance sg13cmos5l_decap_8_402 r0 *1 0,0
Xsg13cmos5l_decap_8_402 \$2 \$1 sg13cmos5l_decap_8
* cell instance sg13cmos5l_decap_8_403 r0 *1 0,0
Xsg13cmos5l_decap_8_403 \$2 \$1 sg13cmos5l_decap_8
* cell instance sg13cmos5l_decap_8_404 r0 *1 0,0
Xsg13cmos5l_decap_8_404 \$2 \$1 sg13cmos5l_decap_8
* cell instance sg13cmos5l_decap_8_405 r0 *1 0,0
Xsg13cmos5l_decap_8_405 \$2 \$1 sg13cmos5l_decap_8
* cell instance sg13cmos5l_decap_8_406 r0 *1 0,0
Xsg13cmos5l_decap_8_406 \$2 \$1 sg13cmos5l_decap_8
* cell instance sg13cmos5l_decap_8_407 r0 *1 0,0
Xsg13cmos5l_decap_8_407 \$2 \$1 sg13cmos5l_decap_8
* cell instance sg13cmos5l_decap_8_408 r0 *1 0,0
Xsg13cmos5l_decap_8_408 \$2 \$1 sg13cmos5l_decap_8
* cell instance sg13cmos5l_decap_8_409 r0 *1 0,0
Xsg13cmos5l_decap_8_409 \$2 \$1 sg13cmos5l_decap_8
* cell instance sg13cmos5l_decap_8_410 r0 *1 0,0
Xsg13cmos5l_decap_8_410 \$2 \$1 sg13cmos5l_decap_8
* cell instance sg13cmos5l_decap_8_411 r0 *1 0,0
Xsg13cmos5l_decap_8_411 \$2 \$1 sg13cmos5l_decap_8
* cell instance sg13cmos5l_decap_8_412 r0 *1 0,0
Xsg13cmos5l_decap_8_412 \$2 \$1 sg13cmos5l_decap_8
* cell instance sg13cmos5l_decap_8_413 r0 *1 0,0
Xsg13cmos5l_decap_8_413 \$2 \$1 sg13cmos5l_decap_8
* cell instance sg13cmos5l_decap_8_414 r0 *1 0,0
Xsg13cmos5l_decap_8_414 \$2 \$1 sg13cmos5l_decap_8
* cell instance sg13cmos5l_decap_8_415 r0 *1 0,0
Xsg13cmos5l_decap_8_415 \$2 \$1 sg13cmos5l_decap_8
* cell instance sg13cmos5l_decap_8_416 r0 *1 0,0
Xsg13cmos5l_decap_8_416 \$2 \$1 sg13cmos5l_decap_8
* cell instance sg13cmos5l_decap_8_417 r0 *1 0,0
Xsg13cmos5l_decap_8_417 \$2 \$1 sg13cmos5l_decap_8
* cell instance sg13cmos5l_decap_8_418 r0 *1 0,0
Xsg13cmos5l_decap_8_418 \$2 \$1 sg13cmos5l_decap_8
* cell instance sg13cmos5l_decap_8_419 r0 *1 0,0
Xsg13cmos5l_decap_8_419 \$2 \$1 sg13cmos5l_decap_8
* cell instance sg13cmos5l_decap_8_420 r0 *1 0,0
Xsg13cmos5l_decap_8_420 \$2 \$1 sg13cmos5l_decap_8
* cell instance sg13cmos5l_decap_8_421 r0 *1 0,0
Xsg13cmos5l_decap_8_421 \$2 \$1 sg13cmos5l_decap_8
* cell instance sg13cmos5l_decap_8_422 r0 *1 0,0
Xsg13cmos5l_decap_8_422 \$2 \$1 sg13cmos5l_decap_8
* cell instance sg13cmos5l_decap_8_423 r0 *1 0,0
Xsg13cmos5l_decap_8_423 \$2 \$1 sg13cmos5l_decap_8
* cell instance sg13cmos5l_decap_8_424 r0 *1 0,0
Xsg13cmos5l_decap_8_424 \$2 \$1 sg13cmos5l_decap_8
* cell instance sg13cmos5l_decap_8_425 r0 *1 0,0
Xsg13cmos5l_decap_8_425 \$2 \$1 sg13cmos5l_decap_8
* cell instance sg13cmos5l_decap_8_426 r0 *1 0,0
Xsg13cmos5l_decap_8_426 \$2 \$1 sg13cmos5l_decap_8
* cell instance sg13cmos5l_decap_8_427 r0 *1 0,0
Xsg13cmos5l_decap_8_427 \$2 \$1 sg13cmos5l_decap_8
* cell instance sg13cmos5l_decap_8_428 r0 *1 0,0
Xsg13cmos5l_decap_8_428 \$2 \$1 sg13cmos5l_decap_8
* cell instance sg13cmos5l_decap_8_429 r0 *1 0,0
Xsg13cmos5l_decap_8_429 \$2 \$1 sg13cmos5l_decap_8
* cell instance sg13cmos5l_decap_8_430 r0 *1 0,0
Xsg13cmos5l_decap_8_430 \$2 \$1 sg13cmos5l_decap_8
* cell instance sg13cmos5l_decap_8_431 r0 *1 0,0
Xsg13cmos5l_decap_8_431 \$2 \$1 sg13cmos5l_decap_8
* cell instance sg13cmos5l_decap_8_432 r0 *1 0,0
Xsg13cmos5l_decap_8_432 \$2 \$1 sg13cmos5l_decap_8
* cell instance sg13cmos5l_decap_8_433 r0 *1 0,0
Xsg13cmos5l_decap_8_433 \$2 \$1 sg13cmos5l_decap_8
* cell instance sg13cmos5l_decap_8_434 r0 *1 0,0
Xsg13cmos5l_decap_8_434 \$2 \$1 sg13cmos5l_decap_8
* cell instance sg13cmos5l_decap_8_435 r0 *1 0,0
Xsg13cmos5l_decap_8_435 \$2 \$1 sg13cmos5l_decap_8
* cell instance sg13cmos5l_decap_8_436 r0 *1 0,0
Xsg13cmos5l_decap_8_436 \$2 \$1 sg13cmos5l_decap_8
* cell instance sg13cmos5l_decap_8_437 r0 *1 0,0
Xsg13cmos5l_decap_8_437 \$2 \$1 sg13cmos5l_decap_8
* cell instance sg13cmos5l_decap_8_438 r0 *1 0,0
Xsg13cmos5l_decap_8_438 \$2 \$1 sg13cmos5l_decap_8
* cell instance sg13cmos5l_decap_8_439 r0 *1 0,0
Xsg13cmos5l_decap_8_439 \$2 \$1 sg13cmos5l_decap_8
* cell instance sg13cmos5l_decap_8_440 r0 *1 0,0
Xsg13cmos5l_decap_8_440 \$2 \$1 sg13cmos5l_decap_8
* cell instance sg13cmos5l_decap_8_441 r0 *1 0,0
Xsg13cmos5l_decap_8_441 \$2 \$1 sg13cmos5l_decap_8
* cell instance sg13cmos5l_decap_8_442 r0 *1 0,0
Xsg13cmos5l_decap_8_442 \$2 \$1 sg13cmos5l_decap_8
* cell instance sg13cmos5l_decap_8_443 r0 *1 0,0
Xsg13cmos5l_decap_8_443 \$2 \$1 sg13cmos5l_decap_8
* cell instance sg13cmos5l_decap_8_444 r0 *1 0,0
Xsg13cmos5l_decap_8_444 \$2 \$1 sg13cmos5l_decap_8
* cell instance sg13cmos5l_decap_8_445 r0 *1 0,0
Xsg13cmos5l_decap_8_445 \$2 \$1 sg13cmos5l_decap_8
* cell instance sg13cmos5l_decap_8_446 r0 *1 0,0
Xsg13cmos5l_decap_8_446 \$2 \$1 sg13cmos5l_decap_8
* cell instance sg13cmos5l_decap_8_447 r0 *1 0,0
Xsg13cmos5l_decap_8_447 \$2 \$1 sg13cmos5l_decap_8
* cell instance sg13cmos5l_decap_8_448 r0 *1 0,0
Xsg13cmos5l_decap_8_448 \$2 \$1 sg13cmos5l_decap_8
* cell instance sg13cmos5l_decap_8_449 r0 *1 0,0
Xsg13cmos5l_decap_8_449 \$2 \$1 sg13cmos5l_decap_8
* cell instance sg13cmos5l_decap_8_450 r0 *1 0,0
Xsg13cmos5l_decap_8_450 \$2 \$1 sg13cmos5l_decap_8
* cell instance sg13cmos5l_decap_8_451 r0 *1 0,0
Xsg13cmos5l_decap_8_451 \$2 \$1 sg13cmos5l_decap_8
* cell instance sg13cmos5l_decap_8_452 r0 *1 0,0
Xsg13cmos5l_decap_8_452 \$2 \$1 sg13cmos5l_decap_8
* cell instance sg13cmos5l_decap_8_453 r0 *1 0,0
Xsg13cmos5l_decap_8_453 \$2 \$1 sg13cmos5l_decap_8
* cell instance sg13cmos5l_decap_8_454 r0 *1 0,0
Xsg13cmos5l_decap_8_454 \$2 \$1 sg13cmos5l_decap_8
* cell instance sg13cmos5l_decap_8_455 r0 *1 0,0
Xsg13cmos5l_decap_8_455 \$2 \$1 sg13cmos5l_decap_8
* cell instance sg13cmos5l_decap_8_456 r0 *1 0,0
Xsg13cmos5l_decap_8_456 \$2 \$1 sg13cmos5l_decap_8
* cell instance sg13cmos5l_decap_8_457 r0 *1 0,0
Xsg13cmos5l_decap_8_457 \$2 \$1 sg13cmos5l_decap_8
* cell instance sg13cmos5l_decap_8_458 r0 *1 0,0
Xsg13cmos5l_decap_8_458 \$2 \$1 sg13cmos5l_decap_8
* cell instance sg13cmos5l_decap_8_459 r0 *1 0,0
Xsg13cmos5l_decap_8_459 \$2 \$1 sg13cmos5l_decap_8
* cell instance sg13cmos5l_decap_8_460 r0 *1 0,0
Xsg13cmos5l_decap_8_460 \$2 \$1 sg13cmos5l_decap_8
* cell instance sg13cmos5l_decap_8_461 r0 *1 0,0
Xsg13cmos5l_decap_8_461 \$2 \$1 sg13cmos5l_decap_8
* cell instance sg13cmos5l_decap_8_462 r0 *1 0,0
Xsg13cmos5l_decap_8_462 \$2 \$1 sg13cmos5l_decap_8
* cell instance sg13cmos5l_decap_8_463 r0 *1 0,0
Xsg13cmos5l_decap_8_463 \$2 \$1 sg13cmos5l_decap_8
* cell instance sg13cmos5l_decap_8_464 r0 *1 0,0
Xsg13cmos5l_decap_8_464 \$2 \$1 sg13cmos5l_decap_8
* cell instance sg13cmos5l_decap_8_465 r0 *1 0,0
Xsg13cmos5l_decap_8_465 \$2 \$1 sg13cmos5l_decap_8
* cell instance sg13cmos5l_decap_8_466 r0 *1 0,0
Xsg13cmos5l_decap_8_466 \$2 \$1 sg13cmos5l_decap_8
* cell instance sg13cmos5l_decap_8_467 r0 *1 0,0
Xsg13cmos5l_decap_8_467 \$2 \$1 sg13cmos5l_decap_8
* cell instance sg13cmos5l_decap_8_468 r0 *1 0,0
Xsg13cmos5l_decap_8_468 \$2 \$1 sg13cmos5l_decap_8
* cell instance sg13cmos5l_decap_8_469 r0 *1 0,0
Xsg13cmos5l_decap_8_469 \$2 \$1 sg13cmos5l_decap_8
* cell instance sg13cmos5l_decap_8_470 r0 *1 0,0
Xsg13cmos5l_decap_8_470 \$2 \$1 sg13cmos5l_decap_8
* cell instance sg13cmos5l_decap_8_471 r0 *1 0,0
Xsg13cmos5l_decap_8_471 \$2 \$1 sg13cmos5l_decap_8
* cell instance sg13cmos5l_decap_8_472 r0 *1 0,0
Xsg13cmos5l_decap_8_472 \$2 \$1 sg13cmos5l_decap_8
* cell instance sg13cmos5l_decap_8_473 r0 *1 0,0
Xsg13cmos5l_decap_8_473 \$2 \$1 sg13cmos5l_decap_8
* cell instance sg13cmos5l_decap_8_474 r0 *1 0,0
Xsg13cmos5l_decap_8_474 \$2 \$1 sg13cmos5l_decap_8
* cell instance sg13cmos5l_decap_8_475 r0 *1 0,0
Xsg13cmos5l_decap_8_475 \$2 \$1 sg13cmos5l_decap_8
* cell instance sg13cmos5l_decap_8_476 r0 *1 0,0
Xsg13cmos5l_decap_8_476 \$2 \$1 sg13cmos5l_decap_8
* cell instance sg13cmos5l_decap_8_477 r0 *1 0,0
Xsg13cmos5l_decap_8_477 \$2 \$1 sg13cmos5l_decap_8
* cell instance sg13cmos5l_decap_8_478 r0 *1 0,0
Xsg13cmos5l_decap_8_478 \$2 \$1 sg13cmos5l_decap_8
* cell instance sg13cmos5l_decap_8_479 r0 *1 0,0
Xsg13cmos5l_decap_8_479 \$2 \$1 sg13cmos5l_decap_8
* cell instance sg13cmos5l_decap_8_480 r0 *1 0,0
Xsg13cmos5l_decap_8_480 \$2 \$1 sg13cmos5l_decap_8
* cell instance sg13cmos5l_decap_8_481 r0 *1 0,0
Xsg13cmos5l_decap_8_481 \$2 \$1 sg13cmos5l_decap_8
* cell instance sg13cmos5l_decap_8_482 r0 *1 0,0
Xsg13cmos5l_decap_8_482 \$2 \$1 sg13cmos5l_decap_8
* cell instance sg13cmos5l_decap_8_483 r0 *1 0,0
Xsg13cmos5l_decap_8_483 \$2 \$1 sg13cmos5l_decap_8
* cell instance sg13cmos5l_decap_8_484 r0 *1 0,0
Xsg13cmos5l_decap_8_484 \$2 \$1 sg13cmos5l_decap_8
* cell instance sg13cmos5l_decap_8_485 r0 *1 0,0
Xsg13cmos5l_decap_8_485 \$2 \$1 sg13cmos5l_decap_8
* cell instance sg13cmos5l_decap_8_486 r0 *1 0,0
Xsg13cmos5l_decap_8_486 \$2 \$1 sg13cmos5l_decap_8
* cell instance sg13cmos5l_decap_8_487 r0 *1 0,0
Xsg13cmos5l_decap_8_487 \$2 \$1 sg13cmos5l_decap_8
* cell instance sg13cmos5l_decap_8_488 r0 *1 0,0
Xsg13cmos5l_decap_8_488 \$2 \$1 sg13cmos5l_decap_8
* cell instance sg13cmos5l_decap_8_489 r0 *1 0,0
Xsg13cmos5l_decap_8_489 \$2 \$1 sg13cmos5l_decap_8
* cell instance sg13cmos5l_decap_8_490 r0 *1 0,0
Xsg13cmos5l_decap_8_490 \$2 \$1 sg13cmos5l_decap_8
* cell instance sg13cmos5l_decap_8_491 r0 *1 0,0
Xsg13cmos5l_decap_8_491 \$2 \$1 sg13cmos5l_decap_8
* cell instance sg13cmos5l_decap_8_492 r0 *1 0,0
Xsg13cmos5l_decap_8_492 \$2 \$1 sg13cmos5l_decap_8
* cell instance sg13cmos5l_decap_8_493 r0 *1 0,0
Xsg13cmos5l_decap_8_493 \$2 \$1 sg13cmos5l_decap_8
* cell instance sg13cmos5l_decap_8_494 r0 *1 0,0
Xsg13cmos5l_decap_8_494 \$2 \$1 sg13cmos5l_decap_8
* cell instance sg13cmos5l_decap_8_495 r0 *1 0,0
Xsg13cmos5l_decap_8_495 \$2 \$1 sg13cmos5l_decap_8
* cell instance sg13cmos5l_decap_8_496 r0 *1 0,0
Xsg13cmos5l_decap_8_496 \$2 \$1 sg13cmos5l_decap_8
* cell instance sg13cmos5l_decap_8_497 r0 *1 0,0
Xsg13cmos5l_decap_8_497 \$2 \$1 sg13cmos5l_decap_8
* cell instance sg13cmos5l_decap_8_498 r0 *1 0,0
Xsg13cmos5l_decap_8_498 \$2 \$1 sg13cmos5l_decap_8
* cell instance sg13cmos5l_decap_8_499 r0 *1 0,0
Xsg13cmos5l_decap_8_499 \$2 \$1 sg13cmos5l_decap_8
* cell instance sg13cmos5l_decap_8_500 r0 *1 0,0
Xsg13cmos5l_decap_8_500 \$2 \$1 sg13cmos5l_decap_8
* cell instance sg13cmos5l_decap_8_501 r0 *1 0,0
Xsg13cmos5l_decap_8_501 \$2 \$1 sg13cmos5l_decap_8
* cell instance sg13cmos5l_decap_8_502 r0 *1 0,0
Xsg13cmos5l_decap_8_502 \$2 \$1 sg13cmos5l_decap_8
* cell instance sg13cmos5l_decap_8_503 r0 *1 0,0
Xsg13cmos5l_decap_8_503 \$2 \$1 sg13cmos5l_decap_8
* cell instance sg13cmos5l_decap_8_504 r0 *1 0,0
Xsg13cmos5l_decap_8_504 \$2 \$1 sg13cmos5l_decap_8
* cell instance sg13cmos5l_decap_8_505 r0 *1 0,0
Xsg13cmos5l_decap_8_505 \$2 \$1 sg13cmos5l_decap_8
* cell instance sg13cmos5l_decap_8_506 r0 *1 0,0
Xsg13cmos5l_decap_8_506 \$2 \$1 sg13cmos5l_decap_8
* cell instance sg13cmos5l_decap_8_507 r0 *1 0,0
Xsg13cmos5l_decap_8_507 \$2 \$1 sg13cmos5l_decap_8
* cell instance sg13cmos5l_decap_8_508 r0 *1 0,0
Xsg13cmos5l_decap_8_508 \$2 \$1 sg13cmos5l_decap_8
* cell instance sg13cmos5l_decap_8_509 r0 *1 0,0
Xsg13cmos5l_decap_8_509 \$2 \$1 sg13cmos5l_decap_8
* cell instance sg13cmos5l_decap_8_510 r0 *1 0,0
Xsg13cmos5l_decap_8_510 \$2 \$1 sg13cmos5l_decap_8
* cell instance sg13cmos5l_decap_8_511 r0 *1 0,0
Xsg13cmos5l_decap_8_511 \$2 \$1 sg13cmos5l_decap_8
* cell instance sg13cmos5l_decap_8_512 r0 *1 0,0
Xsg13cmos5l_decap_8_512 \$2 \$1 sg13cmos5l_decap_8
* cell instance sg13cmos5l_decap_8_513 r0 *1 0,0
Xsg13cmos5l_decap_8_513 \$2 \$1 sg13cmos5l_decap_8
* cell instance sg13cmos5l_decap_8_514 r0 *1 0,0
Xsg13cmos5l_decap_8_514 \$2 \$1 sg13cmos5l_decap_8
* cell instance sg13cmos5l_decap_8_515 r0 *1 0,0
Xsg13cmos5l_decap_8_515 \$2 \$1 sg13cmos5l_decap_8
* cell instance sg13cmos5l_decap_8_516 r0 *1 0,0
Xsg13cmos5l_decap_8_516 \$2 \$1 sg13cmos5l_decap_8
* cell instance sg13cmos5l_decap_8_517 r0 *1 0,0
Xsg13cmos5l_decap_8_517 \$2 \$1 sg13cmos5l_decap_8
* cell instance sg13cmos5l_decap_8_518 r0 *1 0,0
Xsg13cmos5l_decap_8_518 \$2 \$1 sg13cmos5l_decap_8
* cell instance sg13cmos5l_decap_8_519 r0 *1 0,0
Xsg13cmos5l_decap_8_519 \$2 \$1 sg13cmos5l_decap_8
* cell instance sg13cmos5l_decap_8_520 r0 *1 0,0
Xsg13cmos5l_decap_8_520 \$2 \$1 sg13cmos5l_decap_8
* cell instance sg13cmos5l_decap_8_521 r0 *1 0,0
Xsg13cmos5l_decap_8_521 \$2 \$1 sg13cmos5l_decap_8
* cell instance sg13cmos5l_decap_8_522 r0 *1 0,0
Xsg13cmos5l_decap_8_522 \$2 \$1 sg13cmos5l_decap_8
* cell instance sg13cmos5l_decap_8_523 r0 *1 0,0
Xsg13cmos5l_decap_8_523 \$2 \$1 sg13cmos5l_decap_8
* cell instance sg13cmos5l_decap_8_524 r0 *1 0,0
Xsg13cmos5l_decap_8_524 \$2 \$1 sg13cmos5l_decap_8
* cell instance sg13cmos5l_decap_8_525 r0 *1 0,0
Xsg13cmos5l_decap_8_525 \$2 \$1 sg13cmos5l_decap_8
* cell instance sg13cmos5l_decap_8_526 r0 *1 0,0
Xsg13cmos5l_decap_8_526 \$2 \$1 sg13cmos5l_decap_8
* cell instance sg13cmos5l_decap_8_527 r0 *1 0,0
Xsg13cmos5l_decap_8_527 \$2 \$1 sg13cmos5l_decap_8
* cell instance sg13cmos5l_decap_8_528 r0 *1 0,0
Xsg13cmos5l_decap_8_528 \$2 \$1 sg13cmos5l_decap_8
* cell instance sg13cmos5l_decap_8_529 r0 *1 0,0
Xsg13cmos5l_decap_8_529 \$2 \$1 sg13cmos5l_decap_8
* cell instance sg13cmos5l_decap_8_530 r0 *1 0,0
Xsg13cmos5l_decap_8_530 \$2 \$1 sg13cmos5l_decap_8
* cell instance sg13cmos5l_decap_8_531 r0 *1 0,0
Xsg13cmos5l_decap_8_531 \$2 \$1 sg13cmos5l_decap_8
* cell instance sg13cmos5l_decap_8_532 r0 *1 0,0
Xsg13cmos5l_decap_8_532 \$2 \$1 sg13cmos5l_decap_8
* cell instance sg13cmos5l_decap_8_533 r0 *1 0,0
Xsg13cmos5l_decap_8_533 \$2 \$1 sg13cmos5l_decap_8
* cell instance sg13cmos5l_decap_8_534 r0 *1 0,0
Xsg13cmos5l_decap_8_534 \$2 \$1 sg13cmos5l_decap_8
* cell instance sg13cmos5l_decap_8_535 r0 *1 0,0
Xsg13cmos5l_decap_8_535 \$2 \$1 sg13cmos5l_decap_8
* cell instance sg13cmos5l_decap_8_536 r0 *1 0,0
Xsg13cmos5l_decap_8_536 \$2 \$1 sg13cmos5l_decap_8
* cell instance sg13cmos5l_decap_8_537 r0 *1 0,0
Xsg13cmos5l_decap_8_537 \$2 \$1 sg13cmos5l_decap_8
* cell instance sg13cmos5l_decap_8_538 r0 *1 0,0
Xsg13cmos5l_decap_8_538 \$2 \$1 sg13cmos5l_decap_8
* cell instance sg13cmos5l_decap_8_539 r0 *1 0,0
Xsg13cmos5l_decap_8_539 \$2 \$1 sg13cmos5l_decap_8
* cell instance sg13cmos5l_decap_8_540 r0 *1 0,0
Xsg13cmos5l_decap_8_540 \$2 \$1 sg13cmos5l_decap_8
* cell instance sg13cmos5l_decap_8_541 r0 *1 0,0
Xsg13cmos5l_decap_8_541 \$2 \$1 sg13cmos5l_decap_8
* cell instance sg13cmos5l_decap_8_542 r0 *1 0,0
Xsg13cmos5l_decap_8_542 \$2 \$1 sg13cmos5l_decap_8
* cell instance sg13cmos5l_decap_8_543 r0 *1 0,0
Xsg13cmos5l_decap_8_543 \$2 \$1 sg13cmos5l_decap_8
* cell instance sg13cmos5l_decap_8_544 r0 *1 0,0
Xsg13cmos5l_decap_8_544 \$2 \$1 sg13cmos5l_decap_8
* cell instance sg13cmos5l_decap_8_545 r0 *1 0,0
Xsg13cmos5l_decap_8_545 \$2 \$1 sg13cmos5l_decap_8
* cell instance sg13cmos5l_decap_8_546 r0 *1 0,0
Xsg13cmos5l_decap_8_546 \$2 \$1 sg13cmos5l_decap_8
* cell instance sg13cmos5l_decap_8_547 r0 *1 0,0
Xsg13cmos5l_decap_8_547 \$2 \$1 sg13cmos5l_decap_8
* cell instance sg13cmos5l_decap_8_548 r0 *1 0,0
Xsg13cmos5l_decap_8_548 \$2 \$1 sg13cmos5l_decap_8
* cell instance sg13cmos5l_decap_8_549 r0 *1 0,0
Xsg13cmos5l_decap_8_549 \$2 \$1 sg13cmos5l_decap_8
* cell instance sg13cmos5l_decap_8_550 r0 *1 0,0
Xsg13cmos5l_decap_8_550 \$2 \$1 sg13cmos5l_decap_8
* cell instance sg13cmos5l_decap_8_551 r0 *1 0,0
Xsg13cmos5l_decap_8_551 \$2 \$1 sg13cmos5l_decap_8
* cell instance sg13cmos5l_decap_8_552 r0 *1 0,0
Xsg13cmos5l_decap_8_552 \$2 \$1 sg13cmos5l_decap_8
* cell instance sg13cmos5l_decap_8_553 r0 *1 0,0
Xsg13cmos5l_decap_8_553 \$2 \$1 sg13cmos5l_decap_8
* cell instance sg13cmos5l_decap_8_554 r0 *1 0,0
Xsg13cmos5l_decap_8_554 \$2 \$1 sg13cmos5l_decap_8
* cell instance sg13cmos5l_decap_8_555 r0 *1 0,0
Xsg13cmos5l_decap_8_555 \$2 \$1 sg13cmos5l_decap_8
* cell instance sg13cmos5l_decap_8_556 r0 *1 0,0
Xsg13cmos5l_decap_8_556 \$2 \$1 sg13cmos5l_decap_8
* cell instance sg13cmos5l_decap_8_557 r0 *1 0,0
Xsg13cmos5l_decap_8_557 \$2 \$1 sg13cmos5l_decap_8
* cell instance sg13cmos5l_decap_8_558 r0 *1 0,0
Xsg13cmos5l_decap_8_558 \$2 \$1 sg13cmos5l_decap_8
* cell instance sg13cmos5l_decap_8_559 r0 *1 0,0
Xsg13cmos5l_decap_8_559 \$2 \$1 sg13cmos5l_decap_8
* cell instance sg13cmos5l_decap_8_560 r0 *1 0,0
Xsg13cmos5l_decap_8_560 \$2 \$1 sg13cmos5l_decap_8
* cell instance sg13cmos5l_decap_8_561 r0 *1 0,0
Xsg13cmos5l_decap_8_561 \$2 \$1 sg13cmos5l_decap_8
* cell instance sg13cmos5l_decap_8_562 r0 *1 0,0
Xsg13cmos5l_decap_8_562 \$2 \$1 sg13cmos5l_decap_8
* cell instance sg13cmos5l_decap_8_563 r0 *1 0,0
Xsg13cmos5l_decap_8_563 \$2 \$1 sg13cmos5l_decap_8
* cell instance sg13cmos5l_decap_8_564 r0 *1 0,0
Xsg13cmos5l_decap_8_564 \$2 \$1 sg13cmos5l_decap_8
* cell instance sg13cmos5l_decap_8_565 r0 *1 0,0
Xsg13cmos5l_decap_8_565 \$2 \$1 sg13cmos5l_decap_8
* cell instance sg13cmos5l_decap_8_566 r0 *1 0,0
Xsg13cmos5l_decap_8_566 \$2 \$1 sg13cmos5l_decap_8
* cell instance sg13cmos5l_decap_8_567 r0 *1 0,0
Xsg13cmos5l_decap_8_567 \$2 \$1 sg13cmos5l_decap_8
* cell instance sg13cmos5l_decap_8_568 r0 *1 0,0
Xsg13cmos5l_decap_8_568 \$2 \$1 sg13cmos5l_decap_8
* cell instance sg13cmos5l_decap_8_569 r0 *1 0,0
Xsg13cmos5l_decap_8_569 \$2 \$1 sg13cmos5l_decap_8
* cell instance sg13cmos5l_decap_8_570 r0 *1 0,0
Xsg13cmos5l_decap_8_570 \$2 \$1 sg13cmos5l_decap_8
* cell instance sg13cmos5l_decap_8_571 r0 *1 0,0
Xsg13cmos5l_decap_8_571 \$2 \$1 sg13cmos5l_decap_8
* cell instance sg13cmos5l_decap_8_572 r0 *1 0,0
Xsg13cmos5l_decap_8_572 \$2 \$1 sg13cmos5l_decap_8
* cell instance sg13cmos5l_decap_8_573 r0 *1 0,0
Xsg13cmos5l_decap_8_573 \$2 \$1 sg13cmos5l_decap_8
* cell instance sg13cmos5l_decap_8_574 r0 *1 0,0
Xsg13cmos5l_decap_8_574 \$2 \$1 sg13cmos5l_decap_8
* cell instance sg13cmos5l_decap_8_575 r0 *1 0,0
Xsg13cmos5l_decap_8_575 \$2 \$1 sg13cmos5l_decap_8
* cell instance sg13cmos5l_decap_8_576 r0 *1 0,0
Xsg13cmos5l_decap_8_576 \$2 \$1 sg13cmos5l_decap_8
* cell instance sg13cmos5l_decap_8_577 r0 *1 0,0
Xsg13cmos5l_decap_8_577 \$2 \$1 sg13cmos5l_decap_8
* cell instance sg13cmos5l_decap_8_578 r0 *1 0,0
Xsg13cmos5l_decap_8_578 \$2 \$1 sg13cmos5l_decap_8
* cell instance sg13cmos5l_decap_8_579 r0 *1 0,0
Xsg13cmos5l_decap_8_579 \$2 \$1 sg13cmos5l_decap_8
* cell instance sg13cmos5l_decap_8_580 r0 *1 0,0
Xsg13cmos5l_decap_8_580 \$2 \$1 sg13cmos5l_decap_8
* cell instance sg13cmos5l_decap_8_581 r0 *1 0,0
Xsg13cmos5l_decap_8_581 \$2 \$1 sg13cmos5l_decap_8
* cell instance sg13cmos5l_decap_8_582 r0 *1 0,0
Xsg13cmos5l_decap_8_582 \$2 \$1 sg13cmos5l_decap_8
* cell instance sg13cmos5l_decap_8_583 r0 *1 0,0
Xsg13cmos5l_decap_8_583 \$2 \$1 sg13cmos5l_decap_8
* cell instance sg13cmos5l_decap_8_584 r0 *1 0,0
Xsg13cmos5l_decap_8_584 \$2 \$1 sg13cmos5l_decap_8
* cell instance sg13cmos5l_decap_8_585 r0 *1 0,0
Xsg13cmos5l_decap_8_585 \$2 \$1 sg13cmos5l_decap_8
* cell instance sg13cmos5l_decap_8_586 r0 *1 0,0
Xsg13cmos5l_decap_8_586 \$2 \$1 sg13cmos5l_decap_8
* cell instance sg13cmos5l_decap_8_587 r0 *1 0,0
Xsg13cmos5l_decap_8_587 \$2 \$1 sg13cmos5l_decap_8
* cell instance sg13cmos5l_decap_8_588 r0 *1 0,0
Xsg13cmos5l_decap_8_588 \$2 \$1 sg13cmos5l_decap_8
* cell instance sg13cmos5l_decap_8_589 r0 *1 0,0
Xsg13cmos5l_decap_8_589 \$2 \$1 sg13cmos5l_decap_8
* cell instance sg13cmos5l_decap_8_590 r0 *1 0,0
Xsg13cmos5l_decap_8_590 \$2 \$1 sg13cmos5l_decap_8
* cell instance sg13cmos5l_decap_8_591 r0 *1 0,0
Xsg13cmos5l_decap_8_591 \$2 \$1 sg13cmos5l_decap_8
* cell instance sg13cmos5l_decap_8_592 r0 *1 0,0
Xsg13cmos5l_decap_8_592 \$2 \$1 sg13cmos5l_decap_8
* cell instance sg13cmos5l_decap_8_593 r0 *1 0,0
Xsg13cmos5l_decap_8_593 \$2 \$1 sg13cmos5l_decap_8
* cell instance sg13cmos5l_decap_8_594 r0 *1 0,0
Xsg13cmos5l_decap_8_594 \$2 \$1 sg13cmos5l_decap_8
* cell instance sg13cmos5l_decap_8_595 r0 *1 0,0
Xsg13cmos5l_decap_8_595 \$2 \$1 sg13cmos5l_decap_8
* cell instance sg13cmos5l_decap_8_596 r0 *1 0,0
Xsg13cmos5l_decap_8_596 \$2 \$1 sg13cmos5l_decap_8
* cell instance sg13cmos5l_decap_8_597 r0 *1 0,0
Xsg13cmos5l_decap_8_597 \$2 \$1 sg13cmos5l_decap_8
* cell instance sg13cmos5l_decap_8_598 r0 *1 0,0
Xsg13cmos5l_decap_8_598 \$2 \$1 sg13cmos5l_decap_8
* cell instance sg13cmos5l_decap_8_599 r0 *1 0,0
Xsg13cmos5l_decap_8_599 \$2 \$1 sg13cmos5l_decap_8
* cell instance sg13cmos5l_decap_8_600 r0 *1 0,0
Xsg13cmos5l_decap_8_600 \$2 \$1 sg13cmos5l_decap_8
* cell instance sg13cmos5l_decap_8_601 r0 *1 0,0
Xsg13cmos5l_decap_8_601 \$2 \$1 sg13cmos5l_decap_8
* cell instance sg13cmos5l_decap_8_602 r0 *1 0,0
Xsg13cmos5l_decap_8_602 \$2 \$1 sg13cmos5l_decap_8
* cell instance sg13cmos5l_decap_8_603 r0 *1 0,0
Xsg13cmos5l_decap_8_603 \$2 \$1 sg13cmos5l_decap_8
* cell instance sg13cmos5l_decap_8_604 r0 *1 0,0
Xsg13cmos5l_decap_8_604 \$2 \$1 sg13cmos5l_decap_8
* cell instance sg13cmos5l_decap_8_605 r0 *1 0,0
Xsg13cmos5l_decap_8_605 \$2 \$1 sg13cmos5l_decap_8
* cell instance sg13cmos5l_decap_8_606 r0 *1 0,0
Xsg13cmos5l_decap_8_606 \$2 \$1 sg13cmos5l_decap_8
* cell instance sg13cmos5l_decap_8_607 r0 *1 0,0
Xsg13cmos5l_decap_8_607 \$2 \$1 sg13cmos5l_decap_8
* cell instance sg13cmos5l_decap_8_608 r0 *1 0,0
Xsg13cmos5l_decap_8_608 \$2 \$1 sg13cmos5l_decap_8
* cell instance sg13cmos5l_decap_8_609 r0 *1 0,0
Xsg13cmos5l_decap_8_609 \$2 \$1 sg13cmos5l_decap_8
* cell instance sg13cmos5l_decap_8_610 r0 *1 0,0
Xsg13cmos5l_decap_8_610 \$2 \$1 sg13cmos5l_decap_8
* cell instance sg13cmos5l_decap_8_611 r0 *1 0,0
Xsg13cmos5l_decap_8_611 \$2 \$1 sg13cmos5l_decap_8
* cell instance sg13cmos5l_decap_8_612 r0 *1 0,0
Xsg13cmos5l_decap_8_612 \$2 \$1 sg13cmos5l_decap_8
* cell instance sg13cmos5l_decap_8_613 r0 *1 0,0
Xsg13cmos5l_decap_8_613 \$2 \$1 sg13cmos5l_decap_8
* cell instance sg13cmos5l_decap_8_614 r0 *1 0,0
Xsg13cmos5l_decap_8_614 \$2 \$1 sg13cmos5l_decap_8
* cell instance sg13cmos5l_decap_8_615 r0 *1 0,0
Xsg13cmos5l_decap_8_615 \$2 \$1 sg13cmos5l_decap_8
* cell instance sg13cmos5l_decap_8_616 r0 *1 0,0
Xsg13cmos5l_decap_8_616 \$2 \$1 sg13cmos5l_decap_8
* cell instance sg13cmos5l_decap_8_617 r0 *1 0,0
Xsg13cmos5l_decap_8_617 \$2 \$1 sg13cmos5l_decap_8
* cell instance sg13cmos5l_decap_8_618 r0 *1 0,0
Xsg13cmos5l_decap_8_618 \$2 \$1 sg13cmos5l_decap_8
* cell instance sg13cmos5l_decap_8_619 r0 *1 0,0
Xsg13cmos5l_decap_8_619 \$2 \$1 sg13cmos5l_decap_8
* cell instance sg13cmos5l_decap_8_620 r0 *1 0,0
Xsg13cmos5l_decap_8_620 \$2 \$1 sg13cmos5l_decap_8
* cell instance sg13cmos5l_decap_8_621 r0 *1 0,0
Xsg13cmos5l_decap_8_621 \$2 \$1 sg13cmos5l_decap_8
* cell instance sg13cmos5l_decap_8_622 r0 *1 0,0
Xsg13cmos5l_decap_8_622 \$2 \$1 sg13cmos5l_decap_8
* cell instance sg13cmos5l_decap_8_623 r0 *1 0,0
Xsg13cmos5l_decap_8_623 \$2 \$1 sg13cmos5l_decap_8
* cell instance sg13cmos5l_decap_8_624 r0 *1 0,0
Xsg13cmos5l_decap_8_624 \$2 \$1 sg13cmos5l_decap_8
* cell instance sg13cmos5l_decap_8_625 r0 *1 0,0
Xsg13cmos5l_decap_8_625 \$2 \$1 sg13cmos5l_decap_8
* cell instance sg13cmos5l_decap_8_626 r0 *1 0,0
Xsg13cmos5l_decap_8_626 \$2 \$1 sg13cmos5l_decap_8
* cell instance sg13cmos5l_decap_8_627 r0 *1 0,0
Xsg13cmos5l_decap_8_627 \$2 \$1 sg13cmos5l_decap_8
* cell instance sg13cmos5l_decap_8_628 r0 *1 0,0
Xsg13cmos5l_decap_8_628 \$2 \$1 sg13cmos5l_decap_8
* cell instance sg13cmos5l_decap_8_629 r0 *1 0,0
Xsg13cmos5l_decap_8_629 \$2 \$1 sg13cmos5l_decap_8
* cell instance sg13cmos5l_decap_8_630 r0 *1 0,0
Xsg13cmos5l_decap_8_630 \$2 \$1 sg13cmos5l_decap_8
* cell instance sg13cmos5l_decap_8_631 r0 *1 0,0
Xsg13cmos5l_decap_8_631 \$2 \$1 sg13cmos5l_decap_8
* cell instance sg13cmos5l_decap_8_632 r0 *1 0,0
Xsg13cmos5l_decap_8_632 \$2 \$1 sg13cmos5l_decap_8
* cell instance sg13cmos5l_decap_8_633 r0 *1 0,0
Xsg13cmos5l_decap_8_633 \$2 \$1 sg13cmos5l_decap_8
* cell instance sg13cmos5l_decap_8_634 r0 *1 0,0
Xsg13cmos5l_decap_8_634 \$2 \$1 sg13cmos5l_decap_8
* cell instance sg13cmos5l_decap_8_635 r0 *1 0,0
Xsg13cmos5l_decap_8_635 \$2 \$1 sg13cmos5l_decap_8
* cell instance sg13cmos5l_decap_8_636 r0 *1 0,0
Xsg13cmos5l_decap_8_636 \$2 \$1 sg13cmos5l_decap_8
* cell instance sg13cmos5l_decap_8_637 r0 *1 0,0
Xsg13cmos5l_decap_8_637 \$2 \$1 sg13cmos5l_decap_8
* cell instance sg13cmos5l_decap_8_638 r0 *1 0,0
Xsg13cmos5l_decap_8_638 \$2 \$1 sg13cmos5l_decap_8
* cell instance sg13cmos5l_decap_8_639 r0 *1 0,0
Xsg13cmos5l_decap_8_639 \$2 \$1 sg13cmos5l_decap_8
* cell instance sg13cmos5l_decap_8_640 r0 *1 0,0
Xsg13cmos5l_decap_8_640 \$2 \$1 sg13cmos5l_decap_8
* cell instance sg13cmos5l_decap_8_641 r0 *1 0,0
Xsg13cmos5l_decap_8_641 \$2 \$1 sg13cmos5l_decap_8
* cell instance sg13cmos5l_decap_8_642 r0 *1 0,0
Xsg13cmos5l_decap_8_642 \$2 \$1 sg13cmos5l_decap_8
* cell instance sg13cmos5l_decap_8_643 r0 *1 0,0
Xsg13cmos5l_decap_8_643 \$2 \$1 sg13cmos5l_decap_8
* cell instance sg13cmos5l_decap_8_644 r0 *1 0,0
Xsg13cmos5l_decap_8_644 \$2 \$1 sg13cmos5l_decap_8
* cell instance sg13cmos5l_decap_8_645 r0 *1 0,0
Xsg13cmos5l_decap_8_645 \$2 \$1 sg13cmos5l_decap_8
* cell instance sg13cmos5l_decap_8_646 r0 *1 0,0
Xsg13cmos5l_decap_8_646 \$2 \$1 sg13cmos5l_decap_8
* cell instance sg13cmos5l_decap_8_647 r0 *1 0,0
Xsg13cmos5l_decap_8_647 \$2 \$1 sg13cmos5l_decap_8
* cell instance sg13cmos5l_decap_8_648 r0 *1 0,0
Xsg13cmos5l_decap_8_648 \$2 \$1 sg13cmos5l_decap_8
* cell instance sg13cmos5l_decap_8_649 r0 *1 0,0
Xsg13cmos5l_decap_8_649 \$2 \$1 sg13cmos5l_decap_8
* cell instance sg13cmos5l_decap_8_650 r0 *1 0,0
Xsg13cmos5l_decap_8_650 \$2 \$1 sg13cmos5l_decap_8
* cell instance sg13cmos5l_decap_8_651 r0 *1 0,0
Xsg13cmos5l_decap_8_651 \$2 \$1 sg13cmos5l_decap_8
* cell instance sg13cmos5l_decap_8_652 r0 *1 0,0
Xsg13cmos5l_decap_8_652 \$2 \$1 sg13cmos5l_decap_8
* cell instance sg13cmos5l_decap_8_653 r0 *1 0,0
Xsg13cmos5l_decap_8_653 \$2 \$1 sg13cmos5l_decap_8
* cell instance sg13cmos5l_decap_8_654 r0 *1 0,0
Xsg13cmos5l_decap_8_654 \$2 \$1 sg13cmos5l_decap_8
* cell instance sg13cmos5l_decap_8_655 r0 *1 0,0
Xsg13cmos5l_decap_8_655 \$2 \$1 sg13cmos5l_decap_8
* cell instance sg13cmos5l_decap_8_656 r0 *1 0,0
Xsg13cmos5l_decap_8_656 \$2 \$1 sg13cmos5l_decap_8
* cell instance sg13cmos5l_decap_8_657 r0 *1 0,0
Xsg13cmos5l_decap_8_657 \$2 \$1 sg13cmos5l_decap_8
* cell instance sg13cmos5l_decap_8_658 r0 *1 0,0
Xsg13cmos5l_decap_8_658 \$2 \$1 sg13cmos5l_decap_8
* cell instance sg13cmos5l_decap_8_659 r0 *1 0,0
Xsg13cmos5l_decap_8_659 \$2 \$1 sg13cmos5l_decap_8
* cell instance sg13cmos5l_decap_8_660 r0 *1 0,0
Xsg13cmos5l_decap_8_660 \$2 \$1 sg13cmos5l_decap_8
* cell instance sg13cmos5l_decap_8_661 r0 *1 0,0
Xsg13cmos5l_decap_8_661 \$2 \$1 sg13cmos5l_decap_8
* cell instance sg13cmos5l_decap_8_662 r0 *1 0,0
Xsg13cmos5l_decap_8_662 \$2 \$1 sg13cmos5l_decap_8
* cell instance sg13cmos5l_decap_8_663 r0 *1 0,0
Xsg13cmos5l_decap_8_663 \$2 \$1 sg13cmos5l_decap_8
* cell instance sg13cmos5l_decap_8_664 r0 *1 0,0
Xsg13cmos5l_decap_8_664 \$2 \$1 sg13cmos5l_decap_8
* cell instance sg13cmos5l_decap_8_665 r0 *1 0,0
Xsg13cmos5l_decap_8_665 \$2 \$1 sg13cmos5l_decap_8
* cell instance sg13cmos5l_decap_8_666 r0 *1 0,0
Xsg13cmos5l_decap_8_666 \$2 \$1 sg13cmos5l_decap_8
* cell instance sg13cmos5l_decap_8_667 r0 *1 0,0
Xsg13cmos5l_decap_8_667 \$2 \$1 sg13cmos5l_decap_8
* cell instance sg13cmos5l_decap_8_668 r0 *1 0,0
Xsg13cmos5l_decap_8_668 \$2 \$1 sg13cmos5l_decap_8
* cell instance sg13cmos5l_decap_8_669 r0 *1 0,0
Xsg13cmos5l_decap_8_669 \$2 \$1 sg13cmos5l_decap_8
* cell instance sg13cmos5l_decap_8_670 r0 *1 0,0
Xsg13cmos5l_decap_8_670 \$2 \$1 sg13cmos5l_decap_8
* cell instance sg13cmos5l_decap_8_671 r0 *1 0,0
Xsg13cmos5l_decap_8_671 \$2 \$1 sg13cmos5l_decap_8
* cell instance sg13cmos5l_decap_8_672 r0 *1 0,0
Xsg13cmos5l_decap_8_672 \$2 \$1 sg13cmos5l_decap_8
* cell instance sg13cmos5l_decap_8_673 r0 *1 0,0
Xsg13cmos5l_decap_8_673 \$2 \$1 sg13cmos5l_decap_8
* cell instance sg13cmos5l_decap_8_674 r0 *1 0,0
Xsg13cmos5l_decap_8_674 \$2 \$1 sg13cmos5l_decap_8
* cell instance sg13cmos5l_decap_8_675 r0 *1 0,0
Xsg13cmos5l_decap_8_675 \$2 \$1 sg13cmos5l_decap_8
* cell instance sg13cmos5l_decap_8_676 r0 *1 0,0
Xsg13cmos5l_decap_8_676 \$2 \$1 sg13cmos5l_decap_8
* cell instance sg13cmos5l_decap_8_677 r0 *1 0,0
Xsg13cmos5l_decap_8_677 \$2 \$1 sg13cmos5l_decap_8
* cell instance sg13cmos5l_decap_8_678 r0 *1 0,0
Xsg13cmos5l_decap_8_678 \$2 \$1 sg13cmos5l_decap_8
* cell instance sg13cmos5l_decap_8_679 r0 *1 0,0
Xsg13cmos5l_decap_8_679 \$2 \$1 sg13cmos5l_decap_8
* cell instance sg13cmos5l_decap_8_680 r0 *1 0,0
Xsg13cmos5l_decap_8_680 \$2 \$1 sg13cmos5l_decap_8
* cell instance sg13cmos5l_decap_8_681 r0 *1 0,0
Xsg13cmos5l_decap_8_681 \$2 \$1 sg13cmos5l_decap_8
* cell instance sg13cmos5l_decap_8_682 r0 *1 0,0
Xsg13cmos5l_decap_8_682 \$2 \$1 sg13cmos5l_decap_8
* cell instance sg13cmos5l_decap_8_683 r0 *1 0,0
Xsg13cmos5l_decap_8_683 \$2 \$1 sg13cmos5l_decap_8
* cell instance sg13cmos5l_decap_8_684 r0 *1 0,0
Xsg13cmos5l_decap_8_684 \$2 \$1 sg13cmos5l_decap_8
* cell instance sg13cmos5l_decap_8_685 r0 *1 0,0
Xsg13cmos5l_decap_8_685 \$2 \$1 sg13cmos5l_decap_8
* cell instance sg13cmos5l_decap_8_686 r0 *1 0,0
Xsg13cmos5l_decap_8_686 \$2 \$1 sg13cmos5l_decap_8
* cell instance sg13cmos5l_decap_8_687 r0 *1 0,0
Xsg13cmos5l_decap_8_687 \$2 \$1 sg13cmos5l_decap_8
* cell instance sg13cmos5l_decap_8_688 r0 *1 0,0
Xsg13cmos5l_decap_8_688 \$2 \$1 sg13cmos5l_decap_8
* cell instance sg13cmos5l_decap_8_689 r0 *1 0,0
Xsg13cmos5l_decap_8_689 \$2 \$1 sg13cmos5l_decap_8
* cell instance sg13cmos5l_decap_8_690 r0 *1 0,0
Xsg13cmos5l_decap_8_690 \$2 \$1 sg13cmos5l_decap_8
* cell instance sg13cmos5l_decap_8_691 r0 *1 0,0
Xsg13cmos5l_decap_8_691 \$2 \$1 sg13cmos5l_decap_8
* cell instance sg13cmos5l_decap_8_692 r0 *1 0,0
Xsg13cmos5l_decap_8_692 \$2 \$1 sg13cmos5l_decap_8
* cell instance sg13cmos5l_decap_8_693 r0 *1 0,0
Xsg13cmos5l_decap_8_693 \$2 \$1 sg13cmos5l_decap_8
* cell instance sg13cmos5l_decap_8_694 r0 *1 0,0
Xsg13cmos5l_decap_8_694 \$2 \$1 sg13cmos5l_decap_8
* cell instance sg13cmos5l_decap_8_695 r0 *1 0,0
Xsg13cmos5l_decap_8_695 \$2 \$1 sg13cmos5l_decap_8
* cell instance sg13cmos5l_decap_8_696 r0 *1 0,0
Xsg13cmos5l_decap_8_696 \$2 \$1 sg13cmos5l_decap_8
* cell instance sg13cmos5l_decap_8_697 r0 *1 0,0
Xsg13cmos5l_decap_8_697 \$2 \$1 sg13cmos5l_decap_8
* cell instance sg13cmos5l_decap_8_698 r0 *1 0,0
Xsg13cmos5l_decap_8_698 \$2 \$1 sg13cmos5l_decap_8
* cell instance sg13cmos5l_decap_8_699 r0 *1 0,0
Xsg13cmos5l_decap_8_699 \$2 \$1 sg13cmos5l_decap_8
* cell instance sg13cmos5l_decap_8_700 r0 *1 0,0
Xsg13cmos5l_decap_8_700 \$2 \$1 sg13cmos5l_decap_8
* cell instance sg13cmos5l_decap_8_701 r0 *1 0,0
Xsg13cmos5l_decap_8_701 \$2 \$1 sg13cmos5l_decap_8
* cell instance sg13cmos5l_decap_8_702 r0 *1 0,0
Xsg13cmos5l_decap_8_702 \$2 \$1 sg13cmos5l_decap_8
* cell instance sg13cmos5l_decap_8_703 r0 *1 0,0
Xsg13cmos5l_decap_8_703 \$2 \$1 sg13cmos5l_decap_8
* cell instance sg13cmos5l_decap_8_704 r0 *1 0,0
Xsg13cmos5l_decap_8_704 \$2 \$1 sg13cmos5l_decap_8
* cell instance sg13cmos5l_decap_8_705 r0 *1 0,0
Xsg13cmos5l_decap_8_705 \$2 \$1 sg13cmos5l_decap_8
* cell instance sg13cmos5l_decap_8_706 r0 *1 0,0
Xsg13cmos5l_decap_8_706 \$2 \$1 sg13cmos5l_decap_8
* cell instance sg13cmos5l_decap_8_707 r0 *1 0,0
Xsg13cmos5l_decap_8_707 \$2 \$1 sg13cmos5l_decap_8
* cell instance sg13cmos5l_decap_8_708 r0 *1 0,0
Xsg13cmos5l_decap_8_708 \$2 \$1 sg13cmos5l_decap_8
* cell instance sg13cmos5l_decap_8_709 r0 *1 0,0
Xsg13cmos5l_decap_8_709 \$2 \$1 sg13cmos5l_decap_8
* cell instance sg13cmos5l_decap_8_710 r0 *1 0,0
Xsg13cmos5l_decap_8_710 \$2 \$1 sg13cmos5l_decap_8
* cell instance sg13cmos5l_decap_8_711 r0 *1 0,0
Xsg13cmos5l_decap_8_711 \$2 \$1 sg13cmos5l_decap_8
* cell instance sg13cmos5l_decap_8_712 r0 *1 0,0
Xsg13cmos5l_decap_8_712 \$2 \$1 sg13cmos5l_decap_8
* cell instance sg13cmos5l_decap_8_713 r0 *1 0,0
Xsg13cmos5l_decap_8_713 \$2 \$1 sg13cmos5l_decap_8
* cell instance sg13cmos5l_decap_8_714 r0 *1 0,0
Xsg13cmos5l_decap_8_714 \$2 \$1 sg13cmos5l_decap_8
* cell instance sg13cmos5l_decap_8_715 r0 *1 0,0
Xsg13cmos5l_decap_8_715 \$2 \$1 sg13cmos5l_decap_8
* cell instance sg13cmos5l_decap_8_716 r0 *1 0,0
Xsg13cmos5l_decap_8_716 \$2 \$1 sg13cmos5l_decap_8
* cell instance sg13cmos5l_decap_8_717 r0 *1 0,0
Xsg13cmos5l_decap_8_717 \$2 \$1 sg13cmos5l_decap_8
* cell instance sg13cmos5l_decap_8_718 r0 *1 0,0
Xsg13cmos5l_decap_8_718 \$2 \$1 sg13cmos5l_decap_8
* cell instance sg13cmos5l_decap_8_719 r0 *1 0,0
Xsg13cmos5l_decap_8_719 \$2 \$1 sg13cmos5l_decap_8
* cell instance sg13cmos5l_decap_8_720 r0 *1 0,0
Xsg13cmos5l_decap_8_720 \$2 \$1 sg13cmos5l_decap_8
* cell instance sg13cmos5l_decap_8_721 r0 *1 0,0
Xsg13cmos5l_decap_8_721 \$2 \$1 sg13cmos5l_decap_8
* cell instance sg13cmos5l_decap_8_722 r0 *1 0,0
Xsg13cmos5l_decap_8_722 \$2 \$1 sg13cmos5l_decap_8
* cell instance sg13cmos5l_decap_8_723 r0 *1 0,0
Xsg13cmos5l_decap_8_723 \$2 \$1 sg13cmos5l_decap_8
* cell instance sg13cmos5l_decap_8_724 r0 *1 0,0
Xsg13cmos5l_decap_8_724 \$2 \$1 sg13cmos5l_decap_8
* cell instance sg13cmos5l_decap_8_725 r0 *1 0,0
Xsg13cmos5l_decap_8_725 \$2 \$1 sg13cmos5l_decap_8
* cell instance sg13cmos5l_decap_8_726 r0 *1 0,0
Xsg13cmos5l_decap_8_726 \$2 \$1 sg13cmos5l_decap_8
* cell instance sg13cmos5l_decap_8_727 r0 *1 0,0
Xsg13cmos5l_decap_8_727 \$2 \$1 sg13cmos5l_decap_8
* cell instance sg13cmos5l_decap_8_728 r0 *1 0,0
Xsg13cmos5l_decap_8_728 \$2 \$1 sg13cmos5l_decap_8
* cell instance sg13cmos5l_decap_8_729 r0 *1 0,0
Xsg13cmos5l_decap_8_729 \$2 \$1 sg13cmos5l_decap_8
* cell instance sg13cmos5l_decap_8_730 r0 *1 0,0
Xsg13cmos5l_decap_8_730 \$2 \$1 sg13cmos5l_decap_8
* cell instance sg13cmos5l_decap_8_731 r0 *1 0,0
Xsg13cmos5l_decap_8_731 \$2 \$1 sg13cmos5l_decap_8
* cell instance sg13cmos5l_decap_8_732 r0 *1 0,0
Xsg13cmos5l_decap_8_732 \$2 \$1 sg13cmos5l_decap_8
* cell instance sg13cmos5l_decap_8_733 r0 *1 0,0
Xsg13cmos5l_decap_8_733 \$2 \$1 sg13cmos5l_decap_8
* cell instance sg13cmos5l_decap_8_734 r0 *1 0,0
Xsg13cmos5l_decap_8_734 \$2 \$1 sg13cmos5l_decap_8
* cell instance sg13cmos5l_decap_8_735 r0 *1 0,0
Xsg13cmos5l_decap_8_735 \$2 \$1 sg13cmos5l_decap_8
* cell instance sg13cmos5l_decap_8_736 r0 *1 0,0
Xsg13cmos5l_decap_8_736 \$2 \$1 sg13cmos5l_decap_8
* cell instance sg13cmos5l_decap_8_737 r0 *1 0,0
Xsg13cmos5l_decap_8_737 \$2 \$1 sg13cmos5l_decap_8
* cell instance sg13cmos5l_decap_8_738 r0 *1 0,0
Xsg13cmos5l_decap_8_738 \$2 \$1 sg13cmos5l_decap_8
* cell instance sg13cmos5l_decap_8_739 r0 *1 0,0
Xsg13cmos5l_decap_8_739 \$2 \$1 sg13cmos5l_decap_8
* cell instance sg13cmos5l_decap_8_740 r0 *1 0,0
Xsg13cmos5l_decap_8_740 \$2 \$1 sg13cmos5l_decap_8
* cell instance sg13cmos5l_decap_8_741 r0 *1 0,0
Xsg13cmos5l_decap_8_741 \$2 \$1 sg13cmos5l_decap_8
* cell instance sg13cmos5l_decap_8_742 r0 *1 0,0
Xsg13cmos5l_decap_8_742 \$2 \$1 sg13cmos5l_decap_8
* cell instance sg13cmos5l_decap_8_743 r0 *1 0,0
Xsg13cmos5l_decap_8_743 \$2 \$1 sg13cmos5l_decap_8
* cell instance sg13cmos5l_decap_8_744 r0 *1 0,0
Xsg13cmos5l_decap_8_744 \$2 \$1 sg13cmos5l_decap_8
* cell instance sg13cmos5l_decap_8_745 r0 *1 0,0
Xsg13cmos5l_decap_8_745 \$2 \$1 sg13cmos5l_decap_8
* cell instance sg13cmos5l_decap_8_746 r0 *1 0,0
Xsg13cmos5l_decap_8_746 \$2 \$1 sg13cmos5l_decap_8
* cell instance sg13cmos5l_decap_8_747 r0 *1 0,0
Xsg13cmos5l_decap_8_747 \$2 \$1 sg13cmos5l_decap_8
* cell instance sg13cmos5l_decap_8_748 r0 *1 0,0
Xsg13cmos5l_decap_8_748 \$2 \$1 sg13cmos5l_decap_8
* cell instance sg13cmos5l_decap_8_749 r0 *1 0,0
Xsg13cmos5l_decap_8_749 \$2 \$1 sg13cmos5l_decap_8
* cell instance sg13cmos5l_decap_8_750 r0 *1 0,0
Xsg13cmos5l_decap_8_750 \$2 \$1 sg13cmos5l_decap_8
* cell instance sg13cmos5l_decap_8_751 r0 *1 0,0
Xsg13cmos5l_decap_8_751 \$2 \$1 sg13cmos5l_decap_8
* cell instance sg13cmos5l_decap_8_752 r0 *1 0,0
Xsg13cmos5l_decap_8_752 \$2 \$1 sg13cmos5l_decap_8
* cell instance sg13cmos5l_decap_8_753 r0 *1 0,0
Xsg13cmos5l_decap_8_753 \$2 \$1 sg13cmos5l_decap_8
* cell instance sg13cmos5l_decap_8_754 r0 *1 0,0
Xsg13cmos5l_decap_8_754 \$2 \$1 sg13cmos5l_decap_8
* cell instance sg13cmos5l_decap_8_755 r0 *1 0,0
Xsg13cmos5l_decap_8_755 \$2 \$1 sg13cmos5l_decap_8
* cell instance sg13cmos5l_decap_8_756 r0 *1 0,0
Xsg13cmos5l_decap_8_756 \$2 \$1 sg13cmos5l_decap_8
* cell instance sg13cmos5l_decap_8_757 r0 *1 0,0
Xsg13cmos5l_decap_8_757 \$2 \$1 sg13cmos5l_decap_8
* cell instance sg13cmos5l_decap_8_758 r0 *1 0,0
Xsg13cmos5l_decap_8_758 \$2 \$1 sg13cmos5l_decap_8
* cell instance sg13cmos5l_decap_8_759 r0 *1 0,0
Xsg13cmos5l_decap_8_759 \$2 \$1 sg13cmos5l_decap_8
* cell instance sg13cmos5l_decap_8_760 r0 *1 0,0
Xsg13cmos5l_decap_8_760 \$2 \$1 sg13cmos5l_decap_8
* cell instance sg13cmos5l_decap_8_761 r0 *1 0,0
Xsg13cmos5l_decap_8_761 \$2 \$1 sg13cmos5l_decap_8
* cell instance sg13cmos5l_decap_8_762 r0 *1 0,0
Xsg13cmos5l_decap_8_762 \$2 \$1 sg13cmos5l_decap_8
* cell instance sg13cmos5l_decap_8_763 r0 *1 0,0
Xsg13cmos5l_decap_8_763 \$2 \$1 sg13cmos5l_decap_8
* cell instance sg13cmos5l_decap_8_764 r0 *1 0,0
Xsg13cmos5l_decap_8_764 \$2 \$1 sg13cmos5l_decap_8
* cell instance sg13cmos5l_decap_8_765 r0 *1 0,0
Xsg13cmos5l_decap_8_765 \$2 \$1 sg13cmos5l_decap_8
* cell instance sg13cmos5l_decap_8_766 r0 *1 0,0
Xsg13cmos5l_decap_8_766 \$2 \$1 sg13cmos5l_decap_8
* cell instance sg13cmos5l_decap_8_767 r0 *1 0,0
Xsg13cmos5l_decap_8_767 \$2 \$1 sg13cmos5l_decap_8
* cell instance sg13cmos5l_decap_8_768 r0 *1 0,0
Xsg13cmos5l_decap_8_768 \$2 \$1 sg13cmos5l_decap_8
* cell instance sg13cmos5l_decap_8_769 r0 *1 0,0
Xsg13cmos5l_decap_8_769 \$2 \$1 sg13cmos5l_decap_8
* cell instance sg13cmos5l_decap_8_770 r0 *1 0,0
Xsg13cmos5l_decap_8_770 \$2 \$1 sg13cmos5l_decap_8
* cell instance sg13cmos5l_decap_8_771 r0 *1 0,0
Xsg13cmos5l_decap_8_771 \$2 \$1 sg13cmos5l_decap_8
* cell instance sg13cmos5l_decap_8_772 r0 *1 0,0
Xsg13cmos5l_decap_8_772 \$2 \$1 sg13cmos5l_decap_8
* cell instance sg13cmos5l_decap_8_773 r0 *1 0,0
Xsg13cmos5l_decap_8_773 \$2 \$1 sg13cmos5l_decap_8
* cell instance sg13cmos5l_decap_8_774 r0 *1 0,0
Xsg13cmos5l_decap_8_774 \$2 \$1 sg13cmos5l_decap_8
* cell instance sg13cmos5l_decap_8_775 r0 *1 0,0
Xsg13cmos5l_decap_8_775 \$2 \$1 sg13cmos5l_decap_8
* cell instance sg13cmos5l_decap_8_776 r0 *1 0,0
Xsg13cmos5l_decap_8_776 \$2 \$1 sg13cmos5l_decap_8
* cell instance sg13cmos5l_decap_8_777 r0 *1 0,0
Xsg13cmos5l_decap_8_777 \$2 \$1 sg13cmos5l_decap_8
* cell instance sg13cmos5l_decap_8_778 r0 *1 0,0
Xsg13cmos5l_decap_8_778 \$2 \$1 sg13cmos5l_decap_8
* cell instance sg13cmos5l_decap_8_779 r0 *1 0,0
Xsg13cmos5l_decap_8_779 \$2 \$1 sg13cmos5l_decap_8
* cell instance sg13cmos5l_decap_8_780 r0 *1 0,0
Xsg13cmos5l_decap_8_780 \$2 \$1 sg13cmos5l_decap_8
* cell instance sg13cmos5l_decap_8_781 r0 *1 0,0
Xsg13cmos5l_decap_8_781 \$2 \$1 sg13cmos5l_decap_8
* cell instance sg13cmos5l_decap_8_782 r0 *1 0,0
Xsg13cmos5l_decap_8_782 \$2 \$1 sg13cmos5l_decap_8
* cell instance sg13cmos5l_decap_8_783 r0 *1 0,0
Xsg13cmos5l_decap_8_783 \$2 \$1 sg13cmos5l_decap_8
* cell instance sg13cmos5l_decap_8_784 r0 *1 0,0
Xsg13cmos5l_decap_8_784 \$2 \$1 sg13cmos5l_decap_8
* cell instance sg13cmos5l_decap_8_785 r0 *1 0,0
Xsg13cmos5l_decap_8_785 \$2 \$1 sg13cmos5l_decap_8
* cell instance sg13cmos5l_decap_8_786 r0 *1 0,0
Xsg13cmos5l_decap_8_786 \$2 \$1 sg13cmos5l_decap_8
* cell instance sg13cmos5l_decap_8_787 r0 *1 0,0
Xsg13cmos5l_decap_8_787 \$2 \$1 sg13cmos5l_decap_8
* cell instance sg13cmos5l_decap_8_788 r0 *1 0,0
Xsg13cmos5l_decap_8_788 \$2 \$1 sg13cmos5l_decap_8
* cell instance sg13cmos5l_decap_8_789 r0 *1 0,0
Xsg13cmos5l_decap_8_789 \$2 \$1 sg13cmos5l_decap_8
* cell instance sg13cmos5l_decap_8_790 r0 *1 0,0
Xsg13cmos5l_decap_8_790 \$2 \$1 sg13cmos5l_decap_8
* cell instance sg13cmos5l_decap_8_791 r0 *1 0,0
Xsg13cmos5l_decap_8_791 \$2 \$1 sg13cmos5l_decap_8
* cell instance sg13cmos5l_decap_8_792 r0 *1 0,0
Xsg13cmos5l_decap_8_792 \$2 \$1 sg13cmos5l_decap_8
* cell instance sg13cmos5l_decap_8_793 r0 *1 0,0
Xsg13cmos5l_decap_8_793 \$2 \$1 sg13cmos5l_decap_8
* cell instance sg13cmos5l_decap_8_794 r0 *1 0,0
Xsg13cmos5l_decap_8_794 \$2 \$1 sg13cmos5l_decap_8
* cell instance sg13cmos5l_decap_8_795 r0 *1 0,0
Xsg13cmos5l_decap_8_795 \$2 \$1 sg13cmos5l_decap_8
* cell instance sg13cmos5l_decap_8_796 r0 *1 0,0
Xsg13cmos5l_decap_8_796 \$2 \$1 sg13cmos5l_decap_8
* cell instance sg13cmos5l_decap_8_797 r0 *1 0,0
Xsg13cmos5l_decap_8_797 \$2 \$1 sg13cmos5l_decap_8
* cell instance sg13cmos5l_decap_8_798 r0 *1 0,0
Xsg13cmos5l_decap_8_798 \$2 \$1 sg13cmos5l_decap_8
* cell instance sg13cmos5l_decap_8_799 r0 *1 0,0
Xsg13cmos5l_decap_8_799 \$2 \$1 sg13cmos5l_decap_8
* cell instance sg13cmos5l_decap_8_800 r0 *1 0,0
Xsg13cmos5l_decap_8_800 \$2 \$1 sg13cmos5l_decap_8
* cell instance sg13cmos5l_decap_8_801 r0 *1 0,0
Xsg13cmos5l_decap_8_801 \$2 \$1 sg13cmos5l_decap_8
* cell instance sg13cmos5l_decap_8_802 r0 *1 0,0
Xsg13cmos5l_decap_8_802 \$2 \$1 sg13cmos5l_decap_8
* cell instance sg13cmos5l_decap_8_803 r0 *1 0,0
Xsg13cmos5l_decap_8_803 \$2 \$1 sg13cmos5l_decap_8
* cell instance sg13cmos5l_decap_8_804 r0 *1 0,0
Xsg13cmos5l_decap_8_804 \$2 \$1 sg13cmos5l_decap_8
* cell instance sg13cmos5l_decap_8_805 r0 *1 0,0
Xsg13cmos5l_decap_8_805 \$2 \$1 sg13cmos5l_decap_8
* cell instance sg13cmos5l_decap_8_806 r0 *1 0,0
Xsg13cmos5l_decap_8_806 \$2 \$1 sg13cmos5l_decap_8
* cell instance sg13cmos5l_decap_8_807 r0 *1 0,0
Xsg13cmos5l_decap_8_807 \$2 \$1 sg13cmos5l_decap_8
* cell instance sg13cmos5l_decap_8_808 r0 *1 0,0
Xsg13cmos5l_decap_8_808 \$2 \$1 sg13cmos5l_decap_8
* cell instance sg13cmos5l_decap_8_809 r0 *1 0,0
Xsg13cmos5l_decap_8_809 \$2 \$1 sg13cmos5l_decap_8
* cell instance sg13cmos5l_decap_8_810 r0 *1 0,0
Xsg13cmos5l_decap_8_810 \$2 \$1 sg13cmos5l_decap_8
* cell instance sg13cmos5l_decap_8_811 r0 *1 0,0
Xsg13cmos5l_decap_8_811 \$2 \$1 sg13cmos5l_decap_8
* cell instance sg13cmos5l_decap_8_812 r0 *1 0,0
Xsg13cmos5l_decap_8_812 \$2 \$1 sg13cmos5l_decap_8
* cell instance sg13cmos5l_decap_8_813 r0 *1 0,0
Xsg13cmos5l_decap_8_813 \$2 \$1 sg13cmos5l_decap_8
* cell instance sg13cmos5l_decap_8_814 r0 *1 0,0
Xsg13cmos5l_decap_8_814 \$2 \$1 sg13cmos5l_decap_8
* cell instance sg13cmos5l_decap_8_815 r0 *1 0,0
Xsg13cmos5l_decap_8_815 \$2 \$1 sg13cmos5l_decap_8
* cell instance sg13cmos5l_decap_8_816 r0 *1 0,0
Xsg13cmos5l_decap_8_816 \$2 \$1 sg13cmos5l_decap_8
* cell instance sg13cmos5l_decap_8_817 r0 *1 0,0
Xsg13cmos5l_decap_8_817 \$2 \$1 sg13cmos5l_decap_8
* cell instance sg13cmos5l_decap_8_818 r0 *1 0,0
Xsg13cmos5l_decap_8_818 \$2 \$1 sg13cmos5l_decap_8
* cell instance sg13cmos5l_decap_8_819 r0 *1 0,0
Xsg13cmos5l_decap_8_819 \$2 \$1 sg13cmos5l_decap_8
* cell instance sg13cmos5l_decap_8_820 r0 *1 0,0
Xsg13cmos5l_decap_8_820 \$2 \$1 sg13cmos5l_decap_8
* cell instance sg13cmos5l_decap_8_821 r0 *1 0,0
Xsg13cmos5l_decap_8_821 \$2 \$1 sg13cmos5l_decap_8
* cell instance sg13cmos5l_decap_8_822 r0 *1 0,0
Xsg13cmos5l_decap_8_822 \$2 \$1 sg13cmos5l_decap_8
* cell instance sg13cmos5l_decap_8_823 r0 *1 0,0
Xsg13cmos5l_decap_8_823 \$2 \$1 sg13cmos5l_decap_8
* cell instance sg13cmos5l_decap_8_824 r0 *1 0,0
Xsg13cmos5l_decap_8_824 \$2 \$1 sg13cmos5l_decap_8
* cell instance sg13cmos5l_decap_8_825 r0 *1 0,0
Xsg13cmos5l_decap_8_825 \$2 \$1 sg13cmos5l_decap_8
* cell instance sg13cmos5l_decap_8_826 r0 *1 0,0
Xsg13cmos5l_decap_8_826 \$2 \$1 sg13cmos5l_decap_8
* cell instance sg13cmos5l_decap_8_827 r0 *1 0,0
Xsg13cmos5l_decap_8_827 \$2 \$1 sg13cmos5l_decap_8
* cell instance sg13cmos5l_decap_8_828 r0 *1 0,0
Xsg13cmos5l_decap_8_828 \$2 \$1 sg13cmos5l_decap_8
* cell instance sg13cmos5l_decap_8_829 r0 *1 0,0
Xsg13cmos5l_decap_8_829 \$2 \$1 sg13cmos5l_decap_8
* cell instance sg13cmos5l_decap_8_830 r0 *1 0,0
Xsg13cmos5l_decap_8_830 \$2 \$1 sg13cmos5l_decap_8
* cell instance sg13cmos5l_decap_8_831 r0 *1 0,0
Xsg13cmos5l_decap_8_831 \$2 \$1 sg13cmos5l_decap_8
* cell instance sg13cmos5l_decap_8_832 r0 *1 0,0
Xsg13cmos5l_decap_8_832 \$2 \$1 sg13cmos5l_decap_8
* cell instance sg13cmos5l_decap_8_833 r0 *1 0,0
Xsg13cmos5l_decap_8_833 \$2 \$1 sg13cmos5l_decap_8
* cell instance sg13cmos5l_decap_8_834 r0 *1 0,0
Xsg13cmos5l_decap_8_834 \$2 \$1 sg13cmos5l_decap_8
* cell instance sg13cmos5l_decap_8_835 r0 *1 0,0
Xsg13cmos5l_decap_8_835 \$2 \$1 sg13cmos5l_decap_8
* cell instance sg13cmos5l_decap_8_836 r0 *1 0,0
Xsg13cmos5l_decap_8_836 \$2 \$1 sg13cmos5l_decap_8
* cell instance sg13cmos5l_decap_8_837 r0 *1 0,0
Xsg13cmos5l_decap_8_837 \$2 \$1 sg13cmos5l_decap_8
* cell instance sg13cmos5l_decap_8_838 r0 *1 0,0
Xsg13cmos5l_decap_8_838 \$2 \$1 sg13cmos5l_decap_8
* cell instance sg13cmos5l_decap_8_839 r0 *1 0,0
Xsg13cmos5l_decap_8_839 \$2 \$1 sg13cmos5l_decap_8
* cell instance sg13cmos5l_decap_8_840 r0 *1 0,0
Xsg13cmos5l_decap_8_840 \$2 \$1 sg13cmos5l_decap_8
* cell instance sg13cmos5l_decap_8_841 r0 *1 0,0
Xsg13cmos5l_decap_8_841 \$2 \$1 sg13cmos5l_decap_8
* cell instance sg13cmos5l_decap_8_842 r0 *1 0,0
Xsg13cmos5l_decap_8_842 \$2 \$1 sg13cmos5l_decap_8
* cell instance sg13cmos5l_decap_8_843 r0 *1 0,0
Xsg13cmos5l_decap_8_843 \$2 \$1 sg13cmos5l_decap_8
* cell instance sg13cmos5l_decap_8_844 r0 *1 0,0
Xsg13cmos5l_decap_8_844 \$2 \$1 sg13cmos5l_decap_8
* cell instance sg13cmos5l_decap_8_845 r0 *1 0,0
Xsg13cmos5l_decap_8_845 \$2 \$1 sg13cmos5l_decap_8
* cell instance sg13cmos5l_decap_8_846 r0 *1 0,0
Xsg13cmos5l_decap_8_846 \$2 \$1 sg13cmos5l_decap_8
* cell instance sg13cmos5l_decap_8_847 r0 *1 0,0
Xsg13cmos5l_decap_8_847 \$2 \$1 sg13cmos5l_decap_8
* cell instance sg13cmos5l_decap_8_848 r0 *1 0,0
Xsg13cmos5l_decap_8_848 \$2 \$1 sg13cmos5l_decap_8
* cell instance sg13cmos5l_decap_8_849 r0 *1 0,0
Xsg13cmos5l_decap_8_849 \$2 \$1 sg13cmos5l_decap_8
* cell instance sg13cmos5l_decap_8_850 r0 *1 0,0
Xsg13cmos5l_decap_8_850 \$2 \$1 sg13cmos5l_decap_8
* cell instance sg13cmos5l_decap_8_851 r0 *1 0,0
Xsg13cmos5l_decap_8_851 \$2 \$1 sg13cmos5l_decap_8
* cell instance sg13cmos5l_decap_8_852 r0 *1 0,0
Xsg13cmos5l_decap_8_852 \$2 \$1 sg13cmos5l_decap_8
* cell instance sg13cmos5l_decap_8_853 r0 *1 0,0
Xsg13cmos5l_decap_8_853 \$2 \$1 sg13cmos5l_decap_8
* cell instance sg13cmos5l_decap_8_854 r0 *1 0,0
Xsg13cmos5l_decap_8_854 \$2 \$1 sg13cmos5l_decap_8
* cell instance sg13cmos5l_decap_8_855 r0 *1 0,0
Xsg13cmos5l_decap_8_855 \$2 \$1 sg13cmos5l_decap_8
* cell instance sg13cmos5l_decap_8_856 r0 *1 0,0
Xsg13cmos5l_decap_8_856 \$2 \$1 sg13cmos5l_decap_8
* cell instance sg13cmos5l_decap_8_857 r0 *1 0,0
Xsg13cmos5l_decap_8_857 \$2 \$1 sg13cmos5l_decap_8
* cell instance sg13cmos5l_decap_8_858 r0 *1 0,0
Xsg13cmos5l_decap_8_858 \$2 \$1 sg13cmos5l_decap_8
* cell instance sg13cmos5l_decap_8_859 r0 *1 0,0
Xsg13cmos5l_decap_8_859 \$2 \$1 sg13cmos5l_decap_8
* cell instance sg13cmos5l_decap_8_860 r0 *1 0,0
Xsg13cmos5l_decap_8_860 \$2 \$1 sg13cmos5l_decap_8
* cell instance sg13cmos5l_decap_8_861 r0 *1 0,0
Xsg13cmos5l_decap_8_861 \$2 \$1 sg13cmos5l_decap_8
* cell instance sg13cmos5l_decap_8_862 r0 *1 0,0
Xsg13cmos5l_decap_8_862 \$2 \$1 sg13cmos5l_decap_8
* cell instance sg13cmos5l_decap_8_863 r0 *1 0,0
Xsg13cmos5l_decap_8_863 \$2 \$1 sg13cmos5l_decap_8
* cell instance sg13cmos5l_decap_8_864 r0 *1 0,0
Xsg13cmos5l_decap_8_864 \$2 \$1 sg13cmos5l_decap_8
* cell instance sg13cmos5l_decap_8_865 r0 *1 0,0
Xsg13cmos5l_decap_8_865 \$2 \$1 sg13cmos5l_decap_8
* cell instance sg13cmos5l_decap_8_866 r0 *1 0,0
Xsg13cmos5l_decap_8_866 \$2 \$1 sg13cmos5l_decap_8
* cell instance sg13cmos5l_decap_8_867 r0 *1 0,0
Xsg13cmos5l_decap_8_867 \$2 \$1 sg13cmos5l_decap_8
* cell instance sg13cmos5l_decap_8_868 r0 *1 0,0
Xsg13cmos5l_decap_8_868 \$2 \$1 sg13cmos5l_decap_8
* cell instance sg13cmos5l_decap_8_869 r0 *1 0,0
Xsg13cmos5l_decap_8_869 \$2 \$1 sg13cmos5l_decap_8
* cell instance sg13cmos5l_decap_8_870 r0 *1 0,0
Xsg13cmos5l_decap_8_870 \$2 \$1 sg13cmos5l_decap_8
* cell instance sg13cmos5l_decap_8_871 r0 *1 0,0
Xsg13cmos5l_decap_8_871 \$2 \$1 sg13cmos5l_decap_8
* cell instance sg13cmos5l_decap_8_872 r0 *1 0,0
Xsg13cmos5l_decap_8_872 \$2 \$1 sg13cmos5l_decap_8
* cell instance sg13cmos5l_decap_8_873 r0 *1 0,0
Xsg13cmos5l_decap_8_873 \$2 \$1 sg13cmos5l_decap_8
* cell instance sg13cmos5l_decap_8_874 r0 *1 0,0
Xsg13cmos5l_decap_8_874 \$2 \$1 sg13cmos5l_decap_8
* cell instance sg13cmos5l_decap_8_875 r0 *1 0,0
Xsg13cmos5l_decap_8_875 \$2 \$1 sg13cmos5l_decap_8
* cell instance sg13cmos5l_decap_8_876 r0 *1 0,0
Xsg13cmos5l_decap_8_876 \$2 \$1 sg13cmos5l_decap_8
* cell instance sg13cmos5l_decap_8_877 r0 *1 0,0
Xsg13cmos5l_decap_8_877 \$2 \$1 sg13cmos5l_decap_8
* cell instance sg13cmos5l_decap_8_878 r0 *1 0,0
Xsg13cmos5l_decap_8_878 \$2 \$1 sg13cmos5l_decap_8
* cell instance sg13cmos5l_decap_8_879 r0 *1 0,0
Xsg13cmos5l_decap_8_879 \$2 \$1 sg13cmos5l_decap_8
* cell instance sg13cmos5l_decap_8_880 r0 *1 0,0
Xsg13cmos5l_decap_8_880 \$2 \$1 sg13cmos5l_decap_8
* cell instance sg13cmos5l_decap_8_881 r0 *1 0,0
Xsg13cmos5l_decap_8_881 \$2 \$1 sg13cmos5l_decap_8
* cell instance sg13cmos5l_decap_8_882 r0 *1 0,0
Xsg13cmos5l_decap_8_882 \$2 \$1 sg13cmos5l_decap_8
* cell instance sg13cmos5l_decap_8_883 r0 *1 0,0
Xsg13cmos5l_decap_8_883 \$2 \$1 sg13cmos5l_decap_8
* cell instance sg13cmos5l_decap_8_884 r0 *1 0,0
Xsg13cmos5l_decap_8_884 \$2 \$1 sg13cmos5l_decap_8
* cell instance sg13cmos5l_decap_8_885 r0 *1 0,0
Xsg13cmos5l_decap_8_885 \$2 \$1 sg13cmos5l_decap_8
* cell instance sg13cmos5l_decap_8_886 r0 *1 0,0
Xsg13cmos5l_decap_8_886 \$2 \$1 sg13cmos5l_decap_8
* cell instance sg13cmos5l_decap_8_887 r0 *1 0,0
Xsg13cmos5l_decap_8_887 \$2 \$1 sg13cmos5l_decap_8
* cell instance sg13cmos5l_decap_8_888 r0 *1 0,0
Xsg13cmos5l_decap_8_888 \$2 \$1 sg13cmos5l_decap_8
* cell instance sg13cmos5l_decap_8_889 r0 *1 0,0
Xsg13cmos5l_decap_8_889 \$2 \$1 sg13cmos5l_decap_8
* cell instance sg13cmos5l_decap_8_890 r0 *1 0,0
Xsg13cmos5l_decap_8_890 \$2 \$1 sg13cmos5l_decap_8
* cell instance sg13cmos5l_decap_8_891 r0 *1 0,0
Xsg13cmos5l_decap_8_891 \$2 \$1 sg13cmos5l_decap_8
* cell instance sg13cmos5l_decap_8_892 r0 *1 0,0
Xsg13cmos5l_decap_8_892 \$2 \$1 sg13cmos5l_decap_8
* cell instance sg13cmos5l_decap_8_893 r0 *1 0,0
Xsg13cmos5l_decap_8_893 \$2 \$1 sg13cmos5l_decap_8
* cell instance sg13cmos5l_decap_8_894 r0 *1 0,0
Xsg13cmos5l_decap_8_894 \$2 \$1 sg13cmos5l_decap_8
* cell instance sg13cmos5l_decap_8_895 r0 *1 0,0
Xsg13cmos5l_decap_8_895 \$2 \$1 sg13cmos5l_decap_8
* cell instance sg13cmos5l_decap_8_896 r0 *1 0,0
Xsg13cmos5l_decap_8_896 \$2 \$1 sg13cmos5l_decap_8
* cell instance sg13cmos5l_decap_8_897 r0 *1 0,0
Xsg13cmos5l_decap_8_897 \$2 \$1 sg13cmos5l_decap_8
* cell instance sg13cmos5l_decap_8_898 r0 *1 0,0
Xsg13cmos5l_decap_8_898 \$2 \$1 sg13cmos5l_decap_8
* cell instance sg13cmos5l_decap_8_899 r0 *1 0,0
Xsg13cmos5l_decap_8_899 \$2 \$1 sg13cmos5l_decap_8
* cell instance sg13cmos5l_decap_8_900 r0 *1 0,0
Xsg13cmos5l_decap_8_900 \$2 \$1 sg13cmos5l_decap_8
* cell instance sg13cmos5l_decap_8_901 r0 *1 0,0
Xsg13cmos5l_decap_8_901 \$2 \$1 sg13cmos5l_decap_8
* cell instance sg13cmos5l_decap_8_902 r0 *1 0,0
Xsg13cmos5l_decap_8_902 \$2 \$1 sg13cmos5l_decap_8
* cell instance sg13cmos5l_decap_8_903 r0 *1 0,0
Xsg13cmos5l_decap_8_903 \$2 \$1 sg13cmos5l_decap_8
* cell instance sg13cmos5l_decap_8_904 r0 *1 0,0
Xsg13cmos5l_decap_8_904 \$2 \$1 sg13cmos5l_decap_8
* cell instance sg13cmos5l_decap_8_905 r0 *1 0,0
Xsg13cmos5l_decap_8_905 \$2 \$1 sg13cmos5l_decap_8
* cell instance sg13cmos5l_decap_8_906 r0 *1 0,0
Xsg13cmos5l_decap_8_906 \$2 \$1 sg13cmos5l_decap_8
* cell instance sg13cmos5l_decap_8_907 r0 *1 0,0
Xsg13cmos5l_decap_8_907 \$2 \$1 sg13cmos5l_decap_8
* cell instance sg13cmos5l_decap_8_908 r0 *1 0,0
Xsg13cmos5l_decap_8_908 \$2 \$1 sg13cmos5l_decap_8
* cell instance sg13cmos5l_decap_8_909 r0 *1 0,0
Xsg13cmos5l_decap_8_909 \$2 \$1 sg13cmos5l_decap_8
* cell instance sg13cmos5l_decap_8_910 r0 *1 0,0
Xsg13cmos5l_decap_8_910 \$2 \$1 sg13cmos5l_decap_8
* cell instance sg13cmos5l_decap_8_911 r0 *1 0,0
Xsg13cmos5l_decap_8_911 \$2 \$1 sg13cmos5l_decap_8
* cell instance sg13cmos5l_decap_8_912 r0 *1 0,0
Xsg13cmos5l_decap_8_912 \$2 \$1 sg13cmos5l_decap_8
* cell instance sg13cmos5l_decap_8_913 r0 *1 0,0
Xsg13cmos5l_decap_8_913 \$2 \$1 sg13cmos5l_decap_8
* cell instance sg13cmos5l_decap_8_914 r0 *1 0,0
Xsg13cmos5l_decap_8_914 \$2 \$1 sg13cmos5l_decap_8
* cell instance sg13cmos5l_decap_8_915 r0 *1 0,0
Xsg13cmos5l_decap_8_915 \$2 \$1 sg13cmos5l_decap_8
* cell instance sg13cmos5l_decap_8_916 r0 *1 0,0
Xsg13cmos5l_decap_8_916 \$2 \$1 sg13cmos5l_decap_8
* cell instance sg13cmos5l_decap_8_917 r0 *1 0,0
Xsg13cmos5l_decap_8_917 \$2 \$1 sg13cmos5l_decap_8
* cell instance sg13cmos5l_decap_8_918 r0 *1 0,0
Xsg13cmos5l_decap_8_918 \$2 \$1 sg13cmos5l_decap_8
* cell instance sg13cmos5l_decap_8_919 r0 *1 0,0
Xsg13cmos5l_decap_8_919 \$2 \$1 sg13cmos5l_decap_8
* cell instance sg13cmos5l_decap_8_920 r0 *1 0,0
Xsg13cmos5l_decap_8_920 \$2 \$1 sg13cmos5l_decap_8
* cell instance sg13cmos5l_decap_8_921 r0 *1 0,0
Xsg13cmos5l_decap_8_921 \$2 \$1 sg13cmos5l_decap_8
* cell instance sg13cmos5l_decap_8_922 r0 *1 0,0
Xsg13cmos5l_decap_8_922 \$2 \$1 sg13cmos5l_decap_8
* cell instance sg13cmos5l_decap_8_923 r0 *1 0,0
Xsg13cmos5l_decap_8_923 \$2 \$1 sg13cmos5l_decap_8
* cell instance sg13cmos5l_decap_8_924 r0 *1 0,0
Xsg13cmos5l_decap_8_924 \$2 \$1 sg13cmos5l_decap_8
* cell instance sg13cmos5l_decap_8_925 r0 *1 0,0
Xsg13cmos5l_decap_8_925 \$2 \$1 sg13cmos5l_decap_8
* cell instance sg13cmos5l_decap_8_926 r0 *1 0,0
Xsg13cmos5l_decap_8_926 \$2 \$1 sg13cmos5l_decap_8
* cell instance sg13cmos5l_decap_8_927 r0 *1 0,0
Xsg13cmos5l_decap_8_927 \$2 \$1 sg13cmos5l_decap_8
* cell instance sg13cmos5l_decap_8_928 r0 *1 0,0
Xsg13cmos5l_decap_8_928 \$2 \$1 sg13cmos5l_decap_8
* cell instance sg13cmos5l_decap_8_929 r0 *1 0,0
Xsg13cmos5l_decap_8_929 \$2 \$1 sg13cmos5l_decap_8
* cell instance sg13cmos5l_decap_8_930 r0 *1 0,0
Xsg13cmos5l_decap_8_930 \$2 \$1 sg13cmos5l_decap_8
* cell instance sg13cmos5l_decap_8_931 r0 *1 0,0
Xsg13cmos5l_decap_8_931 \$2 \$1 sg13cmos5l_decap_8
* cell instance sg13cmos5l_decap_8_932 r0 *1 0,0
Xsg13cmos5l_decap_8_932 \$2 \$1 sg13cmos5l_decap_8
* cell instance sg13cmos5l_decap_8_933 r0 *1 0,0
Xsg13cmos5l_decap_8_933 \$2 \$1 sg13cmos5l_decap_8
* cell instance sg13cmos5l_decap_8_934 r0 *1 0,0
Xsg13cmos5l_decap_8_934 \$2 \$1 sg13cmos5l_decap_8
* cell instance sg13cmos5l_decap_8_935 r0 *1 0,0
Xsg13cmos5l_decap_8_935 \$2 \$1 sg13cmos5l_decap_8
* cell instance sg13cmos5l_decap_8_936 r0 *1 0,0
Xsg13cmos5l_decap_8_936 \$2 \$1 sg13cmos5l_decap_8
* cell instance sg13cmos5l_decap_8_937 r0 *1 0,0
Xsg13cmos5l_decap_8_937 \$2 \$1 sg13cmos5l_decap_8
* cell instance sg13cmos5l_decap_8_938 r0 *1 0,0
Xsg13cmos5l_decap_8_938 \$2 \$1 sg13cmos5l_decap_8
* cell instance sg13cmos5l_decap_8_939 r0 *1 0,0
Xsg13cmos5l_decap_8_939 \$2 \$1 sg13cmos5l_decap_8
* cell instance sg13cmos5l_decap_8_940 r0 *1 0,0
Xsg13cmos5l_decap_8_940 \$2 \$1 sg13cmos5l_decap_8
* cell instance sg13cmos5l_decap_8_941 r0 *1 0,0
Xsg13cmos5l_decap_8_941 \$2 \$1 sg13cmos5l_decap_8
* cell instance sg13cmos5l_decap_8_942 r0 *1 0,0
Xsg13cmos5l_decap_8_942 \$2 \$1 sg13cmos5l_decap_8
* cell instance sg13cmos5l_decap_8_943 r0 *1 0,0
Xsg13cmos5l_decap_8_943 \$2 \$1 sg13cmos5l_decap_8
* cell instance sg13cmos5l_decap_8_944 r0 *1 0,0
Xsg13cmos5l_decap_8_944 \$2 \$1 sg13cmos5l_decap_8
* cell instance sg13cmos5l_decap_8_945 r0 *1 0,0
Xsg13cmos5l_decap_8_945 \$2 \$1 sg13cmos5l_decap_8
* cell instance sg13cmos5l_decap_8_946 r0 *1 0,0
Xsg13cmos5l_decap_8_946 \$2 \$1 sg13cmos5l_decap_8
* cell instance sg13cmos5l_decap_8_947 r0 *1 0,0
Xsg13cmos5l_decap_8_947 \$2 \$1 sg13cmos5l_decap_8
* cell instance sg13cmos5l_decap_8_948 r0 *1 0,0
Xsg13cmos5l_decap_8_948 \$2 \$1 sg13cmos5l_decap_8
* cell instance sg13cmos5l_decap_8_949 r0 *1 0,0
Xsg13cmos5l_decap_8_949 \$2 \$1 sg13cmos5l_decap_8
* cell instance sg13cmos5l_decap_8_950 r0 *1 0,0
Xsg13cmos5l_decap_8_950 \$2 \$1 sg13cmos5l_decap_8
* cell instance sg13cmos5l_decap_8_951 r0 *1 0,0
Xsg13cmos5l_decap_8_951 \$2 \$1 sg13cmos5l_decap_8
* cell instance sg13cmos5l_decap_8_952 r0 *1 0,0
Xsg13cmos5l_decap_8_952 \$2 \$1 sg13cmos5l_decap_8
* cell instance sg13cmos5l_decap_8_953 r0 *1 0,0
Xsg13cmos5l_decap_8_953 \$2 \$1 sg13cmos5l_decap_8
* cell instance sg13cmos5l_decap_8_954 r0 *1 0,0
Xsg13cmos5l_decap_8_954 \$2 \$1 sg13cmos5l_decap_8
* cell instance sg13cmos5l_decap_8_955 r0 *1 0,0
Xsg13cmos5l_decap_8_955 \$2 \$1 sg13cmos5l_decap_8
* cell instance sg13cmos5l_decap_8_956 r0 *1 0,0
Xsg13cmos5l_decap_8_956 \$2 \$1 sg13cmos5l_decap_8
* cell instance sg13cmos5l_decap_8_957 r0 *1 0,0
Xsg13cmos5l_decap_8_957 \$2 \$1 sg13cmos5l_decap_8
* cell instance sg13cmos5l_decap_8_958 r0 *1 0,0
Xsg13cmos5l_decap_8_958 \$2 \$1 sg13cmos5l_decap_8
* cell instance sg13cmos5l_decap_8_959 r0 *1 0,0
Xsg13cmos5l_decap_8_959 \$2 \$1 sg13cmos5l_decap_8
* cell instance sg13cmos5l_decap_8_960 r0 *1 0,0
Xsg13cmos5l_decap_8_960 \$2 \$1 sg13cmos5l_decap_8
* cell instance sg13cmos5l_decap_8_961 r0 *1 0,0
Xsg13cmos5l_decap_8_961 \$2 \$1 sg13cmos5l_decap_8
* cell instance sg13cmos5l_decap_8_962 r0 *1 0,0
Xsg13cmos5l_decap_8_962 \$2 \$1 sg13cmos5l_decap_8
* cell instance sg13cmos5l_decap_8_963 r0 *1 0,0
Xsg13cmos5l_decap_8_963 \$2 \$1 sg13cmos5l_decap_8
* cell instance sg13cmos5l_decap_8_964 r0 *1 0,0
Xsg13cmos5l_decap_8_964 \$2 \$1 sg13cmos5l_decap_8
* cell instance sg13cmos5l_decap_8_965 r0 *1 0,0
Xsg13cmos5l_decap_8_965 \$2 \$1 sg13cmos5l_decap_8
* cell instance sg13cmos5l_decap_8_966 r0 *1 0,0
Xsg13cmos5l_decap_8_966 \$2 \$1 sg13cmos5l_decap_8
* cell instance sg13cmos5l_decap_8_967 r0 *1 0,0
Xsg13cmos5l_decap_8_967 \$2 \$1 sg13cmos5l_decap_8
* cell instance sg13cmos5l_decap_8_968 r0 *1 0,0
Xsg13cmos5l_decap_8_968 \$2 \$1 sg13cmos5l_decap_8
* cell instance sg13cmos5l_decap_8_969 r0 *1 0,0
Xsg13cmos5l_decap_8_969 \$2 \$1 sg13cmos5l_decap_8
* cell instance sg13cmos5l_decap_8_970 r0 *1 0,0
Xsg13cmos5l_decap_8_970 \$2 \$1 sg13cmos5l_decap_8
* cell instance sg13cmos5l_decap_8_971 r0 *1 0,0
Xsg13cmos5l_decap_8_971 \$2 \$1 sg13cmos5l_decap_8
* cell instance sg13cmos5l_decap_8_972 r0 *1 0,0
Xsg13cmos5l_decap_8_972 \$2 \$1 sg13cmos5l_decap_8
* cell instance sg13cmos5l_decap_8_973 r0 *1 0,0
Xsg13cmos5l_decap_8_973 \$2 \$1 sg13cmos5l_decap_8
* cell instance sg13cmos5l_decap_8_974 r0 *1 0,0
Xsg13cmos5l_decap_8_974 \$2 \$1 sg13cmos5l_decap_8
* cell instance sg13cmos5l_decap_8_975 r0 *1 0,0
Xsg13cmos5l_decap_8_975 \$2 \$1 sg13cmos5l_decap_8
* cell instance sg13cmos5l_decap_8_976 r0 *1 0,0
Xsg13cmos5l_decap_8_976 \$2 \$1 sg13cmos5l_decap_8
* cell instance sg13cmos5l_decap_8_977 r0 *1 0,0
Xsg13cmos5l_decap_8_977 \$2 \$1 sg13cmos5l_decap_8
* cell instance sg13cmos5l_decap_8_978 r0 *1 0,0
Xsg13cmos5l_decap_8_978 \$2 \$1 sg13cmos5l_decap_8
* cell instance sg13cmos5l_decap_8_979 r0 *1 0,0
Xsg13cmos5l_decap_8_979 \$2 \$1 sg13cmos5l_decap_8
* cell instance sg13cmos5l_decap_8_980 r0 *1 0,0
Xsg13cmos5l_decap_8_980 \$2 \$1 sg13cmos5l_decap_8
* cell instance sg13cmos5l_decap_8_981 r0 *1 0,0
Xsg13cmos5l_decap_8_981 \$2 \$1 sg13cmos5l_decap_8
* cell instance sg13cmos5l_decap_8_982 r0 *1 0,0
Xsg13cmos5l_decap_8_982 \$2 \$1 sg13cmos5l_decap_8
* cell instance sg13cmos5l_decap_8_983 r0 *1 0,0
Xsg13cmos5l_decap_8_983 \$2 \$1 sg13cmos5l_decap_8
* cell instance sg13cmos5l_decap_8_984 r0 *1 0,0
Xsg13cmos5l_decap_8_984 \$2 \$1 sg13cmos5l_decap_8
* cell instance sg13cmos5l_decap_8_985 r0 *1 0,0
Xsg13cmos5l_decap_8_985 \$2 \$1 sg13cmos5l_decap_8
* cell instance sg13cmos5l_decap_8_986 r0 *1 0,0
Xsg13cmos5l_decap_8_986 \$2 \$1 sg13cmos5l_decap_8
* cell instance sg13cmos5l_decap_8_987 r0 *1 0,0
Xsg13cmos5l_decap_8_987 \$2 \$1 sg13cmos5l_decap_8
* cell instance sg13cmos5l_decap_8_988 r0 *1 0,0
Xsg13cmos5l_decap_8_988 \$2 \$1 sg13cmos5l_decap_8
* cell instance sg13cmos5l_decap_8_989 r0 *1 0,0
Xsg13cmos5l_decap_8_989 \$2 \$1 sg13cmos5l_decap_8
* cell instance sg13cmos5l_decap_8_990 r0 *1 0,0
Xsg13cmos5l_decap_8_990 \$2 \$1 sg13cmos5l_decap_8
* cell instance sg13cmos5l_decap_8_991 r0 *1 0,0
Xsg13cmos5l_decap_8_991 \$2 \$1 sg13cmos5l_decap_8
* cell instance sg13cmos5l_decap_8_992 r0 *1 0,0
Xsg13cmos5l_decap_8_992 \$2 \$1 sg13cmos5l_decap_8
* cell instance sg13cmos5l_decap_8_993 r0 *1 0,0
Xsg13cmos5l_decap_8_993 \$2 \$1 sg13cmos5l_decap_8
* cell instance sg13cmos5l_decap_8_994 r0 *1 0,0
Xsg13cmos5l_decap_8_994 \$2 \$1 sg13cmos5l_decap_8
* cell instance sg13cmos5l_decap_8_995 r0 *1 0,0
Xsg13cmos5l_decap_8_995 \$2 \$1 sg13cmos5l_decap_8
* cell instance sg13cmos5l_decap_8_996 r0 *1 0,0
Xsg13cmos5l_decap_8_996 \$2 \$1 sg13cmos5l_decap_8
* cell instance sg13cmos5l_decap_8_997 r0 *1 0,0
Xsg13cmos5l_decap_8_997 \$2 \$1 sg13cmos5l_decap_8
* cell instance sg13cmos5l_decap_8_998 r0 *1 0,0
Xsg13cmos5l_decap_8_998 \$2 \$1 sg13cmos5l_decap_8
* cell instance sg13cmos5l_decap_8_999 r0 *1 0,0
Xsg13cmos5l_decap_8_999 \$2 \$1 sg13cmos5l_decap_8
* cell instance sg13cmos5l_decap_8_1000 r0 *1 0,0
Xsg13cmos5l_decap_8_1000 \$2 \$1 sg13cmos5l_decap_8
* cell instance sg13cmos5l_decap_8_1001 r0 *1 0,0
Xsg13cmos5l_decap_8_1001 \$2 \$1 sg13cmos5l_decap_8
* cell instance sg13cmos5l_decap_8_1002 r0 *1 0,0
Xsg13cmos5l_decap_8_1002 \$2 \$1 sg13cmos5l_decap_8
* cell instance sg13cmos5l_decap_8_1003 r0 *1 0,0
Xsg13cmos5l_decap_8_1003 \$2 \$1 sg13cmos5l_decap_8
* cell instance sg13cmos5l_decap_8_1004 r0 *1 0,0
Xsg13cmos5l_decap_8_1004 \$2 \$1 sg13cmos5l_decap_8
* cell instance sg13cmos5l_decap_8_1005 r0 *1 0,0
Xsg13cmos5l_decap_8_1005 \$2 \$1 sg13cmos5l_decap_8
* cell instance sg13cmos5l_decap_8_1006 r0 *1 0,0
Xsg13cmos5l_decap_8_1006 \$2 \$1 sg13cmos5l_decap_8
* cell instance sg13cmos5l_decap_8_1007 r0 *1 0,0
Xsg13cmos5l_decap_8_1007 \$2 \$1 sg13cmos5l_decap_8
* cell instance sg13cmos5l_decap_8_1008 r0 *1 0,0
Xsg13cmos5l_decap_8_1008 \$2 \$1 sg13cmos5l_decap_8
* cell instance sg13cmos5l_decap_8_1009 r0 *1 0,0
Xsg13cmos5l_decap_8_1009 \$2 \$1 sg13cmos5l_decap_8
* cell instance sg13cmos5l_decap_8_1010 r0 *1 0,0
Xsg13cmos5l_decap_8_1010 \$2 \$1 sg13cmos5l_decap_8
* cell instance sg13cmos5l_decap_8_1011 r0 *1 0,0
Xsg13cmos5l_decap_8_1011 \$2 \$1 sg13cmos5l_decap_8
* cell instance sg13cmos5l_decap_8_1012 r0 *1 0,0
Xsg13cmos5l_decap_8_1012 \$2 \$1 sg13cmos5l_decap_8
* cell instance sg13cmos5l_decap_8_1013 r0 *1 0,0
Xsg13cmos5l_decap_8_1013 \$2 \$1 sg13cmos5l_decap_8
* cell instance sg13cmos5l_decap_8_1014 r0 *1 0,0
Xsg13cmos5l_decap_8_1014 \$2 \$1 sg13cmos5l_decap_8
* cell instance sg13cmos5l_decap_8_1015 r0 *1 0,0
Xsg13cmos5l_decap_8_1015 \$2 \$1 sg13cmos5l_decap_8
* cell instance sg13cmos5l_decap_8_1016 r0 *1 0,0
Xsg13cmos5l_decap_8_1016 \$2 \$1 sg13cmos5l_decap_8
* cell instance sg13cmos5l_decap_8_1017 r0 *1 0,0
Xsg13cmos5l_decap_8_1017 \$2 \$1 sg13cmos5l_decap_8
* cell instance sg13cmos5l_decap_8_1018 r0 *1 0,0
Xsg13cmos5l_decap_8_1018 \$2 \$1 sg13cmos5l_decap_8
* cell instance sg13cmos5l_decap_8_1019 r0 *1 0,0
Xsg13cmos5l_decap_8_1019 \$2 \$1 sg13cmos5l_decap_8
* cell instance sg13cmos5l_decap_8_1020 r0 *1 0,0
Xsg13cmos5l_decap_8_1020 \$2 \$1 sg13cmos5l_decap_8
* cell instance sg13cmos5l_decap_8_1021 r0 *1 0,0
Xsg13cmos5l_decap_8_1021 \$2 \$1 sg13cmos5l_decap_8
* cell instance sg13cmos5l_decap_8_1022 r0 *1 0,0
Xsg13cmos5l_decap_8_1022 \$2 \$1 sg13cmos5l_decap_8
* cell instance sg13cmos5l_decap_8_1023 r0 *1 0,0
Xsg13cmos5l_decap_8_1023 \$2 \$1 sg13cmos5l_decap_8
* cell instance sg13cmos5l_decap_8_1024 r0 *1 0,0
Xsg13cmos5l_decap_8_1024 \$2 \$1 sg13cmos5l_decap_8
* cell instance sg13cmos5l_decap_8_1025 r0 *1 0,0
Xsg13cmos5l_decap_8_1025 \$2 \$1 sg13cmos5l_decap_8
* cell instance sg13cmos5l_decap_8_1026 r0 *1 0,0
Xsg13cmos5l_decap_8_1026 \$2 \$1 sg13cmos5l_decap_8
* cell instance sg13cmos5l_decap_8_1027 r0 *1 0,0
Xsg13cmos5l_decap_8_1027 \$2 \$1 sg13cmos5l_decap_8
* cell instance sg13cmos5l_decap_8_1028 r0 *1 0,0
Xsg13cmos5l_decap_8_1028 \$2 \$1 sg13cmos5l_decap_8
* cell instance sg13cmos5l_decap_8_1029 r0 *1 0,0
Xsg13cmos5l_decap_8_1029 \$2 \$1 sg13cmos5l_decap_8
* cell instance sg13cmos5l_decap_8_1030 r0 *1 0,0
Xsg13cmos5l_decap_8_1030 \$2 \$1 sg13cmos5l_decap_8
* cell instance sg13cmos5l_decap_8_1031 r0 *1 0,0
Xsg13cmos5l_decap_8_1031 \$2 \$1 sg13cmos5l_decap_8
* cell instance sg13cmos5l_decap_8_1032 r0 *1 0,0
Xsg13cmos5l_decap_8_1032 \$2 \$1 sg13cmos5l_decap_8
* cell instance sg13cmos5l_decap_8_1033 r0 *1 0,0
Xsg13cmos5l_decap_8_1033 \$2 \$1 sg13cmos5l_decap_8
* cell instance sg13cmos5l_decap_8_1034 r0 *1 0,0
Xsg13cmos5l_decap_8_1034 \$2 \$1 sg13cmos5l_decap_8
* cell instance sg13cmos5l_decap_8_1035 r0 *1 0,0
Xsg13cmos5l_decap_8_1035 \$2 \$1 sg13cmos5l_decap_8
* cell instance sg13cmos5l_decap_8_1036 r0 *1 0,0
Xsg13cmos5l_decap_8_1036 \$2 \$1 sg13cmos5l_decap_8
* cell instance sg13cmos5l_decap_8_1037 r0 *1 0,0
Xsg13cmos5l_decap_8_1037 \$2 \$1 sg13cmos5l_decap_8
* cell instance sg13cmos5l_decap_8_1038 r0 *1 0,0
Xsg13cmos5l_decap_8_1038 \$2 \$1 sg13cmos5l_decap_8
* cell instance sg13cmos5l_decap_8_1039 r0 *1 0,0
Xsg13cmos5l_decap_8_1039 \$2 \$1 sg13cmos5l_decap_8
* cell instance sg13cmos5l_decap_8_1040 r0 *1 0,0
Xsg13cmos5l_decap_8_1040 \$2 \$1 sg13cmos5l_decap_8
* cell instance sg13cmos5l_decap_8_1041 r0 *1 0,0
Xsg13cmos5l_decap_8_1041 \$2 \$1 sg13cmos5l_decap_8
* cell instance sg13cmos5l_decap_8_1042 r0 *1 0,0
Xsg13cmos5l_decap_8_1042 \$2 \$1 sg13cmos5l_decap_8
* cell instance sg13cmos5l_decap_8_1043 r0 *1 0,0
Xsg13cmos5l_decap_8_1043 \$2 \$1 sg13cmos5l_decap_8
* cell instance sg13cmos5l_decap_8_1044 r0 *1 0,0
Xsg13cmos5l_decap_8_1044 \$2 \$1 sg13cmos5l_decap_8
* cell instance sg13cmos5l_decap_8_1045 r0 *1 0,0
Xsg13cmos5l_decap_8_1045 \$2 \$1 sg13cmos5l_decap_8
* cell instance sg13cmos5l_decap_8_1046 r0 *1 0,0
Xsg13cmos5l_decap_8_1046 \$2 \$1 sg13cmos5l_decap_8
* cell instance sg13cmos5l_decap_8_1047 r0 *1 0,0
Xsg13cmos5l_decap_8_1047 \$2 \$1 sg13cmos5l_decap_8
* cell instance sg13cmos5l_decap_8_1048 r0 *1 0,0
Xsg13cmos5l_decap_8_1048 \$2 \$1 sg13cmos5l_decap_8
* cell instance sg13cmos5l_decap_8_1049 r0 *1 0,0
Xsg13cmos5l_decap_8_1049 \$2 \$1 sg13cmos5l_decap_8
* cell instance sg13cmos5l_decap_8_1050 r0 *1 0,0
Xsg13cmos5l_decap_8_1050 \$2 \$1 sg13cmos5l_decap_8
* cell instance sg13cmos5l_decap_8_1051 r0 *1 0,0
Xsg13cmos5l_decap_8_1051 \$2 \$1 sg13cmos5l_decap_8
* cell instance sg13cmos5l_decap_8_1052 r0 *1 0,0
Xsg13cmos5l_decap_8_1052 \$2 \$1 sg13cmos5l_decap_8
* cell instance sg13cmos5l_decap_8_1053 r0 *1 0,0
Xsg13cmos5l_decap_8_1053 \$2 \$1 sg13cmos5l_decap_8
* cell instance sg13cmos5l_decap_8_1054 r0 *1 0,0
Xsg13cmos5l_decap_8_1054 \$2 \$1 sg13cmos5l_decap_8
* cell instance sg13cmos5l_decap_8_1055 r0 *1 0,0
Xsg13cmos5l_decap_8_1055 \$2 \$1 sg13cmos5l_decap_8
* cell instance sg13cmos5l_decap_8_1056 r0 *1 0,0
Xsg13cmos5l_decap_8_1056 \$2 \$1 sg13cmos5l_decap_8
* cell instance sg13cmos5l_decap_8_1057 r0 *1 0,0
Xsg13cmos5l_decap_8_1057 \$2 \$1 sg13cmos5l_decap_8
* cell instance sg13cmos5l_decap_8_1058 r0 *1 0,0
Xsg13cmos5l_decap_8_1058 \$2 \$1 sg13cmos5l_decap_8
* cell instance sg13cmos5l_decap_8_1059 r0 *1 0,0
Xsg13cmos5l_decap_8_1059 \$2 \$1 sg13cmos5l_decap_8
* cell instance sg13cmos5l_decap_8_1060 r0 *1 0,0
Xsg13cmos5l_decap_8_1060 \$2 \$1 sg13cmos5l_decap_8
* cell instance sg13cmos5l_decap_8_1061 r0 *1 0,0
Xsg13cmos5l_decap_8_1061 \$2 \$1 sg13cmos5l_decap_8
* cell instance sg13cmos5l_decap_8_1062 r0 *1 0,0
Xsg13cmos5l_decap_8_1062 \$2 \$1 sg13cmos5l_decap_8
* cell instance sg13cmos5l_decap_8_1063 r0 *1 0,0
Xsg13cmos5l_decap_8_1063 \$2 \$1 sg13cmos5l_decap_8
* cell instance sg13cmos5l_decap_8_1064 r0 *1 0,0
Xsg13cmos5l_decap_8_1064 \$2 \$1 sg13cmos5l_decap_8
* cell instance sg13cmos5l_decap_8_1065 r0 *1 0,0
Xsg13cmos5l_decap_8_1065 \$2 \$1 sg13cmos5l_decap_8
* cell instance sg13cmos5l_decap_8_1066 r0 *1 0,0
Xsg13cmos5l_decap_8_1066 \$2 \$1 sg13cmos5l_decap_8
* cell instance sg13cmos5l_decap_8_1067 r0 *1 0,0
Xsg13cmos5l_decap_8_1067 \$2 \$1 sg13cmos5l_decap_8
* cell instance sg13cmos5l_decap_8_1068 r0 *1 0,0
Xsg13cmos5l_decap_8_1068 \$2 \$1 sg13cmos5l_decap_8
* cell instance sg13cmos5l_decap_8_1069 r0 *1 0,0
Xsg13cmos5l_decap_8_1069 \$2 \$1 sg13cmos5l_decap_8
* cell instance sg13cmos5l_decap_8_1070 r0 *1 0,0
Xsg13cmos5l_decap_8_1070 \$2 \$1 sg13cmos5l_decap_8
* cell instance sg13cmos5l_decap_8_1071 r0 *1 0,0
Xsg13cmos5l_decap_8_1071 \$2 \$1 sg13cmos5l_decap_8
* cell instance sg13cmos5l_decap_8_1072 r0 *1 0,0
Xsg13cmos5l_decap_8_1072 \$2 \$1 sg13cmos5l_decap_8
* cell instance sg13cmos5l_decap_8_1073 r0 *1 0,0
Xsg13cmos5l_decap_8_1073 \$2 \$1 sg13cmos5l_decap_8
* cell instance sg13cmos5l_decap_8_1074 r0 *1 0,0
Xsg13cmos5l_decap_8_1074 \$2 \$1 sg13cmos5l_decap_8
* cell instance sg13cmos5l_decap_8_1075 r0 *1 0,0
Xsg13cmos5l_decap_8_1075 \$2 \$1 sg13cmos5l_decap_8
* cell instance sg13cmos5l_decap_8_1076 r0 *1 0,0
Xsg13cmos5l_decap_8_1076 \$2 \$1 sg13cmos5l_decap_8
* cell instance sg13cmos5l_decap_8_1077 r0 *1 0,0
Xsg13cmos5l_decap_8_1077 \$2 \$1 sg13cmos5l_decap_8
* cell instance sg13cmos5l_decap_8_1078 r0 *1 0,0
Xsg13cmos5l_decap_8_1078 \$2 \$1 sg13cmos5l_decap_8
* cell instance sg13cmos5l_decap_8_1079 r0 *1 0,0
Xsg13cmos5l_decap_8_1079 \$2 \$1 sg13cmos5l_decap_8
* cell instance sg13cmos5l_decap_8_1080 r0 *1 0,0
Xsg13cmos5l_decap_8_1080 \$2 \$1 sg13cmos5l_decap_8
* cell instance sg13cmos5l_decap_8_1081 r0 *1 0,0
Xsg13cmos5l_decap_8_1081 \$2 \$1 sg13cmos5l_decap_8
* cell instance sg13cmos5l_decap_8_1082 r0 *1 0,0
Xsg13cmos5l_decap_8_1082 \$2 \$1 sg13cmos5l_decap_8
* cell instance sg13cmos5l_decap_8_1083 r0 *1 0,0
Xsg13cmos5l_decap_8_1083 \$2 \$1 sg13cmos5l_decap_8
* cell instance sg13cmos5l_decap_8_1084 r0 *1 0,0
Xsg13cmos5l_decap_8_1084 \$2 \$1 sg13cmos5l_decap_8
* cell instance sg13cmos5l_decap_8_1085 r0 *1 0,0
Xsg13cmos5l_decap_8_1085 \$2 \$1 sg13cmos5l_decap_8
* cell instance sg13cmos5l_decap_8_1086 r0 *1 0,0
Xsg13cmos5l_decap_8_1086 \$2 \$1 sg13cmos5l_decap_8
* cell instance sg13cmos5l_decap_8_1087 r0 *1 0,0
Xsg13cmos5l_decap_8_1087 \$2 \$1 sg13cmos5l_decap_8
* cell instance sg13cmos5l_decap_8_1088 r0 *1 0,0
Xsg13cmos5l_decap_8_1088 \$2 \$1 sg13cmos5l_decap_8
* cell instance sg13cmos5l_decap_8_1089 r0 *1 0,0
Xsg13cmos5l_decap_8_1089 \$2 \$1 sg13cmos5l_decap_8
* cell instance sg13cmos5l_decap_8_1090 r0 *1 0,0
Xsg13cmos5l_decap_8_1090 \$2 \$1 sg13cmos5l_decap_8
* cell instance sg13cmos5l_decap_8_1091 r0 *1 0,0
Xsg13cmos5l_decap_8_1091 \$2 \$1 sg13cmos5l_decap_8
* cell instance sg13cmos5l_decap_8_1092 r0 *1 0,0
Xsg13cmos5l_decap_8_1092 \$2 \$1 sg13cmos5l_decap_8
* cell instance sg13cmos5l_decap_8_1093 r0 *1 0,0
Xsg13cmos5l_decap_8_1093 \$2 \$1 sg13cmos5l_decap_8
* cell instance sg13cmos5l_decap_8_1094 r0 *1 0,0
Xsg13cmos5l_decap_8_1094 \$2 \$1 sg13cmos5l_decap_8
* cell instance sg13cmos5l_decap_8_1095 r0 *1 0,0
Xsg13cmos5l_decap_8_1095 \$2 \$1 sg13cmos5l_decap_8
* cell instance sg13cmos5l_decap_8_1096 r0 *1 0,0
Xsg13cmos5l_decap_8_1096 \$2 \$1 sg13cmos5l_decap_8
* cell instance sg13cmos5l_decap_8_1097 r0 *1 0,0
Xsg13cmos5l_decap_8_1097 \$2 \$1 sg13cmos5l_decap_8
* cell instance sg13cmos5l_decap_8_1098 r0 *1 0,0
Xsg13cmos5l_decap_8_1098 \$2 \$1 sg13cmos5l_decap_8
* cell instance sg13cmos5l_decap_8_1099 r0 *1 0,0
Xsg13cmos5l_decap_8_1099 \$2 \$1 sg13cmos5l_decap_8
* cell instance sg13cmos5l_decap_8_1100 r0 *1 0,0
Xsg13cmos5l_decap_8_1100 \$2 \$1 sg13cmos5l_decap_8
* cell instance sg13cmos5l_decap_8_1101 r0 *1 0,0
Xsg13cmos5l_decap_8_1101 \$2 \$1 sg13cmos5l_decap_8
* cell instance sg13cmos5l_decap_8_1102 r0 *1 0,0
Xsg13cmos5l_decap_8_1102 \$2 \$1 sg13cmos5l_decap_8
* cell instance sg13cmos5l_decap_8_1103 r0 *1 0,0
Xsg13cmos5l_decap_8_1103 \$2 \$1 sg13cmos5l_decap_8
* cell instance sg13cmos5l_decap_8_1104 r0 *1 0,0
Xsg13cmos5l_decap_8_1104 \$2 \$1 sg13cmos5l_decap_8
* cell instance sg13cmos5l_decap_8_1105 r0 *1 0,0
Xsg13cmos5l_decap_8_1105 \$2 \$1 sg13cmos5l_decap_8
* cell instance sg13cmos5l_decap_8_1106 r0 *1 0,0
Xsg13cmos5l_decap_8_1106 \$2 \$1 sg13cmos5l_decap_8
* cell instance sg13cmos5l_decap_8_1107 r0 *1 0,0
Xsg13cmos5l_decap_8_1107 \$2 \$1 sg13cmos5l_decap_8
* cell instance sg13cmos5l_decap_8_1108 r0 *1 0,0
Xsg13cmos5l_decap_8_1108 \$2 \$1 sg13cmos5l_decap_8
* cell instance sg13cmos5l_decap_8_1109 r0 *1 0,0
Xsg13cmos5l_decap_8_1109 \$2 \$1 sg13cmos5l_decap_8
* cell instance sg13cmos5l_decap_8_1110 r0 *1 0,0
Xsg13cmos5l_decap_8_1110 \$2 \$1 sg13cmos5l_decap_8
* cell instance sg13cmos5l_decap_8_1111 r0 *1 0,0
Xsg13cmos5l_decap_8_1111 \$2 \$1 sg13cmos5l_decap_8
* cell instance sg13cmos5l_decap_8_1112 r0 *1 0,0
Xsg13cmos5l_decap_8_1112 \$2 \$1 sg13cmos5l_decap_8
* cell instance sg13cmos5l_decap_8_1113 r0 *1 0,0
Xsg13cmos5l_decap_8_1113 \$2 \$1 sg13cmos5l_decap_8
* cell instance sg13cmos5l_decap_8_1114 r0 *1 0,0
Xsg13cmos5l_decap_8_1114 \$2 \$1 sg13cmos5l_decap_8
* cell instance sg13cmos5l_decap_8_1115 r0 *1 0,0
Xsg13cmos5l_decap_8_1115 \$2 \$1 sg13cmos5l_decap_8
* cell instance sg13cmos5l_decap_8_1116 r0 *1 0,0
Xsg13cmos5l_decap_8_1116 \$2 \$1 sg13cmos5l_decap_8
* cell instance sg13cmos5l_decap_8_1117 r0 *1 0,0
Xsg13cmos5l_decap_8_1117 \$2 \$1 sg13cmos5l_decap_8
* cell instance sg13cmos5l_decap_8_1118 r0 *1 0,0
Xsg13cmos5l_decap_8_1118 \$2 \$1 sg13cmos5l_decap_8
* cell instance sg13cmos5l_decap_8_1119 r0 *1 0,0
Xsg13cmos5l_decap_8_1119 \$2 \$1 sg13cmos5l_decap_8
* cell instance sg13cmos5l_decap_8_1120 r0 *1 0,0
Xsg13cmos5l_decap_8_1120 \$2 \$1 sg13cmos5l_decap_8
* cell instance sg13cmos5l_decap_8_1121 r0 *1 0,0
Xsg13cmos5l_decap_8_1121 \$2 \$1 sg13cmos5l_decap_8
* cell instance sg13cmos5l_decap_8_1122 r0 *1 0,0
Xsg13cmos5l_decap_8_1122 \$2 \$1 sg13cmos5l_decap_8
* cell instance sg13cmos5l_decap_8_1123 r0 *1 0,0
Xsg13cmos5l_decap_8_1123 \$2 \$1 sg13cmos5l_decap_8
* cell instance sg13cmos5l_decap_8_1124 r0 *1 0,0
Xsg13cmos5l_decap_8_1124 \$2 \$1 sg13cmos5l_decap_8
* cell instance sg13cmos5l_decap_8_1125 r0 *1 0,0
Xsg13cmos5l_decap_8_1125 \$2 \$1 sg13cmos5l_decap_8
* cell instance sg13cmos5l_decap_8_1126 r0 *1 0,0
Xsg13cmos5l_decap_8_1126 \$2 \$1 sg13cmos5l_decap_8
* cell instance sg13cmos5l_decap_8_1127 r0 *1 0,0
Xsg13cmos5l_decap_8_1127 \$2 \$1 sg13cmos5l_decap_8
* cell instance sg13cmos5l_decap_8_1128 r0 *1 0,0
Xsg13cmos5l_decap_8_1128 \$2 \$1 sg13cmos5l_decap_8
* cell instance sg13cmos5l_decap_8_1129 r0 *1 0,0
Xsg13cmos5l_decap_8_1129 \$2 \$1 sg13cmos5l_decap_8
* cell instance sg13cmos5l_decap_8_1130 r0 *1 0,0
Xsg13cmos5l_decap_8_1130 \$2 \$1 sg13cmos5l_decap_8
* cell instance sg13cmos5l_decap_8_1131 r0 *1 0,0
Xsg13cmos5l_decap_8_1131 \$2 \$1 sg13cmos5l_decap_8
* cell instance sg13cmos5l_decap_8_1132 r0 *1 0,0
Xsg13cmos5l_decap_8_1132 \$2 \$1 sg13cmos5l_decap_8
* cell instance sg13cmos5l_decap_8_1133 r0 *1 0,0
Xsg13cmos5l_decap_8_1133 \$2 \$1 sg13cmos5l_decap_8
* cell instance sg13cmos5l_decap_8_1134 r0 *1 0,0
Xsg13cmos5l_decap_8_1134 \$2 \$1 sg13cmos5l_decap_8
* cell instance sg13cmos5l_decap_8_1135 r0 *1 0,0
Xsg13cmos5l_decap_8_1135 \$2 \$1 sg13cmos5l_decap_8
* cell instance sg13cmos5l_decap_8_1136 r0 *1 0,0
Xsg13cmos5l_decap_8_1136 \$2 \$1 sg13cmos5l_decap_8
* cell instance sg13cmos5l_decap_8_1137 r0 *1 0,0
Xsg13cmos5l_decap_8_1137 \$2 \$1 sg13cmos5l_decap_8
* cell instance sg13cmos5l_decap_8_1138 r0 *1 0,0
Xsg13cmos5l_decap_8_1138 \$2 \$1 sg13cmos5l_decap_8
* cell instance sg13cmos5l_decap_8_1139 r0 *1 0,0
Xsg13cmos5l_decap_8_1139 \$2 \$1 sg13cmos5l_decap_8
* cell instance sg13cmos5l_decap_8_1140 r0 *1 0,0
Xsg13cmos5l_decap_8_1140 \$2 \$1 sg13cmos5l_decap_8
* cell instance sg13cmos5l_decap_8_1141 r0 *1 0,0
Xsg13cmos5l_decap_8_1141 \$2 \$1 sg13cmos5l_decap_8
* cell instance sg13cmos5l_decap_8_1142 r0 *1 0,0
Xsg13cmos5l_decap_8_1142 \$2 \$1 sg13cmos5l_decap_8
* cell instance sg13cmos5l_decap_8_1143 r0 *1 0,0
Xsg13cmos5l_decap_8_1143 \$2 \$1 sg13cmos5l_decap_8
* cell instance sg13cmos5l_decap_8_1144 r0 *1 0,0
Xsg13cmos5l_decap_8_1144 \$2 \$1 sg13cmos5l_decap_8
* cell instance sg13cmos5l_decap_8_1145 r0 *1 0,0
Xsg13cmos5l_decap_8_1145 \$2 \$1 sg13cmos5l_decap_8
* cell instance sg13cmos5l_decap_8_1146 r0 *1 0,0
Xsg13cmos5l_decap_8_1146 \$2 \$1 sg13cmos5l_decap_8
* cell instance sg13cmos5l_decap_8_1147 r0 *1 0,0
Xsg13cmos5l_decap_8_1147 \$2 \$1 sg13cmos5l_decap_8
* cell instance sg13cmos5l_decap_8_1148 r0 *1 0,0
Xsg13cmos5l_decap_8_1148 \$2 \$1 sg13cmos5l_decap_8
* cell instance sg13cmos5l_decap_8_1149 r0 *1 0,0
Xsg13cmos5l_decap_8_1149 \$2 \$1 sg13cmos5l_decap_8
* cell instance sg13cmos5l_decap_8_1150 r0 *1 0,0
Xsg13cmos5l_decap_8_1150 \$2 \$1 sg13cmos5l_decap_8
* cell instance sg13cmos5l_decap_8_1151 r0 *1 0,0
Xsg13cmos5l_decap_8_1151 \$2 \$1 sg13cmos5l_decap_8
* cell instance sg13cmos5l_decap_8_1152 r0 *1 0,0
Xsg13cmos5l_decap_8_1152 \$2 \$1 sg13cmos5l_decap_8
* cell instance sg13cmos5l_decap_8_1153 r0 *1 0,0
Xsg13cmos5l_decap_8_1153 \$2 \$1 sg13cmos5l_decap_8
* cell instance sg13cmos5l_decap_8_1154 r0 *1 0,0
Xsg13cmos5l_decap_8_1154 \$2 \$1 sg13cmos5l_decap_8
* cell instance sg13cmos5l_decap_8_1155 r0 *1 0,0
Xsg13cmos5l_decap_8_1155 \$2 \$1 sg13cmos5l_decap_8
* cell instance sg13cmos5l_decap_8_1156 r0 *1 0,0
Xsg13cmos5l_decap_8_1156 \$2 \$1 sg13cmos5l_decap_8
* cell instance sg13cmos5l_decap_8_1157 r0 *1 0,0
Xsg13cmos5l_decap_8_1157 \$2 \$1 sg13cmos5l_decap_8
* cell instance sg13cmos5l_decap_8_1158 r0 *1 0,0
Xsg13cmos5l_decap_8_1158 \$2 \$1 sg13cmos5l_decap_8
* cell instance sg13cmos5l_decap_8_1159 r0 *1 0,0
Xsg13cmos5l_decap_8_1159 \$2 \$1 sg13cmos5l_decap_8
* cell instance sg13cmos5l_decap_8_1160 r0 *1 0,0
Xsg13cmos5l_decap_8_1160 \$2 \$1 sg13cmos5l_decap_8
* cell instance sg13cmos5l_decap_8_1161 r0 *1 0,0
Xsg13cmos5l_decap_8_1161 \$2 \$1 sg13cmos5l_decap_8
* cell instance sg13cmos5l_decap_8_1162 r0 *1 0,0
Xsg13cmos5l_decap_8_1162 \$2 \$1 sg13cmos5l_decap_8
* cell instance sg13cmos5l_decap_8_1163 r0 *1 0,0
Xsg13cmos5l_decap_8_1163 \$2 \$1 sg13cmos5l_decap_8
* cell instance sg13cmos5l_decap_8_1164 r0 *1 0,0
Xsg13cmos5l_decap_8_1164 \$2 \$1 sg13cmos5l_decap_8
* cell instance sg13cmos5l_decap_8_1165 r0 *1 0,0
Xsg13cmos5l_decap_8_1165 \$2 \$1 sg13cmos5l_decap_8
* cell instance sg13cmos5l_decap_8_1166 r0 *1 0,0
Xsg13cmos5l_decap_8_1166 \$2 \$1 sg13cmos5l_decap_8
* cell instance sg13cmos5l_decap_8_1167 r0 *1 0,0
Xsg13cmos5l_decap_8_1167 \$2 \$1 sg13cmos5l_decap_8
* cell instance sg13cmos5l_decap_8_1168 r0 *1 0,0
Xsg13cmos5l_decap_8_1168 \$2 \$1 sg13cmos5l_decap_8
* cell instance sg13cmos5l_decap_8_1169 r0 *1 0,0
Xsg13cmos5l_decap_8_1169 \$2 \$1 sg13cmos5l_decap_8
* cell instance sg13cmos5l_decap_8_1170 r0 *1 0,0
Xsg13cmos5l_decap_8_1170 \$2 \$1 sg13cmos5l_decap_8
* cell instance sg13cmos5l_decap_8_1171 r0 *1 0,0
Xsg13cmos5l_decap_8_1171 \$2 \$1 sg13cmos5l_decap_8
* cell instance sg13cmos5l_decap_8_1172 r0 *1 0,0
Xsg13cmos5l_decap_8_1172 \$2 \$1 sg13cmos5l_decap_8
* cell instance sg13cmos5l_decap_8_1173 r0 *1 0,0
Xsg13cmos5l_decap_8_1173 \$2 \$1 sg13cmos5l_decap_8
* cell instance sg13cmos5l_decap_8_1174 r0 *1 0,0
Xsg13cmos5l_decap_8_1174 \$2 \$1 sg13cmos5l_decap_8
* cell instance sg13cmos5l_decap_8_1175 r0 *1 0,0
Xsg13cmos5l_decap_8_1175 \$2 \$1 sg13cmos5l_decap_8
* cell instance sg13cmos5l_decap_8_1176 r0 *1 0,0
Xsg13cmos5l_decap_8_1176 \$2 \$1 sg13cmos5l_decap_8
* cell instance sg13cmos5l_decap_8_1177 r0 *1 0,0
Xsg13cmos5l_decap_8_1177 \$2 \$1 sg13cmos5l_decap_8
* cell instance sg13cmos5l_decap_8_1178 r0 *1 0,0
Xsg13cmos5l_decap_8_1178 \$2 \$1 sg13cmos5l_decap_8
* cell instance sg13cmos5l_decap_8_1179 r0 *1 0,0
Xsg13cmos5l_decap_8_1179 \$2 \$1 sg13cmos5l_decap_8
* cell instance sg13cmos5l_decap_8_1180 r0 *1 0,0
Xsg13cmos5l_decap_8_1180 \$2 \$1 sg13cmos5l_decap_8
* cell instance sg13cmos5l_decap_8_1181 r0 *1 0,0
Xsg13cmos5l_decap_8_1181 \$2 \$1 sg13cmos5l_decap_8
* cell instance sg13cmos5l_decap_8_1182 r0 *1 0,0
Xsg13cmos5l_decap_8_1182 \$2 \$1 sg13cmos5l_decap_8
* cell instance sg13cmos5l_decap_8_1183 r0 *1 0,0
Xsg13cmos5l_decap_8_1183 \$2 \$1 sg13cmos5l_decap_8
* cell instance sg13cmos5l_decap_8_1184 r0 *1 0,0
Xsg13cmos5l_decap_8_1184 \$2 \$1 sg13cmos5l_decap_8
* cell instance sg13cmos5l_decap_8_1185 r0 *1 0,0
Xsg13cmos5l_decap_8_1185 \$2 \$1 sg13cmos5l_decap_8
* cell instance sg13cmos5l_decap_8_1186 r0 *1 0,0
Xsg13cmos5l_decap_8_1186 \$2 \$1 sg13cmos5l_decap_8
* cell instance sg13cmos5l_decap_8_1187 r0 *1 0,0
Xsg13cmos5l_decap_8_1187 \$2 \$1 sg13cmos5l_decap_8
* cell instance sg13cmos5l_decap_8_1188 r0 *1 0,0
Xsg13cmos5l_decap_8_1188 \$2 \$1 sg13cmos5l_decap_8
* cell instance sg13cmos5l_decap_8_1189 r0 *1 0,0
Xsg13cmos5l_decap_8_1189 \$2 \$1 sg13cmos5l_decap_8
* cell instance sg13cmos5l_decap_8_1190 r0 *1 0,0
Xsg13cmos5l_decap_8_1190 \$2 \$1 sg13cmos5l_decap_8
* cell instance sg13cmos5l_decap_8_1191 r0 *1 0,0
Xsg13cmos5l_decap_8_1191 \$2 \$1 sg13cmos5l_decap_8
* cell instance sg13cmos5l_decap_8_1192 r0 *1 0,0
Xsg13cmos5l_decap_8_1192 \$2 \$1 sg13cmos5l_decap_8
* cell instance sg13cmos5l_decap_8_1193 r0 *1 0,0
Xsg13cmos5l_decap_8_1193 \$2 \$1 sg13cmos5l_decap_8
* cell instance sg13cmos5l_decap_8_1194 r0 *1 0,0
Xsg13cmos5l_decap_8_1194 \$2 \$1 sg13cmos5l_decap_8
* cell instance sg13cmos5l_decap_8_1195 r0 *1 0,0
Xsg13cmos5l_decap_8_1195 \$2 \$1 sg13cmos5l_decap_8
* cell instance sg13cmos5l_decap_8_1196 r0 *1 0,0
Xsg13cmos5l_decap_8_1196 \$2 \$1 sg13cmos5l_decap_8
* cell instance sg13cmos5l_decap_8_1197 r0 *1 0,0
Xsg13cmos5l_decap_8_1197 \$2 \$1 sg13cmos5l_decap_8
* cell instance sg13cmos5l_decap_8_1198 r0 *1 0,0
Xsg13cmos5l_decap_8_1198 \$2 \$1 sg13cmos5l_decap_8
* cell instance sg13cmos5l_decap_8_1199 r0 *1 0,0
Xsg13cmos5l_decap_8_1199 \$2 \$1 sg13cmos5l_decap_8
* cell instance sg13cmos5l_decap_8_1200 r0 *1 0,0
Xsg13cmos5l_decap_8_1200 \$2 \$1 sg13cmos5l_decap_8
* cell instance sg13cmos5l_decap_8_1201 r0 *1 0,0
Xsg13cmos5l_decap_8_1201 \$2 \$1 sg13cmos5l_decap_8
* cell instance sg13cmos5l_decap_8_1202 r0 *1 0,0
Xsg13cmos5l_decap_8_1202 \$2 \$1 sg13cmos5l_decap_8
* cell instance sg13cmos5l_decap_8_1203 r0 *1 0,0
Xsg13cmos5l_decap_8_1203 \$2 \$1 sg13cmos5l_decap_8
* cell instance sg13cmos5l_decap_8_1204 r0 *1 0,0
Xsg13cmos5l_decap_8_1204 \$2 \$1 sg13cmos5l_decap_8
* cell instance sg13cmos5l_decap_8_1205 r0 *1 0,0
Xsg13cmos5l_decap_8_1205 \$2 \$1 sg13cmos5l_decap_8
* cell instance sg13cmos5l_decap_8_1206 r0 *1 0,0
Xsg13cmos5l_decap_8_1206 \$2 \$1 sg13cmos5l_decap_8
* cell instance sg13cmos5l_decap_8_1207 r0 *1 0,0
Xsg13cmos5l_decap_8_1207 \$2 \$1 sg13cmos5l_decap_8
* cell instance sg13cmos5l_decap_8_1208 r0 *1 0,0
Xsg13cmos5l_decap_8_1208 \$2 \$1 sg13cmos5l_decap_8
* cell instance sg13cmos5l_decap_8_1209 r0 *1 0,0
Xsg13cmos5l_decap_8_1209 \$2 \$1 sg13cmos5l_decap_8
* cell instance sg13cmos5l_decap_8_1210 r0 *1 0,0
Xsg13cmos5l_decap_8_1210 \$2 \$1 sg13cmos5l_decap_8
* cell instance sg13cmos5l_decap_8_1211 r0 *1 0,0
Xsg13cmos5l_decap_8_1211 \$2 \$1 sg13cmos5l_decap_8
* cell instance sg13cmos5l_decap_8_1212 r0 *1 0,0
Xsg13cmos5l_decap_8_1212 \$2 \$1 sg13cmos5l_decap_8
* cell instance sg13cmos5l_decap_8_1213 r0 *1 0,0
Xsg13cmos5l_decap_8_1213 \$2 \$1 sg13cmos5l_decap_8
* cell instance sg13cmos5l_decap_8_1214 r0 *1 0,0
Xsg13cmos5l_decap_8_1214 \$2 \$1 sg13cmos5l_decap_8
* cell instance sg13cmos5l_decap_8_1215 r0 *1 0,0
Xsg13cmos5l_decap_8_1215 \$2 \$1 sg13cmos5l_decap_8
* cell instance sg13cmos5l_decap_8_1216 r0 *1 0,0
Xsg13cmos5l_decap_8_1216 \$2 \$1 sg13cmos5l_decap_8
* cell instance sg13cmos5l_decap_8_1217 r0 *1 0,0
Xsg13cmos5l_decap_8_1217 \$2 \$1 sg13cmos5l_decap_8
* cell instance sg13cmos5l_decap_8_1218 r0 *1 0,0
Xsg13cmos5l_decap_8_1218 \$2 \$1 sg13cmos5l_decap_8
* cell instance sg13cmos5l_decap_8_1219 r0 *1 0,0
Xsg13cmos5l_decap_8_1219 \$2 \$1 sg13cmos5l_decap_8
* cell instance sg13cmos5l_decap_8_1220 r0 *1 0,0
Xsg13cmos5l_decap_8_1220 \$2 \$1 sg13cmos5l_decap_8
* cell instance sg13cmos5l_decap_8_1221 r0 *1 0,0
Xsg13cmos5l_decap_8_1221 \$2 \$1 sg13cmos5l_decap_8
* cell instance sg13cmos5l_decap_8_1222 r0 *1 0,0
Xsg13cmos5l_decap_8_1222 \$2 \$1 sg13cmos5l_decap_8
* cell instance sg13cmos5l_decap_8_1223 r0 *1 0,0
Xsg13cmos5l_decap_8_1223 \$2 \$1 sg13cmos5l_decap_8
* cell instance sg13cmos5l_decap_8_1224 r0 *1 0,0
Xsg13cmos5l_decap_8_1224 \$2 \$1 sg13cmos5l_decap_8
* cell instance sg13cmos5l_decap_8_1225 r0 *1 0,0
Xsg13cmos5l_decap_8_1225 \$2 \$1 sg13cmos5l_decap_8
* cell instance sg13cmos5l_decap_8_1226 r0 *1 0,0
Xsg13cmos5l_decap_8_1226 \$2 \$1 sg13cmos5l_decap_8
* cell instance sg13cmos5l_decap_8_1227 r0 *1 0,0
Xsg13cmos5l_decap_8_1227 \$2 \$1 sg13cmos5l_decap_8
* cell instance sg13cmos5l_decap_8_1228 r0 *1 0,0
Xsg13cmos5l_decap_8_1228 \$2 \$1 sg13cmos5l_decap_8
* cell instance sg13cmos5l_decap_8_1229 r0 *1 0,0
Xsg13cmos5l_decap_8_1229 \$2 \$1 sg13cmos5l_decap_8
* cell instance sg13cmos5l_decap_8_1230 r0 *1 0,0
Xsg13cmos5l_decap_8_1230 \$2 \$1 sg13cmos5l_decap_8
* cell instance sg13cmos5l_decap_8_1231 r0 *1 0,0
Xsg13cmos5l_decap_8_1231 \$2 \$1 sg13cmos5l_decap_8
* cell instance sg13cmos5l_decap_8_1232 r0 *1 0,0
Xsg13cmos5l_decap_8_1232 \$2 \$1 sg13cmos5l_decap_8
* cell instance sg13cmos5l_decap_8_1233 r0 *1 0,0
Xsg13cmos5l_decap_8_1233 \$2 \$1 sg13cmos5l_decap_8
* cell instance sg13cmos5l_decap_8_1234 r0 *1 0,0
Xsg13cmos5l_decap_8_1234 \$2 \$1 sg13cmos5l_decap_8
* cell instance sg13cmos5l_decap_8_1235 r0 *1 0,0
Xsg13cmos5l_decap_8_1235 \$2 \$1 sg13cmos5l_decap_8
* cell instance sg13cmos5l_decap_8_1236 r0 *1 0,0
Xsg13cmos5l_decap_8_1236 \$2 \$1 sg13cmos5l_decap_8
* cell instance sg13cmos5l_decap_8_1237 r0 *1 0,0
Xsg13cmos5l_decap_8_1237 \$2 \$1 sg13cmos5l_decap_8
* cell instance sg13cmos5l_decap_8_1238 r0 *1 0,0
Xsg13cmos5l_decap_8_1238 \$2 \$1 sg13cmos5l_decap_8
* cell instance sg13cmos5l_decap_8_1239 r0 *1 0,0
Xsg13cmos5l_decap_8_1239 \$2 \$1 sg13cmos5l_decap_8
* cell instance sg13cmos5l_decap_8_1240 r0 *1 0,0
Xsg13cmos5l_decap_8_1240 \$2 \$1 sg13cmos5l_decap_8
* cell instance sg13cmos5l_decap_8_1241 r0 *1 0,0
Xsg13cmos5l_decap_8_1241 \$2 \$1 sg13cmos5l_decap_8
* cell instance sg13cmos5l_decap_8_1242 r0 *1 0,0
Xsg13cmos5l_decap_8_1242 \$2 \$1 sg13cmos5l_decap_8
* cell instance sg13cmos5l_decap_8_1243 r0 *1 0,0
Xsg13cmos5l_decap_8_1243 \$2 \$1 sg13cmos5l_decap_8
* cell instance sg13cmos5l_decap_8_1244 r0 *1 0,0
Xsg13cmos5l_decap_8_1244 \$2 \$1 sg13cmos5l_decap_8
* cell instance sg13cmos5l_decap_8_1245 r0 *1 0,0
Xsg13cmos5l_decap_8_1245 \$2 \$1 sg13cmos5l_decap_8
* cell instance sg13cmos5l_decap_8_1246 r0 *1 0,0
Xsg13cmos5l_decap_8_1246 \$2 \$1 sg13cmos5l_decap_8
* cell instance sg13cmos5l_decap_8_1247 r0 *1 0,0
Xsg13cmos5l_decap_8_1247 \$2 \$1 sg13cmos5l_decap_8
* cell instance sg13cmos5l_decap_8_1248 r0 *1 0,0
Xsg13cmos5l_decap_8_1248 \$2 \$1 sg13cmos5l_decap_8
* cell instance sg13cmos5l_decap_8_1249 r0 *1 0,0
Xsg13cmos5l_decap_8_1249 \$2 \$1 sg13cmos5l_decap_8
* cell instance sg13cmos5l_decap_8_1250 r0 *1 0,0
Xsg13cmos5l_decap_8_1250 \$2 \$1 sg13cmos5l_decap_8
* cell instance sg13cmos5l_decap_8_1251 r0 *1 0,0
Xsg13cmos5l_decap_8_1251 \$2 \$1 sg13cmos5l_decap_8
* cell instance sg13cmos5l_decap_8_1252 r0 *1 0,0
Xsg13cmos5l_decap_8_1252 \$2 \$1 sg13cmos5l_decap_8
* cell instance sg13cmos5l_decap_8_1253 r0 *1 0,0
Xsg13cmos5l_decap_8_1253 \$2 \$1 sg13cmos5l_decap_8
* cell instance sg13cmos5l_decap_8_1254 r0 *1 0,0
Xsg13cmos5l_decap_8_1254 \$2 \$1 sg13cmos5l_decap_8
* cell instance sg13cmos5l_decap_8_1255 r0 *1 0,0
Xsg13cmos5l_decap_8_1255 \$2 \$1 sg13cmos5l_decap_8
* cell instance sg13cmos5l_decap_8_1256 r0 *1 0,0
Xsg13cmos5l_decap_8_1256 \$2 \$1 sg13cmos5l_decap_8
* cell instance sg13cmos5l_decap_8_1257 r0 *1 0,0
Xsg13cmos5l_decap_8_1257 \$2 \$1 sg13cmos5l_decap_8
* cell instance sg13cmos5l_decap_8_1258 r0 *1 0,0
Xsg13cmos5l_decap_8_1258 \$2 \$1 sg13cmos5l_decap_8
* cell instance sg13cmos5l_decap_8_1259 r0 *1 0,0
Xsg13cmos5l_decap_8_1259 \$2 \$1 sg13cmos5l_decap_8
* cell instance sg13cmos5l_decap_8_1260 r0 *1 0,0
Xsg13cmos5l_decap_8_1260 \$2 \$1 sg13cmos5l_decap_8
* cell instance sg13cmos5l_decap_8_1261 r0 *1 0,0
Xsg13cmos5l_decap_8_1261 \$2 \$1 sg13cmos5l_decap_8
* cell instance sg13cmos5l_decap_8_1262 r0 *1 0,0
Xsg13cmos5l_decap_8_1262 \$2 \$1 sg13cmos5l_decap_8
* cell instance sg13cmos5l_decap_8_1263 r0 *1 0,0
Xsg13cmos5l_decap_8_1263 \$2 \$1 sg13cmos5l_decap_8
* cell instance sg13cmos5l_decap_8_1264 r0 *1 0,0
Xsg13cmos5l_decap_8_1264 \$2 \$1 sg13cmos5l_decap_8
* cell instance sg13cmos5l_decap_8_1265 r0 *1 0,0
Xsg13cmos5l_decap_8_1265 \$2 \$1 sg13cmos5l_decap_8
* cell instance sg13cmos5l_decap_8_1266 r0 *1 0,0
Xsg13cmos5l_decap_8_1266 \$2 \$1 sg13cmos5l_decap_8
* cell instance sg13cmos5l_decap_8_1267 r0 *1 0,0
Xsg13cmos5l_decap_8_1267 \$2 \$1 sg13cmos5l_decap_8
* cell instance sg13cmos5l_decap_8_1268 r0 *1 0,0
Xsg13cmos5l_decap_8_1268 \$2 \$1 sg13cmos5l_decap_8
* cell instance sg13cmos5l_decap_8_1269 r0 *1 0,0
Xsg13cmos5l_decap_8_1269 \$2 \$1 sg13cmos5l_decap_8
* cell instance sg13cmos5l_decap_8_1270 r0 *1 0,0
Xsg13cmos5l_decap_8_1270 \$2 \$1 sg13cmos5l_decap_8
* cell instance sg13cmos5l_decap_8_1271 r0 *1 0,0
Xsg13cmos5l_decap_8_1271 \$2 \$1 sg13cmos5l_decap_8
* cell instance sg13cmos5l_decap_8_1272 r0 *1 0,0
Xsg13cmos5l_decap_8_1272 \$2 \$1 sg13cmos5l_decap_8
* cell instance sg13cmos5l_decap_8_1273 r0 *1 0,0
Xsg13cmos5l_decap_8_1273 \$2 \$1 sg13cmos5l_decap_8
* cell instance sg13cmos5l_decap_8_1274 r0 *1 0,0
Xsg13cmos5l_decap_8_1274 \$2 \$1 sg13cmos5l_decap_8
* cell instance sg13cmos5l_decap_8_1275 r0 *1 0,0
Xsg13cmos5l_decap_8_1275 \$2 \$1 sg13cmos5l_decap_8
* cell instance sg13cmos5l_decap_8_1276 r0 *1 0,0
Xsg13cmos5l_decap_8_1276 \$2 \$1 sg13cmos5l_decap_8
* cell instance sg13cmos5l_decap_8_1277 r0 *1 0,0
Xsg13cmos5l_decap_8_1277 \$2 \$1 sg13cmos5l_decap_8
* cell instance sg13cmos5l_decap_8_1278 r0 *1 0,0
Xsg13cmos5l_decap_8_1278 \$2 \$1 sg13cmos5l_decap_8
* cell instance sg13cmos5l_decap_8_1279 r0 *1 0,0
Xsg13cmos5l_decap_8_1279 \$2 \$1 sg13cmos5l_decap_8
* cell instance sg13cmos5l_decap_8_1280 r0 *1 0,0
Xsg13cmos5l_decap_8_1280 \$2 \$1 sg13cmos5l_decap_8
* cell instance sg13cmos5l_decap_8_1281 r0 *1 0,0
Xsg13cmos5l_decap_8_1281 \$2 \$1 sg13cmos5l_decap_8
* cell instance sg13cmos5l_decap_8_1282 r0 *1 0,0
Xsg13cmos5l_decap_8_1282 \$2 \$1 sg13cmos5l_decap_8
* cell instance sg13cmos5l_decap_8_1283 r0 *1 0,0
Xsg13cmos5l_decap_8_1283 \$2 \$1 sg13cmos5l_decap_8
* cell instance sg13cmos5l_decap_8_1284 r0 *1 0,0
Xsg13cmos5l_decap_8_1284 \$2 \$1 sg13cmos5l_decap_8
* cell instance sg13cmos5l_decap_8_1285 r0 *1 0,0
Xsg13cmos5l_decap_8_1285 \$2 \$1 sg13cmos5l_decap_8
* cell instance sg13cmos5l_decap_8_1286 r0 *1 0,0
Xsg13cmos5l_decap_8_1286 \$2 \$1 sg13cmos5l_decap_8
* cell instance sg13cmos5l_decap_8_1287 r0 *1 0,0
Xsg13cmos5l_decap_8_1287 \$2 \$1 sg13cmos5l_decap_8
* cell instance sg13cmos5l_decap_8_1288 r0 *1 0,0
Xsg13cmos5l_decap_8_1288 \$2 \$1 sg13cmos5l_decap_8
* cell instance sg13cmos5l_decap_8_1289 r0 *1 0,0
Xsg13cmos5l_decap_8_1289 \$2 \$1 sg13cmos5l_decap_8
* cell instance sg13cmos5l_decap_8_1290 r0 *1 0,0
Xsg13cmos5l_decap_8_1290 \$2 \$1 sg13cmos5l_decap_8
* cell instance sg13cmos5l_decap_8_1291 r0 *1 0,0
Xsg13cmos5l_decap_8_1291 \$2 \$1 sg13cmos5l_decap_8
* cell instance sg13cmos5l_decap_8_1292 r0 *1 0,0
Xsg13cmos5l_decap_8_1292 \$2 \$1 sg13cmos5l_decap_8
* cell instance sg13cmos5l_decap_8_1293 r0 *1 0,0
Xsg13cmos5l_decap_8_1293 \$2 \$1 sg13cmos5l_decap_8
* cell instance sg13cmos5l_decap_8_1294 r0 *1 0,0
Xsg13cmos5l_decap_8_1294 \$2 \$1 sg13cmos5l_decap_8
* cell instance sg13cmos5l_decap_8_1295 r0 *1 0,0
Xsg13cmos5l_decap_8_1295 \$2 \$1 sg13cmos5l_decap_8
* cell instance sg13cmos5l_decap_8_1296 r0 *1 0,0
Xsg13cmos5l_decap_8_1296 \$2 \$1 sg13cmos5l_decap_8
* cell instance sg13cmos5l_decap_8_1297 r0 *1 0,0
Xsg13cmos5l_decap_8_1297 \$2 \$1 sg13cmos5l_decap_8
* cell instance sg13cmos5l_decap_8_1298 r0 *1 0,0
Xsg13cmos5l_decap_8_1298 \$2 \$1 sg13cmos5l_decap_8
* cell instance sg13cmos5l_decap_8_1299 r0 *1 0,0
Xsg13cmos5l_decap_8_1299 \$2 \$1 sg13cmos5l_decap_8
* cell instance sg13cmos5l_decap_8_1300 r0 *1 0,0
Xsg13cmos5l_decap_8_1300 \$2 \$1 sg13cmos5l_decap_8
* cell instance sg13cmos5l_decap_8_1301 r0 *1 0,0
Xsg13cmos5l_decap_8_1301 \$2 \$1 sg13cmos5l_decap_8
* cell instance sg13cmos5l_decap_8_1302 r0 *1 0,0
Xsg13cmos5l_decap_8_1302 \$2 \$1 sg13cmos5l_decap_8
* cell instance sg13cmos5l_decap_8_1303 r0 *1 0,0
Xsg13cmos5l_decap_8_1303 \$2 \$1 sg13cmos5l_decap_8
* cell instance sg13cmos5l_decap_8_1304 r0 *1 0,0
Xsg13cmos5l_decap_8_1304 \$2 \$1 sg13cmos5l_decap_8
* cell instance sg13cmos5l_decap_8_1305 r0 *1 0,0
Xsg13cmos5l_decap_8_1305 \$2 \$1 sg13cmos5l_decap_8
* cell instance sg13cmos5l_decap_8_1306 r0 *1 0,0
Xsg13cmos5l_decap_8_1306 \$2 \$1 sg13cmos5l_decap_8
* cell instance sg13cmos5l_decap_8_1307 r0 *1 0,0
Xsg13cmos5l_decap_8_1307 \$2 \$1 sg13cmos5l_decap_8
* cell instance sg13cmos5l_decap_8_1308 r0 *1 0,0
Xsg13cmos5l_decap_8_1308 \$2 \$1 sg13cmos5l_decap_8
* cell instance sg13cmos5l_decap_8_1309 r0 *1 0,0
Xsg13cmos5l_decap_8_1309 \$2 \$1 sg13cmos5l_decap_8
* cell instance sg13cmos5l_decap_8_1310 r0 *1 0,0
Xsg13cmos5l_decap_8_1310 \$2 \$1 sg13cmos5l_decap_8
* cell instance sg13cmos5l_decap_8_1311 r0 *1 0,0
Xsg13cmos5l_decap_8_1311 \$2 \$1 sg13cmos5l_decap_8
* cell instance sg13cmos5l_decap_8_1312 r0 *1 0,0
Xsg13cmos5l_decap_8_1312 \$2 \$1 sg13cmos5l_decap_8
* cell instance sg13cmos5l_decap_8_1313 r0 *1 0,0
Xsg13cmos5l_decap_8_1313 \$2 \$1 sg13cmos5l_decap_8
* cell instance sg13cmos5l_decap_8_1314 r0 *1 0,0
Xsg13cmos5l_decap_8_1314 \$2 \$1 sg13cmos5l_decap_8
* cell instance sg13cmos5l_decap_8_1315 r0 *1 0,0
Xsg13cmos5l_decap_8_1315 \$2 \$1 sg13cmos5l_decap_8
* cell instance sg13cmos5l_decap_8_1316 r0 *1 0,0
Xsg13cmos5l_decap_8_1316 \$2 \$1 sg13cmos5l_decap_8
* cell instance sg13cmos5l_decap_8_1317 r0 *1 0,0
Xsg13cmos5l_decap_8_1317 \$2 \$1 sg13cmos5l_decap_8
* cell instance sg13cmos5l_decap_8_1318 r0 *1 0,0
Xsg13cmos5l_decap_8_1318 \$2 \$1 sg13cmos5l_decap_8
* cell instance sg13cmos5l_decap_8_1319 r0 *1 0,0
Xsg13cmos5l_decap_8_1319 \$2 \$1 sg13cmos5l_decap_8
* cell instance sg13cmos5l_decap_8_1320 r0 *1 0,0
Xsg13cmos5l_decap_8_1320 \$2 \$1 sg13cmos5l_decap_8
* cell instance sg13cmos5l_decap_8_1321 r0 *1 0,0
Xsg13cmos5l_decap_8_1321 \$2 \$1 sg13cmos5l_decap_8
* cell instance sg13cmos5l_decap_8_1322 r0 *1 0,0
Xsg13cmos5l_decap_8_1322 \$2 \$1 sg13cmos5l_decap_8
* cell instance sg13cmos5l_decap_8_1323 r0 *1 0,0
Xsg13cmos5l_decap_8_1323 \$2 \$1 sg13cmos5l_decap_8
* cell instance sg13cmos5l_decap_8_1324 r0 *1 0,0
Xsg13cmos5l_decap_8_1324 \$2 \$1 sg13cmos5l_decap_8
* cell instance sg13cmos5l_decap_8_1325 r0 *1 0,0
Xsg13cmos5l_decap_8_1325 \$2 \$1 sg13cmos5l_decap_8
* cell instance sg13cmos5l_decap_8_1326 r0 *1 0,0
Xsg13cmos5l_decap_8_1326 \$2 \$1 sg13cmos5l_decap_8
* cell instance sg13cmos5l_decap_8_1327 r0 *1 0,0
Xsg13cmos5l_decap_8_1327 \$2 \$1 sg13cmos5l_decap_8
* cell instance sg13cmos5l_decap_8_1328 r0 *1 0,0
Xsg13cmos5l_decap_8_1328 \$2 \$1 sg13cmos5l_decap_8
* cell instance sg13cmos5l_decap_8_1329 r0 *1 0,0
Xsg13cmos5l_decap_8_1329 \$2 \$1 sg13cmos5l_decap_8
* cell instance sg13cmos5l_decap_8_1330 r0 *1 0,0
Xsg13cmos5l_decap_8_1330 \$2 \$1 sg13cmos5l_decap_8
* cell instance sg13cmos5l_decap_8_1331 r0 *1 0,0
Xsg13cmos5l_decap_8_1331 \$2 \$1 sg13cmos5l_decap_8
* cell instance sg13cmos5l_decap_8_1332 r0 *1 0,0
Xsg13cmos5l_decap_8_1332 \$2 \$1 sg13cmos5l_decap_8
* cell instance sg13cmos5l_decap_8_1333 r0 *1 0,0
Xsg13cmos5l_decap_8_1333 \$2 \$1 sg13cmos5l_decap_8
* cell instance sg13cmos5l_decap_8_1334 r0 *1 0,0
Xsg13cmos5l_decap_8_1334 \$2 \$1 sg13cmos5l_decap_8
* cell instance sg13cmos5l_decap_8_1335 r0 *1 0,0
Xsg13cmos5l_decap_8_1335 \$2 \$1 sg13cmos5l_decap_8
* cell instance sg13cmos5l_decap_8_1336 r0 *1 0,0
Xsg13cmos5l_decap_8_1336 \$2 \$1 sg13cmos5l_decap_8
* cell instance sg13cmos5l_decap_8_1337 r0 *1 0,0
Xsg13cmos5l_decap_8_1337 \$2 \$1 sg13cmos5l_decap_8
* cell instance sg13cmos5l_decap_8_1338 r0 *1 0,0
Xsg13cmos5l_decap_8_1338 \$2 \$1 sg13cmos5l_decap_8
* cell instance sg13cmos5l_decap_8_1339 r0 *1 0,0
Xsg13cmos5l_decap_8_1339 \$2 \$1 sg13cmos5l_decap_8
* cell instance sg13cmos5l_decap_8_1340 r0 *1 0,0
Xsg13cmos5l_decap_8_1340 \$2 \$1 sg13cmos5l_decap_8
* cell instance sg13cmos5l_decap_8_1341 r0 *1 0,0
Xsg13cmos5l_decap_8_1341 \$2 \$1 sg13cmos5l_decap_8
* cell instance sg13cmos5l_decap_8_1342 r0 *1 0,0
Xsg13cmos5l_decap_8_1342 \$2 \$1 sg13cmos5l_decap_8
* cell instance sg13cmos5l_decap_8_1343 r0 *1 0,0
Xsg13cmos5l_decap_8_1343 \$2 \$1 sg13cmos5l_decap_8
* cell instance sg13cmos5l_decap_8_1344 r0 *1 0,0
Xsg13cmos5l_decap_8_1344 \$2 \$1 sg13cmos5l_decap_8
* cell instance sg13cmos5l_decap_8_1345 r0 *1 0,0
Xsg13cmos5l_decap_8_1345 \$2 \$1 sg13cmos5l_decap_8
* cell instance sg13cmos5l_decap_8_1346 r0 *1 0,0
Xsg13cmos5l_decap_8_1346 \$2 \$1 sg13cmos5l_decap_8
* cell instance sg13cmos5l_decap_8_1347 r0 *1 0,0
Xsg13cmos5l_decap_8_1347 \$2 \$1 sg13cmos5l_decap_8
* cell instance sg13cmos5l_decap_8_1348 r0 *1 0,0
Xsg13cmos5l_decap_8_1348 \$2 \$1 sg13cmos5l_decap_8
* cell instance sg13cmos5l_decap_8_1349 r0 *1 0,0
Xsg13cmos5l_decap_8_1349 \$2 \$1 sg13cmos5l_decap_8
* cell instance sg13cmos5l_decap_8_1350 r0 *1 0,0
Xsg13cmos5l_decap_8_1350 \$2 \$1 sg13cmos5l_decap_8
* cell instance sg13cmos5l_decap_8_1351 r0 *1 0,0
Xsg13cmos5l_decap_8_1351 \$2 \$1 sg13cmos5l_decap_8
* cell instance sg13cmos5l_decap_8_1352 r0 *1 0,0
Xsg13cmos5l_decap_8_1352 \$2 \$1 sg13cmos5l_decap_8
* cell instance sg13cmos5l_decap_8_1353 r0 *1 0,0
Xsg13cmos5l_decap_8_1353 \$2 \$1 sg13cmos5l_decap_8
* cell instance sg13cmos5l_decap_8_1354 r0 *1 0,0
Xsg13cmos5l_decap_8_1354 \$2 \$1 sg13cmos5l_decap_8
* cell instance sg13cmos5l_decap_8_1355 r0 *1 0,0
Xsg13cmos5l_decap_8_1355 \$2 \$1 sg13cmos5l_decap_8
* cell instance sg13cmos5l_decap_8_1356 r0 *1 0,0
Xsg13cmos5l_decap_8_1356 \$2 \$1 sg13cmos5l_decap_8
* cell instance sg13cmos5l_decap_8_1357 r0 *1 0,0
Xsg13cmos5l_decap_8_1357 \$2 \$1 sg13cmos5l_decap_8
* cell instance sg13cmos5l_decap_8_1358 r0 *1 0,0
Xsg13cmos5l_decap_8_1358 \$2 \$1 sg13cmos5l_decap_8
* cell instance sg13cmos5l_decap_8_1359 r0 *1 0,0
Xsg13cmos5l_decap_8_1359 \$2 \$1 sg13cmos5l_decap_8
* cell instance sg13cmos5l_decap_8_1360 r0 *1 0,0
Xsg13cmos5l_decap_8_1360 \$2 \$1 sg13cmos5l_decap_8
* cell instance sg13cmos5l_decap_8_1361 r0 *1 0,0
Xsg13cmos5l_decap_8_1361 \$2 \$1 sg13cmos5l_decap_8
* cell instance sg13cmos5l_decap_8_1362 r0 *1 0,0
Xsg13cmos5l_decap_8_1362 \$2 \$1 sg13cmos5l_decap_8
* cell instance sg13cmos5l_decap_8_1363 r0 *1 0,0
Xsg13cmos5l_decap_8_1363 \$2 \$1 sg13cmos5l_decap_8
* cell instance sg13cmos5l_decap_8_1364 r0 *1 0,0
Xsg13cmos5l_decap_8_1364 \$2 \$1 sg13cmos5l_decap_8
* cell instance sg13cmos5l_decap_8_1365 r0 *1 0,0
Xsg13cmos5l_decap_8_1365 \$2 \$1 sg13cmos5l_decap_8
* cell instance sg13cmos5l_decap_8_1366 r0 *1 0,0
Xsg13cmos5l_decap_8_1366 \$2 \$1 sg13cmos5l_decap_8
* cell instance sg13cmos5l_decap_8_1367 r0 *1 0,0
Xsg13cmos5l_decap_8_1367 \$2 \$1 sg13cmos5l_decap_8
* cell instance sg13cmos5l_decap_8_1368 r0 *1 0,0
Xsg13cmos5l_decap_8_1368 \$2 \$1 sg13cmos5l_decap_8
* cell instance sg13cmos5l_decap_8_1369 r0 *1 0,0
Xsg13cmos5l_decap_8_1369 \$2 \$1 sg13cmos5l_decap_8
* cell instance sg13cmos5l_decap_8_1370 r0 *1 0,0
Xsg13cmos5l_decap_8_1370 \$2 \$1 sg13cmos5l_decap_8
* cell instance sg13cmos5l_decap_8_1371 r0 *1 0,0
Xsg13cmos5l_decap_8_1371 \$2 \$1 sg13cmos5l_decap_8
* cell instance sg13cmos5l_decap_8_1372 r0 *1 0,0
Xsg13cmos5l_decap_8_1372 \$2 \$1 sg13cmos5l_decap_8
* cell instance sg13cmos5l_decap_8_1373 r0 *1 0,0
Xsg13cmos5l_decap_8_1373 \$2 \$1 sg13cmos5l_decap_8
* cell instance sg13cmos5l_decap_8_1374 r0 *1 0,0
Xsg13cmos5l_decap_8_1374 \$2 \$1 sg13cmos5l_decap_8
* cell instance sg13cmos5l_decap_8_1375 r0 *1 0,0
Xsg13cmos5l_decap_8_1375 \$2 \$1 sg13cmos5l_decap_8
* cell instance sg13cmos5l_decap_8_1376 r0 *1 0,0
Xsg13cmos5l_decap_8_1376 \$2 \$1 sg13cmos5l_decap_8
* cell instance sg13cmos5l_decap_8_1377 r0 *1 0,0
Xsg13cmos5l_decap_8_1377 \$2 \$1 sg13cmos5l_decap_8
* cell instance sg13cmos5l_decap_8_1378 r0 *1 0,0
Xsg13cmos5l_decap_8_1378 \$2 \$1 sg13cmos5l_decap_8
* cell instance sg13cmos5l_decap_8_1379 r0 *1 0,0
Xsg13cmos5l_decap_8_1379 \$2 \$1 sg13cmos5l_decap_8
* cell instance sg13cmos5l_decap_8_1380 r0 *1 0,0
Xsg13cmos5l_decap_8_1380 \$2 \$1 sg13cmos5l_decap_8
* cell instance sg13cmos5l_decap_8_1381 r0 *1 0,0
Xsg13cmos5l_decap_8_1381 \$2 \$1 sg13cmos5l_decap_8
* cell instance sg13cmos5l_decap_8_1382 r0 *1 0,0
Xsg13cmos5l_decap_8_1382 \$2 \$1 sg13cmos5l_decap_8
* cell instance sg13cmos5l_decap_8_1383 r0 *1 0,0
Xsg13cmos5l_decap_8_1383 \$2 \$1 sg13cmos5l_decap_8
* cell instance sg13cmos5l_decap_8_1384 r0 *1 0,0
Xsg13cmos5l_decap_8_1384 \$2 \$1 sg13cmos5l_decap_8
* cell instance sg13cmos5l_decap_8_1385 r0 *1 0,0
Xsg13cmos5l_decap_8_1385 \$2 \$1 sg13cmos5l_decap_8
* cell instance sg13cmos5l_decap_8_1386 r0 *1 0,0
Xsg13cmos5l_decap_8_1386 \$2 \$1 sg13cmos5l_decap_8
* cell instance sg13cmos5l_decap_8_1387 r0 *1 0,0
Xsg13cmos5l_decap_8_1387 \$2 \$1 sg13cmos5l_decap_8
* cell instance sg13cmos5l_decap_8_1388 r0 *1 0,0
Xsg13cmos5l_decap_8_1388 \$2 \$1 sg13cmos5l_decap_8
* cell instance sg13cmos5l_decap_8_1389 r0 *1 0,0
Xsg13cmos5l_decap_8_1389 \$2 \$1 sg13cmos5l_decap_8
* cell instance sg13cmos5l_decap_8_1390 r0 *1 0,0
Xsg13cmos5l_decap_8_1390 \$2 \$1 sg13cmos5l_decap_8
* cell instance sg13cmos5l_decap_8_1391 r0 *1 0,0
Xsg13cmos5l_decap_8_1391 \$2 \$1 sg13cmos5l_decap_8
* cell instance sg13cmos5l_decap_8_1392 r0 *1 0,0
Xsg13cmos5l_decap_8_1392 \$2 \$1 sg13cmos5l_decap_8
* cell instance sg13cmos5l_decap_8_1393 r0 *1 0,0
Xsg13cmos5l_decap_8_1393 \$2 \$1 sg13cmos5l_decap_8
* cell instance sg13cmos5l_decap_8_1394 r0 *1 0,0
Xsg13cmos5l_decap_8_1394 \$2 \$1 sg13cmos5l_decap_8
* cell instance sg13cmos5l_decap_8_1395 r0 *1 0,0
Xsg13cmos5l_decap_8_1395 \$2 \$1 sg13cmos5l_decap_8
* cell instance sg13cmos5l_decap_8_1396 r0 *1 0,0
Xsg13cmos5l_decap_8_1396 \$2 \$1 sg13cmos5l_decap_8
* cell instance sg13cmos5l_decap_8_1397 r0 *1 0,0
Xsg13cmos5l_decap_8_1397 \$2 \$1 sg13cmos5l_decap_8
* cell instance sg13cmos5l_decap_8_1398 r0 *1 0,0
Xsg13cmos5l_decap_8_1398 \$2 \$1 sg13cmos5l_decap_8
* cell instance sg13cmos5l_decap_8_1399 r0 *1 0,0
Xsg13cmos5l_decap_8_1399 \$2 \$1 sg13cmos5l_decap_8
* cell instance sg13cmos5l_decap_8_1400 r0 *1 0,0
Xsg13cmos5l_decap_8_1400 \$2 \$1 sg13cmos5l_decap_8
* cell instance sg13cmos5l_decap_8_1401 r0 *1 0,0
Xsg13cmos5l_decap_8_1401 \$2 \$1 sg13cmos5l_decap_8
* cell instance sg13cmos5l_decap_8_1402 r0 *1 0,0
Xsg13cmos5l_decap_8_1402 \$2 \$1 sg13cmos5l_decap_8
* cell instance sg13cmos5l_decap_8_1403 r0 *1 0,0
Xsg13cmos5l_decap_8_1403 \$2 \$1 sg13cmos5l_decap_8
* cell instance sg13cmos5l_decap_8_1404 r0 *1 0,0
Xsg13cmos5l_decap_8_1404 \$2 \$1 sg13cmos5l_decap_8
* cell instance sg13cmos5l_decap_8_1405 r0 *1 0,0
Xsg13cmos5l_decap_8_1405 \$2 \$1 sg13cmos5l_decap_8
* cell instance sg13cmos5l_decap_8_1406 r0 *1 0,0
Xsg13cmos5l_decap_8_1406 \$2 \$1 sg13cmos5l_decap_8
* cell instance sg13cmos5l_decap_8_1407 r0 *1 0,0
Xsg13cmos5l_decap_8_1407 \$2 \$1 sg13cmos5l_decap_8
* cell instance sg13cmos5l_decap_8_1408 r0 *1 0,0
Xsg13cmos5l_decap_8_1408 \$2 \$1 sg13cmos5l_decap_8
* cell instance sg13cmos5l_decap_8_1409 r0 *1 0,0
Xsg13cmos5l_decap_8_1409 \$2 \$1 sg13cmos5l_decap_8
* cell instance sg13cmos5l_decap_8_1410 r0 *1 0,0
Xsg13cmos5l_decap_8_1410 \$2 \$1 sg13cmos5l_decap_8
* cell instance sg13cmos5l_decap_8_1411 r0 *1 0,0
Xsg13cmos5l_decap_8_1411 \$2 \$1 sg13cmos5l_decap_8
* cell instance sg13cmos5l_decap_8_1412 r0 *1 0,0
Xsg13cmos5l_decap_8_1412 \$2 \$1 sg13cmos5l_decap_8
* cell instance sg13cmos5l_decap_8_1413 r0 *1 0,0
Xsg13cmos5l_decap_8_1413 \$2 \$1 sg13cmos5l_decap_8
* cell instance sg13cmos5l_decap_8_1414 r0 *1 0,0
Xsg13cmos5l_decap_8_1414 \$2 \$1 sg13cmos5l_decap_8
* cell instance sg13cmos5l_decap_8_1415 r0 *1 0,0
Xsg13cmos5l_decap_8_1415 \$2 \$1 sg13cmos5l_decap_8
* cell instance sg13cmos5l_decap_8_1416 r0 *1 0,0
Xsg13cmos5l_decap_8_1416 \$2 \$1 sg13cmos5l_decap_8
* cell instance sg13cmos5l_decap_8_1417 r0 *1 0,0
Xsg13cmos5l_decap_8_1417 \$2 \$1 sg13cmos5l_decap_8
* cell instance sg13cmos5l_decap_8_1418 r0 *1 0,0
Xsg13cmos5l_decap_8_1418 \$2 \$1 sg13cmos5l_decap_8
* cell instance sg13cmos5l_decap_8_1419 r0 *1 0,0
Xsg13cmos5l_decap_8_1419 \$2 \$1 sg13cmos5l_decap_8
* cell instance sg13cmos5l_decap_8_1420 r0 *1 0,0
Xsg13cmos5l_decap_8_1420 \$2 \$1 sg13cmos5l_decap_8
* cell instance sg13cmos5l_decap_8_1421 r0 *1 0,0
Xsg13cmos5l_decap_8_1421 \$2 \$1 sg13cmos5l_decap_8
* cell instance sg13cmos5l_decap_8_1422 r0 *1 0,0
Xsg13cmos5l_decap_8_1422 \$2 \$1 sg13cmos5l_decap_8
* cell instance sg13cmos5l_decap_8_1423 r0 *1 0,0
Xsg13cmos5l_decap_8_1423 \$2 \$1 sg13cmos5l_decap_8
* cell instance sg13cmos5l_decap_8_1424 r0 *1 0,0
Xsg13cmos5l_decap_8_1424 \$2 \$1 sg13cmos5l_decap_8
* cell instance sg13cmos5l_decap_8_1425 r0 *1 0,0
Xsg13cmos5l_decap_8_1425 \$2 \$1 sg13cmos5l_decap_8
* cell instance sg13cmos5l_decap_8_1426 r0 *1 0,0
Xsg13cmos5l_decap_8_1426 \$2 \$1 sg13cmos5l_decap_8
* cell instance sg13cmos5l_decap_8_1427 r0 *1 0,0
Xsg13cmos5l_decap_8_1427 \$2 \$1 sg13cmos5l_decap_8
* cell instance sg13cmos5l_decap_8_1428 r0 *1 0,0
Xsg13cmos5l_decap_8_1428 \$2 \$1 sg13cmos5l_decap_8
* cell instance sg13cmos5l_decap_8_1429 r0 *1 0,0
Xsg13cmos5l_decap_8_1429 \$2 \$1 sg13cmos5l_decap_8
* cell instance sg13cmos5l_decap_8_1430 r0 *1 0,0
Xsg13cmos5l_decap_8_1430 \$2 \$1 sg13cmos5l_decap_8
* cell instance sg13cmos5l_decap_8_1431 r0 *1 0,0
Xsg13cmos5l_decap_8_1431 \$2 \$1 sg13cmos5l_decap_8
* cell instance sg13cmos5l_decap_8_1432 r0 *1 0,0
Xsg13cmos5l_decap_8_1432 \$2 \$1 sg13cmos5l_decap_8
* cell instance sg13cmos5l_decap_8_1433 r0 *1 0,0
Xsg13cmos5l_decap_8_1433 \$2 \$1 sg13cmos5l_decap_8
* cell instance sg13cmos5l_decap_8_1434 r0 *1 0,0
Xsg13cmos5l_decap_8_1434 \$2 \$1 sg13cmos5l_decap_8
* cell instance sg13cmos5l_decap_8_1435 r0 *1 0,0
Xsg13cmos5l_decap_8_1435 \$2 \$1 sg13cmos5l_decap_8
* cell instance sg13cmos5l_decap_8_1436 r0 *1 0,0
Xsg13cmos5l_decap_8_1436 \$2 \$1 sg13cmos5l_decap_8
* cell instance sg13cmos5l_decap_8_1437 r0 *1 0,0
Xsg13cmos5l_decap_8_1437 \$2 \$1 sg13cmos5l_decap_8
* cell instance sg13cmos5l_decap_8_1438 r0 *1 0,0
Xsg13cmos5l_decap_8_1438 \$2 \$1 sg13cmos5l_decap_8
* cell instance sg13cmos5l_decap_8_1439 r0 *1 0,0
Xsg13cmos5l_decap_8_1439 \$2 \$1 sg13cmos5l_decap_8
* cell instance sg13cmos5l_decap_8_1440 r0 *1 0,0
Xsg13cmos5l_decap_8_1440 \$2 \$1 sg13cmos5l_decap_8
* cell instance sg13cmos5l_decap_8_1441 r0 *1 0,0
Xsg13cmos5l_decap_8_1441 \$2 \$1 sg13cmos5l_decap_8
* cell instance sg13cmos5l_decap_8_1442 r0 *1 0,0
Xsg13cmos5l_decap_8_1442 \$2 \$1 sg13cmos5l_decap_8
* cell instance sg13cmos5l_decap_8_1443 r0 *1 0,0
Xsg13cmos5l_decap_8_1443 \$2 \$1 sg13cmos5l_decap_8
* cell instance sg13cmos5l_decap_8_1444 r0 *1 0,0
Xsg13cmos5l_decap_8_1444 \$2 \$1 sg13cmos5l_decap_8
* cell instance sg13cmos5l_decap_8_1445 r0 *1 0,0
Xsg13cmos5l_decap_8_1445 \$2 \$1 sg13cmos5l_decap_8
* cell instance sg13cmos5l_decap_8_1446 r0 *1 0,0
Xsg13cmos5l_decap_8_1446 \$2 \$1 sg13cmos5l_decap_8
* cell instance sg13cmos5l_decap_8_1447 r0 *1 0,0
Xsg13cmos5l_decap_8_1447 \$2 \$1 sg13cmos5l_decap_8
* cell instance sg13cmos5l_decap_8_1448 r0 *1 0,0
Xsg13cmos5l_decap_8_1448 \$2 \$1 sg13cmos5l_decap_8
* cell instance sg13cmos5l_decap_8_1449 r0 *1 0,0
Xsg13cmos5l_decap_8_1449 \$2 \$1 sg13cmos5l_decap_8
* cell instance sg13cmos5l_decap_8_1450 r0 *1 0,0
Xsg13cmos5l_decap_8_1450 \$2 \$1 sg13cmos5l_decap_8
* cell instance sg13cmos5l_decap_8_1451 r0 *1 0,0
Xsg13cmos5l_decap_8_1451 \$2 \$1 sg13cmos5l_decap_8
* cell instance sg13cmos5l_decap_8_1452 r0 *1 0,0
Xsg13cmos5l_decap_8_1452 \$2 \$1 sg13cmos5l_decap_8
* cell instance sg13cmos5l_decap_8_1453 r0 *1 0,0
Xsg13cmos5l_decap_8_1453 \$2 \$1 sg13cmos5l_decap_8
* cell instance sg13cmos5l_decap_8_1454 r0 *1 0,0
Xsg13cmos5l_decap_8_1454 \$2 \$1 sg13cmos5l_decap_8
* cell instance sg13cmos5l_decap_8_1455 r0 *1 0,0
Xsg13cmos5l_decap_8_1455 \$2 \$1 sg13cmos5l_decap_8
* cell instance sg13cmos5l_decap_8_1456 r0 *1 0,0
Xsg13cmos5l_decap_8_1456 \$2 \$1 sg13cmos5l_decap_8
* cell instance sg13cmos5l_decap_8_1457 r0 *1 0,0
Xsg13cmos5l_decap_8_1457 \$2 \$1 sg13cmos5l_decap_8
* cell instance sg13cmos5l_decap_8_1458 r0 *1 0,0
Xsg13cmos5l_decap_8_1458 \$2 \$1 sg13cmos5l_decap_8
* cell instance sg13cmos5l_decap_8_1459 r0 *1 0,0
Xsg13cmos5l_decap_8_1459 \$2 \$1 sg13cmos5l_decap_8
* cell instance sg13cmos5l_decap_8_1460 r0 *1 0,0
Xsg13cmos5l_decap_8_1460 \$2 \$1 sg13cmos5l_decap_8
* cell instance sg13cmos5l_decap_8_1461 r0 *1 0,0
Xsg13cmos5l_decap_8_1461 \$2 \$1 sg13cmos5l_decap_8
* cell instance sg13cmos5l_decap_8_1462 r0 *1 0,0
Xsg13cmos5l_decap_8_1462 \$2 \$1 sg13cmos5l_decap_8
* cell instance sg13cmos5l_decap_8_1463 r0 *1 0,0
Xsg13cmos5l_decap_8_1463 \$2 \$1 sg13cmos5l_decap_8
* cell instance sg13cmos5l_decap_8_1464 r0 *1 0,0
Xsg13cmos5l_decap_8_1464 \$2 \$1 sg13cmos5l_decap_8
* cell instance sg13cmos5l_decap_8_1465 r0 *1 0,0
Xsg13cmos5l_decap_8_1465 \$2 \$1 sg13cmos5l_decap_8
* cell instance sg13cmos5l_decap_8_1466 r0 *1 0,0
Xsg13cmos5l_decap_8_1466 \$2 \$1 sg13cmos5l_decap_8
* cell instance sg13cmos5l_decap_8_1467 r0 *1 0,0
Xsg13cmos5l_decap_8_1467 \$2 \$1 sg13cmos5l_decap_8
* cell instance sg13cmos5l_decap_8_1468 r0 *1 0,0
Xsg13cmos5l_decap_8_1468 \$2 \$1 sg13cmos5l_decap_8
* cell instance sg13cmos5l_decap_8_1469 r0 *1 0,0
Xsg13cmos5l_decap_8_1469 \$2 \$1 sg13cmos5l_decap_8
* cell instance sg13cmos5l_decap_8_1470 r0 *1 0,0
Xsg13cmos5l_decap_8_1470 \$2 \$1 sg13cmos5l_decap_8
* cell instance sg13cmos5l_decap_8_1471 r0 *1 0,0
Xsg13cmos5l_decap_8_1471 \$2 \$1 sg13cmos5l_decap_8
* cell instance sg13cmos5l_decap_8_1472 r0 *1 0,0
Xsg13cmos5l_decap_8_1472 \$2 \$1 sg13cmos5l_decap_8
* cell instance sg13cmos5l_decap_8_1473 r0 *1 0,0
Xsg13cmos5l_decap_8_1473 \$2 \$1 sg13cmos5l_decap_8
* cell instance sg13cmos5l_decap_8_1474 r0 *1 0,0
Xsg13cmos5l_decap_8_1474 \$2 \$1 sg13cmos5l_decap_8
* cell instance sg13cmos5l_decap_8_1475 r0 *1 0,0
Xsg13cmos5l_decap_8_1475 \$2 \$1 sg13cmos5l_decap_8
* cell instance sg13cmos5l_decap_8_1476 r0 *1 0,0
Xsg13cmos5l_decap_8_1476 \$2 \$1 sg13cmos5l_decap_8
* cell instance sg13cmos5l_decap_8_1477 r0 *1 0,0
Xsg13cmos5l_decap_8_1477 \$2 \$1 sg13cmos5l_decap_8
* cell instance sg13cmos5l_decap_8_1478 r0 *1 0,0
Xsg13cmos5l_decap_8_1478 \$2 \$1 sg13cmos5l_decap_8
* cell instance sg13cmos5l_decap_8_1479 r0 *1 0,0
Xsg13cmos5l_decap_8_1479 \$2 \$1 sg13cmos5l_decap_8
* cell instance sg13cmos5l_decap_8_1480 r0 *1 0,0
Xsg13cmos5l_decap_8_1480 \$2 \$1 sg13cmos5l_decap_8
* cell instance sg13cmos5l_decap_8_1481 r0 *1 0,0
Xsg13cmos5l_decap_8_1481 \$2 \$1 sg13cmos5l_decap_8
* cell instance sg13cmos5l_decap_8_1482 r0 *1 0,0
Xsg13cmos5l_decap_8_1482 \$2 \$1 sg13cmos5l_decap_8
* cell instance sg13cmos5l_decap_8_1483 r0 *1 0,0
Xsg13cmos5l_decap_8_1483 \$2 \$1 sg13cmos5l_decap_8
* cell instance sg13cmos5l_decap_8_1484 r0 *1 0,0
Xsg13cmos5l_decap_8_1484 \$2 \$1 sg13cmos5l_decap_8
* cell instance sg13cmos5l_decap_8_1485 r0 *1 0,0
Xsg13cmos5l_decap_8_1485 \$2 \$1 sg13cmos5l_decap_8
* cell instance sg13cmos5l_decap_8_1486 r0 *1 0,0
Xsg13cmos5l_decap_8_1486 \$2 \$1 sg13cmos5l_decap_8
* cell instance sg13cmos5l_decap_8_1487 r0 *1 0,0
Xsg13cmos5l_decap_8_1487 \$2 \$1 sg13cmos5l_decap_8
* cell instance sg13cmos5l_decap_8_1488 r0 *1 0,0
Xsg13cmos5l_decap_8_1488 \$2 \$1 sg13cmos5l_decap_8
* cell instance sg13cmos5l_decap_8_1489 r0 *1 0,0
Xsg13cmos5l_decap_8_1489 \$2 \$1 sg13cmos5l_decap_8
* cell instance sg13cmos5l_decap_8_1490 r0 *1 0,0
Xsg13cmos5l_decap_8_1490 \$2 \$1 sg13cmos5l_decap_8
* cell instance sg13cmos5l_decap_8_1491 r0 *1 0,0
Xsg13cmos5l_decap_8_1491 \$2 \$1 sg13cmos5l_decap_8
* cell instance sg13cmos5l_decap_8_1492 r0 *1 0,0
Xsg13cmos5l_decap_8_1492 \$2 \$1 sg13cmos5l_decap_8
* cell instance sg13cmos5l_decap_8_1493 r0 *1 0,0
Xsg13cmos5l_decap_8_1493 \$2 \$1 sg13cmos5l_decap_8
* cell instance sg13cmos5l_decap_8_1494 r0 *1 0,0
Xsg13cmos5l_decap_8_1494 \$2 \$1 sg13cmos5l_decap_8
* cell instance sg13cmos5l_decap_8_1495 r0 *1 0,0
Xsg13cmos5l_decap_8_1495 \$2 \$1 sg13cmos5l_decap_8
* cell instance sg13cmos5l_decap_8_1496 r0 *1 0,0
Xsg13cmos5l_decap_8_1496 \$2 \$1 sg13cmos5l_decap_8
* cell instance sg13cmos5l_decap_8_1497 r0 *1 0,0
Xsg13cmos5l_decap_8_1497 \$2 \$1 sg13cmos5l_decap_8
* cell instance sg13cmos5l_decap_8_1498 r0 *1 0,0
Xsg13cmos5l_decap_8_1498 \$2 \$1 sg13cmos5l_decap_8
* cell instance sg13cmos5l_decap_8_1499 r0 *1 0,0
Xsg13cmos5l_decap_8_1499 \$2 \$1 sg13cmos5l_decap_8
* cell instance sg13cmos5l_decap_8_1500 r0 *1 0,0
Xsg13cmos5l_decap_8_1500 \$2 \$1 sg13cmos5l_decap_8
* cell instance sg13cmos5l_decap_8_1501 r0 *1 0,0
Xsg13cmos5l_decap_8_1501 \$2 \$1 sg13cmos5l_decap_8
* cell instance sg13cmos5l_decap_8_1502 r0 *1 0,0
Xsg13cmos5l_decap_8_1502 \$2 \$1 sg13cmos5l_decap_8
* cell instance sg13cmos5l_decap_8_1503 r0 *1 0,0
Xsg13cmos5l_decap_8_1503 \$2 \$1 sg13cmos5l_decap_8
* cell instance sg13cmos5l_decap_8_1504 r0 *1 0,0
Xsg13cmos5l_decap_8_1504 \$2 \$1 sg13cmos5l_decap_8
* cell instance sg13cmos5l_decap_8_1505 r0 *1 0,0
Xsg13cmos5l_decap_8_1505 \$2 \$1 sg13cmos5l_decap_8
* cell instance sg13cmos5l_decap_8_1506 r0 *1 0,0
Xsg13cmos5l_decap_8_1506 \$2 \$1 sg13cmos5l_decap_8
* cell instance sg13cmos5l_decap_8_1507 r0 *1 0,0
Xsg13cmos5l_decap_8_1507 \$2 \$1 sg13cmos5l_decap_8
* cell instance sg13cmos5l_decap_8_1508 r0 *1 0,0
Xsg13cmos5l_decap_8_1508 \$2 \$1 sg13cmos5l_decap_8
* cell instance sg13cmos5l_decap_8_1509 r0 *1 0,0
Xsg13cmos5l_decap_8_1509 \$2 \$1 sg13cmos5l_decap_8
* cell instance sg13cmos5l_decap_8_1510 r0 *1 0,0
Xsg13cmos5l_decap_8_1510 \$2 \$1 sg13cmos5l_decap_8
* cell instance sg13cmos5l_decap_8_1511 r0 *1 0,0
Xsg13cmos5l_decap_8_1511 \$2 \$1 sg13cmos5l_decap_8
* cell instance sg13cmos5l_decap_8_1512 r0 *1 0,0
Xsg13cmos5l_decap_8_1512 \$2 \$1 sg13cmos5l_decap_8
* cell instance sg13cmos5l_decap_8_1513 r0 *1 0,0
Xsg13cmos5l_decap_8_1513 \$2 \$1 sg13cmos5l_decap_8
* cell instance sg13cmos5l_decap_8_1514 r0 *1 0,0
Xsg13cmos5l_decap_8_1514 \$2 \$1 sg13cmos5l_decap_8
* cell instance sg13cmos5l_decap_8_1515 r0 *1 0,0
Xsg13cmos5l_decap_8_1515 \$2 \$1 sg13cmos5l_decap_8
* cell instance sg13cmos5l_decap_8_1516 r0 *1 0,0
Xsg13cmos5l_decap_8_1516 \$2 \$1 sg13cmos5l_decap_8
* cell instance sg13cmos5l_decap_8_1517 r0 *1 0,0
Xsg13cmos5l_decap_8_1517 \$2 \$1 sg13cmos5l_decap_8
* cell instance sg13cmos5l_decap_8_1518 r0 *1 0,0
Xsg13cmos5l_decap_8_1518 \$2 \$1 sg13cmos5l_decap_8
* cell instance sg13cmos5l_decap_8_1519 r0 *1 0,0
Xsg13cmos5l_decap_8_1519 \$2 \$1 sg13cmos5l_decap_8
* cell instance sg13cmos5l_decap_8_1520 r0 *1 0,0
Xsg13cmos5l_decap_8_1520 \$2 \$1 sg13cmos5l_decap_8
* cell instance sg13cmos5l_decap_8_1521 r0 *1 0,0
Xsg13cmos5l_decap_8_1521 \$2 \$1 sg13cmos5l_decap_8
* cell instance sg13cmos5l_decap_8_1522 r0 *1 0,0
Xsg13cmos5l_decap_8_1522 \$2 \$1 sg13cmos5l_decap_8
* cell instance sg13cmos5l_decap_8_1523 r0 *1 0,0
Xsg13cmos5l_decap_8_1523 \$2 \$1 sg13cmos5l_decap_8
* cell instance sg13cmos5l_decap_8_1524 r0 *1 0,0
Xsg13cmos5l_decap_8_1524 \$2 \$1 sg13cmos5l_decap_8
* cell instance sg13cmos5l_decap_8_1525 r0 *1 0,0
Xsg13cmos5l_decap_8_1525 \$2 \$1 sg13cmos5l_decap_8
* cell instance sg13cmos5l_decap_8_1526 r0 *1 0,0
Xsg13cmos5l_decap_8_1526 \$2 \$1 sg13cmos5l_decap_8
* cell instance sg13cmos5l_decap_8_1527 r0 *1 0,0
Xsg13cmos5l_decap_8_1527 \$2 \$1 sg13cmos5l_decap_8
* cell instance sg13cmos5l_decap_8_1528 r0 *1 0,0
Xsg13cmos5l_decap_8_1528 \$2 \$1 sg13cmos5l_decap_8
* cell instance sg13cmos5l_decap_8_1529 r0 *1 0,0
Xsg13cmos5l_decap_8_1529 \$2 \$1 sg13cmos5l_decap_8
* cell instance sg13cmos5l_decap_8_1530 r0 *1 0,0
Xsg13cmos5l_decap_8_1530 \$2 \$1 sg13cmos5l_decap_8
* cell instance sg13cmos5l_decap_8_1531 r0 *1 0,0
Xsg13cmos5l_decap_8_1531 \$2 \$1 sg13cmos5l_decap_8
* cell instance sg13cmos5l_decap_8_1532 r0 *1 0,0
Xsg13cmos5l_decap_8_1532 \$2 \$1 sg13cmos5l_decap_8
* cell instance sg13cmos5l_decap_8_1533 r0 *1 0,0
Xsg13cmos5l_decap_8_1533 \$2 \$1 sg13cmos5l_decap_8
* cell instance sg13cmos5l_decap_8_1534 r0 *1 0,0
Xsg13cmos5l_decap_8_1534 \$2 \$1 sg13cmos5l_decap_8
* cell instance sg13cmos5l_decap_8_1535 r0 *1 0,0
Xsg13cmos5l_decap_8_1535 \$2 \$1 sg13cmos5l_decap_8
* cell instance sg13cmos5l_decap_8_1536 r0 *1 0,0
Xsg13cmos5l_decap_8_1536 \$2 \$1 sg13cmos5l_decap_8
* cell instance sg13cmos5l_decap_8_1537 r0 *1 0,0
Xsg13cmos5l_decap_8_1537 \$2 \$1 sg13cmos5l_decap_8
* cell instance sg13cmos5l_decap_8_1538 r0 *1 0,0
Xsg13cmos5l_decap_8_1538 \$2 \$1 sg13cmos5l_decap_8
* cell instance sg13cmos5l_decap_8_1539 r0 *1 0,0
Xsg13cmos5l_decap_8_1539 \$2 \$1 sg13cmos5l_decap_8
* cell instance sg13cmos5l_decap_8_1540 r0 *1 0,0
Xsg13cmos5l_decap_8_1540 \$2 \$1 sg13cmos5l_decap_8
* cell instance sg13cmos5l_decap_8_1541 r0 *1 0,0
Xsg13cmos5l_decap_8_1541 \$2 \$1 sg13cmos5l_decap_8
* cell instance sg13cmos5l_decap_8_1542 r0 *1 0,0
Xsg13cmos5l_decap_8_1542 \$2 \$1 sg13cmos5l_decap_8
* cell instance sg13cmos5l_decap_8_1543 r0 *1 0,0
Xsg13cmos5l_decap_8_1543 \$2 \$1 sg13cmos5l_decap_8
* cell instance sg13cmos5l_decap_8_1544 r0 *1 0,0
Xsg13cmos5l_decap_8_1544 \$2 \$1 sg13cmos5l_decap_8
* cell instance sg13cmos5l_decap_8_1545 r0 *1 0,0
Xsg13cmos5l_decap_8_1545 \$2 \$1 sg13cmos5l_decap_8
* cell instance sg13cmos5l_decap_8_1546 r0 *1 0,0
Xsg13cmos5l_decap_8_1546 \$2 \$1 sg13cmos5l_decap_8
* cell instance sg13cmos5l_decap_8_1547 r0 *1 0,0
Xsg13cmos5l_decap_8_1547 \$2 \$1 sg13cmos5l_decap_8
* cell instance sg13cmos5l_decap_8_1548 r0 *1 0,0
Xsg13cmos5l_decap_8_1548 \$2 \$1 sg13cmos5l_decap_8
* cell instance sg13cmos5l_decap_8_1549 r0 *1 0,0
Xsg13cmos5l_decap_8_1549 \$2 \$1 sg13cmos5l_decap_8
* cell instance sg13cmos5l_decap_8_1550 r0 *1 0,0
Xsg13cmos5l_decap_8_1550 \$2 \$1 sg13cmos5l_decap_8
* cell instance sg13cmos5l_decap_8_1551 r0 *1 0,0
Xsg13cmos5l_decap_8_1551 \$2 \$1 sg13cmos5l_decap_8
* cell instance sg13cmos5l_decap_8_1552 r0 *1 0,0
Xsg13cmos5l_decap_8_1552 \$2 \$1 sg13cmos5l_decap_8
* cell instance sg13cmos5l_decap_8_1553 r0 *1 0,0
Xsg13cmos5l_decap_8_1553 \$2 \$1 sg13cmos5l_decap_8
* cell instance sg13cmos5l_decap_8_1554 r0 *1 0,0
Xsg13cmos5l_decap_8_1554 \$2 \$1 sg13cmos5l_decap_8
* cell instance sg13cmos5l_decap_8_1555 r0 *1 0,0
Xsg13cmos5l_decap_8_1555 \$2 \$1 sg13cmos5l_decap_8
* cell instance sg13cmos5l_decap_8_1556 r0 *1 0,0
Xsg13cmos5l_decap_8_1556 \$2 \$1 sg13cmos5l_decap_8
* cell instance sg13cmos5l_decap_8_1557 r0 *1 0,0
Xsg13cmos5l_decap_8_1557 \$2 \$1 sg13cmos5l_decap_8
* cell instance sg13cmos5l_decap_8_1558 r0 *1 0,0
Xsg13cmos5l_decap_8_1558 \$2 \$1 sg13cmos5l_decap_8
* cell instance sg13cmos5l_decap_8_1559 r0 *1 0,0
Xsg13cmos5l_decap_8_1559 \$2 \$1 sg13cmos5l_decap_8
* cell instance sg13cmos5l_decap_8_1560 r0 *1 0,0
Xsg13cmos5l_decap_8_1560 \$2 \$1 sg13cmos5l_decap_8
* cell instance sg13cmos5l_decap_8_1561 r0 *1 0,0
Xsg13cmos5l_decap_8_1561 \$2 \$1 sg13cmos5l_decap_8
* cell instance sg13cmos5l_decap_8_1562 r0 *1 0,0
Xsg13cmos5l_decap_8_1562 \$2 \$1 sg13cmos5l_decap_8
* cell instance sg13cmos5l_decap_8_1563 r0 *1 0,0
Xsg13cmos5l_decap_8_1563 \$2 \$1 sg13cmos5l_decap_8
* cell instance sg13cmos5l_decap_8_1564 r0 *1 0,0
Xsg13cmos5l_decap_8_1564 \$2 \$1 sg13cmos5l_decap_8
* cell instance sg13cmos5l_decap_8_1565 r0 *1 0,0
Xsg13cmos5l_decap_8_1565 \$2 \$1 sg13cmos5l_decap_8
* cell instance sg13cmos5l_decap_8_1566 r0 *1 0,0
Xsg13cmos5l_decap_8_1566 \$2 \$1 sg13cmos5l_decap_8
* cell instance sg13cmos5l_decap_8_1567 r0 *1 0,0
Xsg13cmos5l_decap_8_1567 \$2 \$1 sg13cmos5l_decap_8
* cell instance sg13cmos5l_decap_8_1568 r0 *1 0,0
Xsg13cmos5l_decap_8_1568 \$2 \$1 sg13cmos5l_decap_8
* cell instance sg13cmos5l_decap_8_1569 r0 *1 0,0
Xsg13cmos5l_decap_8_1569 \$2 \$1 sg13cmos5l_decap_8
* cell instance sg13cmos5l_decap_8_1570 r0 *1 0,0
Xsg13cmos5l_decap_8_1570 \$2 \$1 sg13cmos5l_decap_8
* cell instance sg13cmos5l_decap_8_1571 r0 *1 0,0
Xsg13cmos5l_decap_8_1571 \$2 \$1 sg13cmos5l_decap_8
* cell instance sg13cmos5l_decap_8_1572 r0 *1 0,0
Xsg13cmos5l_decap_8_1572 \$2 \$1 sg13cmos5l_decap_8
* cell instance sg13cmos5l_decap_8_1573 r0 *1 0,0
Xsg13cmos5l_decap_8_1573 \$2 \$1 sg13cmos5l_decap_8
* cell instance sg13cmos5l_decap_8_1574 r0 *1 0,0
Xsg13cmos5l_decap_8_1574 \$2 \$1 sg13cmos5l_decap_8
* cell instance sg13cmos5l_decap_8_1575 r0 *1 0,0
Xsg13cmos5l_decap_8_1575 \$2 \$1 sg13cmos5l_decap_8
* cell instance sg13cmos5l_decap_8_1576 r0 *1 0,0
Xsg13cmos5l_decap_8_1576 \$2 \$1 sg13cmos5l_decap_8
* cell instance sg13cmos5l_decap_8_1577 r0 *1 0,0
Xsg13cmos5l_decap_8_1577 \$2 \$1 sg13cmos5l_decap_8
* cell instance sg13cmos5l_decap_8_1578 r0 *1 0,0
Xsg13cmos5l_decap_8_1578 \$2 \$1 sg13cmos5l_decap_8
* cell instance sg13cmos5l_decap_8_1579 r0 *1 0,0
Xsg13cmos5l_decap_8_1579 \$2 \$1 sg13cmos5l_decap_8
* cell instance sg13cmos5l_decap_8_1580 r0 *1 0,0
Xsg13cmos5l_decap_8_1580 \$2 \$1 sg13cmos5l_decap_8
* cell instance sg13cmos5l_decap_8_1581 r0 *1 0,0
Xsg13cmos5l_decap_8_1581 \$2 \$1 sg13cmos5l_decap_8
* cell instance sg13cmos5l_decap_8_1582 r0 *1 0,0
Xsg13cmos5l_decap_8_1582 \$2 \$1 sg13cmos5l_decap_8
* cell instance sg13cmos5l_decap_8_1583 r0 *1 0,0
Xsg13cmos5l_decap_8_1583 \$2 \$1 sg13cmos5l_decap_8
* cell instance sg13cmos5l_decap_8_1584 r0 *1 0,0
Xsg13cmos5l_decap_8_1584 \$2 \$1 sg13cmos5l_decap_8
* cell instance sg13cmos5l_decap_8_1585 r0 *1 0,0
Xsg13cmos5l_decap_8_1585 \$2 \$1 sg13cmos5l_decap_8
* cell instance sg13cmos5l_decap_8_1586 r0 *1 0,0
Xsg13cmos5l_decap_8_1586 \$2 \$1 sg13cmos5l_decap_8
* cell instance sg13cmos5l_decap_8_1587 r0 *1 0,0
Xsg13cmos5l_decap_8_1587 \$2 \$1 sg13cmos5l_decap_8
* cell instance sg13cmos5l_decap_8_1588 r0 *1 0,0
Xsg13cmos5l_decap_8_1588 \$2 \$1 sg13cmos5l_decap_8
* cell instance sg13cmos5l_decap_8_1589 r0 *1 0,0
Xsg13cmos5l_decap_8_1589 \$2 \$1 sg13cmos5l_decap_8
* cell instance sg13cmos5l_decap_8_1590 r0 *1 0,0
Xsg13cmos5l_decap_8_1590 \$2 \$1 sg13cmos5l_decap_8
* cell instance sg13cmos5l_decap_8_1591 r0 *1 0,0
Xsg13cmos5l_decap_8_1591 \$2 \$1 sg13cmos5l_decap_8
* cell instance sg13cmos5l_decap_8_1592 r0 *1 0,0
Xsg13cmos5l_decap_8_1592 \$2 \$1 sg13cmos5l_decap_8
* cell instance sg13cmos5l_decap_8_1593 r0 *1 0,0
Xsg13cmos5l_decap_8_1593 \$2 \$1 sg13cmos5l_decap_8
* cell instance sg13cmos5l_decap_8_1594 r0 *1 0,0
Xsg13cmos5l_decap_8_1594 \$2 \$1 sg13cmos5l_decap_8
* cell instance sg13cmos5l_decap_8_1595 r0 *1 0,0
Xsg13cmos5l_decap_8_1595 \$2 \$1 sg13cmos5l_decap_8
* cell instance sg13cmos5l_decap_8_1596 r0 *1 0,0
Xsg13cmos5l_decap_8_1596 \$2 \$1 sg13cmos5l_decap_8
* cell instance sg13cmos5l_decap_8_1597 r0 *1 0,0
Xsg13cmos5l_decap_8_1597 \$2 \$1 sg13cmos5l_decap_8
* cell instance sg13cmos5l_decap_8_1598 r0 *1 0,0
Xsg13cmos5l_decap_8_1598 \$2 \$1 sg13cmos5l_decap_8
* cell instance sg13cmos5l_decap_8_1599 r0 *1 0,0
Xsg13cmos5l_decap_8_1599 \$2 \$1 sg13cmos5l_decap_8
* cell instance sg13cmos5l_decap_8_1600 r0 *1 0,0
Xsg13cmos5l_decap_8_1600 \$2 \$1 sg13cmos5l_decap_8
* cell instance sg13cmos5l_decap_8_1601 r0 *1 0,0
Xsg13cmos5l_decap_8_1601 \$2 \$1 sg13cmos5l_decap_8
* cell instance sg13cmos5l_decap_8_1602 r0 *1 0,0
Xsg13cmos5l_decap_8_1602 \$2 \$1 sg13cmos5l_decap_8
* cell instance sg13cmos5l_decap_8_1603 r0 *1 0,0
Xsg13cmos5l_decap_8_1603 \$2 \$1 sg13cmos5l_decap_8
* cell instance sg13cmos5l_decap_8_1604 r0 *1 0,0
Xsg13cmos5l_decap_8_1604 \$2 \$1 sg13cmos5l_decap_8
* cell instance sg13cmos5l_decap_8_1605 r0 *1 0,0
Xsg13cmos5l_decap_8_1605 \$2 \$1 sg13cmos5l_decap_8
* cell instance sg13cmos5l_decap_8_1606 r0 *1 0,0
Xsg13cmos5l_decap_8_1606 \$2 \$1 sg13cmos5l_decap_8
* cell instance sg13cmos5l_decap_8_1607 r0 *1 0,0
Xsg13cmos5l_decap_8_1607 \$2 \$1 sg13cmos5l_decap_8
* cell instance sg13cmos5l_decap_8_1608 r0 *1 0,0
Xsg13cmos5l_decap_8_1608 \$2 \$1 sg13cmos5l_decap_8
* cell instance sg13cmos5l_decap_8_1609 r0 *1 0,0
Xsg13cmos5l_decap_8_1609 \$2 \$1 sg13cmos5l_decap_8
* cell instance sg13cmos5l_decap_8_1610 r0 *1 0,0
Xsg13cmos5l_decap_8_1610 \$2 \$1 sg13cmos5l_decap_8
* cell instance sg13cmos5l_decap_8_1611 r0 *1 0,0
Xsg13cmos5l_decap_8_1611 \$2 \$1 sg13cmos5l_decap_8
* cell instance sg13cmos5l_decap_8_1612 r0 *1 0,0
Xsg13cmos5l_decap_8_1612 \$2 \$1 sg13cmos5l_decap_8
* cell instance sg13cmos5l_decap_8_1613 r0 *1 0,0
Xsg13cmos5l_decap_8_1613 \$2 \$1 sg13cmos5l_decap_8
* cell instance sg13cmos5l_decap_8_1614 r0 *1 0,0
Xsg13cmos5l_decap_8_1614 \$2 \$1 sg13cmos5l_decap_8
* cell instance sg13cmos5l_decap_8_1615 r0 *1 0,0
Xsg13cmos5l_decap_8_1615 \$2 \$1 sg13cmos5l_decap_8
* cell instance sg13cmos5l_decap_8_1616 r0 *1 0,0
Xsg13cmos5l_decap_8_1616 \$2 \$1 sg13cmos5l_decap_8
* cell instance sg13cmos5l_decap_8_1617 r0 *1 0,0
Xsg13cmos5l_decap_8_1617 \$2 \$1 sg13cmos5l_decap_8
* cell instance sg13cmos5l_decap_8_1618 r0 *1 0,0
Xsg13cmos5l_decap_8_1618 \$2 \$1 sg13cmos5l_decap_8
* cell instance sg13cmos5l_decap_8_1619 r0 *1 0,0
Xsg13cmos5l_decap_8_1619 \$2 \$1 sg13cmos5l_decap_8
* cell instance sg13cmos5l_decap_8_1620 r0 *1 0,0
Xsg13cmos5l_decap_8_1620 \$2 \$1 sg13cmos5l_decap_8
* cell instance sg13cmos5l_decap_8_1621 r0 *1 0,0
Xsg13cmos5l_decap_8_1621 \$2 \$1 sg13cmos5l_decap_8
* cell instance sg13cmos5l_decap_8_1622 r0 *1 0,0
Xsg13cmos5l_decap_8_1622 \$2 \$1 sg13cmos5l_decap_8
* cell instance sg13cmos5l_decap_8_1623 r0 *1 0,0
Xsg13cmos5l_decap_8_1623 \$2 \$1 sg13cmos5l_decap_8
* cell instance sg13cmos5l_decap_8_1624 r0 *1 0,0
Xsg13cmos5l_decap_8_1624 \$2 \$1 sg13cmos5l_decap_8
* cell instance sg13cmos5l_decap_8_1625 r0 *1 0,0
Xsg13cmos5l_decap_8_1625 \$2 \$1 sg13cmos5l_decap_8
* cell instance sg13cmos5l_decap_8_1626 r0 *1 0,0
Xsg13cmos5l_decap_8_1626 \$2 \$1 sg13cmos5l_decap_8
* cell instance sg13cmos5l_decap_8_1627 r0 *1 0,0
Xsg13cmos5l_decap_8_1627 \$2 \$1 sg13cmos5l_decap_8
* cell instance sg13cmos5l_decap_8_1628 r0 *1 0,0
Xsg13cmos5l_decap_8_1628 \$2 \$1 sg13cmos5l_decap_8
* cell instance sg13cmos5l_decap_8_1629 r0 *1 0,0
Xsg13cmos5l_decap_8_1629 \$2 \$1 sg13cmos5l_decap_8
* cell instance sg13cmos5l_decap_8_1630 r0 *1 0,0
Xsg13cmos5l_decap_8_1630 \$2 \$1 sg13cmos5l_decap_8
* cell instance sg13cmos5l_decap_8_1631 r0 *1 0,0
Xsg13cmos5l_decap_8_1631 \$2 \$1 sg13cmos5l_decap_8
* cell instance sg13cmos5l_decap_8_1632 r0 *1 0,0
Xsg13cmos5l_decap_8_1632 \$2 \$1 sg13cmos5l_decap_8
* cell instance sg13cmos5l_decap_8_1633 r0 *1 0,0
Xsg13cmos5l_decap_8_1633 \$2 \$1 sg13cmos5l_decap_8
* cell instance sg13cmos5l_decap_8_1634 r0 *1 0,0
Xsg13cmos5l_decap_8_1634 \$2 \$1 sg13cmos5l_decap_8
* cell instance sg13cmos5l_decap_8_1635 r0 *1 0,0
Xsg13cmos5l_decap_8_1635 \$2 \$1 sg13cmos5l_decap_8
* cell instance sg13cmos5l_decap_8_1636 r0 *1 0,0
Xsg13cmos5l_decap_8_1636 \$2 \$1 sg13cmos5l_decap_8
* cell instance sg13cmos5l_decap_8_1637 r0 *1 0,0
Xsg13cmos5l_decap_8_1637 \$2 \$1 sg13cmos5l_decap_8
* cell instance sg13cmos5l_decap_8_1638 r0 *1 0,0
Xsg13cmos5l_decap_8_1638 \$2 \$1 sg13cmos5l_decap_8
* cell instance sg13cmos5l_decap_8_1639 r0 *1 0,0
Xsg13cmos5l_decap_8_1639 \$2 \$1 sg13cmos5l_decap_8
* cell instance sg13cmos5l_decap_8_1640 r0 *1 0,0
Xsg13cmos5l_decap_8_1640 \$2 \$1 sg13cmos5l_decap_8
* cell instance sg13cmos5l_decap_8_1641 r0 *1 0,0
Xsg13cmos5l_decap_8_1641 \$2 \$1 sg13cmos5l_decap_8
* cell instance sg13cmos5l_decap_8_1642 r0 *1 0,0
Xsg13cmos5l_decap_8_1642 \$2 \$1 sg13cmos5l_decap_8
* cell instance sg13cmos5l_decap_8_1643 r0 *1 0,0
Xsg13cmos5l_decap_8_1643 \$2 \$1 sg13cmos5l_decap_8
* cell instance sg13cmos5l_decap_8_1644 r0 *1 0,0
Xsg13cmos5l_decap_8_1644 \$2 \$1 sg13cmos5l_decap_8
* cell instance sg13cmos5l_decap_8_1645 r0 *1 0,0
Xsg13cmos5l_decap_8_1645 \$2 \$1 sg13cmos5l_decap_8
* cell instance sg13cmos5l_decap_8_1646 r0 *1 0,0
Xsg13cmos5l_decap_8_1646 \$2 \$1 sg13cmos5l_decap_8
* cell instance sg13cmos5l_decap_8_1647 r0 *1 0,0
Xsg13cmos5l_decap_8_1647 \$2 \$1 sg13cmos5l_decap_8
* cell instance sg13cmos5l_decap_8_1648 r0 *1 0,0
Xsg13cmos5l_decap_8_1648 \$2 \$1 sg13cmos5l_decap_8
* cell instance sg13cmos5l_decap_8_1649 r0 *1 0,0
Xsg13cmos5l_decap_8_1649 \$2 \$1 sg13cmos5l_decap_8
* cell instance sg13cmos5l_decap_8_1650 r0 *1 0,0
Xsg13cmos5l_decap_8_1650 \$2 \$1 sg13cmos5l_decap_8
* cell instance sg13cmos5l_decap_8_1651 r0 *1 0,0
Xsg13cmos5l_decap_8_1651 \$2 \$1 sg13cmos5l_decap_8
* cell instance sg13cmos5l_decap_8_1652 r0 *1 0,0
Xsg13cmos5l_decap_8_1652 \$2 \$1 sg13cmos5l_decap_8
* cell instance sg13cmos5l_decap_8_1653 r0 *1 0,0
Xsg13cmos5l_decap_8_1653 \$2 \$1 sg13cmos5l_decap_8
* cell instance sg13cmos5l_decap_8_1654 r0 *1 0,0
Xsg13cmos5l_decap_8_1654 \$2 \$1 sg13cmos5l_decap_8
* cell instance sg13cmos5l_decap_8_1655 r0 *1 0,0
Xsg13cmos5l_decap_8_1655 \$2 \$1 sg13cmos5l_decap_8
* cell instance sg13cmos5l_decap_8_1656 r0 *1 0,0
Xsg13cmos5l_decap_8_1656 \$2 \$1 sg13cmos5l_decap_8
* cell instance sg13cmos5l_decap_8_1657 r0 *1 0,0
Xsg13cmos5l_decap_8_1657 \$2 \$1 sg13cmos5l_decap_8
* cell instance sg13cmos5l_decap_8_1658 r0 *1 0,0
Xsg13cmos5l_decap_8_1658 \$2 \$1 sg13cmos5l_decap_8
* cell instance sg13cmos5l_decap_8_1659 r0 *1 0,0
Xsg13cmos5l_decap_8_1659 \$2 \$1 sg13cmos5l_decap_8
* cell instance sg13cmos5l_decap_8_1660 r0 *1 0,0
Xsg13cmos5l_decap_8_1660 \$2 \$1 sg13cmos5l_decap_8
* cell instance sg13cmos5l_decap_8_1661 r0 *1 0,0
Xsg13cmos5l_decap_8_1661 \$2 \$1 sg13cmos5l_decap_8
* cell instance sg13cmos5l_decap_8_1662 r0 *1 0,0
Xsg13cmos5l_decap_8_1662 \$2 \$1 sg13cmos5l_decap_8
* cell instance sg13cmos5l_decap_8_1663 r0 *1 0,0
Xsg13cmos5l_decap_8_1663 \$2 \$1 sg13cmos5l_decap_8
* cell instance sg13cmos5l_decap_8_1664 r0 *1 0,0
Xsg13cmos5l_decap_8_1664 \$2 \$1 sg13cmos5l_decap_8
* cell instance sg13cmos5l_decap_8_1665 r0 *1 0,0
Xsg13cmos5l_decap_8_1665 \$2 \$1 sg13cmos5l_decap_8
* cell instance sg13cmos5l_decap_8_1666 r0 *1 0,0
Xsg13cmos5l_decap_8_1666 \$2 \$1 sg13cmos5l_decap_8
* cell instance sg13cmos5l_decap_8_1667 r0 *1 0,0
Xsg13cmos5l_decap_8_1667 \$2 \$1 sg13cmos5l_decap_8
* cell instance sg13cmos5l_decap_8_1668 r0 *1 0,0
Xsg13cmos5l_decap_8_1668 \$2 \$1 sg13cmos5l_decap_8
* cell instance sg13cmos5l_decap_8_1669 r0 *1 0,0
Xsg13cmos5l_decap_8_1669 \$2 \$1 sg13cmos5l_decap_8
* cell instance sg13cmos5l_decap_8_1670 r0 *1 0,0
Xsg13cmos5l_decap_8_1670 \$2 \$1 sg13cmos5l_decap_8
* cell instance sg13cmos5l_decap_8_1671 r0 *1 0,0
Xsg13cmos5l_decap_8_1671 \$2 \$1 sg13cmos5l_decap_8
* cell instance sg13cmos5l_decap_8_1672 r0 *1 0,0
Xsg13cmos5l_decap_8_1672 \$2 \$1 sg13cmos5l_decap_8
* cell instance sg13cmos5l_decap_8_1673 r0 *1 0,0
Xsg13cmos5l_decap_8_1673 \$2 \$1 sg13cmos5l_decap_8
* cell instance sg13cmos5l_decap_8_1674 r0 *1 0,0
Xsg13cmos5l_decap_8_1674 \$2 \$1 sg13cmos5l_decap_8
* cell instance sg13cmos5l_decap_8_1675 r0 *1 0,0
Xsg13cmos5l_decap_8_1675 \$2 \$1 sg13cmos5l_decap_8
* cell instance sg13cmos5l_decap_8_1676 r0 *1 0,0
Xsg13cmos5l_decap_8_1676 \$2 \$1 sg13cmos5l_decap_8
* cell instance sg13cmos5l_decap_8_1677 r0 *1 0,0
Xsg13cmos5l_decap_8_1677 \$2 \$1 sg13cmos5l_decap_8
* cell instance sg13cmos5l_decap_8_1678 r0 *1 0,0
Xsg13cmos5l_decap_8_1678 \$2 \$1 sg13cmos5l_decap_8
* cell instance sg13cmos5l_decap_8_1679 r0 *1 0,0
Xsg13cmos5l_decap_8_1679 \$2 \$1 sg13cmos5l_decap_8
* cell instance sg13cmos5l_decap_8_1680 r0 *1 0,0
Xsg13cmos5l_decap_8_1680 \$2 \$1 sg13cmos5l_decap_8
* cell instance sg13cmos5l_decap_8_1681 r0 *1 0,0
Xsg13cmos5l_decap_8_1681 \$2 \$1 sg13cmos5l_decap_8
* cell instance sg13cmos5l_decap_8_1682 r0 *1 0,0
Xsg13cmos5l_decap_8_1682 \$2 \$1 sg13cmos5l_decap_8
* cell instance sg13cmos5l_decap_8_1683 r0 *1 0,0
Xsg13cmos5l_decap_8_1683 \$2 \$1 sg13cmos5l_decap_8
* cell instance sg13cmos5l_decap_8_1684 r0 *1 0,0
Xsg13cmos5l_decap_8_1684 \$2 \$1 sg13cmos5l_decap_8
* cell instance sg13cmos5l_decap_8_1685 r0 *1 0,0
Xsg13cmos5l_decap_8_1685 \$2 \$1 sg13cmos5l_decap_8
* cell instance sg13cmos5l_decap_8_1686 r0 *1 0,0
Xsg13cmos5l_decap_8_1686 \$2 \$1 sg13cmos5l_decap_8
* cell instance sg13cmos5l_decap_8_1687 r0 *1 0,0
Xsg13cmos5l_decap_8_1687 \$2 \$1 sg13cmos5l_decap_8
* cell instance sg13cmos5l_decap_8_1688 r0 *1 0,0
Xsg13cmos5l_decap_8_1688 \$2 \$1 sg13cmos5l_decap_8
* cell instance sg13cmos5l_decap_8_1689 r0 *1 0,0
Xsg13cmos5l_decap_8_1689 \$2 \$1 sg13cmos5l_decap_8
* cell instance sg13cmos5l_decap_8_1690 r0 *1 0,0
Xsg13cmos5l_decap_8_1690 \$2 \$1 sg13cmos5l_decap_8
* cell instance sg13cmos5l_decap_8_1691 r0 *1 0,0
Xsg13cmos5l_decap_8_1691 \$2 \$1 sg13cmos5l_decap_8
* cell instance sg13cmos5l_decap_8_1692 r0 *1 0,0
Xsg13cmos5l_decap_8_1692 \$2 \$1 sg13cmos5l_decap_8
* cell instance sg13cmos5l_decap_8_1693 r0 *1 0,0
Xsg13cmos5l_decap_8_1693 \$2 \$1 sg13cmos5l_decap_8
* cell instance sg13cmos5l_decap_8_1694 r0 *1 0,0
Xsg13cmos5l_decap_8_1694 \$2 \$1 sg13cmos5l_decap_8
* cell instance sg13cmos5l_decap_8_1695 r0 *1 0,0
Xsg13cmos5l_decap_8_1695 \$2 \$1 sg13cmos5l_decap_8
* cell instance sg13cmos5l_decap_8_1696 r0 *1 0,0
Xsg13cmos5l_decap_8_1696 \$2 \$1 sg13cmos5l_decap_8
* cell instance sg13cmos5l_decap_8_1697 r0 *1 0,0
Xsg13cmos5l_decap_8_1697 \$2 \$1 sg13cmos5l_decap_8
* cell instance sg13cmos5l_decap_8_1698 r0 *1 0,0
Xsg13cmos5l_decap_8_1698 \$2 \$1 sg13cmos5l_decap_8
* cell instance sg13cmos5l_decap_8_1699 r0 *1 0,0
Xsg13cmos5l_decap_8_1699 \$2 \$1 sg13cmos5l_decap_8
* cell instance sg13cmos5l_decap_8_1700 r0 *1 0,0
Xsg13cmos5l_decap_8_1700 \$2 \$1 sg13cmos5l_decap_8
* cell instance sg13cmos5l_decap_8_1701 r0 *1 0,0
Xsg13cmos5l_decap_8_1701 \$2 \$1 sg13cmos5l_decap_8
* cell instance sg13cmos5l_decap_8_1702 r0 *1 0,0
Xsg13cmos5l_decap_8_1702 \$2 \$1 sg13cmos5l_decap_8
* cell instance sg13cmos5l_decap_8_1703 r0 *1 0,0
Xsg13cmos5l_decap_8_1703 \$2 \$1 sg13cmos5l_decap_8
* cell instance sg13cmos5l_decap_8_1704 r0 *1 0,0
Xsg13cmos5l_decap_8_1704 \$2 \$1 sg13cmos5l_decap_8
* cell instance sg13cmos5l_decap_8_1705 r0 *1 0,0
Xsg13cmos5l_decap_8_1705 \$2 \$1 sg13cmos5l_decap_8
* cell instance sg13cmos5l_decap_8_1706 r0 *1 0,0
Xsg13cmos5l_decap_8_1706 \$2 \$1 sg13cmos5l_decap_8
* cell instance sg13cmos5l_decap_8_1707 r0 *1 0,0
Xsg13cmos5l_decap_8_1707 \$2 \$1 sg13cmos5l_decap_8
* cell instance sg13cmos5l_decap_8_1708 r0 *1 0,0
Xsg13cmos5l_decap_8_1708 \$2 \$1 sg13cmos5l_decap_8
* cell instance sg13cmos5l_decap_8_1709 r0 *1 0,0
Xsg13cmos5l_decap_8_1709 \$2 \$1 sg13cmos5l_decap_8
* cell instance sg13cmos5l_decap_8_1710 r0 *1 0,0
Xsg13cmos5l_decap_8_1710 \$2 \$1 sg13cmos5l_decap_8
* cell instance sg13cmos5l_decap_8_1711 r0 *1 0,0
Xsg13cmos5l_decap_8_1711 \$2 \$1 sg13cmos5l_decap_8
* cell instance sg13cmos5l_decap_8_1712 r0 *1 0,0
Xsg13cmos5l_decap_8_1712 \$2 \$1 sg13cmos5l_decap_8
* cell instance sg13cmos5l_decap_8_1713 r0 *1 0,0
Xsg13cmos5l_decap_8_1713 \$2 \$1 sg13cmos5l_decap_8
* cell instance sg13cmos5l_decap_8_1714 r0 *1 0,0
Xsg13cmos5l_decap_8_1714 \$2 \$1 sg13cmos5l_decap_8
* cell instance sg13cmos5l_decap_8_1715 r0 *1 0,0
Xsg13cmos5l_decap_8_1715 \$2 \$1 sg13cmos5l_decap_8
* cell instance sg13cmos5l_decap_8_1716 r0 *1 0,0
Xsg13cmos5l_decap_8_1716 \$2 \$1 sg13cmos5l_decap_8
* cell instance sg13cmos5l_decap_8_1717 r0 *1 0,0
Xsg13cmos5l_decap_8_1717 \$2 \$1 sg13cmos5l_decap_8
* cell instance sg13cmos5l_decap_8_1718 r0 *1 0,0
Xsg13cmos5l_decap_8_1718 \$2 \$1 sg13cmos5l_decap_8
* cell instance sg13cmos5l_decap_8_1719 r0 *1 0,0
Xsg13cmos5l_decap_8_1719 \$2 \$1 sg13cmos5l_decap_8
* cell instance sg13cmos5l_decap_8_1720 r0 *1 0,0
Xsg13cmos5l_decap_8_1720 \$2 \$1 sg13cmos5l_decap_8
* cell instance sg13cmos5l_decap_8_1721 r0 *1 0,0
Xsg13cmos5l_decap_8_1721 \$2 \$1 sg13cmos5l_decap_8
* cell instance sg13cmos5l_decap_8_1722 r0 *1 0,0
Xsg13cmos5l_decap_8_1722 \$2 \$1 sg13cmos5l_decap_8
* cell instance sg13cmos5l_decap_8_1723 r0 *1 0,0
Xsg13cmos5l_decap_8_1723 \$2 \$1 sg13cmos5l_decap_8
* cell instance sg13cmos5l_decap_8_1724 r0 *1 0,0
Xsg13cmos5l_decap_8_1724 \$2 \$1 sg13cmos5l_decap_8
* cell instance sg13cmos5l_decap_8_1725 r0 *1 0,0
Xsg13cmos5l_decap_8_1725 \$2 \$1 sg13cmos5l_decap_8
* cell instance sg13cmos5l_decap_8_1726 r0 *1 0,0
Xsg13cmos5l_decap_8_1726 \$2 \$1 sg13cmos5l_decap_8
* cell instance sg13cmos5l_decap_8_1727 r0 *1 0,0
Xsg13cmos5l_decap_8_1727 \$2 \$1 sg13cmos5l_decap_8
* cell instance sg13cmos5l_decap_8_1728 r0 *1 0,0
Xsg13cmos5l_decap_8_1728 \$2 \$1 sg13cmos5l_decap_8
* cell instance sg13cmos5l_decap_8_1729 r0 *1 0,0
Xsg13cmos5l_decap_8_1729 \$2 \$1 sg13cmos5l_decap_8
* cell instance sg13cmos5l_decap_8_1730 r0 *1 0,0
Xsg13cmos5l_decap_8_1730 \$2 \$1 sg13cmos5l_decap_8
* cell instance sg13cmos5l_decap_8_1731 r0 *1 0,0
Xsg13cmos5l_decap_8_1731 \$2 \$1 sg13cmos5l_decap_8
* cell instance sg13cmos5l_decap_8_1732 r0 *1 0,0
Xsg13cmos5l_decap_8_1732 \$2 \$1 sg13cmos5l_decap_8
* cell instance sg13cmos5l_decap_8_1733 r0 *1 0,0
Xsg13cmos5l_decap_8_1733 \$2 \$1 sg13cmos5l_decap_8
* cell instance sg13cmos5l_decap_8_1734 r0 *1 0,0
Xsg13cmos5l_decap_8_1734 \$2 \$1 sg13cmos5l_decap_8
* cell instance sg13cmos5l_decap_8_1735 r0 *1 0,0
Xsg13cmos5l_decap_8_1735 \$2 \$1 sg13cmos5l_decap_8
* cell instance sg13cmos5l_decap_8_1736 r0 *1 0,0
Xsg13cmos5l_decap_8_1736 \$2 \$1 sg13cmos5l_decap_8
* cell instance sg13cmos5l_decap_8_1737 r0 *1 0,0
Xsg13cmos5l_decap_8_1737 \$2 \$1 sg13cmos5l_decap_8
* cell instance sg13cmos5l_decap_8_1738 r0 *1 0,0
Xsg13cmos5l_decap_8_1738 \$2 \$1 sg13cmos5l_decap_8
* cell instance sg13cmos5l_decap_8_1739 r0 *1 0,0
Xsg13cmos5l_decap_8_1739 \$2 \$1 sg13cmos5l_decap_8
* cell instance sg13cmos5l_decap_8_1740 r0 *1 0,0
Xsg13cmos5l_decap_8_1740 \$2 \$1 sg13cmos5l_decap_8
* cell instance sg13cmos5l_decap_8_1741 r0 *1 0,0
Xsg13cmos5l_decap_8_1741 \$2 \$1 sg13cmos5l_decap_8
* cell instance sg13cmos5l_decap_8_1742 r0 *1 0,0
Xsg13cmos5l_decap_8_1742 \$2 \$1 sg13cmos5l_decap_8
* cell instance sg13cmos5l_decap_8_1743 r0 *1 0,0
Xsg13cmos5l_decap_8_1743 \$2 \$1 sg13cmos5l_decap_8
* cell instance sg13cmos5l_decap_8_1744 r0 *1 0,0
Xsg13cmos5l_decap_8_1744 \$2 \$1 sg13cmos5l_decap_8
* cell instance sg13cmos5l_decap_8_1745 r0 *1 0,0
Xsg13cmos5l_decap_8_1745 \$2 \$1 sg13cmos5l_decap_8
* cell instance sg13cmos5l_decap_8_1746 r0 *1 0,0
Xsg13cmos5l_decap_8_1746 \$2 \$1 sg13cmos5l_decap_8
* cell instance sg13cmos5l_decap_8_1747 r0 *1 0,0
Xsg13cmos5l_decap_8_1747 \$2 \$1 sg13cmos5l_decap_8
* cell instance sg13cmos5l_decap_8_1748 r0 *1 0,0
Xsg13cmos5l_decap_8_1748 \$2 \$1 sg13cmos5l_decap_8
* cell instance sg13cmos5l_decap_8_1749 r0 *1 0,0
Xsg13cmos5l_decap_8_1749 \$2 \$1 sg13cmos5l_decap_8
* cell instance sg13cmos5l_decap_8_1750 r0 *1 0,0
Xsg13cmos5l_decap_8_1750 \$2 \$1 sg13cmos5l_decap_8
* cell instance sg13cmos5l_decap_8_1751 r0 *1 0,0
Xsg13cmos5l_decap_8_1751 \$2 \$1 sg13cmos5l_decap_8
* cell instance sg13cmos5l_decap_8_1752 r0 *1 0,0
Xsg13cmos5l_decap_8_1752 \$2 \$1 sg13cmos5l_decap_8
* cell instance sg13cmos5l_decap_8_1753 r0 *1 0,0
Xsg13cmos5l_decap_8_1753 \$2 \$1 sg13cmos5l_decap_8
* cell instance sg13cmos5l_decap_8_1754 r0 *1 0,0
Xsg13cmos5l_decap_8_1754 \$2 \$1 sg13cmos5l_decap_8
* cell instance sg13cmos5l_decap_8_1755 r0 *1 0,0
Xsg13cmos5l_decap_8_1755 \$2 \$1 sg13cmos5l_decap_8
* cell instance sg13cmos5l_decap_8_1756 r0 *1 0,0
Xsg13cmos5l_decap_8_1756 \$2 \$1 sg13cmos5l_decap_8
* cell instance sg13cmos5l_decap_8_1757 r0 *1 0,0
Xsg13cmos5l_decap_8_1757 \$2 \$1 sg13cmos5l_decap_8
* cell instance sg13cmos5l_decap_8_1758 r0 *1 0,0
Xsg13cmos5l_decap_8_1758 \$2 \$1 sg13cmos5l_decap_8
* cell instance sg13cmos5l_decap_8_1759 r0 *1 0,0
Xsg13cmos5l_decap_8_1759 \$2 \$1 sg13cmos5l_decap_8
* cell instance sg13cmos5l_decap_8_1760 r0 *1 0,0
Xsg13cmos5l_decap_8_1760 \$2 \$1 sg13cmos5l_decap_8
* cell instance sg13cmos5l_decap_8_1761 r0 *1 0,0
Xsg13cmos5l_decap_8_1761 \$2 \$1 sg13cmos5l_decap_8
* cell instance sg13cmos5l_decap_8_1762 r0 *1 0,0
Xsg13cmos5l_decap_8_1762 \$2 \$1 sg13cmos5l_decap_8
* cell instance sg13cmos5l_decap_8_1763 r0 *1 0,0
Xsg13cmos5l_decap_8_1763 \$2 \$1 sg13cmos5l_decap_8
* cell instance sg13cmos5l_decap_8_1764 r0 *1 0,0
Xsg13cmos5l_decap_8_1764 \$2 \$1 sg13cmos5l_decap_8
* cell instance sg13cmos5l_decap_8_1765 r0 *1 0,0
Xsg13cmos5l_decap_8_1765 \$2 \$1 sg13cmos5l_decap_8
* cell instance sg13cmos5l_decap_8_1766 r0 *1 0,0
Xsg13cmos5l_decap_8_1766 \$2 \$1 sg13cmos5l_decap_8
* cell instance sg13cmos5l_decap_8_1767 r0 *1 0,0
Xsg13cmos5l_decap_8_1767 \$2 \$1 sg13cmos5l_decap_8
* cell instance sg13cmos5l_decap_8_1768 r0 *1 0,0
Xsg13cmos5l_decap_8_1768 \$2 \$1 sg13cmos5l_decap_8
* cell instance sg13cmos5l_decap_8_1769 r0 *1 0,0
Xsg13cmos5l_decap_8_1769 \$2 \$1 sg13cmos5l_decap_8
* cell instance sg13cmos5l_decap_8_1770 r0 *1 0,0
Xsg13cmos5l_decap_8_1770 \$2 \$1 sg13cmos5l_decap_8
* cell instance sg13cmos5l_decap_8_1771 r0 *1 0,0
Xsg13cmos5l_decap_8_1771 \$2 \$1 sg13cmos5l_decap_8
* cell instance sg13cmos5l_decap_8_1772 r0 *1 0,0
Xsg13cmos5l_decap_8_1772 \$2 \$1 sg13cmos5l_decap_8
* cell instance sg13cmos5l_decap_8_1773 r0 *1 0,0
Xsg13cmos5l_decap_8_1773 \$2 \$1 sg13cmos5l_decap_8
* cell instance sg13cmos5l_decap_8_1774 r0 *1 0,0
Xsg13cmos5l_decap_8_1774 \$2 \$1 sg13cmos5l_decap_8
* cell instance sg13cmos5l_decap_8_1775 r0 *1 0,0
Xsg13cmos5l_decap_8_1775 \$2 \$1 sg13cmos5l_decap_8
* cell instance sg13cmos5l_decap_8_1776 r0 *1 0,0
Xsg13cmos5l_decap_8_1776 \$2 \$1 sg13cmos5l_decap_8
* cell instance sg13cmos5l_decap_8_1777 r0 *1 0,0
Xsg13cmos5l_decap_8_1777 \$2 \$1 sg13cmos5l_decap_8
* cell instance sg13cmos5l_decap_8_1778 r0 *1 0,0
Xsg13cmos5l_decap_8_1778 \$2 \$1 sg13cmos5l_decap_8
* cell instance sg13cmos5l_decap_8_1779 r0 *1 0,0
Xsg13cmos5l_decap_8_1779 \$2 \$1 sg13cmos5l_decap_8
* cell instance sg13cmos5l_decap_8_1780 r0 *1 0,0
Xsg13cmos5l_decap_8_1780 \$2 \$1 sg13cmos5l_decap_8
* cell instance sg13cmos5l_decap_8_1781 r0 *1 0,0
Xsg13cmos5l_decap_8_1781 \$2 \$1 sg13cmos5l_decap_8
* cell instance sg13cmos5l_decap_8_1782 r0 *1 0,0
Xsg13cmos5l_decap_8_1782 \$2 \$1 sg13cmos5l_decap_8
* cell instance sg13cmos5l_decap_8_1783 r0 *1 0,0
Xsg13cmos5l_decap_8_1783 \$2 \$1 sg13cmos5l_decap_8
* cell instance sg13cmos5l_decap_8_1784 r0 *1 0,0
Xsg13cmos5l_decap_8_1784 \$2 \$1 sg13cmos5l_decap_8
* cell instance sg13cmos5l_decap_8_1785 r0 *1 0,0
Xsg13cmos5l_decap_8_1785 \$2 \$1 sg13cmos5l_decap_8
* cell instance sg13cmos5l_decap_8_1786 r0 *1 0,0
Xsg13cmos5l_decap_8_1786 \$2 \$1 sg13cmos5l_decap_8
* cell instance sg13cmos5l_decap_8_1787 r0 *1 0,0
Xsg13cmos5l_decap_8_1787 \$2 \$1 sg13cmos5l_decap_8
* cell instance sg13cmos5l_decap_8_1788 r0 *1 0,0
Xsg13cmos5l_decap_8_1788 \$2 \$1 sg13cmos5l_decap_8
* cell instance sg13cmos5l_decap_8_1789 r0 *1 0,0
Xsg13cmos5l_decap_8_1789 \$2 \$1 sg13cmos5l_decap_8
* cell instance sg13cmos5l_decap_8_1790 r0 *1 0,0
Xsg13cmos5l_decap_8_1790 \$2 \$1 sg13cmos5l_decap_8
* cell instance sg13cmos5l_decap_8_1791 r0 *1 0,0
Xsg13cmos5l_decap_8_1791 \$2 \$1 sg13cmos5l_decap_8
* cell instance sg13cmos5l_decap_8_1792 r0 *1 0,0
Xsg13cmos5l_decap_8_1792 \$2 \$1 sg13cmos5l_decap_8
* cell instance sg13cmos5l_decap_8_1793 r0 *1 0,0
Xsg13cmos5l_decap_8_1793 \$2 \$1 sg13cmos5l_decap_8
* cell instance sg13cmos5l_decap_8_1794 r0 *1 0,0
Xsg13cmos5l_decap_8_1794 \$2 \$1 sg13cmos5l_decap_8
* cell instance sg13cmos5l_decap_8_1795 r0 *1 0,0
Xsg13cmos5l_decap_8_1795 \$2 \$1 sg13cmos5l_decap_8
* cell instance sg13cmos5l_decap_8_1796 r0 *1 0,0
Xsg13cmos5l_decap_8_1796 \$2 \$1 sg13cmos5l_decap_8
* cell instance sg13cmos5l_decap_8_1797 r0 *1 0,0
Xsg13cmos5l_decap_8_1797 \$2 \$1 sg13cmos5l_decap_8
* cell instance sg13cmos5l_decap_8_1798 r0 *1 0,0
Xsg13cmos5l_decap_8_1798 \$2 \$1 sg13cmos5l_decap_8
* cell instance sg13cmos5l_decap_8_1799 r0 *1 0,0
Xsg13cmos5l_decap_8_1799 \$2 \$1 sg13cmos5l_decap_8
* cell instance sg13cmos5l_decap_8_1800 r0 *1 0,0
Xsg13cmos5l_decap_8_1800 \$2 \$1 sg13cmos5l_decap_8
* cell instance sg13cmos5l_decap_8_1801 r0 *1 0,0
Xsg13cmos5l_decap_8_1801 \$2 \$1 sg13cmos5l_decap_8
* cell instance sg13cmos5l_decap_8_1802 r0 *1 0,0
Xsg13cmos5l_decap_8_1802 \$2 \$1 sg13cmos5l_decap_8
* cell instance sg13cmos5l_decap_8_1803 r0 *1 0,0
Xsg13cmos5l_decap_8_1803 \$2 \$1 sg13cmos5l_decap_8
* cell instance sg13cmos5l_decap_8_1804 r0 *1 0,0
Xsg13cmos5l_decap_8_1804 \$2 \$1 sg13cmos5l_decap_8
* cell instance sg13cmos5l_decap_8_1805 r0 *1 0,0
Xsg13cmos5l_decap_8_1805 \$2 \$1 sg13cmos5l_decap_8
* cell instance sg13cmos5l_decap_8_1806 r0 *1 0,0
Xsg13cmos5l_decap_8_1806 \$2 \$1 sg13cmos5l_decap_8
* cell instance sg13cmos5l_decap_8_1807 r0 *1 0,0
Xsg13cmos5l_decap_8_1807 \$2 \$1 sg13cmos5l_decap_8
* cell instance sg13cmos5l_decap_8_1808 r0 *1 0,0
Xsg13cmos5l_decap_8_1808 \$2 \$1 sg13cmos5l_decap_8
* cell instance sg13cmos5l_decap_8_1809 r0 *1 0,0
Xsg13cmos5l_decap_8_1809 \$2 \$1 sg13cmos5l_decap_8
* cell instance sg13cmos5l_decap_8_1810 r0 *1 0,0
Xsg13cmos5l_decap_8_1810 \$2 \$1 sg13cmos5l_decap_8
* cell instance sg13cmos5l_decap_8_1811 r0 *1 0,0
Xsg13cmos5l_decap_8_1811 \$2 \$1 sg13cmos5l_decap_8
* cell instance sg13cmos5l_decap_8_1812 r0 *1 0,0
Xsg13cmos5l_decap_8_1812 \$2 \$1 sg13cmos5l_decap_8
* cell instance sg13cmos5l_decap_8_1813 r0 *1 0,0
Xsg13cmos5l_decap_8_1813 \$2 \$1 sg13cmos5l_decap_8
* cell instance sg13cmos5l_decap_8_1814 r0 *1 0,0
Xsg13cmos5l_decap_8_1814 \$2 \$1 sg13cmos5l_decap_8
* cell instance sg13cmos5l_decap_8_1815 r0 *1 0,0
Xsg13cmos5l_decap_8_1815 \$2 \$1 sg13cmos5l_decap_8
* cell instance sg13cmos5l_decap_8_1816 r0 *1 0,0
Xsg13cmos5l_decap_8_1816 \$2 \$1 sg13cmos5l_decap_8
* cell instance sg13cmos5l_decap_8_1817 r0 *1 0,0
Xsg13cmos5l_decap_8_1817 \$2 \$1 sg13cmos5l_decap_8
* cell instance sg13cmos5l_decap_8_1818 r0 *1 0,0
Xsg13cmos5l_decap_8_1818 \$2 \$1 sg13cmos5l_decap_8
* cell instance sg13cmos5l_decap_8_1819 r0 *1 0,0
Xsg13cmos5l_decap_8_1819 \$2 \$1 sg13cmos5l_decap_8
* cell instance sg13cmos5l_decap_8_1820 r0 *1 0,0
Xsg13cmos5l_decap_8_1820 \$2 \$1 sg13cmos5l_decap_8
* cell instance sg13cmos5l_decap_8_1821 r0 *1 0,0
Xsg13cmos5l_decap_8_1821 \$2 \$1 sg13cmos5l_decap_8
* cell instance sg13cmos5l_decap_8_1822 r0 *1 0,0
Xsg13cmos5l_decap_8_1822 \$2 \$1 sg13cmos5l_decap_8
* cell instance sg13cmos5l_decap_8_1823 r0 *1 0,0
Xsg13cmos5l_decap_8_1823 \$2 \$1 sg13cmos5l_decap_8
* cell instance sg13cmos5l_decap_8_1824 r0 *1 0,0
Xsg13cmos5l_decap_8_1824 \$2 \$1 sg13cmos5l_decap_8
* cell instance sg13cmos5l_decap_8_1825 r0 *1 0,0
Xsg13cmos5l_decap_8_1825 \$2 \$1 sg13cmos5l_decap_8
* cell instance sg13cmos5l_decap_8_1826 r0 *1 0,0
Xsg13cmos5l_decap_8_1826 \$2 \$1 sg13cmos5l_decap_8
* cell instance sg13cmos5l_decap_8_1827 r0 *1 0,0
Xsg13cmos5l_decap_8_1827 \$2 \$1 sg13cmos5l_decap_8
* cell instance sg13cmos5l_decap_8_1828 r0 *1 0,0
Xsg13cmos5l_decap_8_1828 \$2 \$1 sg13cmos5l_decap_8
* cell instance sg13cmos5l_decap_8_1829 r0 *1 0,0
Xsg13cmos5l_decap_8_1829 \$2 \$1 sg13cmos5l_decap_8
* cell instance sg13cmos5l_decap_8_1830 r0 *1 0,0
Xsg13cmos5l_decap_8_1830 \$2 \$1 sg13cmos5l_decap_8
* cell instance sg13cmos5l_decap_8_1831 r0 *1 0,0
Xsg13cmos5l_decap_8_1831 \$2 \$1 sg13cmos5l_decap_8
* cell instance sg13cmos5l_decap_8_1832 r0 *1 0,0
Xsg13cmos5l_decap_8_1832 \$2 \$1 sg13cmos5l_decap_8
* cell instance sg13cmos5l_decap_8_1833 r0 *1 0,0
Xsg13cmos5l_decap_8_1833 \$2 \$1 sg13cmos5l_decap_8
* cell instance sg13cmos5l_decap_8_1834 r0 *1 0,0
Xsg13cmos5l_decap_8_1834 \$2 \$1 sg13cmos5l_decap_8
* cell instance sg13cmos5l_decap_8_1835 r0 *1 0,0
Xsg13cmos5l_decap_8_1835 \$2 \$1 sg13cmos5l_decap_8
* cell instance sg13cmos5l_decap_8_1836 r0 *1 0,0
Xsg13cmos5l_decap_8_1836 \$2 \$1 sg13cmos5l_decap_8
* cell instance sg13cmos5l_decap_8_1837 r0 *1 0,0
Xsg13cmos5l_decap_8_1837 \$2 \$1 sg13cmos5l_decap_8
* cell instance sg13cmos5l_decap_8_1838 r0 *1 0,0
Xsg13cmos5l_decap_8_1838 \$2 \$1 sg13cmos5l_decap_8
* cell instance sg13cmos5l_decap_8_1839 r0 *1 0,0
Xsg13cmos5l_decap_8_1839 \$2 \$1 sg13cmos5l_decap_8
* cell instance sg13cmos5l_decap_8_1840 r0 *1 0,0
Xsg13cmos5l_decap_8_1840 \$2 \$1 sg13cmos5l_decap_8
* cell instance sg13cmos5l_decap_8_1841 r0 *1 0,0
Xsg13cmos5l_decap_8_1841 \$2 \$1 sg13cmos5l_decap_8
* cell instance sg13cmos5l_decap_8_1842 r0 *1 0,0
Xsg13cmos5l_decap_8_1842 \$2 \$1 sg13cmos5l_decap_8
* cell instance sg13cmos5l_decap_8_1843 r0 *1 0,0
Xsg13cmos5l_decap_8_1843 \$2 \$1 sg13cmos5l_decap_8
* cell instance sg13cmos5l_decap_8_1844 r0 *1 0,0
Xsg13cmos5l_decap_8_1844 \$2 \$1 sg13cmos5l_decap_8
* cell instance sg13cmos5l_decap_8_1845 r0 *1 0,0
Xsg13cmos5l_decap_8_1845 \$2 \$1 sg13cmos5l_decap_8
* cell instance sg13cmos5l_decap_8_1846 r0 *1 0,0
Xsg13cmos5l_decap_8_1846 \$2 \$1 sg13cmos5l_decap_8
* cell instance sg13cmos5l_decap_8_1847 r0 *1 0,0
Xsg13cmos5l_decap_8_1847 \$2 \$1 sg13cmos5l_decap_8
* cell instance sg13cmos5l_decap_8_1848 r0 *1 0,0
Xsg13cmos5l_decap_8_1848 \$2 \$1 sg13cmos5l_decap_8
* cell instance sg13cmos5l_decap_8_1849 r0 *1 0,0
Xsg13cmos5l_decap_8_1849 \$2 \$1 sg13cmos5l_decap_8
* cell instance sg13cmos5l_decap_8_1850 r0 *1 0,0
Xsg13cmos5l_decap_8_1850 \$2 \$1 sg13cmos5l_decap_8
* cell instance sg13cmos5l_decap_8_1851 r0 *1 0,0
Xsg13cmos5l_decap_8_1851 \$2 \$1 sg13cmos5l_decap_8
* cell instance sg13cmos5l_decap_8_1852 r0 *1 0,0
Xsg13cmos5l_decap_8_1852 \$2 \$1 sg13cmos5l_decap_8
* cell instance sg13cmos5l_decap_8_1853 r0 *1 0,0
Xsg13cmos5l_decap_8_1853 \$2 \$1 sg13cmos5l_decap_8
* cell instance sg13cmos5l_decap_8_1854 r0 *1 0,0
Xsg13cmos5l_decap_8_1854 \$2 \$1 sg13cmos5l_decap_8
* cell instance sg13cmos5l_decap_8_1855 r0 *1 0,0
Xsg13cmos5l_decap_8_1855 \$2 \$1 sg13cmos5l_decap_8
* cell instance sg13cmos5l_decap_8_1856 r0 *1 0,0
Xsg13cmos5l_decap_8_1856 \$2 \$1 sg13cmos5l_decap_8
* cell instance sg13cmos5l_decap_8_1857 r0 *1 0,0
Xsg13cmos5l_decap_8_1857 \$2 \$1 sg13cmos5l_decap_8
* cell instance sg13cmos5l_decap_8_1858 r0 *1 0,0
Xsg13cmos5l_decap_8_1858 \$2 \$1 sg13cmos5l_decap_8
* cell instance sg13cmos5l_decap_8_1859 r0 *1 0,0
Xsg13cmos5l_decap_8_1859 \$2 \$1 sg13cmos5l_decap_8
* cell instance sg13cmos5l_decap_8_1860 r0 *1 0,0
Xsg13cmos5l_decap_8_1860 \$2 \$1 sg13cmos5l_decap_8
* cell instance sg13cmos5l_decap_8_1861 r0 *1 0,0
Xsg13cmos5l_decap_8_1861 \$2 \$1 sg13cmos5l_decap_8
* cell instance sg13cmos5l_decap_8_1862 r0 *1 0,0
Xsg13cmos5l_decap_8_1862 \$2 \$1 sg13cmos5l_decap_8
* cell instance sg13cmos5l_decap_8_1863 r0 *1 0,0
Xsg13cmos5l_decap_8_1863 \$2 \$1 sg13cmos5l_decap_8
* cell instance sg13cmos5l_decap_8_1864 r0 *1 0,0
Xsg13cmos5l_decap_8_1864 \$2 \$1 sg13cmos5l_decap_8
* cell instance sg13cmos5l_decap_8_1865 r0 *1 0,0
Xsg13cmos5l_decap_8_1865 \$2 \$1 sg13cmos5l_decap_8
* cell instance sg13cmos5l_decap_8_1866 r0 *1 0,0
Xsg13cmos5l_decap_8_1866 \$2 \$1 sg13cmos5l_decap_8
* cell instance sg13cmos5l_decap_8_1867 r0 *1 0,0
Xsg13cmos5l_decap_8_1867 \$2 \$1 sg13cmos5l_decap_8
* cell instance sg13cmos5l_decap_8_1868 r0 *1 0,0
Xsg13cmos5l_decap_8_1868 \$2 \$1 sg13cmos5l_decap_8
* cell instance sg13cmos5l_decap_8_1869 r0 *1 0,0
Xsg13cmos5l_decap_8_1869 \$2 \$1 sg13cmos5l_decap_8
* cell instance sg13cmos5l_decap_8_1870 r0 *1 0,0
Xsg13cmos5l_decap_8_1870 \$2 \$1 sg13cmos5l_decap_8
* cell instance sg13cmos5l_decap_8_1871 r0 *1 0,0
Xsg13cmos5l_decap_8_1871 \$2 \$1 sg13cmos5l_decap_8
* cell instance sg13cmos5l_decap_8_1872 r0 *1 0,0
Xsg13cmos5l_decap_8_1872 \$2 \$1 sg13cmos5l_decap_8
* cell instance sg13cmos5l_decap_8_1873 r0 *1 0,0
Xsg13cmos5l_decap_8_1873 \$2 \$1 sg13cmos5l_decap_8
* cell instance sg13cmos5l_decap_8_1874 r0 *1 0,0
Xsg13cmos5l_decap_8_1874 \$2 \$1 sg13cmos5l_decap_8
* cell instance sg13cmos5l_decap_8_1875 r0 *1 0,0
Xsg13cmos5l_decap_8_1875 \$2 \$1 sg13cmos5l_decap_8
* cell instance sg13cmos5l_decap_8_1876 r0 *1 0,0
Xsg13cmos5l_decap_8_1876 \$2 \$1 sg13cmos5l_decap_8
* cell instance sg13cmos5l_decap_8_1877 r0 *1 0,0
Xsg13cmos5l_decap_8_1877 \$2 \$1 sg13cmos5l_decap_8
* cell instance sg13cmos5l_decap_8_1878 r0 *1 0,0
Xsg13cmos5l_decap_8_1878 \$2 \$1 sg13cmos5l_decap_8
* cell instance sg13cmos5l_decap_8_1879 r0 *1 0,0
Xsg13cmos5l_decap_8_1879 \$2 \$1 sg13cmos5l_decap_8
* cell instance sg13cmos5l_decap_8_1880 r0 *1 0,0
Xsg13cmos5l_decap_8_1880 \$2 \$1 sg13cmos5l_decap_8
* cell instance sg13cmos5l_decap_8_1881 r0 *1 0,0
Xsg13cmos5l_decap_8_1881 \$2 \$1 sg13cmos5l_decap_8
* cell instance sg13cmos5l_decap_8_1882 r0 *1 0,0
Xsg13cmos5l_decap_8_1882 \$2 \$1 sg13cmos5l_decap_8
* cell instance sg13cmos5l_decap_8_1883 r0 *1 0,0
Xsg13cmos5l_decap_8_1883 \$2 \$1 sg13cmos5l_decap_8
* cell instance sg13cmos5l_decap_8_1884 r0 *1 0,0
Xsg13cmos5l_decap_8_1884 \$2 \$1 sg13cmos5l_decap_8
* cell instance sg13cmos5l_decap_8_1885 r0 *1 0,0
Xsg13cmos5l_decap_8_1885 \$2 \$1 sg13cmos5l_decap_8
* cell instance sg13cmos5l_decap_8_1886 r0 *1 0,0
Xsg13cmos5l_decap_8_1886 \$2 \$1 sg13cmos5l_decap_8
* cell instance sg13cmos5l_decap_8_1887 r0 *1 0,0
Xsg13cmos5l_decap_8_1887 \$2 \$1 sg13cmos5l_decap_8
* cell instance sg13cmos5l_decap_8_1888 r0 *1 0,0
Xsg13cmos5l_decap_8_1888 \$2 \$1 sg13cmos5l_decap_8
* cell instance sg13cmos5l_decap_8_1889 r0 *1 0,0
Xsg13cmos5l_decap_8_1889 \$2 \$1 sg13cmos5l_decap_8
* cell instance sg13cmos5l_decap_8_1890 r0 *1 0,0
Xsg13cmos5l_decap_8_1890 \$2 \$1 sg13cmos5l_decap_8
* cell instance sg13cmos5l_decap_8_1891 r0 *1 0,0
Xsg13cmos5l_decap_8_1891 \$2 \$1 sg13cmos5l_decap_8
* cell instance sg13cmos5l_decap_8_1892 r0 *1 0,0
Xsg13cmos5l_decap_8_1892 \$2 \$1 sg13cmos5l_decap_8
* cell instance sg13cmos5l_decap_8_1893 r0 *1 0,0
Xsg13cmos5l_decap_8_1893 \$2 \$1 sg13cmos5l_decap_8
* cell instance sg13cmos5l_decap_8_1894 r0 *1 0,0
Xsg13cmos5l_decap_8_1894 \$2 \$1 sg13cmos5l_decap_8
* cell instance sg13cmos5l_decap_8_1895 r0 *1 0,0
Xsg13cmos5l_decap_8_1895 \$2 \$1 sg13cmos5l_decap_8
* cell instance sg13cmos5l_decap_8_1896 r0 *1 0,0
Xsg13cmos5l_decap_8_1896 \$2 \$1 sg13cmos5l_decap_8
* cell instance sg13cmos5l_decap_8_1897 r0 *1 0,0
Xsg13cmos5l_decap_8_1897 \$2 \$1 sg13cmos5l_decap_8
* cell instance sg13cmos5l_decap_8_1898 r0 *1 0,0
Xsg13cmos5l_decap_8_1898 \$2 \$1 sg13cmos5l_decap_8
* cell instance sg13cmos5l_decap_8_1899 r0 *1 0,0
Xsg13cmos5l_decap_8_1899 \$2 \$1 sg13cmos5l_decap_8
* cell instance sg13cmos5l_decap_8_1900 r0 *1 0,0
Xsg13cmos5l_decap_8_1900 \$2 \$1 sg13cmos5l_decap_8
* cell instance sg13cmos5l_decap_8_1901 r0 *1 0,0
Xsg13cmos5l_decap_8_1901 \$2 \$1 sg13cmos5l_decap_8
* cell instance sg13cmos5l_decap_8_1902 r0 *1 0,0
Xsg13cmos5l_decap_8_1902 \$2 \$1 sg13cmos5l_decap_8
* cell instance sg13cmos5l_decap_8_1903 r0 *1 0,0
Xsg13cmos5l_decap_8_1903 \$2 \$1 sg13cmos5l_decap_8
* cell instance sg13cmos5l_decap_8_1904 r0 *1 0,0
Xsg13cmos5l_decap_8_1904 \$2 \$1 sg13cmos5l_decap_8
* cell instance sg13cmos5l_decap_8_1905 r0 *1 0,0
Xsg13cmos5l_decap_8_1905 \$2 \$1 sg13cmos5l_decap_8
* cell instance sg13cmos5l_decap_8_1906 r0 *1 0,0
Xsg13cmos5l_decap_8_1906 \$2 \$1 sg13cmos5l_decap_8
* cell instance sg13cmos5l_decap_8_1907 r0 *1 0,0
Xsg13cmos5l_decap_8_1907 \$2 \$1 sg13cmos5l_decap_8
* cell instance sg13cmos5l_decap_8_1908 r0 *1 0,0
Xsg13cmos5l_decap_8_1908 \$2 \$1 sg13cmos5l_decap_8
* cell instance sg13cmos5l_decap_8_1909 r0 *1 0,0
Xsg13cmos5l_decap_8_1909 \$2 \$1 sg13cmos5l_decap_8
* cell instance sg13cmos5l_decap_8_1910 r0 *1 0,0
Xsg13cmos5l_decap_8_1910 \$2 \$1 sg13cmos5l_decap_8
* cell instance sg13cmos5l_decap_8_1911 r0 *1 0,0
Xsg13cmos5l_decap_8_1911 \$2 \$1 sg13cmos5l_decap_8
* cell instance sg13cmos5l_decap_8_1912 r0 *1 0,0
Xsg13cmos5l_decap_8_1912 \$2 \$1 sg13cmos5l_decap_8
* cell instance sg13cmos5l_decap_8_1913 r0 *1 0,0
Xsg13cmos5l_decap_8_1913 \$2 \$1 sg13cmos5l_decap_8
* cell instance sg13cmos5l_decap_8_1914 r0 *1 0,0
Xsg13cmos5l_decap_8_1914 \$2 \$1 sg13cmos5l_decap_8
* cell instance sg13cmos5l_decap_8_1915 r0 *1 0,0
Xsg13cmos5l_decap_8_1915 \$2 \$1 sg13cmos5l_decap_8
* cell instance sg13cmos5l_decap_8_1916 r0 *1 0,0
Xsg13cmos5l_decap_8_1916 \$2 \$1 sg13cmos5l_decap_8
* cell instance sg13cmos5l_decap_8_1917 r0 *1 0,0
Xsg13cmos5l_decap_8_1917 \$2 \$1 sg13cmos5l_decap_8
* cell instance sg13cmos5l_decap_8_1918 r0 *1 0,0
Xsg13cmos5l_decap_8_1918 \$2 \$1 sg13cmos5l_decap_8
* cell instance sg13cmos5l_decap_8_1919 r0 *1 0,0
Xsg13cmos5l_decap_8_1919 \$2 \$1 sg13cmos5l_decap_8
* cell instance sg13cmos5l_decap_8_1920 r0 *1 0,0
Xsg13cmos5l_decap_8_1920 \$2 \$1 sg13cmos5l_decap_8
* cell instance sg13cmos5l_decap_8_1921 r0 *1 0,0
Xsg13cmos5l_decap_8_1921 \$2 \$1 sg13cmos5l_decap_8
* cell instance sg13cmos5l_decap_8_1922 r0 *1 0,0
Xsg13cmos5l_decap_8_1922 \$2 \$1 sg13cmos5l_decap_8
* cell instance sg13cmos5l_decap_8_1923 r0 *1 0,0
Xsg13cmos5l_decap_8_1923 \$2 \$1 sg13cmos5l_decap_8
* cell instance sg13cmos5l_decap_8_1924 r0 *1 0,0
Xsg13cmos5l_decap_8_1924 \$2 \$1 sg13cmos5l_decap_8
* cell instance sg13cmos5l_decap_8_1925 r0 *1 0,0
Xsg13cmos5l_decap_8_1925 \$2 \$1 sg13cmos5l_decap_8
* cell instance sg13cmos5l_decap_8_1926 r0 *1 0,0
Xsg13cmos5l_decap_8_1926 \$2 \$1 sg13cmos5l_decap_8
* cell instance sg13cmos5l_decap_8_1927 r0 *1 0,0
Xsg13cmos5l_decap_8_1927 \$2 \$1 sg13cmos5l_decap_8
* cell instance sg13cmos5l_decap_8_1928 r0 *1 0,0
Xsg13cmos5l_decap_8_1928 \$2 \$1 sg13cmos5l_decap_8
* cell instance sg13cmos5l_decap_8_1929 r0 *1 0,0
Xsg13cmos5l_decap_8_1929 \$2 \$1 sg13cmos5l_decap_8
* cell instance sg13cmos5l_decap_8_1930 r0 *1 0,0
Xsg13cmos5l_decap_8_1930 \$2 \$1 sg13cmos5l_decap_8
* cell instance sg13cmos5l_decap_8_1931 r0 *1 0,0
Xsg13cmos5l_decap_8_1931 \$2 \$1 sg13cmos5l_decap_8
* cell instance sg13cmos5l_decap_8_1932 r0 *1 0,0
Xsg13cmos5l_decap_8_1932 \$2 \$1 sg13cmos5l_decap_8
* cell instance sg13cmos5l_decap_8_1933 r0 *1 0,0
Xsg13cmos5l_decap_8_1933 \$2 \$1 sg13cmos5l_decap_8
* cell instance sg13cmos5l_decap_8_1934 r0 *1 0,0
Xsg13cmos5l_decap_8_1934 \$2 \$1 sg13cmos5l_decap_8
* cell instance sg13cmos5l_decap_8_1935 r0 *1 0,0
Xsg13cmos5l_decap_8_1935 \$2 \$1 sg13cmos5l_decap_8
* cell instance sg13cmos5l_decap_8_1936 r0 *1 0,0
Xsg13cmos5l_decap_8_1936 \$2 \$1 sg13cmos5l_decap_8
* cell instance sg13cmos5l_decap_8_1937 r0 *1 0,0
Xsg13cmos5l_decap_8_1937 \$2 \$1 sg13cmos5l_decap_8
* cell instance sg13cmos5l_decap_8_1938 r0 *1 0,0
Xsg13cmos5l_decap_8_1938 \$2 \$1 sg13cmos5l_decap_8
* cell instance sg13cmos5l_decap_8_1939 r0 *1 0,0
Xsg13cmos5l_decap_8_1939 \$2 \$1 sg13cmos5l_decap_8
* cell instance sg13cmos5l_decap_8_1940 r0 *1 0,0
Xsg13cmos5l_decap_8_1940 \$2 \$1 sg13cmos5l_decap_8
* cell instance sg13cmos5l_decap_8_1941 r0 *1 0,0
Xsg13cmos5l_decap_8_1941 \$2 \$1 sg13cmos5l_decap_8
* cell instance sg13cmos5l_decap_8_1942 r0 *1 0,0
Xsg13cmos5l_decap_8_1942 \$2 \$1 sg13cmos5l_decap_8
* cell instance sg13cmos5l_decap_8_1943 r0 *1 0,0
Xsg13cmos5l_decap_8_1943 \$2 \$1 sg13cmos5l_decap_8
* cell instance sg13cmos5l_decap_8_1944 r0 *1 0,0
Xsg13cmos5l_decap_8_1944 \$2 \$1 sg13cmos5l_decap_8
* cell instance sg13cmos5l_decap_8_1945 r0 *1 0,0
Xsg13cmos5l_decap_8_1945 \$2 \$1 sg13cmos5l_decap_8
* cell instance sg13cmos5l_decap_8_1946 r0 *1 0,0
Xsg13cmos5l_decap_8_1946 \$2 \$1 sg13cmos5l_decap_8
* cell instance sg13cmos5l_decap_8_1947 r0 *1 0,0
Xsg13cmos5l_decap_8_1947 \$2 \$1 sg13cmos5l_decap_8
* cell instance sg13cmos5l_decap_8_1948 r0 *1 0,0
Xsg13cmos5l_decap_8_1948 \$2 \$1 sg13cmos5l_decap_8
* cell instance sg13cmos5l_decap_8_1949 r0 *1 0,0
Xsg13cmos5l_decap_8_1949 \$2 \$1 sg13cmos5l_decap_8
* cell instance sg13cmos5l_decap_8_1950 r0 *1 0,0
Xsg13cmos5l_decap_8_1950 \$2 \$1 sg13cmos5l_decap_8
* cell instance sg13cmos5l_decap_8_1951 r0 *1 0,0
Xsg13cmos5l_decap_8_1951 \$2 \$1 sg13cmos5l_decap_8
* cell instance sg13cmos5l_decap_8_1952 r0 *1 0,0
Xsg13cmos5l_decap_8_1952 \$2 \$1 sg13cmos5l_decap_8
* cell instance sg13cmos5l_decap_8_1953 r0 *1 0,0
Xsg13cmos5l_decap_8_1953 \$2 \$1 sg13cmos5l_decap_8
* cell instance sg13cmos5l_decap_8_1954 r0 *1 0,0
Xsg13cmos5l_decap_8_1954 \$2 \$1 sg13cmos5l_decap_8
* cell instance sg13cmos5l_decap_8_1955 r0 *1 0,0
Xsg13cmos5l_decap_8_1955 \$2 \$1 sg13cmos5l_decap_8
* cell instance sg13cmos5l_decap_8_1956 r0 *1 0,0
Xsg13cmos5l_decap_8_1956 \$2 \$1 sg13cmos5l_decap_8
* cell instance sg13cmos5l_decap_8_1957 r0 *1 0,0
Xsg13cmos5l_decap_8_1957 \$2 \$1 sg13cmos5l_decap_8
* cell instance sg13cmos5l_decap_8_1958 r0 *1 0,0
Xsg13cmos5l_decap_8_1958 \$2 \$1 sg13cmos5l_decap_8
* cell instance sg13cmos5l_decap_8_1959 r0 *1 0,0
Xsg13cmos5l_decap_8_1959 \$2 \$1 sg13cmos5l_decap_8
* cell instance sg13cmos5l_decap_8_1960 r0 *1 0,0
Xsg13cmos5l_decap_8_1960 \$2 \$1 sg13cmos5l_decap_8
* cell instance sg13cmos5l_decap_8_1961 r0 *1 0,0
Xsg13cmos5l_decap_8_1961 \$2 \$1 sg13cmos5l_decap_8
* cell instance sg13cmos5l_decap_8_1962 r0 *1 0,0
Xsg13cmos5l_decap_8_1962 \$2 \$1 sg13cmos5l_decap_8
* cell instance sg13cmos5l_decap_8_1963 r0 *1 0,0
Xsg13cmos5l_decap_8_1963 \$2 \$1 sg13cmos5l_decap_8
* cell instance sg13cmos5l_decap_8_1964 r0 *1 0,0
Xsg13cmos5l_decap_8_1964 \$2 \$1 sg13cmos5l_decap_8
* cell instance sg13cmos5l_decap_8_1965 r0 *1 0,0
Xsg13cmos5l_decap_8_1965 \$2 \$1 sg13cmos5l_decap_8
* cell instance sg13cmos5l_decap_8_1966 r0 *1 0,0
Xsg13cmos5l_decap_8_1966 \$2 \$1 sg13cmos5l_decap_8
* cell instance sg13cmos5l_decap_8_1967 r0 *1 0,0
Xsg13cmos5l_decap_8_1967 \$2 \$1 sg13cmos5l_decap_8
* cell instance sg13cmos5l_decap_8_1968 r0 *1 0,0
Xsg13cmos5l_decap_8_1968 \$2 \$1 sg13cmos5l_decap_8
* cell instance sg13cmos5l_decap_8_1969 r0 *1 0,0
Xsg13cmos5l_decap_8_1969 \$2 \$1 sg13cmos5l_decap_8
* cell instance sg13cmos5l_decap_8_1970 r0 *1 0,0
Xsg13cmos5l_decap_8_1970 \$2 \$1 sg13cmos5l_decap_8
* cell instance sg13cmos5l_decap_8_1971 r0 *1 0,0
Xsg13cmos5l_decap_8_1971 \$2 \$1 sg13cmos5l_decap_8
* cell instance sg13cmos5l_decap_8_1972 r0 *1 0,0
Xsg13cmos5l_decap_8_1972 \$2 \$1 sg13cmos5l_decap_8
* cell instance sg13cmos5l_decap_8_1973 r0 *1 0,0
Xsg13cmos5l_decap_8_1973 \$2 \$1 sg13cmos5l_decap_8
* cell instance sg13cmos5l_decap_8_1974 r0 *1 0,0
Xsg13cmos5l_decap_8_1974 \$2 \$1 sg13cmos5l_decap_8
* cell instance sg13cmos5l_decap_8_1975 r0 *1 0,0
Xsg13cmos5l_decap_8_1975 \$2 \$1 sg13cmos5l_decap_8
* cell instance sg13cmos5l_decap_8_1976 r0 *1 0,0
Xsg13cmos5l_decap_8_1976 \$2 \$1 sg13cmos5l_decap_8
* cell instance sg13cmos5l_decap_8_1977 r0 *1 0,0
Xsg13cmos5l_decap_8_1977 \$2 \$1 sg13cmos5l_decap_8
* cell instance sg13cmos5l_decap_8_1978 r0 *1 0,0
Xsg13cmos5l_decap_8_1978 \$2 \$1 sg13cmos5l_decap_8
* cell instance sg13cmos5l_decap_8_1979 r0 *1 0,0
Xsg13cmos5l_decap_8_1979 \$2 \$1 sg13cmos5l_decap_8
* cell instance sg13cmos5l_decap_8_1980 r0 *1 0,0
Xsg13cmos5l_decap_8_1980 \$2 \$1 sg13cmos5l_decap_8
* cell instance sg13cmos5l_decap_8_1981 r0 *1 0,0
Xsg13cmos5l_decap_8_1981 \$2 \$1 sg13cmos5l_decap_8
* cell instance sg13cmos5l_decap_8_1982 r0 *1 0,0
Xsg13cmos5l_decap_8_1982 \$2 \$1 sg13cmos5l_decap_8
* cell instance sg13cmos5l_decap_8_1983 r0 *1 0,0
Xsg13cmos5l_decap_8_1983 \$2 \$1 sg13cmos5l_decap_8
* cell instance sg13cmos5l_decap_8_1984 r0 *1 0,0
Xsg13cmos5l_decap_8_1984 \$2 \$1 sg13cmos5l_decap_8
* cell instance sg13cmos5l_decap_8_1985 r0 *1 0,0
Xsg13cmos5l_decap_8_1985 \$2 \$1 sg13cmos5l_decap_8
* cell instance sg13cmos5l_decap_8_1986 r0 *1 0,0
Xsg13cmos5l_decap_8_1986 \$2 \$1 sg13cmos5l_decap_8
* cell instance sg13cmos5l_decap_8_1987 r0 *1 0,0
Xsg13cmos5l_decap_8_1987 \$2 \$1 sg13cmos5l_decap_8
* cell instance sg13cmos5l_decap_8_1988 r0 *1 0,0
Xsg13cmos5l_decap_8_1988 \$2 \$1 sg13cmos5l_decap_8
* cell instance sg13cmos5l_decap_8_1989 r0 *1 0,0
Xsg13cmos5l_decap_8_1989 \$2 \$1 sg13cmos5l_decap_8
* cell instance sg13cmos5l_decap_8_1990 r0 *1 0,0
Xsg13cmos5l_decap_8_1990 \$2 \$1 sg13cmos5l_decap_8
* cell instance sg13cmos5l_decap_8_1991 r0 *1 0,0
Xsg13cmos5l_decap_8_1991 \$2 \$1 sg13cmos5l_decap_8
* cell instance sg13cmos5l_decap_8_1992 r0 *1 0,0
Xsg13cmos5l_decap_8_1992 \$2 \$1 sg13cmos5l_decap_8
* cell instance sg13cmos5l_decap_8_1993 r0 *1 0,0
Xsg13cmos5l_decap_8_1993 \$2 \$1 sg13cmos5l_decap_8
* cell instance sg13cmos5l_decap_8_1994 r0 *1 0,0
Xsg13cmos5l_decap_8_1994 \$2 \$1 sg13cmos5l_decap_8
* cell instance sg13cmos5l_decap_8_1995 r0 *1 0,0
Xsg13cmos5l_decap_8_1995 \$2 \$1 sg13cmos5l_decap_8
* cell instance sg13cmos5l_decap_8_1996 r0 *1 0,0
Xsg13cmos5l_decap_8_1996 \$2 \$1 sg13cmos5l_decap_8
* cell instance sg13cmos5l_decap_8_1997 r0 *1 0,0
Xsg13cmos5l_decap_8_1997 \$2 \$1 sg13cmos5l_decap_8
* cell instance sg13cmos5l_decap_8_1998 r0 *1 0,0
Xsg13cmos5l_decap_8_1998 \$2 \$1 sg13cmos5l_decap_8
* cell instance sg13cmos5l_decap_8_1999 r0 *1 0,0
Xsg13cmos5l_decap_8_1999 \$2 \$1 sg13cmos5l_decap_8
* cell instance sg13cmos5l_decap_8_2000 r0 *1 0,0
Xsg13cmos5l_decap_8_2000 \$2 \$1 sg13cmos5l_decap_8
* cell instance sg13cmos5l_decap_8_2001 r0 *1 0,0
Xsg13cmos5l_decap_8_2001 \$2 \$1 sg13cmos5l_decap_8
* cell instance sg13cmos5l_decap_8_2002 r0 *1 0,0
Xsg13cmos5l_decap_8_2002 \$2 \$1 sg13cmos5l_decap_8
* cell instance sg13cmos5l_decap_8_2003 r0 *1 0,0
Xsg13cmos5l_decap_8_2003 \$2 \$1 sg13cmos5l_decap_8
* cell instance sg13cmos5l_decap_8_2004 r0 *1 0,0
Xsg13cmos5l_decap_8_2004 \$2 \$1 sg13cmos5l_decap_8
* cell instance sg13cmos5l_decap_8_2005 r0 *1 0,0
Xsg13cmos5l_decap_8_2005 \$2 \$1 sg13cmos5l_decap_8
* cell instance sg13cmos5l_decap_8_2006 r0 *1 0,0
Xsg13cmos5l_decap_8_2006 \$2 \$1 sg13cmos5l_decap_8
* cell instance sg13cmos5l_decap_8_2007 r0 *1 0,0
Xsg13cmos5l_decap_8_2007 \$2 \$1 sg13cmos5l_decap_8
* cell instance sg13cmos5l_decap_8_2008 r0 *1 0,0
Xsg13cmos5l_decap_8_2008 \$2 \$1 sg13cmos5l_decap_8
* cell instance sg13cmos5l_decap_8_2009 r0 *1 0,0
Xsg13cmos5l_decap_8_2009 \$2 \$1 sg13cmos5l_decap_8
* cell instance sg13cmos5l_decap_8_2010 r0 *1 0,0
Xsg13cmos5l_decap_8_2010 \$2 \$1 sg13cmos5l_decap_8
* cell instance sg13cmos5l_decap_8_2011 r0 *1 0,0
Xsg13cmos5l_decap_8_2011 \$2 \$1 sg13cmos5l_decap_8
* cell instance sg13cmos5l_decap_8_2012 r0 *1 0,0
Xsg13cmos5l_decap_8_2012 \$2 \$1 sg13cmos5l_decap_8
* cell instance sg13cmos5l_decap_8_2013 r0 *1 0,0
Xsg13cmos5l_decap_8_2013 \$2 \$1 sg13cmos5l_decap_8
* cell instance sg13cmos5l_decap_8_2014 r0 *1 0,0
Xsg13cmos5l_decap_8_2014 \$2 \$1 sg13cmos5l_decap_8
* cell instance sg13cmos5l_decap_8_2015 r0 *1 0,0
Xsg13cmos5l_decap_8_2015 \$2 \$1 sg13cmos5l_decap_8
* cell instance sg13cmos5l_decap_8_2016 r0 *1 0,0
Xsg13cmos5l_decap_8_2016 \$2 \$1 sg13cmos5l_decap_8
* cell instance sg13cmos5l_decap_8_2017 r0 *1 0,0
Xsg13cmos5l_decap_8_2017 \$2 \$1 sg13cmos5l_decap_8
* cell instance sg13cmos5l_decap_8_2018 r0 *1 0,0
Xsg13cmos5l_decap_8_2018 \$2 \$1 sg13cmos5l_decap_8
* cell instance sg13cmos5l_decap_8_2019 r0 *1 0,0
Xsg13cmos5l_decap_8_2019 \$2 \$1 sg13cmos5l_decap_8
* cell instance sg13cmos5l_decap_8_2020 r0 *1 0,0
Xsg13cmos5l_decap_8_2020 \$2 \$1 sg13cmos5l_decap_8
* cell instance sg13cmos5l_decap_8_2021 r0 *1 0,0
Xsg13cmos5l_decap_8_2021 \$2 \$1 sg13cmos5l_decap_8
* cell instance sg13cmos5l_decap_8_2022 r0 *1 0,0
Xsg13cmos5l_decap_8_2022 \$2 \$1 sg13cmos5l_decap_8
* cell instance sg13cmos5l_decap_8_2023 r0 *1 0,0
Xsg13cmos5l_decap_8_2023 \$2 \$1 sg13cmos5l_decap_8
* cell instance sg13cmos5l_decap_8_2024 r0 *1 0,0
Xsg13cmos5l_decap_8_2024 \$2 \$1 sg13cmos5l_decap_8
* cell instance sg13cmos5l_decap_8_2025 r0 *1 0,0
Xsg13cmos5l_decap_8_2025 \$2 \$1 sg13cmos5l_decap_8
* cell instance sg13cmos5l_decap_8_2026 r0 *1 0,0
Xsg13cmos5l_decap_8_2026 \$2 \$1 sg13cmos5l_decap_8
* cell instance sg13cmos5l_decap_8_2027 r0 *1 0,0
Xsg13cmos5l_decap_8_2027 \$2 \$1 sg13cmos5l_decap_8
* cell instance sg13cmos5l_decap_8_2028 r0 *1 0,0
Xsg13cmos5l_decap_8_2028 \$2 \$1 sg13cmos5l_decap_8
* cell instance sg13cmos5l_decap_8_2029 r0 *1 0,0
Xsg13cmos5l_decap_8_2029 \$2 \$1 sg13cmos5l_decap_8
* cell instance sg13cmos5l_decap_8_2030 r0 *1 0,0
Xsg13cmos5l_decap_8_2030 \$2 \$1 sg13cmos5l_decap_8
* cell instance sg13cmos5l_decap_8_2031 r0 *1 0,0
Xsg13cmos5l_decap_8_2031 \$2 \$1 sg13cmos5l_decap_8
* cell instance sg13cmos5l_decap_8_2032 r0 *1 0,0
Xsg13cmos5l_decap_8_2032 \$2 \$1 sg13cmos5l_decap_8
* cell instance sg13cmos5l_decap_8_2033 r0 *1 0,0
Xsg13cmos5l_decap_8_2033 \$2 \$1 sg13cmos5l_decap_8
* cell instance sg13cmos5l_decap_8_2034 r0 *1 0,0
Xsg13cmos5l_decap_8_2034 \$2 \$1 sg13cmos5l_decap_8
* cell instance sg13cmos5l_decap_8_2035 r0 *1 0,0
Xsg13cmos5l_decap_8_2035 \$2 \$1 sg13cmos5l_decap_8
* cell instance sg13cmos5l_decap_8_2036 r0 *1 0,0
Xsg13cmos5l_decap_8_2036 \$2 \$1 sg13cmos5l_decap_8
* cell instance sg13cmos5l_decap_8_2037 r0 *1 0,0
Xsg13cmos5l_decap_8_2037 \$2 \$1 sg13cmos5l_decap_8
* cell instance sg13cmos5l_decap_8_2038 r0 *1 0,0
Xsg13cmos5l_decap_8_2038 \$2 \$1 sg13cmos5l_decap_8
* cell instance sg13cmos5l_decap_8_2039 r0 *1 0,0
Xsg13cmos5l_decap_8_2039 \$2 \$1 sg13cmos5l_decap_8
* cell instance sg13cmos5l_decap_8_2040 r0 *1 0,0
Xsg13cmos5l_decap_8_2040 \$2 \$1 sg13cmos5l_decap_8
* cell instance sg13cmos5l_decap_8_2041 r0 *1 0,0
Xsg13cmos5l_decap_8_2041 \$2 \$1 sg13cmos5l_decap_8
* cell instance sg13cmos5l_decap_8_2042 r0 *1 0,0
Xsg13cmos5l_decap_8_2042 \$2 \$1 sg13cmos5l_decap_8
* cell instance sg13cmos5l_decap_8_2043 r0 *1 0,0
Xsg13cmos5l_decap_8_2043 \$2 \$1 sg13cmos5l_decap_8
* cell instance sg13cmos5l_decap_8_2044 r0 *1 0,0
Xsg13cmos5l_decap_8_2044 \$2 \$1 sg13cmos5l_decap_8
* cell instance sg13cmos5l_decap_8_2045 r0 *1 0,0
Xsg13cmos5l_decap_8_2045 \$2 \$1 sg13cmos5l_decap_8
* cell instance sg13cmos5l_decap_8_2046 r0 *1 0,0
Xsg13cmos5l_decap_8_2046 \$2 \$1 sg13cmos5l_decap_8
* cell instance sg13cmos5l_decap_8_2047 r0 *1 0,0
Xsg13cmos5l_decap_8_2047 \$2 \$1 sg13cmos5l_decap_8
* cell instance sg13cmos5l_decap_8_2048 r0 *1 0,0
Xsg13cmos5l_decap_8_2048 \$2 \$1 sg13cmos5l_decap_8
* cell instance sg13cmos5l_decap_8_2049 r0 *1 0,0
Xsg13cmos5l_decap_8_2049 \$2 \$1 sg13cmos5l_decap_8
* cell instance sg13cmos5l_decap_8_2050 r0 *1 0,0
Xsg13cmos5l_decap_8_2050 \$2 \$1 sg13cmos5l_decap_8
* cell instance sg13cmos5l_decap_8_2051 r0 *1 0,0
Xsg13cmos5l_decap_8_2051 \$2 \$1 sg13cmos5l_decap_8
* cell instance sg13cmos5l_decap_8_2052 r0 *1 0,0
Xsg13cmos5l_decap_8_2052 \$2 \$1 sg13cmos5l_decap_8
* cell instance sg13cmos5l_decap_8_2053 r0 *1 0,0
Xsg13cmos5l_decap_8_2053 \$2 \$1 sg13cmos5l_decap_8
* cell instance sg13cmos5l_decap_8_2054 r0 *1 0,0
Xsg13cmos5l_decap_8_2054 \$2 \$1 sg13cmos5l_decap_8
* cell instance sg13cmos5l_decap_8_2055 r0 *1 0,0
Xsg13cmos5l_decap_8_2055 \$2 \$1 sg13cmos5l_decap_8
* cell instance sg13cmos5l_decap_8_2056 r0 *1 0,0
Xsg13cmos5l_decap_8_2056 \$2 \$1 sg13cmos5l_decap_8
* cell instance sg13cmos5l_decap_8_2057 r0 *1 0,0
Xsg13cmos5l_decap_8_2057 \$2 \$1 sg13cmos5l_decap_8
* cell instance sg13cmos5l_decap_8_2058 r0 *1 0,0
Xsg13cmos5l_decap_8_2058 \$2 \$1 sg13cmos5l_decap_8
* cell instance sg13cmos5l_decap_8_2059 r0 *1 0,0
Xsg13cmos5l_decap_8_2059 \$2 \$1 sg13cmos5l_decap_8
* cell instance sg13cmos5l_decap_8_2060 r0 *1 0,0
Xsg13cmos5l_decap_8_2060 \$2 \$1 sg13cmos5l_decap_8
* cell instance sg13cmos5l_decap_8_2061 r0 *1 0,0
Xsg13cmos5l_decap_8_2061 \$2 \$1 sg13cmos5l_decap_8
* cell instance sg13cmos5l_decap_8_2062 r0 *1 0,0
Xsg13cmos5l_decap_8_2062 \$2 \$1 sg13cmos5l_decap_8
* cell instance sg13cmos5l_decap_8_2063 r0 *1 0,0
Xsg13cmos5l_decap_8_2063 \$2 \$1 sg13cmos5l_decap_8
* cell instance sg13cmos5l_decap_8_2064 r0 *1 0,0
Xsg13cmos5l_decap_8_2064 \$2 \$1 sg13cmos5l_decap_8
* cell instance sg13cmos5l_decap_8_2065 r0 *1 0,0
Xsg13cmos5l_decap_8_2065 \$2 \$1 sg13cmos5l_decap_8
* cell instance sg13cmos5l_decap_8_2066 r0 *1 0,0
Xsg13cmos5l_decap_8_2066 \$2 \$1 sg13cmos5l_decap_8
* cell instance sg13cmos5l_decap_8_2067 r0 *1 0,0
Xsg13cmos5l_decap_8_2067 \$2 \$1 sg13cmos5l_decap_8
* cell instance sg13cmos5l_decap_8_2068 r0 *1 0,0
Xsg13cmos5l_decap_8_2068 \$2 \$1 sg13cmos5l_decap_8
* cell instance sg13cmos5l_decap_8_2069 r0 *1 0,0
Xsg13cmos5l_decap_8_2069 \$2 \$1 sg13cmos5l_decap_8
* cell instance sg13cmos5l_decap_8_2070 r0 *1 0,0
Xsg13cmos5l_decap_8_2070 \$2 \$1 sg13cmos5l_decap_8
* cell instance sg13cmos5l_decap_8_2071 r0 *1 0,0
Xsg13cmos5l_decap_8_2071 \$2 \$1 sg13cmos5l_decap_8
* cell instance sg13cmos5l_decap_8_2072 r0 *1 0,0
Xsg13cmos5l_decap_8_2072 \$2 \$1 sg13cmos5l_decap_8
* cell instance sg13cmos5l_decap_8_2073 r0 *1 0,0
Xsg13cmos5l_decap_8_2073 \$2 \$1 sg13cmos5l_decap_8
* cell instance sg13cmos5l_decap_8_2074 r0 *1 0,0
Xsg13cmos5l_decap_8_2074 \$2 \$1 sg13cmos5l_decap_8
* cell instance sg13cmos5l_decap_8_2075 r0 *1 0,0
Xsg13cmos5l_decap_8_2075 \$2 \$1 sg13cmos5l_decap_8
* cell instance sg13cmos5l_decap_8_2076 r0 *1 0,0
Xsg13cmos5l_decap_8_2076 \$2 \$1 sg13cmos5l_decap_8
* cell instance sg13cmos5l_decap_8_2077 r0 *1 0,0
Xsg13cmos5l_decap_8_2077 \$2 \$1 sg13cmos5l_decap_8
* cell instance sg13cmos5l_decap_8_2078 r0 *1 0,0
Xsg13cmos5l_decap_8_2078 \$2 \$1 sg13cmos5l_decap_8
* cell instance sg13cmos5l_decap_8_2079 r0 *1 0,0
Xsg13cmos5l_decap_8_2079 \$2 \$1 sg13cmos5l_decap_8
* cell instance sg13cmos5l_decap_8_2080 r0 *1 0,0
Xsg13cmos5l_decap_8_2080 \$2 \$1 sg13cmos5l_decap_8
* cell instance sg13cmos5l_decap_8_2081 r0 *1 0,0
Xsg13cmos5l_decap_8_2081 \$2 \$1 sg13cmos5l_decap_8
* cell instance sg13cmos5l_decap_8_2082 r0 *1 0,0
Xsg13cmos5l_decap_8_2082 \$2 \$1 sg13cmos5l_decap_8
* cell instance sg13cmos5l_decap_8_2083 r0 *1 0,0
Xsg13cmos5l_decap_8_2083 \$2 \$1 sg13cmos5l_decap_8
* cell instance sg13cmos5l_decap_8_2084 r0 *1 0,0
Xsg13cmos5l_decap_8_2084 \$2 \$1 sg13cmos5l_decap_8
* cell instance sg13cmos5l_decap_8_2085 r0 *1 0,0
Xsg13cmos5l_decap_8_2085 \$2 \$1 sg13cmos5l_decap_8
* cell instance sg13cmos5l_decap_8_2086 r0 *1 0,0
Xsg13cmos5l_decap_8_2086 \$2 \$1 sg13cmos5l_decap_8
* cell instance sg13cmos5l_decap_8_2087 r0 *1 0,0
Xsg13cmos5l_decap_8_2087 \$2 \$1 sg13cmos5l_decap_8
* cell instance sg13cmos5l_decap_8_2088 r0 *1 0,0
Xsg13cmos5l_decap_8_2088 \$2 \$1 sg13cmos5l_decap_8
* cell instance sg13cmos5l_decap_8_2089 r0 *1 0,0
Xsg13cmos5l_decap_8_2089 \$2 \$1 sg13cmos5l_decap_8
* cell instance sg13cmos5l_decap_8_2090 r0 *1 0,0
Xsg13cmos5l_decap_8_2090 \$2 \$1 sg13cmos5l_decap_8
* cell instance sg13cmos5l_decap_8_2091 r0 *1 0,0
Xsg13cmos5l_decap_8_2091 \$2 \$1 sg13cmos5l_decap_8
* cell instance sg13cmos5l_decap_8_2092 r0 *1 0,0
Xsg13cmos5l_decap_8_2092 \$2 \$1 sg13cmos5l_decap_8
* cell instance sg13cmos5l_decap_8_2093 r0 *1 0,0
Xsg13cmos5l_decap_8_2093 \$2 \$1 sg13cmos5l_decap_8
* cell instance sg13cmos5l_decap_8_2094 r0 *1 0,0
Xsg13cmos5l_decap_8_2094 \$2 \$1 sg13cmos5l_decap_8
* cell instance sg13cmos5l_decap_8_2095 r0 *1 0,0
Xsg13cmos5l_decap_8_2095 \$2 \$1 sg13cmos5l_decap_8
* cell instance sg13cmos5l_decap_8_2096 r0 *1 0,0
Xsg13cmos5l_decap_8_2096 \$2 \$1 sg13cmos5l_decap_8
* cell instance sg13cmos5l_decap_8_2097 r0 *1 0,0
Xsg13cmos5l_decap_8_2097 \$2 \$1 sg13cmos5l_decap_8
* cell instance sg13cmos5l_decap_8_2098 r0 *1 0,0
Xsg13cmos5l_decap_8_2098 \$2 \$1 sg13cmos5l_decap_8
* cell instance sg13cmos5l_decap_8_2099 r0 *1 0,0
Xsg13cmos5l_decap_8_2099 \$2 \$1 sg13cmos5l_decap_8
* cell instance sg13cmos5l_decap_8_2100 r0 *1 0,0
Xsg13cmos5l_decap_8_2100 \$2 \$1 sg13cmos5l_decap_8
* cell instance sg13cmos5l_decap_8_2101 r0 *1 0,0
Xsg13cmos5l_decap_8_2101 \$2 \$1 sg13cmos5l_decap_8
* cell instance sg13cmos5l_decap_8_2102 r0 *1 0,0
Xsg13cmos5l_decap_8_2102 \$2 \$1 sg13cmos5l_decap_8
* cell instance sg13cmos5l_decap_8_2103 r0 *1 0,0
Xsg13cmos5l_decap_8_2103 \$2 \$1 sg13cmos5l_decap_8
* cell instance sg13cmos5l_decap_8_2104 r0 *1 0,0
Xsg13cmos5l_decap_8_2104 \$2 \$1 sg13cmos5l_decap_8
* cell instance sg13cmos5l_decap_8_2105 r0 *1 0,0
Xsg13cmos5l_decap_8_2105 \$2 \$1 sg13cmos5l_decap_8
* cell instance sg13cmos5l_decap_8_2106 r0 *1 0,0
Xsg13cmos5l_decap_8_2106 \$2 \$1 sg13cmos5l_decap_8
* cell instance sg13cmos5l_decap_8_2107 r0 *1 0,0
Xsg13cmos5l_decap_8_2107 \$2 \$1 sg13cmos5l_decap_8
* cell instance sg13cmos5l_decap_8_2108 r0 *1 0,0
Xsg13cmos5l_decap_8_2108 \$2 \$1 sg13cmos5l_decap_8
* cell instance sg13cmos5l_decap_8_2109 r0 *1 0,0
Xsg13cmos5l_decap_8_2109 \$2 \$1 sg13cmos5l_decap_8
* cell instance sg13cmos5l_decap_8_2110 r0 *1 0,0
Xsg13cmos5l_decap_8_2110 \$2 \$1 sg13cmos5l_decap_8
* cell instance sg13cmos5l_decap_8_2111 r0 *1 0,0
Xsg13cmos5l_decap_8_2111 \$2 \$1 sg13cmos5l_decap_8
* cell instance sg13cmos5l_decap_8_2112 r0 *1 0,0
Xsg13cmos5l_decap_8_2112 \$2 \$1 sg13cmos5l_decap_8
* cell instance sg13cmos5l_decap_8_2113 r0 *1 0,0
Xsg13cmos5l_decap_8_2113 \$2 \$1 sg13cmos5l_decap_8
* cell instance sg13cmos5l_decap_8_2114 r0 *1 0,0
Xsg13cmos5l_decap_8_2114 \$2 \$1 sg13cmos5l_decap_8
* cell instance sg13cmos5l_decap_8_2115 r0 *1 0,0
Xsg13cmos5l_decap_8_2115 \$2 \$1 sg13cmos5l_decap_8
* cell instance sg13cmos5l_decap_8_2116 r0 *1 0,0
Xsg13cmos5l_decap_8_2116 \$2 \$1 sg13cmos5l_decap_8
* cell instance sg13cmos5l_decap_8_2117 r0 *1 0,0
Xsg13cmos5l_decap_8_2117 \$2 \$1 sg13cmos5l_decap_8
* cell instance sg13cmos5l_decap_8_2118 r0 *1 0,0
Xsg13cmos5l_decap_8_2118 \$2 \$1 sg13cmos5l_decap_8
* cell instance sg13cmos5l_decap_8_2119 r0 *1 0,0
Xsg13cmos5l_decap_8_2119 \$2 \$1 sg13cmos5l_decap_8
* cell instance sg13cmos5l_decap_8_2120 r0 *1 0,0
Xsg13cmos5l_decap_8_2120 \$2 \$1 sg13cmos5l_decap_8
* cell instance sg13cmos5l_decap_8_2121 r0 *1 0,0
Xsg13cmos5l_decap_8_2121 \$2 \$1 sg13cmos5l_decap_8
* cell instance sg13cmos5l_decap_8_2122 r0 *1 0,0
Xsg13cmos5l_decap_8_2122 \$2 \$1 sg13cmos5l_decap_8
* cell instance sg13cmos5l_decap_8_2123 r0 *1 0,0
Xsg13cmos5l_decap_8_2123 \$2 \$1 sg13cmos5l_decap_8
* cell instance sg13cmos5l_decap_8_2124 r0 *1 0,0
Xsg13cmos5l_decap_8_2124 \$2 \$1 sg13cmos5l_decap_8
* cell instance sg13cmos5l_decap_8_2125 r0 *1 0,0
Xsg13cmos5l_decap_8_2125 \$2 \$1 sg13cmos5l_decap_8
* cell instance sg13cmos5l_decap_8_2126 r0 *1 0,0
Xsg13cmos5l_decap_8_2126 \$2 \$1 sg13cmos5l_decap_8
* cell instance sg13cmos5l_decap_8_2127 r0 *1 0,0
Xsg13cmos5l_decap_8_2127 \$2 \$1 sg13cmos5l_decap_8
* cell instance sg13cmos5l_decap_8_2128 r0 *1 0,0
Xsg13cmos5l_decap_8_2128 \$2 \$1 sg13cmos5l_decap_8
* cell instance sg13cmos5l_decap_8_2129 r0 *1 0,0
Xsg13cmos5l_decap_8_2129 \$2 \$1 sg13cmos5l_decap_8
* cell instance sg13cmos5l_decap_8_2130 r0 *1 0,0
Xsg13cmos5l_decap_8_2130 \$2 \$1 sg13cmos5l_decap_8
* cell instance sg13cmos5l_decap_8_2131 r0 *1 0,0
Xsg13cmos5l_decap_8_2131 \$2 \$1 sg13cmos5l_decap_8
* cell instance sg13cmos5l_decap_8_2132 r0 *1 0,0
Xsg13cmos5l_decap_8_2132 \$2 \$1 sg13cmos5l_decap_8
* cell instance sg13cmos5l_decap_8_2133 r0 *1 0,0
Xsg13cmos5l_decap_8_2133 \$2 \$1 sg13cmos5l_decap_8
* cell instance sg13cmos5l_decap_8_2134 r0 *1 0,0
Xsg13cmos5l_decap_8_2134 \$2 \$1 sg13cmos5l_decap_8
* cell instance sg13cmos5l_decap_8_2135 r0 *1 0,0
Xsg13cmos5l_decap_8_2135 \$2 \$1 sg13cmos5l_decap_8
* cell instance sg13cmos5l_decap_8_2136 r0 *1 0,0
Xsg13cmos5l_decap_8_2136 \$2 \$1 sg13cmos5l_decap_8
* cell instance sg13cmos5l_decap_8_2137 r0 *1 0,0
Xsg13cmos5l_decap_8_2137 \$2 \$1 sg13cmos5l_decap_8
* cell instance sg13cmos5l_decap_8_2138 r0 *1 0,0
Xsg13cmos5l_decap_8_2138 \$2 \$1 sg13cmos5l_decap_8
* cell instance sg13cmos5l_decap_8_2139 r0 *1 0,0
Xsg13cmos5l_decap_8_2139 \$2 \$1 sg13cmos5l_decap_8
* cell instance sg13cmos5l_decap_8_2140 r0 *1 0,0
Xsg13cmos5l_decap_8_2140 \$2 \$1 sg13cmos5l_decap_8
* cell instance sg13cmos5l_decap_8_2141 r0 *1 0,0
Xsg13cmos5l_decap_8_2141 \$2 \$1 sg13cmos5l_decap_8
* cell instance sg13cmos5l_decap_8_2142 r0 *1 0,0
Xsg13cmos5l_decap_8_2142 \$2 \$1 sg13cmos5l_decap_8
* cell instance sg13cmos5l_decap_8_2143 r0 *1 0,0
Xsg13cmos5l_decap_8_2143 \$2 \$1 sg13cmos5l_decap_8
* cell instance sg13cmos5l_decap_8_2144 r0 *1 0,0
Xsg13cmos5l_decap_8_2144 \$2 \$1 sg13cmos5l_decap_8
* cell instance sg13cmos5l_decap_8_2145 r0 *1 0,0
Xsg13cmos5l_decap_8_2145 \$2 \$1 sg13cmos5l_decap_8
* cell instance sg13cmos5l_decap_8_2146 r0 *1 0,0
Xsg13cmos5l_decap_8_2146 \$2 \$1 sg13cmos5l_decap_8
* cell instance sg13cmos5l_decap_8_2147 r0 *1 0,0
Xsg13cmos5l_decap_8_2147 \$2 \$1 sg13cmos5l_decap_8
* cell instance sg13cmos5l_decap_8_2148 r0 *1 0,0
Xsg13cmos5l_decap_8_2148 \$2 \$1 sg13cmos5l_decap_8
* cell instance sg13cmos5l_decap_8_2149 r0 *1 0,0
Xsg13cmos5l_decap_8_2149 \$2 \$1 sg13cmos5l_decap_8
* cell instance sg13cmos5l_decap_8_2150 r0 *1 0,0
Xsg13cmos5l_decap_8_2150 \$2 \$1 sg13cmos5l_decap_8
* cell instance sg13cmos5l_decap_8_2151 r0 *1 0,0
Xsg13cmos5l_decap_8_2151 \$2 \$1 sg13cmos5l_decap_8
* cell instance sg13cmos5l_decap_8_2152 r0 *1 0,0
Xsg13cmos5l_decap_8_2152 \$2 \$1 sg13cmos5l_decap_8
* cell instance sg13cmos5l_decap_8_2153 r0 *1 0,0
Xsg13cmos5l_decap_8_2153 \$2 \$1 sg13cmos5l_decap_8
* cell instance sg13cmos5l_decap_8_2154 r0 *1 0,0
Xsg13cmos5l_decap_8_2154 \$2 \$1 sg13cmos5l_decap_8
* cell instance sg13cmos5l_decap_8_2155 r0 *1 0,0
Xsg13cmos5l_decap_8_2155 \$2 \$1 sg13cmos5l_decap_8
* cell instance sg13cmos5l_decap_8_2156 r0 *1 0,0
Xsg13cmos5l_decap_8_2156 \$2 \$1 sg13cmos5l_decap_8
* cell instance sg13cmos5l_decap_8_2157 r0 *1 0,0
Xsg13cmos5l_decap_8_2157 \$2 \$1 sg13cmos5l_decap_8
* cell instance sg13cmos5l_decap_8_2158 r0 *1 0,0
Xsg13cmos5l_decap_8_2158 \$2 \$1 sg13cmos5l_decap_8
* cell instance sg13cmos5l_decap_8_2159 r0 *1 0,0
Xsg13cmos5l_decap_8_2159 \$2 \$1 sg13cmos5l_decap_8
* cell instance sg13cmos5l_decap_8_2160 r0 *1 0,0
Xsg13cmos5l_decap_8_2160 \$2 \$1 sg13cmos5l_decap_8
* cell instance sg13cmos5l_decap_8_2161 r0 *1 0,0
Xsg13cmos5l_decap_8_2161 \$2 \$1 sg13cmos5l_decap_8
* cell instance sg13cmos5l_decap_8_2162 r0 *1 0,0
Xsg13cmos5l_decap_8_2162 \$2 \$1 sg13cmos5l_decap_8
* cell instance sg13cmos5l_decap_8_2163 r0 *1 0,0
Xsg13cmos5l_decap_8_2163 \$2 \$1 sg13cmos5l_decap_8
* cell instance sg13cmos5l_decap_8_2164 r0 *1 0,0
Xsg13cmos5l_decap_8_2164 \$2 \$1 sg13cmos5l_decap_8
* cell instance sg13cmos5l_decap_8_2165 r0 *1 0,0
Xsg13cmos5l_decap_8_2165 \$2 \$1 sg13cmos5l_decap_8
* cell instance sg13cmos5l_decap_8_2166 r0 *1 0,0
Xsg13cmos5l_decap_8_2166 \$2 \$1 sg13cmos5l_decap_8
* cell instance sg13cmos5l_decap_8_2167 r0 *1 0,0
Xsg13cmos5l_decap_8_2167 \$2 \$1 sg13cmos5l_decap_8
* cell instance sg13cmos5l_decap_8_2168 r0 *1 0,0
Xsg13cmos5l_decap_8_2168 \$2 \$1 sg13cmos5l_decap_8
* cell instance sg13cmos5l_decap_8_2169 r0 *1 0,0
Xsg13cmos5l_decap_8_2169 \$2 \$1 sg13cmos5l_decap_8
* cell instance sg13cmos5l_decap_8_2170 r0 *1 0,0
Xsg13cmos5l_decap_8_2170 \$2 \$1 sg13cmos5l_decap_8
* cell instance sg13cmos5l_decap_8_2171 r0 *1 0,0
Xsg13cmos5l_decap_8_2171 \$2 \$1 sg13cmos5l_decap_8
* cell instance sg13cmos5l_decap_8_2172 r0 *1 0,0
Xsg13cmos5l_decap_8_2172 \$2 \$1 sg13cmos5l_decap_8
* cell instance sg13cmos5l_decap_8_2173 r0 *1 0,0
Xsg13cmos5l_decap_8_2173 \$2 \$1 sg13cmos5l_decap_8
* cell instance sg13cmos5l_decap_8_2174 r0 *1 0,0
Xsg13cmos5l_decap_8_2174 \$2 \$1 sg13cmos5l_decap_8
* cell instance sg13cmos5l_decap_8_2175 r0 *1 0,0
Xsg13cmos5l_decap_8_2175 \$2 \$1 sg13cmos5l_decap_8
* cell instance sg13cmos5l_decap_8_2176 r0 *1 0,0
Xsg13cmos5l_decap_8_2176 \$2 \$1 sg13cmos5l_decap_8
* cell instance sg13cmos5l_decap_8_2177 r0 *1 0,0
Xsg13cmos5l_decap_8_2177 \$2 \$1 sg13cmos5l_decap_8
* cell instance sg13cmos5l_decap_8_2178 r0 *1 0,0
Xsg13cmos5l_decap_8_2178 \$2 \$1 sg13cmos5l_decap_8
* cell instance sg13cmos5l_decap_8_2179 r0 *1 0,0
Xsg13cmos5l_decap_8_2179 \$2 \$1 sg13cmos5l_decap_8
* cell instance sg13cmos5l_decap_8_2180 r0 *1 0,0
Xsg13cmos5l_decap_8_2180 \$2 \$1 sg13cmos5l_decap_8
* cell instance sg13cmos5l_decap_8_2181 r0 *1 0,0
Xsg13cmos5l_decap_8_2181 \$2 \$1 sg13cmos5l_decap_8
* cell instance sg13cmos5l_decap_8_2182 r0 *1 0,0
Xsg13cmos5l_decap_8_2182 \$2 \$1 sg13cmos5l_decap_8
* cell instance sg13cmos5l_decap_8_2183 r0 *1 0,0
Xsg13cmos5l_decap_8_2183 \$2 \$1 sg13cmos5l_decap_8
* cell instance sg13cmos5l_decap_8_2184 r0 *1 0,0
Xsg13cmos5l_decap_8_2184 \$2 \$1 sg13cmos5l_decap_8
* cell instance sg13cmos5l_decap_8_2185 r0 *1 0,0
Xsg13cmos5l_decap_8_2185 \$2 \$1 sg13cmos5l_decap_8
* cell instance sg13cmos5l_decap_8_2186 r0 *1 0,0
Xsg13cmos5l_decap_8_2186 \$2 \$1 sg13cmos5l_decap_8
* cell instance sg13cmos5l_decap_8_2187 r0 *1 0,0
Xsg13cmos5l_decap_8_2187 \$2 \$1 sg13cmos5l_decap_8
* cell instance sg13cmos5l_decap_8_2188 r0 *1 0,0
Xsg13cmos5l_decap_8_2188 \$2 \$1 sg13cmos5l_decap_8
* cell instance sg13cmos5l_decap_8_2189 r0 *1 0,0
Xsg13cmos5l_decap_8_2189 \$2 \$1 sg13cmos5l_decap_8
* cell instance sg13cmos5l_decap_8_2190 r0 *1 0,0
Xsg13cmos5l_decap_8_2190 \$2 \$1 sg13cmos5l_decap_8
* cell instance sg13cmos5l_decap_8_2191 r0 *1 0,0
Xsg13cmos5l_decap_8_2191 \$2 \$1 sg13cmos5l_decap_8
* cell instance sg13cmos5l_decap_8_2192 r0 *1 0,0
Xsg13cmos5l_decap_8_2192 \$2 \$1 sg13cmos5l_decap_8
* cell instance sg13cmos5l_decap_8_2193 r0 *1 0,0
Xsg13cmos5l_decap_8_2193 \$2 \$1 sg13cmos5l_decap_8
* cell instance sg13cmos5l_decap_8_2194 r0 *1 0,0
Xsg13cmos5l_decap_8_2194 \$2 \$1 sg13cmos5l_decap_8
* cell instance sg13cmos5l_decap_8_2195 r0 *1 0,0
Xsg13cmos5l_decap_8_2195 \$2 \$1 sg13cmos5l_decap_8
* cell instance sg13cmos5l_decap_8_2196 r0 *1 0,0
Xsg13cmos5l_decap_8_2196 \$2 \$1 sg13cmos5l_decap_8
* cell instance sg13cmos5l_decap_8_2197 r0 *1 0,0
Xsg13cmos5l_decap_8_2197 \$2 \$1 sg13cmos5l_decap_8
* cell instance sg13cmos5l_decap_8_2198 r0 *1 0,0
Xsg13cmos5l_decap_8_2198 \$2 \$1 sg13cmos5l_decap_8
* cell instance sg13cmos5l_decap_8_2199 r0 *1 0,0
Xsg13cmos5l_decap_8_2199 \$2 \$1 sg13cmos5l_decap_8
* cell instance sg13cmos5l_decap_8_2200 r0 *1 0,0
Xsg13cmos5l_decap_8_2200 \$2 \$1 sg13cmos5l_decap_8
* cell instance sg13cmos5l_decap_8_2201 r0 *1 0,0
Xsg13cmos5l_decap_8_2201 \$2 \$1 sg13cmos5l_decap_8
* cell instance sg13cmos5l_decap_8_2202 r0 *1 0,0
Xsg13cmos5l_decap_8_2202 \$2 \$1 sg13cmos5l_decap_8
* cell instance sg13cmos5l_decap_8_2203 r0 *1 0,0
Xsg13cmos5l_decap_8_2203 \$2 \$1 sg13cmos5l_decap_8
* cell instance sg13cmos5l_decap_8_2204 r0 *1 0,0
Xsg13cmos5l_decap_8_2204 \$2 \$1 sg13cmos5l_decap_8
* cell instance sg13cmos5l_decap_8_2205 r0 *1 0,0
Xsg13cmos5l_decap_8_2205 \$2 \$1 sg13cmos5l_decap_8
* cell instance sg13cmos5l_decap_8_2206 r0 *1 0,0
Xsg13cmos5l_decap_8_2206 \$2 \$1 sg13cmos5l_decap_8
* cell instance sg13cmos5l_decap_8_2207 r0 *1 0,0
Xsg13cmos5l_decap_8_2207 \$2 \$1 sg13cmos5l_decap_8
* cell instance sg13cmos5l_decap_8_2208 r0 *1 0,0
Xsg13cmos5l_decap_8_2208 \$2 \$1 sg13cmos5l_decap_8
* cell instance sg13cmos5l_decap_8_2209 r0 *1 0,0
Xsg13cmos5l_decap_8_2209 \$2 \$1 sg13cmos5l_decap_8
* cell instance sg13cmos5l_decap_8_2210 r0 *1 0,0
Xsg13cmos5l_decap_8_2210 \$2 \$1 sg13cmos5l_decap_8
* cell instance sg13cmos5l_decap_8_2211 r0 *1 0,0
Xsg13cmos5l_decap_8_2211 \$2 \$1 sg13cmos5l_decap_8
* cell instance sg13cmos5l_decap_8_2212 r0 *1 0,0
Xsg13cmos5l_decap_8_2212 \$2 \$1 sg13cmos5l_decap_8
* cell instance sg13cmos5l_decap_8_2213 r0 *1 0,0
Xsg13cmos5l_decap_8_2213 \$2 \$1 sg13cmos5l_decap_8
* cell instance sg13cmos5l_decap_8_2214 r0 *1 0,0
Xsg13cmos5l_decap_8_2214 \$2 \$1 sg13cmos5l_decap_8
* cell instance sg13cmos5l_decap_8_2215 r0 *1 0,0
Xsg13cmos5l_decap_8_2215 \$2 \$1 sg13cmos5l_decap_8
* cell instance sg13cmos5l_decap_8_2216 r0 *1 0,0
Xsg13cmos5l_decap_8_2216 \$2 \$1 sg13cmos5l_decap_8
* cell instance sg13cmos5l_decap_8_2217 r0 *1 0,0
Xsg13cmos5l_decap_8_2217 \$2 \$1 sg13cmos5l_decap_8
* cell instance sg13cmos5l_decap_8_2218 r0 *1 0,0
Xsg13cmos5l_decap_8_2218 \$2 \$1 sg13cmos5l_decap_8
* cell instance sg13cmos5l_decap_8_2219 r0 *1 0,0
Xsg13cmos5l_decap_8_2219 \$2 \$1 sg13cmos5l_decap_8
* cell instance sg13cmos5l_decap_8_2220 r0 *1 0,0
Xsg13cmos5l_decap_8_2220 \$2 \$1 sg13cmos5l_decap_8
* cell instance sg13cmos5l_decap_8_2221 r0 *1 0,0
Xsg13cmos5l_decap_8_2221 \$2 \$1 sg13cmos5l_decap_8
* cell instance sg13cmos5l_decap_8_2222 r0 *1 0,0
Xsg13cmos5l_decap_8_2222 \$2 \$1 sg13cmos5l_decap_8
* cell instance sg13cmos5l_decap_8_2223 r0 *1 0,0
Xsg13cmos5l_decap_8_2223 \$2 \$1 sg13cmos5l_decap_8
* cell instance sg13cmos5l_decap_8_2224 r0 *1 0,0
Xsg13cmos5l_decap_8_2224 \$2 \$1 sg13cmos5l_decap_8
* cell instance sg13cmos5l_decap_8_2225 r0 *1 0,0
Xsg13cmos5l_decap_8_2225 \$2 \$1 sg13cmos5l_decap_8
* cell instance sg13cmos5l_decap_8_2226 r0 *1 0,0
Xsg13cmos5l_decap_8_2226 \$2 \$1 sg13cmos5l_decap_8
* cell instance sg13cmos5l_decap_8_2227 r0 *1 0,0
Xsg13cmos5l_decap_8_2227 \$2 \$1 sg13cmos5l_decap_8
* cell instance sg13cmos5l_decap_8_2228 r0 *1 0,0
Xsg13cmos5l_decap_8_2228 \$2 \$1 sg13cmos5l_decap_8
* cell instance sg13cmos5l_decap_8_2229 r0 *1 0,0
Xsg13cmos5l_decap_8_2229 \$2 \$1 sg13cmos5l_decap_8
* cell instance sg13cmos5l_decap_8_2230 r0 *1 0,0
Xsg13cmos5l_decap_8_2230 \$2 \$1 sg13cmos5l_decap_8
* cell instance sg13cmos5l_decap_8_2231 r0 *1 0,0
Xsg13cmos5l_decap_8_2231 \$2 \$1 sg13cmos5l_decap_8
* cell instance sg13cmos5l_decap_8_2232 r0 *1 0,0
Xsg13cmos5l_decap_8_2232 \$2 \$1 sg13cmos5l_decap_8
* cell instance sg13cmos5l_decap_8_2233 r0 *1 0,0
Xsg13cmos5l_decap_8_2233 \$2 \$1 sg13cmos5l_decap_8
* cell instance sg13cmos5l_decap_8_2234 r0 *1 0,0
Xsg13cmos5l_decap_8_2234 \$2 \$1 sg13cmos5l_decap_8
* cell instance sg13cmos5l_decap_8_2235 r0 *1 0,0
Xsg13cmos5l_decap_8_2235 \$2 \$1 sg13cmos5l_decap_8
* cell instance sg13cmos5l_decap_8_2236 r0 *1 0,0
Xsg13cmos5l_decap_8_2236 \$2 \$1 sg13cmos5l_decap_8
* cell instance sg13cmos5l_decap_8_2237 r0 *1 0,0
Xsg13cmos5l_decap_8_2237 \$2 \$1 sg13cmos5l_decap_8
* cell instance sg13cmos5l_decap_8_2238 r0 *1 0,0
Xsg13cmos5l_decap_8_2238 \$2 \$1 sg13cmos5l_decap_8
* cell instance sg13cmos5l_decap_8_2239 r0 *1 0,0
Xsg13cmos5l_decap_8_2239 \$2 \$1 sg13cmos5l_decap_8
* cell instance sg13cmos5l_decap_8_2240 r0 *1 0,0
Xsg13cmos5l_decap_8_2240 \$2 \$1 sg13cmos5l_decap_8
* cell instance sg13cmos5l_decap_8_2241 r0 *1 0,0
Xsg13cmos5l_decap_8_2241 \$2 \$1 sg13cmos5l_decap_8
* cell instance sg13cmos5l_decap_8_2242 r0 *1 0,0
Xsg13cmos5l_decap_8_2242 \$2 \$1 sg13cmos5l_decap_8
* cell instance sg13cmos5l_decap_8_2243 r0 *1 0,0
Xsg13cmos5l_decap_8_2243 \$2 \$1 sg13cmos5l_decap_8
* cell instance sg13cmos5l_decap_8_2244 r0 *1 0,0
Xsg13cmos5l_decap_8_2244 \$2 \$1 sg13cmos5l_decap_8
* cell instance sg13cmos5l_decap_8_2245 r0 *1 0,0
Xsg13cmos5l_decap_8_2245 \$2 \$1 sg13cmos5l_decap_8
* cell instance sg13cmos5l_decap_8_2246 r0 *1 0,0
Xsg13cmos5l_decap_8_2246 \$2 \$1 sg13cmos5l_decap_8
* cell instance sg13cmos5l_decap_8_2247 r0 *1 0,0
Xsg13cmos5l_decap_8_2247 \$2 \$1 sg13cmos5l_decap_8
* cell instance sg13cmos5l_decap_8_2248 r0 *1 0,0
Xsg13cmos5l_decap_8_2248 \$2 \$1 sg13cmos5l_decap_8
* cell instance sg13cmos5l_decap_8_2249 r0 *1 0,0
Xsg13cmos5l_decap_8_2249 \$2 \$1 sg13cmos5l_decap_8
* cell instance sg13cmos5l_decap_8_2250 r0 *1 0,0
Xsg13cmos5l_decap_8_2250 \$2 \$1 sg13cmos5l_decap_8
* cell instance sg13cmos5l_decap_8_2251 r0 *1 0,0
Xsg13cmos5l_decap_8_2251 \$2 \$1 sg13cmos5l_decap_8
* cell instance sg13cmos5l_decap_8_2252 r0 *1 0,0
Xsg13cmos5l_decap_8_2252 \$2 \$1 sg13cmos5l_decap_8
* cell instance sg13cmos5l_decap_8_2253 r0 *1 0,0
Xsg13cmos5l_decap_8_2253 \$2 \$1 sg13cmos5l_decap_8
* cell instance sg13cmos5l_decap_8_2254 r0 *1 0,0
Xsg13cmos5l_decap_8_2254 \$2 \$1 sg13cmos5l_decap_8
* cell instance sg13cmos5l_decap_8_2255 r0 *1 0,0
Xsg13cmos5l_decap_8_2255 \$2 \$1 sg13cmos5l_decap_8
* cell instance sg13cmos5l_decap_8_2256 r0 *1 0,0
Xsg13cmos5l_decap_8_2256 \$2 \$1 sg13cmos5l_decap_8
* cell instance sg13cmos5l_decap_8_2257 r0 *1 0,0
Xsg13cmos5l_decap_8_2257 \$2 \$1 sg13cmos5l_decap_8
* cell instance sg13cmos5l_decap_8_2258 r0 *1 0,0
Xsg13cmos5l_decap_8_2258 \$2 \$1 sg13cmos5l_decap_8
* cell instance sg13cmos5l_decap_8_2259 r0 *1 0,0
Xsg13cmos5l_decap_8_2259 \$2 \$1 sg13cmos5l_decap_8
* cell instance sg13cmos5l_decap_8_2260 r0 *1 0,0
Xsg13cmos5l_decap_8_2260 \$2 \$1 sg13cmos5l_decap_8
* cell instance sg13cmos5l_decap_8_2261 r0 *1 0,0
Xsg13cmos5l_decap_8_2261 \$2 \$1 sg13cmos5l_decap_8
* cell instance sg13cmos5l_decap_8_2262 r0 *1 0,0
Xsg13cmos5l_decap_8_2262 \$2 \$1 sg13cmos5l_decap_8
* cell instance sg13cmos5l_decap_8_2263 r0 *1 0,0
Xsg13cmos5l_decap_8_2263 \$2 \$1 sg13cmos5l_decap_8
* cell instance sg13cmos5l_decap_8_2264 r0 *1 0,0
Xsg13cmos5l_decap_8_2264 \$2 \$1 sg13cmos5l_decap_8
* cell instance sg13cmos5l_decap_8_2265 r0 *1 0,0
Xsg13cmos5l_decap_8_2265 \$2 \$1 sg13cmos5l_decap_8
* cell instance sg13cmos5l_decap_8_2266 r0 *1 0,0
Xsg13cmos5l_decap_8_2266 \$2 \$1 sg13cmos5l_decap_8
* cell instance sg13cmos5l_decap_8_2267 r0 *1 0,0
Xsg13cmos5l_decap_8_2267 \$2 \$1 sg13cmos5l_decap_8
* cell instance sg13cmos5l_decap_8_2268 r0 *1 0,0
Xsg13cmos5l_decap_8_2268 \$2 \$1 sg13cmos5l_decap_8
* cell instance sg13cmos5l_decap_8_2269 r0 *1 0,0
Xsg13cmos5l_decap_8_2269 \$2 \$1 sg13cmos5l_decap_8
* cell instance sg13cmos5l_decap_8_2270 r0 *1 0,0
Xsg13cmos5l_decap_8_2270 \$2 \$1 sg13cmos5l_decap_8
* cell instance sg13cmos5l_decap_8_2271 r0 *1 0,0
Xsg13cmos5l_decap_8_2271 \$2 \$1 sg13cmos5l_decap_8
* cell instance sg13cmos5l_decap_8_2272 r0 *1 0,0
Xsg13cmos5l_decap_8_2272 \$2 \$1 sg13cmos5l_decap_8
* cell instance sg13cmos5l_decap_8_2273 r0 *1 0,0
Xsg13cmos5l_decap_8_2273 \$2 \$1 sg13cmos5l_decap_8
* cell instance sg13cmos5l_decap_8_2274 r0 *1 0,0
Xsg13cmos5l_decap_8_2274 \$2 \$1 sg13cmos5l_decap_8
* cell instance sg13cmos5l_decap_8_2275 r0 *1 0,0
Xsg13cmos5l_decap_8_2275 \$2 \$1 sg13cmos5l_decap_8
* cell instance sg13cmos5l_decap_8_2276 r0 *1 0,0
Xsg13cmos5l_decap_8_2276 \$2 \$1 sg13cmos5l_decap_8
* cell instance sg13cmos5l_decap_8_2277 r0 *1 0,0
Xsg13cmos5l_decap_8_2277 \$2 \$1 sg13cmos5l_decap_8
* cell instance sg13cmos5l_decap_8_2278 r0 *1 0,0
Xsg13cmos5l_decap_8_2278 \$2 \$1 sg13cmos5l_decap_8
* cell instance sg13cmos5l_decap_8_2279 r0 *1 0,0
Xsg13cmos5l_decap_8_2279 \$2 \$1 sg13cmos5l_decap_8
* cell instance sg13cmos5l_decap_8_2280 r0 *1 0,0
Xsg13cmos5l_decap_8_2280 \$2 \$1 sg13cmos5l_decap_8
* cell instance sg13cmos5l_decap_8_2281 r0 *1 0,0
Xsg13cmos5l_decap_8_2281 \$2 \$1 sg13cmos5l_decap_8
* cell instance sg13cmos5l_decap_8_2282 r0 *1 0,0
Xsg13cmos5l_decap_8_2282 \$2 \$1 sg13cmos5l_decap_8
* cell instance sg13cmos5l_decap_8_2283 r0 *1 0,0
Xsg13cmos5l_decap_8_2283 \$2 \$1 sg13cmos5l_decap_8
* cell instance sg13cmos5l_decap_8_2284 r0 *1 0,0
Xsg13cmos5l_decap_8_2284 \$2 \$1 sg13cmos5l_decap_8
* cell instance sg13cmos5l_decap_8_2285 r0 *1 0,0
Xsg13cmos5l_decap_8_2285 \$2 \$1 sg13cmos5l_decap_8
* cell instance sg13cmos5l_decap_8_2286 r0 *1 0,0
Xsg13cmos5l_decap_8_2286 \$2 \$1 sg13cmos5l_decap_8
* cell instance sg13cmos5l_decap_8_2287 r0 *1 0,0
Xsg13cmos5l_decap_8_2287 \$2 \$1 sg13cmos5l_decap_8
* cell instance sg13cmos5l_decap_8_2288 r0 *1 0,0
Xsg13cmos5l_decap_8_2288 \$2 \$1 sg13cmos5l_decap_8
* cell instance sg13cmos5l_decap_8_2289 r0 *1 0,0
Xsg13cmos5l_decap_8_2289 \$2 \$1 sg13cmos5l_decap_8
* cell instance sg13cmos5l_decap_8_2290 r0 *1 0,0
Xsg13cmos5l_decap_8_2290 \$2 \$1 sg13cmos5l_decap_8
* cell instance sg13cmos5l_decap_8_2291 r0 *1 0,0
Xsg13cmos5l_decap_8_2291 \$2 \$1 sg13cmos5l_decap_8
* cell instance sg13cmos5l_decap_8_2292 r0 *1 0,0
Xsg13cmos5l_decap_8_2292 \$2 \$1 sg13cmos5l_decap_8
* cell instance sg13cmos5l_decap_8_2293 r0 *1 0,0
Xsg13cmos5l_decap_8_2293 \$2 \$1 sg13cmos5l_decap_8
* cell instance sg13cmos5l_decap_8_2294 r0 *1 0,0
Xsg13cmos5l_decap_8_2294 \$2 \$1 sg13cmos5l_decap_8
* cell instance sg13cmos5l_decap_8_2295 r0 *1 0,0
Xsg13cmos5l_decap_8_2295 \$2 \$1 sg13cmos5l_decap_8
* cell instance sg13cmos5l_decap_8_2296 r0 *1 0,0
Xsg13cmos5l_decap_8_2296 \$2 \$1 sg13cmos5l_decap_8
* cell instance sg13cmos5l_decap_8_2297 r0 *1 0,0
Xsg13cmos5l_decap_8_2297 \$2 \$1 sg13cmos5l_decap_8
* cell instance sg13cmos5l_decap_8_2298 r0 *1 0,0
Xsg13cmos5l_decap_8_2298 \$2 \$1 sg13cmos5l_decap_8
* cell instance sg13cmos5l_decap_8_2299 r0 *1 0,0
Xsg13cmos5l_decap_8_2299 \$2 \$1 sg13cmos5l_decap_8
* cell instance sg13cmos5l_decap_8_2300 r0 *1 0,0
Xsg13cmos5l_decap_8_2300 \$2 \$1 sg13cmos5l_decap_8
* cell instance sg13cmos5l_decap_8_2301 r0 *1 0,0
Xsg13cmos5l_decap_8_2301 \$2 \$1 sg13cmos5l_decap_8
* cell instance sg13cmos5l_decap_8_2302 r0 *1 0,0
Xsg13cmos5l_decap_8_2302 \$2 \$1 sg13cmos5l_decap_8
* cell instance sg13cmos5l_decap_8_2303 r0 *1 0,0
Xsg13cmos5l_decap_8_2303 \$2 \$1 sg13cmos5l_decap_8
* cell instance sg13cmos5l_decap_8_2304 r0 *1 0,0
Xsg13cmos5l_decap_8_2304 \$2 \$1 sg13cmos5l_decap_8
* cell instance sg13cmos5l_decap_8_2305 r0 *1 0,0
Xsg13cmos5l_decap_8_2305 \$2 \$1 sg13cmos5l_decap_8
* cell instance sg13cmos5l_decap_8_2306 r0 *1 0,0
Xsg13cmos5l_decap_8_2306 \$2 \$1 sg13cmos5l_decap_8
* cell instance sg13cmos5l_decap_8_2307 r0 *1 0,0
Xsg13cmos5l_decap_8_2307 \$2 \$1 sg13cmos5l_decap_8
* cell instance sg13cmos5l_decap_8_2308 r0 *1 0,0
Xsg13cmos5l_decap_8_2308 \$2 \$1 sg13cmos5l_decap_8
* cell instance sg13cmos5l_decap_8_2309 r0 *1 0,0
Xsg13cmos5l_decap_8_2309 \$2 \$1 sg13cmos5l_decap_8
* cell instance sg13cmos5l_decap_8_2310 r0 *1 0,0
Xsg13cmos5l_decap_8_2310 \$2 \$1 sg13cmos5l_decap_8
* cell instance sg13cmos5l_decap_8_2311 r0 *1 0,0
Xsg13cmos5l_decap_8_2311 \$2 \$1 sg13cmos5l_decap_8
* cell instance sg13cmos5l_decap_8_2312 r0 *1 0,0
Xsg13cmos5l_decap_8_2312 \$2 \$1 sg13cmos5l_decap_8
* cell instance sg13cmos5l_decap_8_2313 r0 *1 0,0
Xsg13cmos5l_decap_8_2313 \$2 \$1 sg13cmos5l_decap_8
* cell instance sg13cmos5l_decap_8_2314 r0 *1 0,0
Xsg13cmos5l_decap_8_2314 \$2 \$1 sg13cmos5l_decap_8
* cell instance sg13cmos5l_decap_8_2315 r0 *1 0,0
Xsg13cmos5l_decap_8_2315 \$2 \$1 sg13cmos5l_decap_8
* cell instance sg13cmos5l_decap_8_2316 r0 *1 0,0
Xsg13cmos5l_decap_8_2316 \$2 \$1 sg13cmos5l_decap_8
* cell instance sg13cmos5l_decap_8_2317 r0 *1 0,0
Xsg13cmos5l_decap_8_2317 \$2 \$1 sg13cmos5l_decap_8
* cell instance sg13cmos5l_decap_8_2318 r0 *1 0,0
Xsg13cmos5l_decap_8_2318 \$2 \$1 sg13cmos5l_decap_8
* cell instance sg13cmos5l_decap_8_2319 r0 *1 0,0
Xsg13cmos5l_decap_8_2319 \$2 \$1 sg13cmos5l_decap_8
* cell instance sg13cmos5l_decap_8_2320 r0 *1 0,0
Xsg13cmos5l_decap_8_2320 \$2 \$1 sg13cmos5l_decap_8
* cell instance sg13cmos5l_decap_8_2321 r0 *1 0,0
Xsg13cmos5l_decap_8_2321 \$2 \$1 sg13cmos5l_decap_8
* cell instance sg13cmos5l_decap_8_2322 r0 *1 0,0
Xsg13cmos5l_decap_8_2322 \$2 \$1 sg13cmos5l_decap_8
* cell instance sg13cmos5l_decap_8_2323 r0 *1 0,0
Xsg13cmos5l_decap_8_2323 \$2 \$1 sg13cmos5l_decap_8
* cell instance sg13cmos5l_decap_8_2324 r0 *1 0,0
Xsg13cmos5l_decap_8_2324 \$2 \$1 sg13cmos5l_decap_8
* cell instance sg13cmos5l_decap_8_2325 r0 *1 0,0
Xsg13cmos5l_decap_8_2325 \$2 \$1 sg13cmos5l_decap_8
* cell instance sg13cmos5l_decap_8_2326 r0 *1 0,0
Xsg13cmos5l_decap_8_2326 \$2 \$1 sg13cmos5l_decap_8
* cell instance sg13cmos5l_decap_8_2327 r0 *1 0,0
Xsg13cmos5l_decap_8_2327 \$2 \$1 sg13cmos5l_decap_8
* cell instance sg13cmos5l_decap_8_2328 r0 *1 0,0
Xsg13cmos5l_decap_8_2328 \$2 \$1 sg13cmos5l_decap_8
* cell instance sg13cmos5l_decap_8_2329 r0 *1 0,0
Xsg13cmos5l_decap_8_2329 \$2 \$1 sg13cmos5l_decap_8
* cell instance sg13cmos5l_decap_8_2330 r0 *1 0,0
Xsg13cmos5l_decap_8_2330 \$2 \$1 sg13cmos5l_decap_8
* cell instance sg13cmos5l_decap_8_2331 r0 *1 0,0
Xsg13cmos5l_decap_8_2331 \$2 \$1 sg13cmos5l_decap_8
* cell instance sg13cmos5l_decap_8_2332 r0 *1 0,0
Xsg13cmos5l_decap_8_2332 \$2 \$1 sg13cmos5l_decap_8
* cell instance sg13cmos5l_decap_8_2333 r0 *1 0,0
Xsg13cmos5l_decap_8_2333 \$2 \$1 sg13cmos5l_decap_8
* cell instance sg13cmos5l_decap_8_2334 r0 *1 0,0
Xsg13cmos5l_decap_8_2334 \$2 \$1 sg13cmos5l_decap_8
* cell instance sg13cmos5l_decap_8_2335 r0 *1 0,0
Xsg13cmos5l_decap_8_2335 \$2 \$1 sg13cmos5l_decap_8
* cell instance sg13cmos5l_decap_8_2336 r0 *1 0,0
Xsg13cmos5l_decap_8_2336 \$2 \$1 sg13cmos5l_decap_8
* cell instance sg13cmos5l_decap_8_2337 r0 *1 0,0
Xsg13cmos5l_decap_8_2337 \$2 \$1 sg13cmos5l_decap_8
* cell instance sg13cmos5l_decap_8_2338 r0 *1 0,0
Xsg13cmos5l_decap_8_2338 \$2 \$1 sg13cmos5l_decap_8
* cell instance sg13cmos5l_decap_8_2339 r0 *1 0,0
Xsg13cmos5l_decap_8_2339 \$2 \$1 sg13cmos5l_decap_8
* cell instance sg13cmos5l_decap_8_2340 r0 *1 0,0
Xsg13cmos5l_decap_8_2340 \$2 \$1 sg13cmos5l_decap_8
* cell instance sg13cmos5l_decap_8_2341 r0 *1 0,0
Xsg13cmos5l_decap_8_2341 \$2 \$1 sg13cmos5l_decap_8
* cell instance sg13cmos5l_decap_8_2342 r0 *1 0,0
Xsg13cmos5l_decap_8_2342 \$2 \$1 sg13cmos5l_decap_8
* cell instance sg13cmos5l_decap_8_2343 r0 *1 0,0
Xsg13cmos5l_decap_8_2343 \$2 \$1 sg13cmos5l_decap_8
* cell instance sg13cmos5l_decap_8_2344 r0 *1 0,0
Xsg13cmos5l_decap_8_2344 \$2 \$1 sg13cmos5l_decap_8
* cell instance sg13cmos5l_decap_8_2345 r0 *1 0,0
Xsg13cmos5l_decap_8_2345 \$2 \$1 sg13cmos5l_decap_8
* cell instance sg13cmos5l_decap_8_2346 r0 *1 0,0
Xsg13cmos5l_decap_8_2346 \$2 \$1 sg13cmos5l_decap_8
* cell instance sg13cmos5l_decap_8_2347 r0 *1 0,0
Xsg13cmos5l_decap_8_2347 \$2 \$1 sg13cmos5l_decap_8
* cell instance sg13cmos5l_decap_8_2348 r0 *1 0,0
Xsg13cmos5l_decap_8_2348 \$2 \$1 sg13cmos5l_decap_8
* cell instance sg13cmos5l_decap_8_2349 r0 *1 0,0
Xsg13cmos5l_decap_8_2349 \$2 \$1 sg13cmos5l_decap_8
* cell instance sg13cmos5l_decap_8_2350 r0 *1 0,0
Xsg13cmos5l_decap_8_2350 \$2 \$1 sg13cmos5l_decap_8
* cell instance sg13cmos5l_decap_8_2351 r0 *1 0,0
Xsg13cmos5l_decap_8_2351 \$2 \$1 sg13cmos5l_decap_8
* cell instance sg13cmos5l_decap_8_2352 r0 *1 0,0
Xsg13cmos5l_decap_8_2352 \$2 \$1 sg13cmos5l_decap_8
* cell instance sg13cmos5l_decap_8_2353 r0 *1 0,0
Xsg13cmos5l_decap_8_2353 \$2 \$1 sg13cmos5l_decap_8
* cell instance sg13cmos5l_decap_8_2354 r0 *1 0,0
Xsg13cmos5l_decap_8_2354 \$2 \$1 sg13cmos5l_decap_8
* cell instance sg13cmos5l_decap_8_2355 r0 *1 0,0
Xsg13cmos5l_decap_8_2355 \$2 \$1 sg13cmos5l_decap_8
* cell instance sg13cmos5l_decap_8_2356 r0 *1 0,0
Xsg13cmos5l_decap_8_2356 \$2 \$1 sg13cmos5l_decap_8
* cell instance sg13cmos5l_decap_8_2357 r0 *1 0,0
Xsg13cmos5l_decap_8_2357 \$2 \$1 sg13cmos5l_decap_8
* cell instance sg13cmos5l_decap_8_2358 r0 *1 0,0
Xsg13cmos5l_decap_8_2358 \$2 \$1 sg13cmos5l_decap_8
* cell instance sg13cmos5l_decap_8_2359 r0 *1 0,0
Xsg13cmos5l_decap_8_2359 \$2 \$1 sg13cmos5l_decap_8
* cell instance sg13cmos5l_decap_8_2360 r0 *1 0,0
Xsg13cmos5l_decap_8_2360 \$2 \$1 sg13cmos5l_decap_8
* cell instance sg13cmos5l_decap_8_2361 r0 *1 0,0
Xsg13cmos5l_decap_8_2361 \$2 \$1 sg13cmos5l_decap_8
* cell instance sg13cmos5l_decap_8_2362 r0 *1 0,0
Xsg13cmos5l_decap_8_2362 \$2 \$1 sg13cmos5l_decap_8
* cell instance sg13cmos5l_decap_8_2363 r0 *1 0,0
Xsg13cmos5l_decap_8_2363 \$2 \$1 sg13cmos5l_decap_8
* cell instance sg13cmos5l_decap_8_2364 r0 *1 0,0
Xsg13cmos5l_decap_8_2364 \$2 \$1 sg13cmos5l_decap_8
* cell instance sg13cmos5l_decap_8_2365 r0 *1 0,0
Xsg13cmos5l_decap_8_2365 \$2 \$1 sg13cmos5l_decap_8
* cell instance sg13cmos5l_decap_8_2366 r0 *1 0,0
Xsg13cmos5l_decap_8_2366 \$2 \$1 sg13cmos5l_decap_8
* cell instance sg13cmos5l_decap_8_2367 r0 *1 0,0
Xsg13cmos5l_decap_8_2367 \$2 \$1 sg13cmos5l_decap_8
* cell instance sg13cmos5l_decap_8_2368 r0 *1 0,0
Xsg13cmos5l_decap_8_2368 \$2 \$1 sg13cmos5l_decap_8
* cell instance sg13cmos5l_decap_8_2369 r0 *1 0,0
Xsg13cmos5l_decap_8_2369 \$2 \$1 sg13cmos5l_decap_8
* cell instance sg13cmos5l_decap_8_2370 r0 *1 0,0
Xsg13cmos5l_decap_8_2370 \$2 \$1 sg13cmos5l_decap_8
* cell instance sg13cmos5l_decap_8_2371 r0 *1 0,0
Xsg13cmos5l_decap_8_2371 \$2 \$1 sg13cmos5l_decap_8
* cell instance sg13cmos5l_decap_8_2372 r0 *1 0,0
Xsg13cmos5l_decap_8_2372 \$2 \$1 sg13cmos5l_decap_8
* cell instance sg13cmos5l_decap_8_2373 r0 *1 0,0
Xsg13cmos5l_decap_8_2373 \$2 \$1 sg13cmos5l_decap_8
* cell instance sg13cmos5l_decap_8_2374 r0 *1 0,0
Xsg13cmos5l_decap_8_2374 \$2 \$1 sg13cmos5l_decap_8
* cell instance sg13cmos5l_decap_8_2375 r0 *1 0,0
Xsg13cmos5l_decap_8_2375 \$2 \$1 sg13cmos5l_decap_8
* cell instance sg13cmos5l_decap_8_2376 r0 *1 0,0
Xsg13cmos5l_decap_8_2376 \$2 \$1 sg13cmos5l_decap_8
* cell instance sg13cmos5l_decap_8_2377 r0 *1 0,0
Xsg13cmos5l_decap_8_2377 \$2 \$1 sg13cmos5l_decap_8
* cell instance sg13cmos5l_decap_8_2378 r0 *1 0,0
Xsg13cmos5l_decap_8_2378 \$2 \$1 sg13cmos5l_decap_8
* cell instance sg13cmos5l_decap_8_2379 r0 *1 0,0
Xsg13cmos5l_decap_8_2379 \$2 \$1 sg13cmos5l_decap_8
* cell instance sg13cmos5l_decap_8_2380 r0 *1 0,0
Xsg13cmos5l_decap_8_2380 \$2 \$1 sg13cmos5l_decap_8
* cell instance sg13cmos5l_decap_8_2381 r0 *1 0,0
Xsg13cmos5l_decap_8_2381 \$2 \$1 sg13cmos5l_decap_8
* cell instance sg13cmos5l_decap_8_2382 r0 *1 0,0
Xsg13cmos5l_decap_8_2382 \$2 \$1 sg13cmos5l_decap_8
* cell instance sg13cmos5l_decap_8_2383 r0 *1 0,0
Xsg13cmos5l_decap_8_2383 \$2 \$1 sg13cmos5l_decap_8
* cell instance sg13cmos5l_decap_8_2384 r0 *1 0,0
Xsg13cmos5l_decap_8_2384 \$2 \$1 sg13cmos5l_decap_8
* cell instance sg13cmos5l_decap_8_2385 r0 *1 0,0
Xsg13cmos5l_decap_8_2385 \$2 \$1 sg13cmos5l_decap_8
* cell instance sg13cmos5l_decap_8_2386 r0 *1 0,0
Xsg13cmos5l_decap_8_2386 \$2 \$1 sg13cmos5l_decap_8
* cell instance sg13cmos5l_decap_8_2387 r0 *1 0,0
Xsg13cmos5l_decap_8_2387 \$2 \$1 sg13cmos5l_decap_8
* cell instance sg13cmos5l_decap_8_2388 r0 *1 0,0
Xsg13cmos5l_decap_8_2388 \$2 \$1 sg13cmos5l_decap_8
* cell instance sg13cmos5l_decap_8_2389 r0 *1 0,0
Xsg13cmos5l_decap_8_2389 \$2 \$1 sg13cmos5l_decap_8
* cell instance sg13cmos5l_decap_8_2390 r0 *1 0,0
Xsg13cmos5l_decap_8_2390 \$2 \$1 sg13cmos5l_decap_8
* cell instance sg13cmos5l_decap_8_2391 r0 *1 0,0
Xsg13cmos5l_decap_8_2391 \$2 \$1 sg13cmos5l_decap_8
* cell instance sg13cmos5l_decap_8_2392 r0 *1 0,0
Xsg13cmos5l_decap_8_2392 \$2 \$1 sg13cmos5l_decap_8
* cell instance sg13cmos5l_decap_8_2393 r0 *1 0,0
Xsg13cmos5l_decap_8_2393 \$2 \$1 sg13cmos5l_decap_8
* cell instance sg13cmos5l_decap_8_2394 r0 *1 0,0
Xsg13cmos5l_decap_8_2394 \$2 \$1 sg13cmos5l_decap_8
* cell instance sg13cmos5l_decap_8_2395 r0 *1 0,0
Xsg13cmos5l_decap_8_2395 \$2 \$1 sg13cmos5l_decap_8
* cell instance sg13cmos5l_decap_8_2396 r0 *1 0,0
Xsg13cmos5l_decap_8_2396 \$2 \$1 sg13cmos5l_decap_8
* cell instance sg13cmos5l_decap_8_2397 r0 *1 0,0
Xsg13cmos5l_decap_8_2397 \$2 \$1 sg13cmos5l_decap_8
* cell instance sg13cmos5l_decap_8_2398 r0 *1 0,0
Xsg13cmos5l_decap_8_2398 \$2 \$1 sg13cmos5l_decap_8
* cell instance sg13cmos5l_decap_8_2399 r0 *1 0,0
Xsg13cmos5l_decap_8_2399 \$2 \$1 sg13cmos5l_decap_8
* cell instance sg13cmos5l_decap_8_2400 r0 *1 0,0
Xsg13cmos5l_decap_8_2400 \$2 \$1 sg13cmos5l_decap_8
* cell instance sg13cmos5l_decap_8_2401 r0 *1 0,0
Xsg13cmos5l_decap_8_2401 \$2 \$1 sg13cmos5l_decap_8
* cell instance sg13cmos5l_decap_8_2402 r0 *1 0,0
Xsg13cmos5l_decap_8_2402 \$2 \$1 sg13cmos5l_decap_8
* cell instance sg13cmos5l_decap_8_2403 r0 *1 0,0
Xsg13cmos5l_decap_8_2403 \$2 \$1 sg13cmos5l_decap_8
* cell instance sg13cmos5l_decap_8_2404 r0 *1 0,0
Xsg13cmos5l_decap_8_2404 \$2 \$1 sg13cmos5l_decap_8
* cell instance sg13cmos5l_decap_8_2405 r0 *1 0,0
Xsg13cmos5l_decap_8_2405 \$2 \$1 sg13cmos5l_decap_8
* cell instance sg13cmos5l_decap_8_2406 r0 *1 0,0
Xsg13cmos5l_decap_8_2406 \$2 \$1 sg13cmos5l_decap_8
* cell instance sg13cmos5l_decap_8_2407 r0 *1 0,0
Xsg13cmos5l_decap_8_2407 \$2 \$1 sg13cmos5l_decap_8
* cell instance sg13cmos5l_decap_8_2408 r0 *1 0,0
Xsg13cmos5l_decap_8_2408 \$2 \$1 sg13cmos5l_decap_8
* cell instance sg13cmos5l_decap_8_2409 r0 *1 0,0
Xsg13cmos5l_decap_8_2409 \$2 \$1 sg13cmos5l_decap_8
* cell instance sg13cmos5l_decap_8_2410 r0 *1 0,0
Xsg13cmos5l_decap_8_2410 \$2 \$1 sg13cmos5l_decap_8
* cell instance sg13cmos5l_decap_8_2411 r0 *1 0,0
Xsg13cmos5l_decap_8_2411 \$2 \$1 sg13cmos5l_decap_8
* cell instance sg13cmos5l_decap_8_2412 r0 *1 0,0
Xsg13cmos5l_decap_8_2412 \$2 \$1 sg13cmos5l_decap_8
* cell instance sg13cmos5l_decap_8_2413 r0 *1 0,0
Xsg13cmos5l_decap_8_2413 \$2 \$1 sg13cmos5l_decap_8
* cell instance sg13cmos5l_decap_8_2414 r0 *1 0,0
Xsg13cmos5l_decap_8_2414 \$2 \$1 sg13cmos5l_decap_8
* cell instance sg13cmos5l_decap_8_2415 r0 *1 0,0
Xsg13cmos5l_decap_8_2415 \$2 \$1 sg13cmos5l_decap_8
* cell instance sg13cmos5l_decap_8_2416 r0 *1 0,0
Xsg13cmos5l_decap_8_2416 \$2 \$1 sg13cmos5l_decap_8
* cell instance sg13cmos5l_decap_8_2417 r0 *1 0,0
Xsg13cmos5l_decap_8_2417 \$2 \$1 sg13cmos5l_decap_8
* cell instance sg13cmos5l_decap_8_2418 r0 *1 0,0
Xsg13cmos5l_decap_8_2418 \$2 \$1 sg13cmos5l_decap_8
* cell instance sg13cmos5l_decap_8_2419 r0 *1 0,0
Xsg13cmos5l_decap_8_2419 \$2 \$1 sg13cmos5l_decap_8
* cell instance sg13cmos5l_decap_8_2420 r0 *1 0,0
Xsg13cmos5l_decap_8_2420 \$2 \$1 sg13cmos5l_decap_8
* cell instance sg13cmos5l_decap_8_2421 r0 *1 0,0
Xsg13cmos5l_decap_8_2421 \$2 \$1 sg13cmos5l_decap_8
* cell instance sg13cmos5l_decap_8_2422 r0 *1 0,0
Xsg13cmos5l_decap_8_2422 \$2 \$1 sg13cmos5l_decap_8
* cell instance sg13cmos5l_decap_8_2423 r0 *1 0,0
Xsg13cmos5l_decap_8_2423 \$2 \$1 sg13cmos5l_decap_8
* cell instance sg13cmos5l_decap_8_2424 r0 *1 0,0
Xsg13cmos5l_decap_8_2424 \$2 \$1 sg13cmos5l_decap_8
* cell instance sg13cmos5l_decap_8_2425 r0 *1 0,0
Xsg13cmos5l_decap_8_2425 \$2 \$1 sg13cmos5l_decap_8
* cell instance sg13cmos5l_decap_8_2426 r0 *1 0,0
Xsg13cmos5l_decap_8_2426 \$2 \$1 sg13cmos5l_decap_8
* cell instance sg13cmos5l_decap_8_2427 r0 *1 0,0
Xsg13cmos5l_decap_8_2427 \$2 \$1 sg13cmos5l_decap_8
* cell instance sg13cmos5l_decap_8_2428 r0 *1 0,0
Xsg13cmos5l_decap_8_2428 \$2 \$1 sg13cmos5l_decap_8
* cell instance sg13cmos5l_decap_8_2429 r0 *1 0,0
Xsg13cmos5l_decap_8_2429 \$2 \$1 sg13cmos5l_decap_8
* cell instance sg13cmos5l_decap_8_2430 r0 *1 0,0
Xsg13cmos5l_decap_8_2430 \$2 \$1 sg13cmos5l_decap_8
* cell instance sg13cmos5l_decap_8_2431 r0 *1 0,0
Xsg13cmos5l_decap_8_2431 \$2 \$1 sg13cmos5l_decap_8
* cell instance sg13cmos5l_decap_8_2432 r0 *1 0,0
Xsg13cmos5l_decap_8_2432 \$2 \$1 sg13cmos5l_decap_8
* cell instance sg13cmos5l_decap_8_2433 r0 *1 0,0
Xsg13cmos5l_decap_8_2433 \$2 \$1 sg13cmos5l_decap_8
* cell instance sg13cmos5l_decap_8_2434 r0 *1 0,0
Xsg13cmos5l_decap_8_2434 \$2 \$1 sg13cmos5l_decap_8
* cell instance sg13cmos5l_decap_8_2435 r0 *1 0,0
Xsg13cmos5l_decap_8_2435 \$2 \$1 sg13cmos5l_decap_8
* cell instance sg13cmos5l_decap_8_2436 r0 *1 0,0
Xsg13cmos5l_decap_8_2436 \$2 \$1 sg13cmos5l_decap_8
* cell instance sg13cmos5l_decap_8_2437 r0 *1 0,0
Xsg13cmos5l_decap_8_2437 \$2 \$1 sg13cmos5l_decap_8
* cell instance sg13cmos5l_decap_8_2438 r0 *1 0,0
Xsg13cmos5l_decap_8_2438 \$2 \$1 sg13cmos5l_decap_8
* cell instance sg13cmos5l_decap_8_2439 r0 *1 0,0
Xsg13cmos5l_decap_8_2439 \$2 \$1 sg13cmos5l_decap_8
* cell instance sg13cmos5l_decap_8_2440 r0 *1 0,0
Xsg13cmos5l_decap_8_2440 \$2 \$1 sg13cmos5l_decap_8
* cell instance sg13cmos5l_decap_8_2441 r0 *1 0,0
Xsg13cmos5l_decap_8_2441 \$2 \$1 sg13cmos5l_decap_8
* cell instance sg13cmos5l_decap_8_2442 r0 *1 0,0
Xsg13cmos5l_decap_8_2442 \$2 \$1 sg13cmos5l_decap_8
* cell instance sg13cmos5l_decap_8_2443 r0 *1 0,0
Xsg13cmos5l_decap_8_2443 \$2 \$1 sg13cmos5l_decap_8
* cell instance sg13cmos5l_decap_8_2444 r0 *1 0,0
Xsg13cmos5l_decap_8_2444 \$2 \$1 sg13cmos5l_decap_8
* cell instance sg13cmos5l_decap_8_2445 r0 *1 0,0
Xsg13cmos5l_decap_8_2445 \$2 \$1 sg13cmos5l_decap_8
* cell instance sg13cmos5l_decap_8_2446 r0 *1 0,0
Xsg13cmos5l_decap_8_2446 \$2 \$1 sg13cmos5l_decap_8
* cell instance sg13cmos5l_decap_8_2447 r0 *1 0,0
Xsg13cmos5l_decap_8_2447 \$2 \$1 sg13cmos5l_decap_8
* cell instance sg13cmos5l_decap_8_2448 r0 *1 0,0
Xsg13cmos5l_decap_8_2448 \$2 \$1 sg13cmos5l_decap_8
* cell instance sg13cmos5l_decap_8_2449 r0 *1 0,0
Xsg13cmos5l_decap_8_2449 \$2 \$1 sg13cmos5l_decap_8
* cell instance sg13cmos5l_decap_8_2450 r0 *1 0,0
Xsg13cmos5l_decap_8_2450 \$2 \$1 sg13cmos5l_decap_8
* cell instance sg13cmos5l_decap_8_2451 r0 *1 0,0
Xsg13cmos5l_decap_8_2451 \$2 \$1 sg13cmos5l_decap_8
* cell instance sg13cmos5l_decap_8_2452 r0 *1 0,0
Xsg13cmos5l_decap_8_2452 \$2 \$1 sg13cmos5l_decap_8
* cell instance sg13cmos5l_decap_8_2453 r0 *1 0,0
Xsg13cmos5l_decap_8_2453 \$2 \$1 sg13cmos5l_decap_8
* cell instance sg13cmos5l_decap_8_2454 r0 *1 0,0
Xsg13cmos5l_decap_8_2454 \$2 \$1 sg13cmos5l_decap_8
* cell instance sg13cmos5l_decap_8_2455 r0 *1 0,0
Xsg13cmos5l_decap_8_2455 \$2 \$1 sg13cmos5l_decap_8
* cell instance sg13cmos5l_decap_8_2456 r0 *1 0,0
Xsg13cmos5l_decap_8_2456 \$2 \$1 sg13cmos5l_decap_8
* cell instance sg13cmos5l_decap_8_2457 r0 *1 0,0
Xsg13cmos5l_decap_8_2457 \$2 \$1 sg13cmos5l_decap_8
* cell instance sg13cmos5l_decap_8_2458 r0 *1 0,0
Xsg13cmos5l_decap_8_2458 \$2 \$1 sg13cmos5l_decap_8
* cell instance sg13cmos5l_decap_8_2459 r0 *1 0,0
Xsg13cmos5l_decap_8_2459 \$2 \$1 sg13cmos5l_decap_8
* cell instance sg13cmos5l_decap_8_2460 r0 *1 0,0
Xsg13cmos5l_decap_8_2460 \$2 \$1 sg13cmos5l_decap_8
* cell instance sg13cmos5l_decap_8_2461 r0 *1 0,0
Xsg13cmos5l_decap_8_2461 \$2 \$1 sg13cmos5l_decap_8
* cell instance sg13cmos5l_decap_8_2462 r0 *1 0,0
Xsg13cmos5l_decap_8_2462 \$2 \$1 sg13cmos5l_decap_8
* cell instance sg13cmos5l_decap_8_2463 r0 *1 0,0
Xsg13cmos5l_decap_8_2463 \$2 \$1 sg13cmos5l_decap_8
* cell instance sg13cmos5l_decap_8_2464 r0 *1 0,0
Xsg13cmos5l_decap_8_2464 \$2 \$1 sg13cmos5l_decap_8
* cell instance sg13cmos5l_decap_8_2465 r0 *1 0,0
Xsg13cmos5l_decap_8_2465 \$2 \$1 sg13cmos5l_decap_8
* cell instance sg13cmos5l_decap_8_2466 r0 *1 0,0
Xsg13cmos5l_decap_8_2466 \$2 \$1 sg13cmos5l_decap_8
* cell instance sg13cmos5l_decap_8_2467 r0 *1 0,0
Xsg13cmos5l_decap_8_2467 \$2 \$1 sg13cmos5l_decap_8
* cell instance sg13cmos5l_decap_8_2468 r0 *1 0,0
Xsg13cmos5l_decap_8_2468 \$2 \$1 sg13cmos5l_decap_8
* cell instance sg13cmos5l_decap_8_2469 r0 *1 0,0
Xsg13cmos5l_decap_8_2469 \$2 \$1 sg13cmos5l_decap_8
* cell instance sg13cmos5l_decap_8_2470 r0 *1 0,0
Xsg13cmos5l_decap_8_2470 \$2 \$1 sg13cmos5l_decap_8
* cell instance sg13cmos5l_decap_8_2471 r0 *1 0,0
Xsg13cmos5l_decap_8_2471 \$2 \$1 sg13cmos5l_decap_8
* cell instance sg13cmos5l_decap_8_2472 r0 *1 0,0
Xsg13cmos5l_decap_8_2472 \$2 \$1 sg13cmos5l_decap_8
* cell instance sg13cmos5l_decap_8_2473 r0 *1 0,0
Xsg13cmos5l_decap_8_2473 \$2 \$1 sg13cmos5l_decap_8
* cell instance sg13cmos5l_decap_8_2474 r0 *1 0,0
Xsg13cmos5l_decap_8_2474 \$2 \$1 sg13cmos5l_decap_8
* cell instance sg13cmos5l_decap_8_2475 r0 *1 0,0
Xsg13cmos5l_decap_8_2475 \$2 \$1 sg13cmos5l_decap_8
* cell instance sg13cmos5l_decap_8_2476 r0 *1 0,0
Xsg13cmos5l_decap_8_2476 \$2 \$1 sg13cmos5l_decap_8
* cell instance sg13cmos5l_decap_8_2477 r0 *1 0,0
Xsg13cmos5l_decap_8_2477 \$2 \$1 sg13cmos5l_decap_8
* cell instance sg13cmos5l_decap_8_2478 r0 *1 0,0
Xsg13cmos5l_decap_8_2478 \$2 \$1 sg13cmos5l_decap_8
* cell instance sg13cmos5l_decap_8_2479 r0 *1 0,0
Xsg13cmos5l_decap_8_2479 \$2 \$1 sg13cmos5l_decap_8
* cell instance sg13cmos5l_decap_8_2480 r0 *1 0,0
Xsg13cmos5l_decap_8_2480 \$2 \$1 sg13cmos5l_decap_8
* cell instance sg13cmos5l_decap_8_2481 r0 *1 0,0
Xsg13cmos5l_decap_8_2481 \$2 \$1 sg13cmos5l_decap_8
* cell instance sg13cmos5l_decap_8_2482 r0 *1 0,0
Xsg13cmos5l_decap_8_2482 \$2 \$1 sg13cmos5l_decap_8
* cell instance sg13cmos5l_decap_8_2483 r0 *1 0,0
Xsg13cmos5l_decap_8_2483 \$2 \$1 sg13cmos5l_decap_8
* cell instance sg13cmos5l_decap_8_2484 r0 *1 0,0
Xsg13cmos5l_decap_8_2484 \$2 \$1 sg13cmos5l_decap_8
* cell instance sg13cmos5l_decap_8_2485 r0 *1 0,0
Xsg13cmos5l_decap_8_2485 \$2 \$1 sg13cmos5l_decap_8
* cell instance sg13cmos5l_decap_8_2486 r0 *1 0,0
Xsg13cmos5l_decap_8_2486 \$2 \$1 sg13cmos5l_decap_8
* cell instance sg13cmos5l_decap_8_2487 r0 *1 0,0
Xsg13cmos5l_decap_8_2487 \$2 \$1 sg13cmos5l_decap_8
* cell instance sg13cmos5l_decap_8_2488 r0 *1 0,0
Xsg13cmos5l_decap_8_2488 \$2 \$1 sg13cmos5l_decap_8
* cell instance sg13cmos5l_decap_8_2489 r0 *1 0,0
Xsg13cmos5l_decap_8_2489 \$2 \$1 sg13cmos5l_decap_8
* cell instance sg13cmos5l_decap_8_2490 r0 *1 0,0
Xsg13cmos5l_decap_8_2490 \$2 \$1 sg13cmos5l_decap_8
* cell instance sg13cmos5l_decap_8_2491 r0 *1 0,0
Xsg13cmos5l_decap_8_2491 \$2 \$1 sg13cmos5l_decap_8
* cell instance sg13cmos5l_decap_8_2492 r0 *1 0,0
Xsg13cmos5l_decap_8_2492 \$2 \$1 sg13cmos5l_decap_8
* cell instance sg13cmos5l_decap_8_2493 r0 *1 0,0
Xsg13cmos5l_decap_8_2493 \$2 \$1 sg13cmos5l_decap_8
* cell instance sg13cmos5l_decap_8_2494 r0 *1 0,0
Xsg13cmos5l_decap_8_2494 \$2 \$1 sg13cmos5l_decap_8
* cell instance sg13cmos5l_decap_8_2495 r0 *1 0,0
Xsg13cmos5l_decap_8_2495 \$2 \$1 sg13cmos5l_decap_8
* cell instance sg13cmos5l_decap_8_2496 r0 *1 0,0
Xsg13cmos5l_decap_8_2496 \$2 \$1 sg13cmos5l_decap_8
* cell instance sg13cmos5l_decap_8_2497 r0 *1 0,0
Xsg13cmos5l_decap_8_2497 \$2 \$1 sg13cmos5l_decap_8
* cell instance sg13cmos5l_decap_8_2498 r0 *1 0,0
Xsg13cmos5l_decap_8_2498 \$2 \$1 sg13cmos5l_decap_8
* cell instance sg13cmos5l_decap_8_2499 r0 *1 0,0
Xsg13cmos5l_decap_8_2499 \$2 \$1 sg13cmos5l_decap_8
* cell instance sg13cmos5l_decap_8_2500 r0 *1 0,0
Xsg13cmos5l_decap_8_2500 \$2 \$1 sg13cmos5l_decap_8
* cell instance sg13cmos5l_decap_8_2501 r0 *1 0,0
Xsg13cmos5l_decap_8_2501 \$2 \$1 sg13cmos5l_decap_8
* cell instance sg13cmos5l_decap_8_2502 r0 *1 0,0
Xsg13cmos5l_decap_8_2502 \$2 \$1 sg13cmos5l_decap_8
* cell instance sg13cmos5l_decap_8_2503 r0 *1 0,0
Xsg13cmos5l_decap_8_2503 \$2 \$1 sg13cmos5l_decap_8
* cell instance sg13cmos5l_decap_8_2504 r0 *1 0,0
Xsg13cmos5l_decap_8_2504 \$2 \$1 sg13cmos5l_decap_8
* cell instance sg13cmos5l_decap_8_2505 r0 *1 0,0
Xsg13cmos5l_decap_8_2505 \$2 \$1 sg13cmos5l_decap_8
* cell instance sg13cmos5l_decap_8_2506 r0 *1 0,0
Xsg13cmos5l_decap_8_2506 \$2 \$1 sg13cmos5l_decap_8
* cell instance sg13cmos5l_decap_8_2507 r0 *1 0,0
Xsg13cmos5l_decap_8_2507 \$2 \$1 sg13cmos5l_decap_8
* cell instance sg13cmos5l_decap_8_2508 r0 *1 0,0
Xsg13cmos5l_decap_8_2508 \$2 \$1 sg13cmos5l_decap_8
* cell instance sg13cmos5l_decap_8_2509 r0 *1 0,0
Xsg13cmos5l_decap_8_2509 \$2 \$1 sg13cmos5l_decap_8
* cell instance sg13cmos5l_decap_8_2510 r0 *1 0,0
Xsg13cmos5l_decap_8_2510 \$2 \$1 sg13cmos5l_decap_8
* cell instance sg13cmos5l_decap_8_2511 r0 *1 0,0
Xsg13cmos5l_decap_8_2511 \$2 \$1 sg13cmos5l_decap_8
* cell instance sg13cmos5l_decap_8_2512 r0 *1 0,0
Xsg13cmos5l_decap_8_2512 \$2 \$1 sg13cmos5l_decap_8
* cell instance sg13cmos5l_decap_8_2513 r0 *1 0,0
Xsg13cmos5l_decap_8_2513 \$2 \$1 sg13cmos5l_decap_8
* cell instance sg13cmos5l_decap_8_2514 r0 *1 0,0
Xsg13cmos5l_decap_8_2514 \$2 \$1 sg13cmos5l_decap_8
* cell instance sg13cmos5l_decap_8_2515 r0 *1 0,0
Xsg13cmos5l_decap_8_2515 \$2 \$1 sg13cmos5l_decap_8
* cell instance sg13cmos5l_decap_8_2516 r0 *1 0,0
Xsg13cmos5l_decap_8_2516 \$2 \$1 sg13cmos5l_decap_8
* cell instance sg13cmos5l_decap_8_2517 r0 *1 0,0
Xsg13cmos5l_decap_8_2517 \$2 \$1 sg13cmos5l_decap_8
* cell instance sg13cmos5l_decap_8_2518 r0 *1 0,0
Xsg13cmos5l_decap_8_2518 \$2 \$1 sg13cmos5l_decap_8
* cell instance sg13cmos5l_decap_8_2519 r0 *1 0,0
Xsg13cmos5l_decap_8_2519 \$2 \$1 sg13cmos5l_decap_8
* cell instance sg13cmos5l_decap_8_2520 r0 *1 0,0
Xsg13cmos5l_decap_8_2520 \$2 \$1 sg13cmos5l_decap_8
* cell instance sg13cmos5l_decap_8_2521 r0 *1 0,0
Xsg13cmos5l_decap_8_2521 \$2 \$1 sg13cmos5l_decap_8
* cell instance sg13cmos5l_decap_8_2522 r0 *1 0,0
Xsg13cmos5l_decap_8_2522 \$2 \$1 sg13cmos5l_decap_8
* cell instance sg13cmos5l_decap_8_2523 r0 *1 0,0
Xsg13cmos5l_decap_8_2523 \$2 \$1 sg13cmos5l_decap_8
* cell instance sg13cmos5l_decap_8_2524 r0 *1 0,0
Xsg13cmos5l_decap_8_2524 \$2 \$1 sg13cmos5l_decap_8
* cell instance sg13cmos5l_decap_8_2525 r0 *1 0,0
Xsg13cmos5l_decap_8_2525 \$2 \$1 sg13cmos5l_decap_8
* cell instance sg13cmos5l_decap_8_2526 r0 *1 0,0
Xsg13cmos5l_decap_8_2526 \$2 \$1 sg13cmos5l_decap_8
* cell instance sg13cmos5l_decap_8_2527 r0 *1 0,0
Xsg13cmos5l_decap_8_2527 \$2 \$1 sg13cmos5l_decap_8
* cell instance sg13cmos5l_decap_8_2528 r0 *1 0,0
Xsg13cmos5l_decap_8_2528 \$2 \$1 sg13cmos5l_decap_8
* cell instance sg13cmos5l_decap_8_2529 r0 *1 0,0
Xsg13cmos5l_decap_8_2529 \$2 \$1 sg13cmos5l_decap_8
* cell instance sg13cmos5l_decap_8_2530 r0 *1 0,0
Xsg13cmos5l_decap_8_2530 \$2 \$1 sg13cmos5l_decap_8
* cell instance sg13cmos5l_decap_8_2531 r0 *1 0,0
Xsg13cmos5l_decap_8_2531 \$2 \$1 sg13cmos5l_decap_8
* cell instance sg13cmos5l_decap_8_2532 r0 *1 0,0
Xsg13cmos5l_decap_8_2532 \$2 \$1 sg13cmos5l_decap_8
* cell instance sg13cmos5l_decap_8_2533 r0 *1 0,0
Xsg13cmos5l_decap_8_2533 \$2 \$1 sg13cmos5l_decap_8
* cell instance sg13cmos5l_decap_8_2534 r0 *1 0,0
Xsg13cmos5l_decap_8_2534 \$2 \$1 sg13cmos5l_decap_8
* cell instance sg13cmos5l_decap_8_2535 r0 *1 0,0
Xsg13cmos5l_decap_8_2535 \$2 \$1 sg13cmos5l_decap_8
* cell instance sg13cmos5l_decap_8_2536 r0 *1 0,0
Xsg13cmos5l_decap_8_2536 \$2 \$1 sg13cmos5l_decap_8
* cell instance sg13cmos5l_decap_8_2537 r0 *1 0,0
Xsg13cmos5l_decap_8_2537 \$2 \$1 sg13cmos5l_decap_8
* cell instance sg13cmos5l_decap_8_2538 r0 *1 0,0
Xsg13cmos5l_decap_8_2538 \$2 \$1 sg13cmos5l_decap_8
* cell instance sg13cmos5l_decap_8_2539 r0 *1 0,0
Xsg13cmos5l_decap_8_2539 \$2 \$1 sg13cmos5l_decap_8
* cell instance sg13cmos5l_decap_8_2540 r0 *1 0,0
Xsg13cmos5l_decap_8_2540 \$2 \$1 sg13cmos5l_decap_8
* cell instance sg13cmos5l_decap_8_2541 r0 *1 0,0
Xsg13cmos5l_decap_8_2541 \$2 \$1 sg13cmos5l_decap_8
* cell instance sg13cmos5l_decap_8_2542 r0 *1 0,0
Xsg13cmos5l_decap_8_2542 \$2 \$1 sg13cmos5l_decap_8
* cell instance sg13cmos5l_decap_8_2543 r0 *1 0,0
Xsg13cmos5l_decap_8_2543 \$2 \$1 sg13cmos5l_decap_8
* cell instance sg13cmos5l_decap_8_2544 r0 *1 0,0
Xsg13cmos5l_decap_8_2544 \$2 \$1 sg13cmos5l_decap_8
* cell instance sg13cmos5l_decap_8_2545 r0 *1 0,0
Xsg13cmos5l_decap_8_2545 \$2 \$1 sg13cmos5l_decap_8
* cell instance sg13cmos5l_decap_8_2546 r0 *1 0,0
Xsg13cmos5l_decap_8_2546 \$2 \$1 sg13cmos5l_decap_8
* cell instance sg13cmos5l_decap_8_2547 r0 *1 0,0
Xsg13cmos5l_decap_8_2547 \$2 \$1 sg13cmos5l_decap_8
* cell instance sg13cmos5l_decap_8_2548 r0 *1 0,0
Xsg13cmos5l_decap_8_2548 \$2 \$1 sg13cmos5l_decap_8
* cell instance sg13cmos5l_decap_8_2549 r0 *1 0,0
Xsg13cmos5l_decap_8_2549 \$2 \$1 sg13cmos5l_decap_8
* cell instance sg13cmos5l_decap_8_2550 r0 *1 0,0
Xsg13cmos5l_decap_8_2550 \$2 \$1 sg13cmos5l_decap_8
* cell instance sg13cmos5l_decap_8_2551 r0 *1 0,0
Xsg13cmos5l_decap_8_2551 \$2 \$1 sg13cmos5l_decap_8
* cell instance sg13cmos5l_decap_8_2552 r0 *1 0,0
Xsg13cmos5l_decap_8_2552 \$2 \$1 sg13cmos5l_decap_8
* cell instance sg13cmos5l_decap_8_2553 r0 *1 0,0
Xsg13cmos5l_decap_8_2553 \$2 \$1 sg13cmos5l_decap_8
* cell instance sg13cmos5l_decap_8_2554 r0 *1 0,0
Xsg13cmos5l_decap_8_2554 \$2 \$1 sg13cmos5l_decap_8
* cell instance sg13cmos5l_decap_8_2555 r0 *1 0,0
Xsg13cmos5l_decap_8_2555 \$2 \$1 sg13cmos5l_decap_8
* cell instance sg13cmos5l_decap_8_2556 r0 *1 0,0
Xsg13cmos5l_decap_8_2556 \$2 \$1 sg13cmos5l_decap_8
* cell instance sg13cmos5l_decap_8_2557 r0 *1 0,0
Xsg13cmos5l_decap_8_2557 \$2 \$1 sg13cmos5l_decap_8
* cell instance sg13cmos5l_decap_8_2558 r0 *1 0,0
Xsg13cmos5l_decap_8_2558 \$2 \$1 sg13cmos5l_decap_8
* cell instance sg13cmos5l_decap_8_2559 r0 *1 0,0
Xsg13cmos5l_decap_8_2559 \$2 \$1 sg13cmos5l_decap_8
* cell instance sg13cmos5l_decap_8_2560 r0 *1 0,0
Xsg13cmos5l_decap_8_2560 \$2 \$1 sg13cmos5l_decap_8
* cell instance sg13cmos5l_decap_8_2561 r0 *1 0,0
Xsg13cmos5l_decap_8_2561 \$2 \$1 sg13cmos5l_decap_8
* cell instance sg13cmos5l_decap_8_2562 r0 *1 0,0
Xsg13cmos5l_decap_8_2562 \$2 \$1 sg13cmos5l_decap_8
* cell instance sg13cmos5l_decap_8_2563 r0 *1 0,0
Xsg13cmos5l_decap_8_2563 \$2 \$1 sg13cmos5l_decap_8
* cell instance sg13cmos5l_decap_8_2564 r0 *1 0,0
Xsg13cmos5l_decap_8_2564 \$2 \$1 sg13cmos5l_decap_8
* cell instance sg13cmos5l_decap_8_2565 r0 *1 0,0
Xsg13cmos5l_decap_8_2565 \$2 \$1 sg13cmos5l_decap_8
* cell instance sg13cmos5l_decap_8_2566 r0 *1 0,0
Xsg13cmos5l_decap_8_2566 \$2 \$1 sg13cmos5l_decap_8
* cell instance sg13cmos5l_decap_8_2567 r0 *1 0,0
Xsg13cmos5l_decap_8_2567 \$2 \$1 sg13cmos5l_decap_8
* cell instance sg13cmos5l_decap_8_2568 r0 *1 0,0
Xsg13cmos5l_decap_8_2568 \$2 \$1 sg13cmos5l_decap_8
* cell instance sg13cmos5l_decap_8_2569 r0 *1 0,0
Xsg13cmos5l_decap_8_2569 \$2 \$1 sg13cmos5l_decap_8
* cell instance sg13cmos5l_decap_8_2570 r0 *1 0,0
Xsg13cmos5l_decap_8_2570 \$2 \$1 sg13cmos5l_decap_8
* cell instance sg13cmos5l_decap_8_2571 r0 *1 0,0
Xsg13cmos5l_decap_8_2571 \$2 \$1 sg13cmos5l_decap_8
* cell instance sg13cmos5l_decap_8_2572 r0 *1 0,0
Xsg13cmos5l_decap_8_2572 \$2 \$1 sg13cmos5l_decap_8
* cell instance sg13cmos5l_decap_8_2573 r0 *1 0,0
Xsg13cmos5l_decap_8_2573 \$2 \$1 sg13cmos5l_decap_8
* cell instance sg13cmos5l_decap_8_2574 r0 *1 0,0
Xsg13cmos5l_decap_8_2574 \$2 \$1 sg13cmos5l_decap_8
* cell instance sg13cmos5l_decap_8_2575 r0 *1 0,0
Xsg13cmos5l_decap_8_2575 \$2 \$1 sg13cmos5l_decap_8
* cell instance sg13cmos5l_decap_8_2576 r0 *1 0,0
Xsg13cmos5l_decap_8_2576 \$2 \$1 sg13cmos5l_decap_8
* cell instance sg13cmos5l_decap_8_2577 r0 *1 0,0
Xsg13cmos5l_decap_8_2577 \$2 \$1 sg13cmos5l_decap_8
* cell instance sg13cmos5l_decap_8_2578 r0 *1 0,0
Xsg13cmos5l_decap_8_2578 \$2 \$1 sg13cmos5l_decap_8
* cell instance sg13cmos5l_decap_8_2579 r0 *1 0,0
Xsg13cmos5l_decap_8_2579 \$2 \$1 sg13cmos5l_decap_8
* cell instance sg13cmos5l_decap_8_2580 r0 *1 0,0
Xsg13cmos5l_decap_8_2580 \$2 \$1 sg13cmos5l_decap_8
* cell instance sg13cmos5l_decap_8_2581 r0 *1 0,0
Xsg13cmos5l_decap_8_2581 \$2 \$1 sg13cmos5l_decap_8
* cell instance sg13cmos5l_decap_8_2582 r0 *1 0,0
Xsg13cmos5l_decap_8_2582 \$2 \$1 sg13cmos5l_decap_8
* cell instance sg13cmos5l_decap_8_2583 r0 *1 0,0
Xsg13cmos5l_decap_8_2583 \$2 \$1 sg13cmos5l_decap_8
* cell instance sg13cmos5l_decap_8_2584 r0 *1 0,0
Xsg13cmos5l_decap_8_2584 \$2 \$1 sg13cmos5l_decap_8
* cell instance sg13cmos5l_decap_8_2585 r0 *1 0,0
Xsg13cmos5l_decap_8_2585 \$2 \$1 sg13cmos5l_decap_8
* cell instance sg13cmos5l_decap_8_2586 r0 *1 0,0
Xsg13cmos5l_decap_8_2586 \$2 \$1 sg13cmos5l_decap_8
* cell instance sg13cmos5l_decap_8_2587 r0 *1 0,0
Xsg13cmos5l_decap_8_2587 \$2 \$1 sg13cmos5l_decap_8
* cell instance sg13cmos5l_decap_8_2588 r0 *1 0,0
Xsg13cmos5l_decap_8_2588 \$2 \$1 sg13cmos5l_decap_8
* cell instance sg13cmos5l_decap_8_2589 r0 *1 0,0
Xsg13cmos5l_decap_8_2589 \$2 \$1 sg13cmos5l_decap_8
* cell instance sg13cmos5l_decap_8_2590 r0 *1 0,0
Xsg13cmos5l_decap_8_2590 \$2 \$1 sg13cmos5l_decap_8
* cell instance sg13cmos5l_decap_8_2591 r0 *1 0,0
Xsg13cmos5l_decap_8_2591 \$2 \$1 sg13cmos5l_decap_8
* cell instance sg13cmos5l_decap_8_2592 r0 *1 0,0
Xsg13cmos5l_decap_8_2592 \$2 \$1 sg13cmos5l_decap_8
* cell instance sg13cmos5l_decap_8_2593 r0 *1 0,0
Xsg13cmos5l_decap_8_2593 \$2 \$1 sg13cmos5l_decap_8
* cell instance sg13cmos5l_decap_8_2594 r0 *1 0,0
Xsg13cmos5l_decap_8_2594 \$2 \$1 sg13cmos5l_decap_8
* cell instance sg13cmos5l_decap_8_2595 r0 *1 0,0
Xsg13cmos5l_decap_8_2595 \$2 \$1 sg13cmos5l_decap_8
* cell instance sg13cmos5l_decap_8_2596 r0 *1 0,0
Xsg13cmos5l_decap_8_2596 \$2 \$1 sg13cmos5l_decap_8
* cell instance sg13cmos5l_decap_8_2597 r0 *1 0,0
Xsg13cmos5l_decap_8_2597 \$2 \$1 sg13cmos5l_decap_8
* cell instance sg13cmos5l_decap_8_2598 r0 *1 0,0
Xsg13cmos5l_decap_8_2598 \$2 \$1 sg13cmos5l_decap_8
* cell instance sg13cmos5l_decap_8_2599 r0 *1 0,0
Xsg13cmos5l_decap_8_2599 \$2 \$1 sg13cmos5l_decap_8
* cell instance sg13cmos5l_decap_8_2600 r0 *1 0,0
Xsg13cmos5l_decap_8_2600 \$2 \$1 sg13cmos5l_decap_8
* cell instance sg13cmos5l_decap_8_2601 r0 *1 0,0
Xsg13cmos5l_decap_8_2601 \$2 \$1 sg13cmos5l_decap_8
* cell instance sg13cmos5l_decap_8_2602 r0 *1 0,0
Xsg13cmos5l_decap_8_2602 \$2 \$1 sg13cmos5l_decap_8
* cell instance sg13cmos5l_decap_8_2603 r0 *1 0,0
Xsg13cmos5l_decap_8_2603 \$2 \$1 sg13cmos5l_decap_8
* cell instance sg13cmos5l_decap_8_2604 r0 *1 0,0
Xsg13cmos5l_decap_8_2604 \$2 \$1 sg13cmos5l_decap_8
* cell instance sg13cmos5l_decap_8_2605 r0 *1 0,0
Xsg13cmos5l_decap_8_2605 \$2 \$1 sg13cmos5l_decap_8
* cell instance sg13cmos5l_decap_8_2606 r0 *1 0,0
Xsg13cmos5l_decap_8_2606 \$2 \$1 sg13cmos5l_decap_8
* cell instance sg13cmos5l_decap_8_2607 r0 *1 0,0
Xsg13cmos5l_decap_8_2607 \$2 \$1 sg13cmos5l_decap_8
* cell instance sg13cmos5l_decap_8_2608 r0 *1 0,0
Xsg13cmos5l_decap_8_2608 \$2 \$1 sg13cmos5l_decap_8
* cell instance sg13cmos5l_decap_8_2609 r0 *1 0,0
Xsg13cmos5l_decap_8_2609 \$2 \$1 sg13cmos5l_decap_8
* cell instance sg13cmos5l_decap_8_2610 r0 *1 0,0
Xsg13cmos5l_decap_8_2610 \$2 \$1 sg13cmos5l_decap_8
* cell instance sg13cmos5l_decap_8_2611 r0 *1 0,0
Xsg13cmos5l_decap_8_2611 \$2 \$1 sg13cmos5l_decap_8
* cell instance sg13cmos5l_decap_8_2612 r0 *1 0,0
Xsg13cmos5l_decap_8_2612 \$2 \$1 sg13cmos5l_decap_8
* cell instance sg13cmos5l_decap_8_2613 r0 *1 0,0
Xsg13cmos5l_decap_8_2613 \$2 \$1 sg13cmos5l_decap_8
* cell instance sg13cmos5l_decap_8_2614 r0 *1 0,0
Xsg13cmos5l_decap_8_2614 \$2 \$1 sg13cmos5l_decap_8
* cell instance sg13cmos5l_decap_8_2615 r0 *1 0,0
Xsg13cmos5l_decap_8_2615 \$2 \$1 sg13cmos5l_decap_8
* cell instance sg13cmos5l_decap_8_2616 r0 *1 0,0
Xsg13cmos5l_decap_8_2616 \$2 \$1 sg13cmos5l_decap_8
* cell instance sg13cmos5l_decap_8_2617 r0 *1 0,0
Xsg13cmos5l_decap_8_2617 \$2 \$1 sg13cmos5l_decap_8
* cell instance sg13cmos5l_decap_8_2618 r0 *1 0,0
Xsg13cmos5l_decap_8_2618 \$2 \$1 sg13cmos5l_decap_8
* cell instance sg13cmos5l_decap_8_2619 r0 *1 0,0
Xsg13cmos5l_decap_8_2619 \$2 \$1 sg13cmos5l_decap_8
* cell instance sg13cmos5l_decap_8_2620 r0 *1 0,0
Xsg13cmos5l_decap_8_2620 \$2 \$1 sg13cmos5l_decap_8
* cell instance sg13cmos5l_decap_8_2621 r0 *1 0,0
Xsg13cmos5l_decap_8_2621 \$2 \$1 sg13cmos5l_decap_8
* cell instance sg13cmos5l_decap_8_2622 r0 *1 0,0
Xsg13cmos5l_decap_8_2622 \$2 \$1 sg13cmos5l_decap_8
* cell instance sg13cmos5l_decap_8_2623 r0 *1 0,0
Xsg13cmos5l_decap_8_2623 \$2 \$1 sg13cmos5l_decap_8
* cell instance sg13cmos5l_decap_8_2624 r0 *1 0,0
Xsg13cmos5l_decap_8_2624 \$2 \$1 sg13cmos5l_decap_8
* cell instance sg13cmos5l_decap_8_2625 r0 *1 0,0
Xsg13cmos5l_decap_8_2625 \$2 \$1 sg13cmos5l_decap_8
* cell instance sg13cmos5l_decap_8_2626 r0 *1 0,0
Xsg13cmos5l_decap_8_2626 \$2 \$1 sg13cmos5l_decap_8
* cell instance sg13cmos5l_decap_8_2627 r0 *1 0,0
Xsg13cmos5l_decap_8_2627 \$2 \$1 sg13cmos5l_decap_8
* cell instance sg13cmos5l_decap_8_2628 r0 *1 0,0
Xsg13cmos5l_decap_8_2628 \$2 \$1 sg13cmos5l_decap_8
* cell instance sg13cmos5l_decap_8_2629 r0 *1 0,0
Xsg13cmos5l_decap_8_2629 \$2 \$1 sg13cmos5l_decap_8
* cell instance sg13cmos5l_decap_8_2630 r0 *1 0,0
Xsg13cmos5l_decap_8_2630 \$2 \$1 sg13cmos5l_decap_8
* cell instance sg13cmos5l_decap_8_2631 r0 *1 0,0
Xsg13cmos5l_decap_8_2631 \$2 \$1 sg13cmos5l_decap_8
* cell instance sg13cmos5l_decap_8_2632 r0 *1 0,0
Xsg13cmos5l_decap_8_2632 \$2 \$1 sg13cmos5l_decap_8
* cell instance sg13cmos5l_decap_8_2633 r0 *1 0,0
Xsg13cmos5l_decap_8_2633 \$2 \$1 sg13cmos5l_decap_8
* cell instance sg13cmos5l_decap_8_2634 r0 *1 0,0
Xsg13cmos5l_decap_8_2634 \$2 \$1 sg13cmos5l_decap_8
* cell instance sg13cmos5l_decap_8_2635 r0 *1 0,0
Xsg13cmos5l_decap_8_2635 \$2 \$1 sg13cmos5l_decap_8
* cell instance sg13cmos5l_decap_8_2636 r0 *1 0,0
Xsg13cmos5l_decap_8_2636 \$2 \$1 sg13cmos5l_decap_8
* cell instance sg13cmos5l_decap_8_2637 r0 *1 0,0
Xsg13cmos5l_decap_8_2637 \$2 \$1 sg13cmos5l_decap_8
* cell instance sg13cmos5l_decap_8_2638 r0 *1 0,0
Xsg13cmos5l_decap_8_2638 \$2 \$1 sg13cmos5l_decap_8
* cell instance sg13cmos5l_decap_8_2639 r0 *1 0,0
Xsg13cmos5l_decap_8_2639 \$2 \$1 sg13cmos5l_decap_8
* cell instance sg13cmos5l_decap_8_2640 r0 *1 0,0
Xsg13cmos5l_decap_8_2640 \$2 \$1 sg13cmos5l_decap_8
* cell instance sg13cmos5l_decap_8_2641 r0 *1 0,0
Xsg13cmos5l_decap_8_2641 \$2 \$1 sg13cmos5l_decap_8
* cell instance sg13cmos5l_decap_8_2642 r0 *1 0,0
Xsg13cmos5l_decap_8_2642 \$2 \$1 sg13cmos5l_decap_8
* cell instance sg13cmos5l_decap_8_2643 r0 *1 0,0
Xsg13cmos5l_decap_8_2643 \$2 \$1 sg13cmos5l_decap_8
* cell instance sg13cmos5l_decap_8_2644 r0 *1 0,0
Xsg13cmos5l_decap_8_2644 \$2 \$1 sg13cmos5l_decap_8
* cell instance sg13cmos5l_decap_8_2645 r0 *1 0,0
Xsg13cmos5l_decap_8_2645 \$2 \$1 sg13cmos5l_decap_8
* cell instance sg13cmos5l_decap_8_2646 r0 *1 0,0
Xsg13cmos5l_decap_8_2646 \$2 \$1 sg13cmos5l_decap_8
* cell instance sg13cmos5l_decap_8_2647 r0 *1 0,0
Xsg13cmos5l_decap_8_2647 \$2 \$1 sg13cmos5l_decap_8
* cell instance sg13cmos5l_decap_8_2648 r0 *1 0,0
Xsg13cmos5l_decap_8_2648 \$2 \$1 sg13cmos5l_decap_8
* cell instance sg13cmos5l_decap_8_2649 r0 *1 0,0
Xsg13cmos5l_decap_8_2649 \$2 \$1 sg13cmos5l_decap_8
* cell instance sg13cmos5l_decap_8_2650 r0 *1 0,0
Xsg13cmos5l_decap_8_2650 \$2 \$1 sg13cmos5l_decap_8
* cell instance sg13cmos5l_decap_8_2651 r0 *1 0,0
Xsg13cmos5l_decap_8_2651 \$2 \$1 sg13cmos5l_decap_8
* cell instance sg13cmos5l_decap_8_2652 r0 *1 0,0
Xsg13cmos5l_decap_8_2652 \$2 \$1 sg13cmos5l_decap_8
* cell instance sg13cmos5l_decap_8_2653 r0 *1 0,0
Xsg13cmos5l_decap_8_2653 \$2 \$1 sg13cmos5l_decap_8
* cell instance sg13cmos5l_decap_8_2654 r0 *1 0,0
Xsg13cmos5l_decap_8_2654 \$2 \$1 sg13cmos5l_decap_8
* cell instance sg13cmos5l_decap_8_2655 r0 *1 0,0
Xsg13cmos5l_decap_8_2655 \$2 \$1 sg13cmos5l_decap_8
* cell instance sg13cmos5l_decap_8_2656 r0 *1 0,0
Xsg13cmos5l_decap_8_2656 \$2 \$1 sg13cmos5l_decap_8
* cell instance sg13cmos5l_decap_8_2657 r0 *1 0,0
Xsg13cmos5l_decap_8_2657 \$2 \$1 sg13cmos5l_decap_8
* cell instance sg13cmos5l_decap_8_2658 r0 *1 0,0
Xsg13cmos5l_decap_8_2658 \$2 \$1 sg13cmos5l_decap_8
* cell instance sg13cmos5l_decap_8_2659 r0 *1 0,0
Xsg13cmos5l_decap_8_2659 \$2 \$1 sg13cmos5l_decap_8
* cell instance sg13cmos5l_decap_8_2660 r0 *1 0,0
Xsg13cmos5l_decap_8_2660 \$2 \$1 sg13cmos5l_decap_8
* cell instance sg13cmos5l_decap_8_2661 r0 *1 0,0
Xsg13cmos5l_decap_8_2661 \$2 \$1 sg13cmos5l_decap_8
* cell instance sg13cmos5l_decap_8_2662 r0 *1 0,0
Xsg13cmos5l_decap_8_2662 \$2 \$1 sg13cmos5l_decap_8
* cell instance sg13cmos5l_decap_8_2663 r0 *1 0,0
Xsg13cmos5l_decap_8_2663 \$2 \$1 sg13cmos5l_decap_8
* cell instance sg13cmos5l_decap_8_2664 r0 *1 0,0
Xsg13cmos5l_decap_8_2664 \$2 \$1 sg13cmos5l_decap_8
* cell instance sg13cmos5l_decap_8_2665 r0 *1 0,0
Xsg13cmos5l_decap_8_2665 \$2 \$1 sg13cmos5l_decap_8
* cell instance sg13cmos5l_decap_8_2666 r0 *1 0,0
Xsg13cmos5l_decap_8_2666 \$2 \$1 sg13cmos5l_decap_8
* cell instance sg13cmos5l_decap_8_2667 r0 *1 0,0
Xsg13cmos5l_decap_8_2667 \$2 \$1 sg13cmos5l_decap_8
* cell instance sg13cmos5l_decap_8_2668 r0 *1 0,0
Xsg13cmos5l_decap_8_2668 \$2 \$1 sg13cmos5l_decap_8
* cell instance sg13cmos5l_decap_8_2669 r0 *1 0,0
Xsg13cmos5l_decap_8_2669 \$2 \$1 sg13cmos5l_decap_8
* cell instance sg13cmos5l_decap_8_2670 r0 *1 0,0
Xsg13cmos5l_decap_8_2670 \$2 \$1 sg13cmos5l_decap_8
* cell instance sg13cmos5l_decap_8_2671 r0 *1 0,0
Xsg13cmos5l_decap_8_2671 \$2 \$1 sg13cmos5l_decap_8
* cell instance sg13cmos5l_decap_8_2672 r0 *1 0,0
Xsg13cmos5l_decap_8_2672 \$2 \$1 sg13cmos5l_decap_8
* cell instance sg13cmos5l_decap_8_2673 r0 *1 0,0
Xsg13cmos5l_decap_8_2673 \$2 \$1 sg13cmos5l_decap_8
* cell instance sg13cmos5l_decap_8_2674 r0 *1 0,0
Xsg13cmos5l_decap_8_2674 \$2 \$1 sg13cmos5l_decap_8
* cell instance sg13cmos5l_decap_8_2675 r0 *1 0,0
Xsg13cmos5l_decap_8_2675 \$2 \$1 sg13cmos5l_decap_8
* cell instance sg13cmos5l_decap_8_2676 r0 *1 0,0
Xsg13cmos5l_decap_8_2676 \$2 \$1 sg13cmos5l_decap_8
* cell instance sg13cmos5l_decap_8_2677 r0 *1 0,0
Xsg13cmos5l_decap_8_2677 \$2 \$1 sg13cmos5l_decap_8
* cell instance sg13cmos5l_decap_8_2678 r0 *1 0,0
Xsg13cmos5l_decap_8_2678 \$2 \$1 sg13cmos5l_decap_8
* cell instance sg13cmos5l_decap_8_2679 r0 *1 0,0
Xsg13cmos5l_decap_8_2679 \$2 \$1 sg13cmos5l_decap_8
* cell instance sg13cmos5l_decap_8_2680 r0 *1 0,0
Xsg13cmos5l_decap_8_2680 \$2 \$1 sg13cmos5l_decap_8
* cell instance sg13cmos5l_decap_8_2681 r0 *1 0,0
Xsg13cmos5l_decap_8_2681 \$2 \$1 sg13cmos5l_decap_8
* cell instance sg13cmos5l_decap_8_2682 r0 *1 0,0
Xsg13cmos5l_decap_8_2682 \$2 \$1 sg13cmos5l_decap_8
* cell instance sg13cmos5l_decap_8_2683 r0 *1 0,0
Xsg13cmos5l_decap_8_2683 \$2 \$1 sg13cmos5l_decap_8
* cell instance sg13cmos5l_decap_8_2684 r0 *1 0,0
Xsg13cmos5l_decap_8_2684 \$2 \$1 sg13cmos5l_decap_8
* cell instance sg13cmos5l_decap_8_2685 r0 *1 0,0
Xsg13cmos5l_decap_8_2685 \$2 \$1 sg13cmos5l_decap_8
* cell instance sg13cmos5l_decap_8_2686 r0 *1 0,0
Xsg13cmos5l_decap_8_2686 \$2 \$1 sg13cmos5l_decap_8
* cell instance sg13cmos5l_decap_8_2687 r0 *1 0,0
Xsg13cmos5l_decap_8_2687 \$2 \$1 sg13cmos5l_decap_8
* cell instance sg13cmos5l_decap_8_2688 r0 *1 0,0
Xsg13cmos5l_decap_8_2688 \$2 \$1 sg13cmos5l_decap_8
* cell instance sg13cmos5l_decap_8_2689 r0 *1 0,0
Xsg13cmos5l_decap_8_2689 \$2 \$1 sg13cmos5l_decap_8
* cell instance sg13cmos5l_decap_8_2690 r0 *1 0,0
Xsg13cmos5l_decap_8_2690 \$2 \$1 sg13cmos5l_decap_8
* cell instance sg13cmos5l_decap_8_2691 r0 *1 0,0
Xsg13cmos5l_decap_8_2691 \$2 \$1 sg13cmos5l_decap_8
* cell instance sg13cmos5l_decap_8_2692 r0 *1 0,0
Xsg13cmos5l_decap_8_2692 \$2 \$1 sg13cmos5l_decap_8
* cell instance sg13cmos5l_decap_8_2693 r0 *1 0,0
Xsg13cmos5l_decap_8_2693 \$2 \$1 sg13cmos5l_decap_8
* cell instance sg13cmos5l_decap_8_2694 r0 *1 0,0
Xsg13cmos5l_decap_8_2694 \$2 \$1 sg13cmos5l_decap_8
* cell instance sg13cmos5l_decap_8_2695 r0 *1 0,0
Xsg13cmos5l_decap_8_2695 \$2 \$1 sg13cmos5l_decap_8
* cell instance sg13cmos5l_decap_8_2696 r0 *1 0,0
Xsg13cmos5l_decap_8_2696 \$2 \$1 sg13cmos5l_decap_8
* cell instance sg13cmos5l_decap_8_2697 r0 *1 0,0
Xsg13cmos5l_decap_8_2697 \$2 \$1 sg13cmos5l_decap_8
* cell instance sg13cmos5l_decap_8_2698 r0 *1 0,0
Xsg13cmos5l_decap_8_2698 \$2 \$1 sg13cmos5l_decap_8
* cell instance sg13cmos5l_decap_8_2699 r0 *1 0,0
Xsg13cmos5l_decap_8_2699 \$2 \$1 sg13cmos5l_decap_8
* cell instance sg13cmos5l_decap_8_2700 r0 *1 0,0
Xsg13cmos5l_decap_8_2700 \$2 \$1 sg13cmos5l_decap_8
* cell instance sg13cmos5l_decap_8_2701 r0 *1 0,0
Xsg13cmos5l_decap_8_2701 \$2 \$1 sg13cmos5l_decap_8
* cell instance sg13cmos5l_decap_8_2702 r0 *1 0,0
Xsg13cmos5l_decap_8_2702 \$2 \$1 sg13cmos5l_decap_8
* cell instance sg13cmos5l_decap_8_2703 r0 *1 0,0
Xsg13cmos5l_decap_8_2703 \$2 \$1 sg13cmos5l_decap_8
* cell instance sg13cmos5l_decap_8_2704 r0 *1 0,0
Xsg13cmos5l_decap_8_2704 \$2 \$1 sg13cmos5l_decap_8
* cell instance sg13cmos5l_decap_8_2705 r0 *1 0,0
Xsg13cmos5l_decap_8_2705 \$2 \$1 sg13cmos5l_decap_8
* cell instance sg13cmos5l_decap_8_2706 r0 *1 0,0
Xsg13cmos5l_decap_8_2706 \$2 \$1 sg13cmos5l_decap_8
* cell instance sg13cmos5l_decap_8_2707 r0 *1 0,0
Xsg13cmos5l_decap_8_2707 \$2 \$1 sg13cmos5l_decap_8
* cell instance sg13cmos5l_decap_8_2708 r0 *1 0,0
Xsg13cmos5l_decap_8_2708 \$2 \$1 sg13cmos5l_decap_8
* cell instance sg13cmos5l_decap_8_2709 r0 *1 0,0
Xsg13cmos5l_decap_8_2709 \$2 \$1 sg13cmos5l_decap_8
* cell instance sg13cmos5l_decap_8_2710 r0 *1 0,0
Xsg13cmos5l_decap_8_2710 \$2 \$1 sg13cmos5l_decap_8
* cell instance sg13cmos5l_decap_8_2711 r0 *1 0,0
Xsg13cmos5l_decap_8_2711 \$2 \$1 sg13cmos5l_decap_8
* cell instance sg13cmos5l_decap_8_2712 r0 *1 0,0
Xsg13cmos5l_decap_8_2712 \$2 \$1 sg13cmos5l_decap_8
* cell instance sg13cmos5l_decap_8_2713 r0 *1 0,0
Xsg13cmos5l_decap_8_2713 \$2 \$1 sg13cmos5l_decap_8
* cell instance sg13cmos5l_decap_8_2714 r0 *1 0,0
Xsg13cmos5l_decap_8_2714 \$2 \$1 sg13cmos5l_decap_8
* cell instance sg13cmos5l_decap_8_2715 r0 *1 0,0
Xsg13cmos5l_decap_8_2715 \$2 \$1 sg13cmos5l_decap_8
* cell instance sg13cmos5l_decap_8_2716 r0 *1 0,0
Xsg13cmos5l_decap_8_2716 \$2 \$1 sg13cmos5l_decap_8
* cell instance sg13cmos5l_decap_8_2717 r0 *1 0,0
Xsg13cmos5l_decap_8_2717 \$2 \$1 sg13cmos5l_decap_8
* cell instance sg13cmos5l_decap_8_2718 r0 *1 0,0
Xsg13cmos5l_decap_8_2718 \$2 \$1 sg13cmos5l_decap_8
* cell instance sg13cmos5l_decap_8_2719 r0 *1 0,0
Xsg13cmos5l_decap_8_2719 \$2 \$1 sg13cmos5l_decap_8
* cell instance sg13cmos5l_decap_8_2720 r0 *1 0,0
Xsg13cmos5l_decap_8_2720 \$2 \$1 sg13cmos5l_decap_8
* cell instance sg13cmos5l_decap_8_2721 r0 *1 0,0
Xsg13cmos5l_decap_8_2721 \$2 \$1 sg13cmos5l_decap_8
* cell instance sg13cmos5l_decap_8_2722 r0 *1 0,0
Xsg13cmos5l_decap_8_2722 \$2 \$1 sg13cmos5l_decap_8
* cell instance sg13cmos5l_decap_8_2723 r0 *1 0,0
Xsg13cmos5l_decap_8_2723 \$2 \$1 sg13cmos5l_decap_8
* cell instance sg13cmos5l_decap_8_2724 r0 *1 0,0
Xsg13cmos5l_decap_8_2724 \$2 \$1 sg13cmos5l_decap_8
* cell instance sg13cmos5l_decap_8_2725 r0 *1 0,0
Xsg13cmos5l_decap_8_2725 \$2 \$1 sg13cmos5l_decap_8
* cell instance sg13cmos5l_decap_8_2726 r0 *1 0,0
Xsg13cmos5l_decap_8_2726 \$2 \$1 sg13cmos5l_decap_8
* cell instance sg13cmos5l_decap_8_2727 r0 *1 0,0
Xsg13cmos5l_decap_8_2727 \$2 \$1 sg13cmos5l_decap_8
* cell instance sg13cmos5l_decap_8_2728 r0 *1 0,0
Xsg13cmos5l_decap_8_2728 \$2 \$1 sg13cmos5l_decap_8
* cell instance sg13cmos5l_decap_8_2729 r0 *1 0,0
Xsg13cmos5l_decap_8_2729 \$2 \$1 sg13cmos5l_decap_8
* cell instance sg13cmos5l_decap_8_2730 r0 *1 0,0
Xsg13cmos5l_decap_8_2730 \$2 \$1 sg13cmos5l_decap_8
* cell instance sg13cmos5l_decap_8_2731 r0 *1 0,0
Xsg13cmos5l_decap_8_2731 \$2 \$1 sg13cmos5l_decap_8
* cell instance sg13cmos5l_decap_8_2732 r0 *1 0,0
Xsg13cmos5l_decap_8_2732 \$2 \$1 sg13cmos5l_decap_8
* cell instance sg13cmos5l_decap_8_2733 r0 *1 0,0
Xsg13cmos5l_decap_8_2733 \$2 \$1 sg13cmos5l_decap_8
* cell instance sg13cmos5l_decap_8_2734 r0 *1 0,0
Xsg13cmos5l_decap_8_2734 \$2 \$1 sg13cmos5l_decap_8
* cell instance sg13cmos5l_decap_8_2735 r0 *1 0,0
Xsg13cmos5l_decap_8_2735 \$2 \$1 sg13cmos5l_decap_8
* cell instance sg13cmos5l_decap_8_2736 r0 *1 0,0
Xsg13cmos5l_decap_8_2736 \$2 \$1 sg13cmos5l_decap_8
* cell instance sg13cmos5l_decap_8_2737 r0 *1 0,0
Xsg13cmos5l_decap_8_2737 \$2 \$1 sg13cmos5l_decap_8
* cell instance sg13cmos5l_decap_8_2738 r0 *1 0,0
Xsg13cmos5l_decap_8_2738 \$2 \$1 sg13cmos5l_decap_8
* cell instance sg13cmos5l_decap_8_2739 r0 *1 0,0
Xsg13cmos5l_decap_8_2739 \$2 \$1 sg13cmos5l_decap_8
* cell instance sg13cmos5l_decap_8_2740 r0 *1 0,0
Xsg13cmos5l_decap_8_2740 \$2 \$1 sg13cmos5l_decap_8
* cell instance sg13cmos5l_decap_8_2741 r0 *1 0,0
Xsg13cmos5l_decap_8_2741 \$2 \$1 sg13cmos5l_decap_8
* cell instance sg13cmos5l_decap_8_2742 r0 *1 0,0
Xsg13cmos5l_decap_8_2742 \$2 \$1 sg13cmos5l_decap_8
* cell instance sg13cmos5l_decap_8_2743 r0 *1 0,0
Xsg13cmos5l_decap_8_2743 \$2 \$1 sg13cmos5l_decap_8
* cell instance sg13cmos5l_decap_8_2744 r0 *1 0,0
Xsg13cmos5l_decap_8_2744 \$2 \$1 sg13cmos5l_decap_8
* cell instance sg13cmos5l_decap_8_2745 r0 *1 0,0
Xsg13cmos5l_decap_8_2745 \$2 \$1 sg13cmos5l_decap_8
* cell instance sg13cmos5l_decap_8_2746 r0 *1 0,0
Xsg13cmos5l_decap_8_2746 \$2 \$1 sg13cmos5l_decap_8
* cell instance sg13cmos5l_decap_8_2747 r0 *1 0,0
Xsg13cmos5l_decap_8_2747 \$2 \$1 sg13cmos5l_decap_8
* cell instance sg13cmos5l_decap_8_2748 r0 *1 0,0
Xsg13cmos5l_decap_8_2748 \$2 \$1 sg13cmos5l_decap_8
* cell instance sg13cmos5l_decap_8_2749 r0 *1 0,0
Xsg13cmos5l_decap_8_2749 \$2 \$1 sg13cmos5l_decap_8
* cell instance sg13cmos5l_decap_8_2750 r0 *1 0,0
Xsg13cmos5l_decap_8_2750 \$2 \$1 sg13cmos5l_decap_8
* cell instance sg13cmos5l_decap_8_2751 r0 *1 0,0
Xsg13cmos5l_decap_8_2751 \$2 \$1 sg13cmos5l_decap_8
* cell instance sg13cmos5l_decap_8_2752 r0 *1 0,0
Xsg13cmos5l_decap_8_2752 \$2 \$1 sg13cmos5l_decap_8
* cell instance sg13cmos5l_decap_8_2753 r0 *1 0,0
Xsg13cmos5l_decap_8_2753 \$2 \$1 sg13cmos5l_decap_8
* cell instance sg13cmos5l_decap_8_2754 r0 *1 0,0
Xsg13cmos5l_decap_8_2754 \$2 \$1 sg13cmos5l_decap_8
* cell instance sg13cmos5l_decap_8_2755 r0 *1 0,0
Xsg13cmos5l_decap_8_2755 \$2 \$1 sg13cmos5l_decap_8
* cell instance sg13cmos5l_decap_8_2756 r0 *1 0,0
Xsg13cmos5l_decap_8_2756 \$2 \$1 sg13cmos5l_decap_8
* cell instance sg13cmos5l_decap_8_2757 r0 *1 0,0
Xsg13cmos5l_decap_8_2757 \$2 \$1 sg13cmos5l_decap_8
* cell instance sg13cmos5l_decap_8_2758 r0 *1 0,0
Xsg13cmos5l_decap_8_2758 \$2 \$1 sg13cmos5l_decap_8
* cell instance sg13cmos5l_decap_8_2759 r0 *1 0,0
Xsg13cmos5l_decap_8_2759 \$2 \$1 sg13cmos5l_decap_8
* cell instance sg13cmos5l_decap_8_2760 r0 *1 0,0
Xsg13cmos5l_decap_8_2760 \$2 \$1 sg13cmos5l_decap_8
* cell instance sg13cmos5l_decap_8_2761 r0 *1 0,0
Xsg13cmos5l_decap_8_2761 \$2 \$1 sg13cmos5l_decap_8
* cell instance sg13cmos5l_decap_8_2762 r0 *1 0,0
Xsg13cmos5l_decap_8_2762 \$2 \$1 sg13cmos5l_decap_8
* cell instance sg13cmos5l_decap_8_2763 r0 *1 0,0
Xsg13cmos5l_decap_8_2763 \$2 \$1 sg13cmos5l_decap_8
* cell instance sg13cmos5l_decap_8_2764 r0 *1 0,0
Xsg13cmos5l_decap_8_2764 \$2 \$1 sg13cmos5l_decap_8
* cell instance sg13cmos5l_decap_8_2765 r0 *1 0,0
Xsg13cmos5l_decap_8_2765 \$2 \$1 sg13cmos5l_decap_8
* cell instance sg13cmos5l_decap_8_2766 r0 *1 0,0
Xsg13cmos5l_decap_8_2766 \$2 \$1 sg13cmos5l_decap_8
* cell instance sg13cmos5l_decap_8_2767 r0 *1 0,0
Xsg13cmos5l_decap_8_2767 \$2 \$1 sg13cmos5l_decap_8
* cell instance sg13cmos5l_decap_8_2768 r0 *1 0,0
Xsg13cmos5l_decap_8_2768 \$2 \$1 sg13cmos5l_decap_8
* cell instance sg13cmos5l_decap_8_2769 r0 *1 0,0
Xsg13cmos5l_decap_8_2769 \$2 \$1 sg13cmos5l_decap_8
* cell instance sg13cmos5l_decap_8_2770 r0 *1 0,0
Xsg13cmos5l_decap_8_2770 \$2 \$1 sg13cmos5l_decap_8
* cell instance sg13cmos5l_decap_8_2771 r0 *1 0,0
Xsg13cmos5l_decap_8_2771 \$2 \$1 sg13cmos5l_decap_8
* cell instance sg13cmos5l_decap_8_2772 r0 *1 0,0
Xsg13cmos5l_decap_8_2772 \$2 \$1 sg13cmos5l_decap_8
* cell instance sg13cmos5l_decap_8_2773 r0 *1 0,0
Xsg13cmos5l_decap_8_2773 \$2 \$1 sg13cmos5l_decap_8
* cell instance sg13cmos5l_decap_8_2774 r0 *1 0,0
Xsg13cmos5l_decap_8_2774 \$2 \$1 sg13cmos5l_decap_8
* cell instance sg13cmos5l_decap_8_2775 r0 *1 0,0
Xsg13cmos5l_decap_8_2775 \$2 \$1 sg13cmos5l_decap_8
* cell instance sg13cmos5l_decap_8_2776 r0 *1 0,0
Xsg13cmos5l_decap_8_2776 \$2 \$1 sg13cmos5l_decap_8
* cell instance sg13cmos5l_decap_8_2777 r0 *1 0,0
Xsg13cmos5l_decap_8_2777 \$2 \$1 sg13cmos5l_decap_8
* cell instance sg13cmos5l_decap_8_2778 r0 *1 0,0
Xsg13cmos5l_decap_8_2778 \$2 \$1 sg13cmos5l_decap_8
* cell instance sg13cmos5l_decap_8_2779 r0 *1 0,0
Xsg13cmos5l_decap_8_2779 \$2 \$1 sg13cmos5l_decap_8
* cell instance sg13cmos5l_decap_8_2780 r0 *1 0,0
Xsg13cmos5l_decap_8_2780 \$2 \$1 sg13cmos5l_decap_8
* cell instance sg13cmos5l_decap_8_2781 r0 *1 0,0
Xsg13cmos5l_decap_8_2781 \$2 \$1 sg13cmos5l_decap_8
* cell instance sg13cmos5l_decap_8_2782 r0 *1 0,0
Xsg13cmos5l_decap_8_2782 \$2 \$1 sg13cmos5l_decap_8
* cell instance sg13cmos5l_decap_8_2783 r0 *1 0,0
Xsg13cmos5l_decap_8_2783 \$2 \$1 sg13cmos5l_decap_8
* cell instance sg13cmos5l_decap_8_2784 r0 *1 0,0
Xsg13cmos5l_decap_8_2784 \$2 \$1 sg13cmos5l_decap_8
* cell instance sg13cmos5l_decap_8_2785 r0 *1 0,0
Xsg13cmos5l_decap_8_2785 \$2 \$1 sg13cmos5l_decap_8
* cell instance sg13cmos5l_decap_8_2786 r0 *1 0,0
Xsg13cmos5l_decap_8_2786 \$2 \$1 sg13cmos5l_decap_8
* cell instance sg13cmos5l_decap_8_2787 r0 *1 0,0
Xsg13cmos5l_decap_8_2787 \$2 \$1 sg13cmos5l_decap_8
* cell instance sg13cmos5l_decap_8_2788 r0 *1 0,0
Xsg13cmos5l_decap_8_2788 \$2 \$1 sg13cmos5l_decap_8
* cell instance sg13cmos5l_decap_8_2789 r0 *1 0,0
Xsg13cmos5l_decap_8_2789 \$2 \$1 sg13cmos5l_decap_8
* cell instance sg13cmos5l_decap_8_2790 r0 *1 0,0
Xsg13cmos5l_decap_8_2790 \$2 \$1 sg13cmos5l_decap_8
* cell instance sg13cmos5l_decap_8_2791 r0 *1 0,0
Xsg13cmos5l_decap_8_2791 \$2 \$1 sg13cmos5l_decap_8
* cell instance sg13cmos5l_decap_8_2792 r0 *1 0,0
Xsg13cmos5l_decap_8_2792 \$2 \$1 sg13cmos5l_decap_8
* cell instance sg13cmos5l_decap_8_2793 r0 *1 0,0
Xsg13cmos5l_decap_8_2793 \$2 \$1 sg13cmos5l_decap_8
* cell instance sg13cmos5l_decap_8_2794 r0 *1 0,0
Xsg13cmos5l_decap_8_2794 \$2 \$1 sg13cmos5l_decap_8
* cell instance sg13cmos5l_decap_8_2795 r0 *1 0,0
Xsg13cmos5l_decap_8_2795 \$2 \$1 sg13cmos5l_decap_8
* cell instance sg13cmos5l_decap_8_2796 r0 *1 0,0
Xsg13cmos5l_decap_8_2796 \$2 \$1 sg13cmos5l_decap_8
* cell instance sg13cmos5l_decap_8_2797 r0 *1 0,0
Xsg13cmos5l_decap_8_2797 \$2 \$1 sg13cmos5l_decap_8
* cell instance sg13cmos5l_decap_8_2798 r0 *1 0,0
Xsg13cmos5l_decap_8_2798 \$2 \$1 sg13cmos5l_decap_8
* cell instance sg13cmos5l_decap_8_2799 r0 *1 0,0
Xsg13cmos5l_decap_8_2799 \$2 \$1 sg13cmos5l_decap_8
* cell instance sg13cmos5l_decap_8_2800 r0 *1 0,0
Xsg13cmos5l_decap_8_2800 \$2 \$1 sg13cmos5l_decap_8
* cell instance sg13cmos5l_decap_8_2801 r0 *1 0,0
Xsg13cmos5l_decap_8_2801 \$2 \$1 sg13cmos5l_decap_8
* cell instance sg13cmos5l_decap_8_2802 r0 *1 0,0
Xsg13cmos5l_decap_8_2802 \$2 \$1 sg13cmos5l_decap_8
* cell instance sg13cmos5l_decap_8_2803 r0 *1 0,0
Xsg13cmos5l_decap_8_2803 \$2 \$1 sg13cmos5l_decap_8
* cell instance sg13cmos5l_decap_8_2804 r0 *1 0,0
Xsg13cmos5l_decap_8_2804 \$2 \$1 sg13cmos5l_decap_8
* cell instance sg13cmos5l_decap_8_2805 r0 *1 0,0
Xsg13cmos5l_decap_8_2805 \$2 \$1 sg13cmos5l_decap_8
* cell instance sg13cmos5l_decap_8_2806 r0 *1 0,0
Xsg13cmos5l_decap_8_2806 \$2 \$1 sg13cmos5l_decap_8
* cell instance sg13cmos5l_decap_8_2807 r0 *1 0,0
Xsg13cmos5l_decap_8_2807 \$2 \$1 sg13cmos5l_decap_8
* cell instance sg13cmos5l_decap_8_2808 r0 *1 0,0
Xsg13cmos5l_decap_8_2808 \$2 \$1 sg13cmos5l_decap_8
* cell instance sg13cmos5l_decap_8_2809 r0 *1 0,0
Xsg13cmos5l_decap_8_2809 \$2 \$1 sg13cmos5l_decap_8
* cell instance sg13cmos5l_decap_8_2810 r0 *1 0,0
Xsg13cmos5l_decap_8_2810 \$2 \$1 sg13cmos5l_decap_8
* cell instance sg13cmos5l_decap_8_2811 r0 *1 0,0
Xsg13cmos5l_decap_8_2811 \$2 \$1 sg13cmos5l_decap_8
* cell instance sg13cmos5l_decap_8_2812 r0 *1 0,0
Xsg13cmos5l_decap_8_2812 \$2 \$1 sg13cmos5l_decap_8
* cell instance sg13cmos5l_decap_8_2813 r0 *1 0,0
Xsg13cmos5l_decap_8_2813 \$2 \$1 sg13cmos5l_decap_8
* cell instance sg13cmos5l_decap_8_2814 r0 *1 0,0
Xsg13cmos5l_decap_8_2814 \$2 \$1 sg13cmos5l_decap_8
* cell instance sg13cmos5l_decap_8_2815 r0 *1 0,0
Xsg13cmos5l_decap_8_2815 \$2 \$1 sg13cmos5l_decap_8
* cell instance sg13cmos5l_decap_8_2816 r0 *1 0,0
Xsg13cmos5l_decap_8_2816 \$2 \$1 sg13cmos5l_decap_8
* cell instance sg13cmos5l_decap_8_2817 r0 *1 0,0
Xsg13cmos5l_decap_8_2817 \$2 \$1 sg13cmos5l_decap_8
* cell instance sg13cmos5l_decap_8_2818 r0 *1 0,0
Xsg13cmos5l_decap_8_2818 \$2 \$1 sg13cmos5l_decap_8
* cell instance sg13cmos5l_decap_8_2819 r0 *1 0,0
Xsg13cmos5l_decap_8_2819 \$2 \$1 sg13cmos5l_decap_8
* cell instance sg13cmos5l_decap_8_2820 r0 *1 0,0
Xsg13cmos5l_decap_8_2820 \$2 \$1 sg13cmos5l_decap_8
* cell instance sg13cmos5l_decap_8_2821 r0 *1 0,0
Xsg13cmos5l_decap_8_2821 \$2 \$1 sg13cmos5l_decap_8
* cell instance sg13cmos5l_decap_8_2822 r0 *1 0,0
Xsg13cmos5l_decap_8_2822 \$2 \$1 sg13cmos5l_decap_8
* cell instance sg13cmos5l_decap_8_2823 r0 *1 0,0
Xsg13cmos5l_decap_8_2823 \$2 \$1 sg13cmos5l_decap_8
* cell instance sg13cmos5l_decap_8_2824 r0 *1 0,0
Xsg13cmos5l_decap_8_2824 \$2 \$1 sg13cmos5l_decap_8
* cell instance sg13cmos5l_decap_8_2825 r0 *1 0,0
Xsg13cmos5l_decap_8_2825 \$2 \$1 sg13cmos5l_decap_8
* cell instance sg13cmos5l_decap_8_2826 r0 *1 0,0
Xsg13cmos5l_decap_8_2826 \$2 \$1 sg13cmos5l_decap_8
* cell instance sg13cmos5l_decap_8_2827 r0 *1 0,0
Xsg13cmos5l_decap_8_2827 \$2 \$1 sg13cmos5l_decap_8
* cell instance sg13cmos5l_decap_8_2828 r0 *1 0,0
Xsg13cmos5l_decap_8_2828 \$2 \$1 sg13cmos5l_decap_8
* cell instance sg13cmos5l_decap_8_2829 r0 *1 0,0
Xsg13cmos5l_decap_8_2829 \$2 \$1 sg13cmos5l_decap_8
* cell instance sg13cmos5l_decap_8_2830 r0 *1 0,0
Xsg13cmos5l_decap_8_2830 \$2 \$1 sg13cmos5l_decap_8
* cell instance sg13cmos5l_decap_8_2831 r0 *1 0,0
Xsg13cmos5l_decap_8_2831 \$2 \$1 sg13cmos5l_decap_8
* cell instance sg13cmos5l_decap_8_2832 r0 *1 0,0
Xsg13cmos5l_decap_8_2832 \$2 \$1 sg13cmos5l_decap_8
* cell instance sg13cmos5l_decap_8_2833 r0 *1 0,0
Xsg13cmos5l_decap_8_2833 \$2 \$1 sg13cmos5l_decap_8
* cell instance sg13cmos5l_decap_8_2834 r0 *1 0,0
Xsg13cmos5l_decap_8_2834 \$2 \$1 sg13cmos5l_decap_8
* cell instance sg13cmos5l_decap_8_2835 r0 *1 0,0
Xsg13cmos5l_decap_8_2835 \$2 \$1 sg13cmos5l_decap_8
* cell instance sg13cmos5l_decap_8_2836 r0 *1 0,0
Xsg13cmos5l_decap_8_2836 \$2 \$1 sg13cmos5l_decap_8
* cell instance sg13cmos5l_decap_8_2837 r0 *1 0,0
Xsg13cmos5l_decap_8_2837 \$2 \$1 sg13cmos5l_decap_8
* cell instance sg13cmos5l_decap_8_2838 r0 *1 0,0
Xsg13cmos5l_decap_8_2838 \$2 \$1 sg13cmos5l_decap_8
* cell instance sg13cmos5l_decap_8_2839 r0 *1 0,0
Xsg13cmos5l_decap_8_2839 \$2 \$1 sg13cmos5l_decap_8
* cell instance sg13cmos5l_decap_8_2840 r0 *1 0,0
Xsg13cmos5l_decap_8_2840 \$2 \$1 sg13cmos5l_decap_8
* cell instance sg13cmos5l_decap_8_2841 r0 *1 0,0
Xsg13cmos5l_decap_8_2841 \$2 \$1 sg13cmos5l_decap_8
* cell instance sg13cmos5l_decap_8_2842 r0 *1 0,0
Xsg13cmos5l_decap_8_2842 \$2 \$1 sg13cmos5l_decap_8
* cell instance sg13cmos5l_decap_8_2843 r0 *1 0,0
Xsg13cmos5l_decap_8_2843 \$2 \$1 sg13cmos5l_decap_8
* cell instance sg13cmos5l_decap_8_2844 r0 *1 0,0
Xsg13cmos5l_decap_8_2844 \$2 \$1 sg13cmos5l_decap_8
* cell instance sg13cmos5l_decap_8_2845 r0 *1 0,0
Xsg13cmos5l_decap_8_2845 \$2 \$1 sg13cmos5l_decap_8
* cell instance sg13cmos5l_decap_8_2846 r0 *1 0,0
Xsg13cmos5l_decap_8_2846 \$2 \$1 sg13cmos5l_decap_8
* cell instance sg13cmos5l_decap_8_2847 r0 *1 0,0
Xsg13cmos5l_decap_8_2847 \$2 \$1 sg13cmos5l_decap_8
* cell instance sg13cmos5l_decap_8_2848 r0 *1 0,0
Xsg13cmos5l_decap_8_2848 \$2 \$1 sg13cmos5l_decap_8
* cell instance sg13cmos5l_decap_8_2849 r0 *1 0,0
Xsg13cmos5l_decap_8_2849 \$2 \$1 sg13cmos5l_decap_8
* cell instance sg13cmos5l_decap_8_2850 r0 *1 0,0
Xsg13cmos5l_decap_8_2850 \$2 \$1 sg13cmos5l_decap_8
* cell instance sg13cmos5l_decap_8_2851 r0 *1 0,0
Xsg13cmos5l_decap_8_2851 \$2 \$1 sg13cmos5l_decap_8
* cell instance sg13cmos5l_decap_8_2852 r0 *1 0,0
Xsg13cmos5l_decap_8_2852 \$2 \$1 sg13cmos5l_decap_8
* cell instance sg13cmos5l_decap_8_2853 r0 *1 0,0
Xsg13cmos5l_decap_8_2853 \$2 \$1 sg13cmos5l_decap_8
* cell instance sg13cmos5l_decap_8_2854 r0 *1 0,0
Xsg13cmos5l_decap_8_2854 \$2 \$1 sg13cmos5l_decap_8
* cell instance sg13cmos5l_decap_8_2855 r0 *1 0,0
Xsg13cmos5l_decap_8_2855 \$2 \$1 sg13cmos5l_decap_8
* cell instance sg13cmos5l_decap_8_2856 r0 *1 0,0
Xsg13cmos5l_decap_8_2856 \$2 \$1 sg13cmos5l_decap_8
* cell instance sg13cmos5l_decap_8_2857 r0 *1 0,0
Xsg13cmos5l_decap_8_2857 \$2 \$1 sg13cmos5l_decap_8
* cell instance sg13cmos5l_decap_8_2858 r0 *1 0,0
Xsg13cmos5l_decap_8_2858 \$2 \$1 sg13cmos5l_decap_8
* cell instance sg13cmos5l_decap_8_2859 r0 *1 0,0
Xsg13cmos5l_decap_8_2859 \$2 \$1 sg13cmos5l_decap_8
* cell instance sg13cmos5l_decap_8_2860 r0 *1 0,0
Xsg13cmos5l_decap_8_2860 \$2 \$1 sg13cmos5l_decap_8
* cell instance sg13cmos5l_decap_8_2861 r0 *1 0,0
Xsg13cmos5l_decap_8_2861 \$2 \$1 sg13cmos5l_decap_8
* cell instance sg13cmos5l_decap_8_2862 r0 *1 0,0
Xsg13cmos5l_decap_8_2862 \$2 \$1 sg13cmos5l_decap_8
* cell instance sg13cmos5l_decap_8_2863 r0 *1 0,0
Xsg13cmos5l_decap_8_2863 \$2 \$1 sg13cmos5l_decap_8
* cell instance sg13cmos5l_decap_8_2864 r0 *1 0,0
Xsg13cmos5l_decap_8_2864 \$2 \$1 sg13cmos5l_decap_8
* cell instance sg13cmos5l_decap_8_2865 r0 *1 0,0
Xsg13cmos5l_decap_8_2865 \$2 \$1 sg13cmos5l_decap_8
* cell instance sg13cmos5l_decap_8_2866 r0 *1 0,0
Xsg13cmos5l_decap_8_2866 \$2 \$1 sg13cmos5l_decap_8
* cell instance sg13cmos5l_decap_8_2867 r0 *1 0,0
Xsg13cmos5l_decap_8_2867 \$2 \$1 sg13cmos5l_decap_8
* cell instance sg13cmos5l_decap_8_2868 r0 *1 0,0
Xsg13cmos5l_decap_8_2868 \$2 \$1 sg13cmos5l_decap_8
* cell instance sg13cmos5l_decap_8_2869 r0 *1 0,0
Xsg13cmos5l_decap_8_2869 \$2 \$1 sg13cmos5l_decap_8
* cell instance sg13cmos5l_decap_8_2870 r0 *1 0,0
Xsg13cmos5l_decap_8_2870 \$2 \$1 sg13cmos5l_decap_8
* cell instance sg13cmos5l_decap_8_2871 r0 *1 0,0
Xsg13cmos5l_decap_8_2871 \$2 \$1 sg13cmos5l_decap_8
* cell instance sg13cmos5l_decap_8_2872 r0 *1 0,0
Xsg13cmos5l_decap_8_2872 \$2 \$1 sg13cmos5l_decap_8
* cell instance sg13cmos5l_decap_8_2873 r0 *1 0,0
Xsg13cmos5l_decap_8_2873 \$2 \$1 sg13cmos5l_decap_8
* cell instance sg13cmos5l_decap_8_2874 r0 *1 0,0
Xsg13cmos5l_decap_8_2874 \$2 \$1 sg13cmos5l_decap_8
* cell instance sg13cmos5l_decap_8_2875 r0 *1 0,0
Xsg13cmos5l_decap_8_2875 \$2 \$1 sg13cmos5l_decap_8
* cell instance sg13cmos5l_decap_8_2876 r0 *1 0,0
Xsg13cmos5l_decap_8_2876 \$2 \$1 sg13cmos5l_decap_8
* cell instance sg13cmos5l_decap_8_2877 r0 *1 0,0
Xsg13cmos5l_decap_8_2877 \$2 \$1 sg13cmos5l_decap_8
* cell instance sg13cmos5l_decap_8_2878 r0 *1 0,0
Xsg13cmos5l_decap_8_2878 \$2 \$1 sg13cmos5l_decap_8
* cell instance sg13cmos5l_decap_8_2879 r0 *1 0,0
Xsg13cmos5l_decap_8_2879 \$2 \$1 sg13cmos5l_decap_8
* cell instance sg13cmos5l_decap_8_2880 r0 *1 0,0
Xsg13cmos5l_decap_8_2880 \$2 \$1 sg13cmos5l_decap_8
* cell instance sg13cmos5l_decap_8_2881 r0 *1 0,0
Xsg13cmos5l_decap_8_2881 \$2 \$1 sg13cmos5l_decap_8
* cell instance sg13cmos5l_decap_8_2882 r0 *1 0,0
Xsg13cmos5l_decap_8_2882 \$2 \$1 sg13cmos5l_decap_8
* cell instance sg13cmos5l_decap_8_2883 r0 *1 0,0
Xsg13cmos5l_decap_8_2883 \$2 \$1 sg13cmos5l_decap_8
* cell instance sg13cmos5l_decap_8_2884 r0 *1 0,0
Xsg13cmos5l_decap_8_2884 \$2 \$1 sg13cmos5l_decap_8
* cell instance sg13cmos5l_decap_8_2885 r0 *1 0,0
Xsg13cmos5l_decap_8_2885 \$2 \$1 sg13cmos5l_decap_8
* cell instance sg13cmos5l_decap_8_2886 r0 *1 0,0
Xsg13cmos5l_decap_8_2886 \$2 \$1 sg13cmos5l_decap_8
* cell instance sg13cmos5l_decap_8_2887 r0 *1 0,0
Xsg13cmos5l_decap_8_2887 \$2 \$1 sg13cmos5l_decap_8
* cell instance sg13cmos5l_decap_8_2888 r0 *1 0,0
Xsg13cmos5l_decap_8_2888 \$2 \$1 sg13cmos5l_decap_8
* cell instance sg13cmos5l_decap_8_2889 r0 *1 0,0
Xsg13cmos5l_decap_8_2889 \$2 \$1 sg13cmos5l_decap_8
* cell instance sg13cmos5l_decap_8_2890 r0 *1 0,0
Xsg13cmos5l_decap_8_2890 \$2 \$1 sg13cmos5l_decap_8
* cell instance sg13cmos5l_decap_8_2891 r0 *1 0,0
Xsg13cmos5l_decap_8_2891 \$2 \$1 sg13cmos5l_decap_8
* cell instance sg13cmos5l_decap_8_2892 r0 *1 0,0
Xsg13cmos5l_decap_8_2892 \$2 \$1 sg13cmos5l_decap_8
* cell instance sg13cmos5l_decap_8_2893 r0 *1 0,0
Xsg13cmos5l_decap_8_2893 \$2 \$1 sg13cmos5l_decap_8
* cell instance sg13cmos5l_decap_8_2894 r0 *1 0,0
Xsg13cmos5l_decap_8_2894 \$2 \$1 sg13cmos5l_decap_8
* cell instance sg13cmos5l_decap_8_2895 r0 *1 0,0
Xsg13cmos5l_decap_8_2895 \$2 \$1 sg13cmos5l_decap_8
* cell instance sg13cmos5l_decap_8_2896 r0 *1 0,0
Xsg13cmos5l_decap_8_2896 \$2 \$1 sg13cmos5l_decap_8
* cell instance sg13cmos5l_decap_8_2897 r0 *1 0,0
Xsg13cmos5l_decap_8_2897 \$2 \$1 sg13cmos5l_decap_8
* cell instance sg13cmos5l_decap_8_2898 r0 *1 0,0
Xsg13cmos5l_decap_8_2898 \$2 \$1 sg13cmos5l_decap_8
* cell instance sg13cmos5l_decap_8_2899 r0 *1 0,0
Xsg13cmos5l_decap_8_2899 \$2 \$1 sg13cmos5l_decap_8
* cell instance sg13cmos5l_decap_8_2900 r0 *1 0,0
Xsg13cmos5l_decap_8_2900 \$2 \$1 sg13cmos5l_decap_8
* cell instance sg13cmos5l_decap_8_2901 r0 *1 0,0
Xsg13cmos5l_decap_8_2901 \$2 \$1 sg13cmos5l_decap_8
* cell instance sg13cmos5l_decap_8_2902 r0 *1 0,0
Xsg13cmos5l_decap_8_2902 \$2 \$1 sg13cmos5l_decap_8
* cell instance sg13cmos5l_decap_8_2903 r0 *1 0,0
Xsg13cmos5l_decap_8_2903 \$2 \$1 sg13cmos5l_decap_8
* cell instance sg13cmos5l_decap_8_2904 r0 *1 0,0
Xsg13cmos5l_decap_8_2904 \$2 \$1 sg13cmos5l_decap_8
* cell instance sg13cmos5l_decap_8_2905 r0 *1 0,0
Xsg13cmos5l_decap_8_2905 \$2 \$1 sg13cmos5l_decap_8
* cell instance sg13cmos5l_decap_8_2906 r0 *1 0,0
Xsg13cmos5l_decap_8_2906 \$2 \$1 sg13cmos5l_decap_8
* cell instance sg13cmos5l_decap_8_2907 r0 *1 0,0
Xsg13cmos5l_decap_8_2907 \$2 \$1 sg13cmos5l_decap_8
* cell instance sg13cmos5l_decap_8_2908 r0 *1 0,0
Xsg13cmos5l_decap_8_2908 \$2 \$1 sg13cmos5l_decap_8
* cell instance sg13cmos5l_decap_8_2909 r0 *1 0,0
Xsg13cmos5l_decap_8_2909 \$2 \$1 sg13cmos5l_decap_8
* cell instance sg13cmos5l_decap_8_2910 r0 *1 0,0
Xsg13cmos5l_decap_8_2910 \$2 \$1 sg13cmos5l_decap_8
* cell instance sg13cmos5l_decap_8_2911 r0 *1 0,0
Xsg13cmos5l_decap_8_2911 \$2 \$1 sg13cmos5l_decap_8
* cell instance sg13cmos5l_decap_8_2912 r0 *1 0,0
Xsg13cmos5l_decap_8_2912 \$2 \$1 sg13cmos5l_decap_8
* cell instance sg13cmos5l_decap_8_2913 r0 *1 0,0
Xsg13cmos5l_decap_8_2913 \$2 \$1 sg13cmos5l_decap_8
* cell instance sg13cmos5l_decap_8_2914 r0 *1 0,0
Xsg13cmos5l_decap_8_2914 \$2 \$1 sg13cmos5l_decap_8
* cell instance sg13cmos5l_decap_8_2915 r0 *1 0,0
Xsg13cmos5l_decap_8_2915 \$2 \$1 sg13cmos5l_decap_8
* cell instance sg13cmos5l_decap_8_2916 r0 *1 0,0
Xsg13cmos5l_decap_8_2916 \$2 \$1 sg13cmos5l_decap_8
* cell instance sg13cmos5l_decap_8_2917 r0 *1 0,0
Xsg13cmos5l_decap_8_2917 \$2 \$1 sg13cmos5l_decap_8
* cell instance sg13cmos5l_decap_8_2918 r0 *1 0,0
Xsg13cmos5l_decap_8_2918 \$2 \$1 sg13cmos5l_decap_8
* cell instance sg13cmos5l_decap_8_2919 r0 *1 0,0
Xsg13cmos5l_decap_8_2919 \$2 \$1 sg13cmos5l_decap_8
* cell instance sg13cmos5l_decap_8_2920 r0 *1 0,0
Xsg13cmos5l_decap_8_2920 \$2 \$1 sg13cmos5l_decap_8
* cell instance sg13cmos5l_decap_8_2921 r0 *1 0,0
Xsg13cmos5l_decap_8_2921 \$2 \$1 sg13cmos5l_decap_8
* cell instance sg13cmos5l_decap_8_2922 r0 *1 0,0
Xsg13cmos5l_decap_8_2922 \$2 \$1 sg13cmos5l_decap_8
* cell instance sg13cmos5l_decap_8_2923 r0 *1 0,0
Xsg13cmos5l_decap_8_2923 \$2 \$1 sg13cmos5l_decap_8
* cell instance sg13cmos5l_decap_8_2924 r0 *1 0,0
Xsg13cmos5l_decap_8_2924 \$2 \$1 sg13cmos5l_decap_8
* cell instance sg13cmos5l_decap_8_2925 r0 *1 0,0
Xsg13cmos5l_decap_8_2925 \$2 \$1 sg13cmos5l_decap_8
* cell instance sg13cmos5l_decap_8_2926 r0 *1 0,0
Xsg13cmos5l_decap_8_2926 \$2 \$1 sg13cmos5l_decap_8
* cell instance sg13cmos5l_decap_8_2927 r0 *1 0,0
Xsg13cmos5l_decap_8_2927 \$2 \$1 sg13cmos5l_decap_8
* cell instance sg13cmos5l_decap_8_2928 r0 *1 0,0
Xsg13cmos5l_decap_8_2928 \$2 \$1 sg13cmos5l_decap_8
* cell instance sg13cmos5l_decap_8_2929 r0 *1 0,0
Xsg13cmos5l_decap_8_2929 \$2 \$1 sg13cmos5l_decap_8
* cell instance sg13cmos5l_decap_8_2930 r0 *1 0,0
Xsg13cmos5l_decap_8_2930 \$2 \$1 sg13cmos5l_decap_8
* cell instance sg13cmos5l_decap_8_2931 r0 *1 0,0
Xsg13cmos5l_decap_8_2931 \$2 \$1 sg13cmos5l_decap_8
* cell instance sg13cmos5l_decap_8_2932 r0 *1 0,0
Xsg13cmos5l_decap_8_2932 \$2 \$1 sg13cmos5l_decap_8
* cell instance sg13cmos5l_decap_8_2933 r0 *1 0,0
Xsg13cmos5l_decap_8_2933 \$2 \$1 sg13cmos5l_decap_8
* cell instance sg13cmos5l_decap_8_2934 r0 *1 0,0
Xsg13cmos5l_decap_8_2934 \$2 \$1 sg13cmos5l_decap_8
* cell instance sg13cmos5l_decap_8_2935 r0 *1 0,0
Xsg13cmos5l_decap_8_2935 \$2 \$1 sg13cmos5l_decap_8
* cell instance sg13cmos5l_decap_8_2936 r0 *1 0,0
Xsg13cmos5l_decap_8_2936 \$2 \$1 sg13cmos5l_decap_8
* cell instance sg13cmos5l_decap_8_2937 r0 *1 0,0
Xsg13cmos5l_decap_8_2937 \$2 \$1 sg13cmos5l_decap_8
* cell instance sg13cmos5l_decap_8_2938 r0 *1 0,0
Xsg13cmos5l_decap_8_2938 \$2 \$1 sg13cmos5l_decap_8
* cell instance sg13cmos5l_decap_8_2939 r0 *1 0,0
Xsg13cmos5l_decap_8_2939 \$2 \$1 sg13cmos5l_decap_8
* cell instance sg13cmos5l_decap_8_2940 r0 *1 0,0
Xsg13cmos5l_decap_8_2940 \$2 \$1 sg13cmos5l_decap_8
* cell instance sg13cmos5l_decap_8_2941 r0 *1 0,0
Xsg13cmos5l_decap_8_2941 \$2 \$1 sg13cmos5l_decap_8
* cell instance sg13cmos5l_decap_8_2942 r0 *1 0,0
Xsg13cmos5l_decap_8_2942 \$2 \$1 sg13cmos5l_decap_8
* cell instance sg13cmos5l_decap_8_2943 r0 *1 0,0
Xsg13cmos5l_decap_8_2943 \$2 \$1 sg13cmos5l_decap_8
* cell instance sg13cmos5l_decap_8_2944 r0 *1 0,0
Xsg13cmos5l_decap_8_2944 \$2 \$1 sg13cmos5l_decap_8
* cell instance sg13cmos5l_decap_8_2945 r0 *1 0,0
Xsg13cmos5l_decap_8_2945 \$2 \$1 sg13cmos5l_decap_8
* cell instance sg13cmos5l_decap_8_2946 r0 *1 0,0
Xsg13cmos5l_decap_8_2946 \$2 \$1 sg13cmos5l_decap_8
* cell instance sg13cmos5l_decap_8_2947 r0 *1 0,0
Xsg13cmos5l_decap_8_2947 \$2 \$1 sg13cmos5l_decap_8
* cell instance sg13cmos5l_decap_8_2948 r0 *1 0,0
Xsg13cmos5l_decap_8_2948 \$2 \$1 sg13cmos5l_decap_8
* cell instance sg13cmos5l_decap_8_2949 r0 *1 0,0
Xsg13cmos5l_decap_8_2949 \$2 \$1 sg13cmos5l_decap_8
* cell instance sg13cmos5l_decap_8_2950 r0 *1 0,0
Xsg13cmos5l_decap_8_2950 \$2 \$1 sg13cmos5l_decap_8
* cell instance sg13cmos5l_decap_8_2951 r0 *1 0,0
Xsg13cmos5l_decap_8_2951 \$2 \$1 sg13cmos5l_decap_8
* cell instance sg13cmos5l_decap_8_2952 r0 *1 0,0
Xsg13cmos5l_decap_8_2952 \$2 \$1 sg13cmos5l_decap_8
* cell instance sg13cmos5l_decap_8_2953 r0 *1 0,0
Xsg13cmos5l_decap_8_2953 \$2 \$1 sg13cmos5l_decap_8
* cell instance sg13cmos5l_decap_8_2954 r0 *1 0,0
Xsg13cmos5l_decap_8_2954 \$2 \$1 sg13cmos5l_decap_8
* cell instance sg13cmos5l_decap_8_2955 r0 *1 0,0
Xsg13cmos5l_decap_8_2955 \$2 \$1 sg13cmos5l_decap_8
* cell instance sg13cmos5l_decap_8_2956 r0 *1 0,0
Xsg13cmos5l_decap_8_2956 \$2 \$1 sg13cmos5l_decap_8
* cell instance sg13cmos5l_decap_8_2957 r0 *1 0,0
Xsg13cmos5l_decap_8_2957 \$2 \$1 sg13cmos5l_decap_8
* cell instance sg13cmos5l_decap_8_2958 r0 *1 0,0
Xsg13cmos5l_decap_8_2958 \$2 \$1 sg13cmos5l_decap_8
* cell instance sg13cmos5l_decap_8_2959 r0 *1 0,0
Xsg13cmos5l_decap_8_2959 \$2 \$1 sg13cmos5l_decap_8
* cell instance sg13cmos5l_decap_8_2960 r0 *1 0,0
Xsg13cmos5l_decap_8_2960 \$2 \$1 sg13cmos5l_decap_8
* cell instance sg13cmos5l_decap_8_2961 r0 *1 0,0
Xsg13cmos5l_decap_8_2961 \$2 \$1 sg13cmos5l_decap_8
* cell instance sg13cmos5l_decap_8_2962 r0 *1 0,0
Xsg13cmos5l_decap_8_2962 \$2 \$1 sg13cmos5l_decap_8
* cell instance sg13cmos5l_decap_8_2963 r0 *1 0,0
Xsg13cmos5l_decap_8_2963 \$2 \$1 sg13cmos5l_decap_8
* cell instance sg13cmos5l_decap_8_2964 r0 *1 0,0
Xsg13cmos5l_decap_8_2964 \$2 \$1 sg13cmos5l_decap_8
* cell instance sg13cmos5l_decap_8_2965 r0 *1 0,0
Xsg13cmos5l_decap_8_2965 \$2 \$1 sg13cmos5l_decap_8
* cell instance sg13cmos5l_decap_8_2966 r0 *1 0,0
Xsg13cmos5l_decap_8_2966 \$2 \$1 sg13cmos5l_decap_8
* cell instance sg13cmos5l_decap_8_2967 r0 *1 0,0
Xsg13cmos5l_decap_8_2967 \$2 \$1 sg13cmos5l_decap_8
* cell instance sg13cmos5l_decap_8_2968 r0 *1 0,0
Xsg13cmos5l_decap_8_2968 \$2 \$1 sg13cmos5l_decap_8
* cell instance sg13cmos5l_decap_8_2969 r0 *1 0,0
Xsg13cmos5l_decap_8_2969 \$2 \$1 sg13cmos5l_decap_8
* cell instance sg13cmos5l_decap_8_2970 r0 *1 0,0
Xsg13cmos5l_decap_8_2970 \$2 \$1 sg13cmos5l_decap_8
* cell instance sg13cmos5l_decap_8_2971 r0 *1 0,0
Xsg13cmos5l_decap_8_2971 \$2 \$1 sg13cmos5l_decap_8
* cell instance sg13cmos5l_decap_8_2972 r0 *1 0,0
Xsg13cmos5l_decap_8_2972 \$2 \$1 sg13cmos5l_decap_8
* cell instance sg13cmos5l_decap_8_2973 r0 *1 0,0
Xsg13cmos5l_decap_8_2973 \$2 \$1 sg13cmos5l_decap_8
* cell instance sg13cmos5l_decap_8_2974 r0 *1 0,0
Xsg13cmos5l_decap_8_2974 \$2 \$1 sg13cmos5l_decap_8
* cell instance sg13cmos5l_decap_8_2975 r0 *1 0,0
Xsg13cmos5l_decap_8_2975 \$2 \$1 sg13cmos5l_decap_8
* cell instance sg13cmos5l_decap_8_2976 r0 *1 0,0
Xsg13cmos5l_decap_8_2976 \$2 \$1 sg13cmos5l_decap_8
* cell instance sg13cmos5l_decap_8_2977 r0 *1 0,0
Xsg13cmos5l_decap_8_2977 \$2 \$1 sg13cmos5l_decap_8
* cell instance sg13cmos5l_decap_8_2978 r0 *1 0,0
Xsg13cmos5l_decap_8_2978 \$2 \$1 sg13cmos5l_decap_8
* cell instance sg13cmos5l_decap_8_2979 r0 *1 0,0
Xsg13cmos5l_decap_8_2979 \$2 \$1 sg13cmos5l_decap_8
* cell instance sg13cmos5l_decap_8_2980 r0 *1 0,0
Xsg13cmos5l_decap_8_2980 \$2 \$1 sg13cmos5l_decap_8
* cell instance sg13cmos5l_decap_8_2981 r0 *1 0,0
Xsg13cmos5l_decap_8_2981 \$2 \$1 sg13cmos5l_decap_8
* cell instance sg13cmos5l_decap_8_2982 r0 *1 0,0
Xsg13cmos5l_decap_8_2982 \$2 \$1 sg13cmos5l_decap_8
* cell instance sg13cmos5l_decap_8_2983 r0 *1 0,0
Xsg13cmos5l_decap_8_2983 \$2 \$1 sg13cmos5l_decap_8
* cell instance sg13cmos5l_decap_8_2984 r0 *1 0,0
Xsg13cmos5l_decap_8_2984 \$2 \$1 sg13cmos5l_decap_8
* cell instance sg13cmos5l_decap_8_2985 r0 *1 0,0
Xsg13cmos5l_decap_8_2985 \$2 \$1 sg13cmos5l_decap_8
* cell instance sg13cmos5l_decap_8_2986 r0 *1 0,0
Xsg13cmos5l_decap_8_2986 \$2 \$1 sg13cmos5l_decap_8
* cell instance sg13cmos5l_decap_8_2987 r0 *1 0,0
Xsg13cmos5l_decap_8_2987 \$2 \$1 sg13cmos5l_decap_8
* cell instance sg13cmos5l_decap_8_2988 r0 *1 0,0
Xsg13cmos5l_decap_8_2988 \$2 \$1 sg13cmos5l_decap_8
* cell instance sg13cmos5l_decap_8_2989 r0 *1 0,0
Xsg13cmos5l_decap_8_2989 \$2 \$1 sg13cmos5l_decap_8
* cell instance sg13cmos5l_decap_8_2990 r0 *1 0,0
Xsg13cmos5l_decap_8_2990 \$2 \$1 sg13cmos5l_decap_8
* cell instance sg13cmos5l_decap_8_2991 r0 *1 0,0
Xsg13cmos5l_decap_8_2991 \$2 \$1 sg13cmos5l_decap_8
* cell instance sg13cmos5l_decap_8_2992 r0 *1 0,0
Xsg13cmos5l_decap_8_2992 \$2 \$1 sg13cmos5l_decap_8
* cell instance sg13cmos5l_decap_8_2993 r0 *1 0,0
Xsg13cmos5l_decap_8_2993 \$2 \$1 sg13cmos5l_decap_8
* cell instance sg13cmos5l_decap_8_2994 r0 *1 0,0
Xsg13cmos5l_decap_8_2994 \$2 \$1 sg13cmos5l_decap_8
* cell instance sg13cmos5l_decap_8_2995 r0 *1 0,0
Xsg13cmos5l_decap_8_2995 \$2 \$1 sg13cmos5l_decap_8
* cell instance sg13cmos5l_decap_8_2996 r0 *1 0,0
Xsg13cmos5l_decap_8_2996 \$2 \$1 sg13cmos5l_decap_8
* cell instance sg13cmos5l_decap_8_2997 r0 *1 0,0
Xsg13cmos5l_decap_8_2997 \$2 \$1 sg13cmos5l_decap_8
* cell instance sg13cmos5l_decap_8_2998 r0 *1 0,0
Xsg13cmos5l_decap_8_2998 \$2 \$1 sg13cmos5l_decap_8
* cell instance sg13cmos5l_decap_8_2999 r0 *1 0,0
Xsg13cmos5l_decap_8_2999 \$2 \$1 sg13cmos5l_decap_8
* cell instance sg13cmos5l_decap_8_3000 r0 *1 0,0
Xsg13cmos5l_decap_8_3000 \$2 \$1 sg13cmos5l_decap_8
* cell instance sg13cmos5l_decap_8_3001 r0 *1 0,0
Xsg13cmos5l_decap_8_3001 \$2 \$1 sg13cmos5l_decap_8
* cell instance sg13cmos5l_decap_8_3002 r0 *1 0,0
Xsg13cmos5l_decap_8_3002 \$2 \$1 sg13cmos5l_decap_8
* cell instance sg13cmos5l_decap_8_3003 r0 *1 0,0
Xsg13cmos5l_decap_8_3003 \$2 \$1 sg13cmos5l_decap_8
* cell instance sg13cmos5l_decap_8_3004 r0 *1 0,0
Xsg13cmos5l_decap_8_3004 \$2 \$1 sg13cmos5l_decap_8
* cell instance sg13cmos5l_decap_8_3005 r0 *1 0,0
Xsg13cmos5l_decap_8_3005 \$2 \$1 sg13cmos5l_decap_8
* cell instance sg13cmos5l_decap_8_3006 r0 *1 0,0
Xsg13cmos5l_decap_8_3006 \$2 \$1 sg13cmos5l_decap_8
* cell instance sg13cmos5l_decap_8_3007 r0 *1 0,0
Xsg13cmos5l_decap_8_3007 \$2 \$1 sg13cmos5l_decap_8
* cell instance sg13cmos5l_decap_8_3008 r0 *1 0,0
Xsg13cmos5l_decap_8_3008 \$2 \$1 sg13cmos5l_decap_8
* cell instance sg13cmos5l_decap_8_3009 r0 *1 0,0
Xsg13cmos5l_decap_8_3009 \$2 \$1 sg13cmos5l_decap_8
* cell instance sg13cmos5l_decap_8_3010 r0 *1 0,0
Xsg13cmos5l_decap_8_3010 \$2 \$1 sg13cmos5l_decap_8
* cell instance sg13cmos5l_decap_8_3011 r0 *1 0,0
Xsg13cmos5l_decap_8_3011 \$2 \$1 sg13cmos5l_decap_8
* cell instance sg13cmos5l_decap_8_3012 r0 *1 0,0
Xsg13cmos5l_decap_8_3012 \$2 \$1 sg13cmos5l_decap_8
* cell instance sg13cmos5l_decap_8_3013 r0 *1 0,0
Xsg13cmos5l_decap_8_3013 \$2 \$1 sg13cmos5l_decap_8
* cell instance sg13cmos5l_decap_8_3014 r0 *1 0,0
Xsg13cmos5l_decap_8_3014 \$2 \$1 sg13cmos5l_decap_8
* cell instance sg13cmos5l_decap_8_3015 r0 *1 0,0
Xsg13cmos5l_decap_8_3015 \$2 \$1 sg13cmos5l_decap_8
* cell instance sg13cmos5l_decap_8_3016 r0 *1 0,0
Xsg13cmos5l_decap_8_3016 \$2 \$1 sg13cmos5l_decap_8
* cell instance sg13cmos5l_decap_8_3017 r0 *1 0,0
Xsg13cmos5l_decap_8_3017 \$2 \$1 sg13cmos5l_decap_8
* cell instance sg13cmos5l_decap_8_3018 r0 *1 0,0
Xsg13cmos5l_decap_8_3018 \$2 \$1 sg13cmos5l_decap_8
* cell instance sg13cmos5l_decap_8_3019 r0 *1 0,0
Xsg13cmos5l_decap_8_3019 \$2 \$1 sg13cmos5l_decap_8
* cell instance sg13cmos5l_decap_8_3020 r0 *1 0,0
Xsg13cmos5l_decap_8_3020 \$2 \$1 sg13cmos5l_decap_8
* cell instance sg13cmos5l_decap_8_3021 r0 *1 0,0
Xsg13cmos5l_decap_8_3021 \$2 \$1 sg13cmos5l_decap_8
* cell instance sg13cmos5l_decap_8_3022 r0 *1 0,0
Xsg13cmos5l_decap_8_3022 \$2 \$1 sg13cmos5l_decap_8
* cell instance sg13cmos5l_decap_8_3023 r0 *1 0,0
Xsg13cmos5l_decap_8_3023 \$2 \$1 sg13cmos5l_decap_8
* cell instance sg13cmos5l_decap_8_3024 r0 *1 0,0
Xsg13cmos5l_decap_8_3024 \$2 \$1 sg13cmos5l_decap_8
* cell instance sg13cmos5l_decap_8_3025 r0 *1 0,0
Xsg13cmos5l_decap_8_3025 \$2 \$1 sg13cmos5l_decap_8
* cell instance sg13cmos5l_decap_8_3026 r0 *1 0,0
Xsg13cmos5l_decap_8_3026 \$2 \$1 sg13cmos5l_decap_8
* cell instance sg13cmos5l_decap_8_3027 r0 *1 0,0
Xsg13cmos5l_decap_8_3027 \$2 \$1 sg13cmos5l_decap_8
* cell instance sg13cmos5l_decap_8_3028 r0 *1 0,0
Xsg13cmos5l_decap_8_3028 \$2 \$1 sg13cmos5l_decap_8
* cell instance sg13cmos5l_decap_8_3029 r0 *1 0,0
Xsg13cmos5l_decap_8_3029 \$2 \$1 sg13cmos5l_decap_8
* cell instance sg13cmos5l_decap_8_3030 r0 *1 0,0
Xsg13cmos5l_decap_8_3030 \$2 \$1 sg13cmos5l_decap_8
* cell instance sg13cmos5l_decap_8_3031 r0 *1 0,0
Xsg13cmos5l_decap_8_3031 \$2 \$1 sg13cmos5l_decap_8
* cell instance sg13cmos5l_decap_8_3032 r0 *1 0,0
Xsg13cmos5l_decap_8_3032 \$2 \$1 sg13cmos5l_decap_8
* cell instance sg13cmos5l_decap_8_3033 r0 *1 0,0
Xsg13cmos5l_decap_8_3033 \$2 \$1 sg13cmos5l_decap_8
* cell instance sg13cmos5l_decap_8_3034 r0 *1 0,0
Xsg13cmos5l_decap_8_3034 \$2 \$1 sg13cmos5l_decap_8
* cell instance sg13cmos5l_decap_8_3035 r0 *1 0,0
Xsg13cmos5l_decap_8_3035 \$2 \$1 sg13cmos5l_decap_8
* cell instance sg13cmos5l_decap_8_3036 r0 *1 0,0
Xsg13cmos5l_decap_8_3036 \$2 \$1 sg13cmos5l_decap_8
* cell instance sg13cmos5l_decap_8_3037 r0 *1 0,0
Xsg13cmos5l_decap_8_3037 \$2 \$1 sg13cmos5l_decap_8
* cell instance sg13cmos5l_decap_8_3038 r0 *1 0,0
Xsg13cmos5l_decap_8_3038 \$2 \$1 sg13cmos5l_decap_8
* cell instance sg13cmos5l_decap_8_3039 r0 *1 0,0
Xsg13cmos5l_decap_8_3039 \$2 \$1 sg13cmos5l_decap_8
* cell instance sg13cmos5l_decap_8_3040 r0 *1 0,0
Xsg13cmos5l_decap_8_3040 \$2 \$1 sg13cmos5l_decap_8
* cell instance sg13cmos5l_decap_8_3041 r0 *1 0,0
Xsg13cmos5l_decap_8_3041 \$2 \$1 sg13cmos5l_decap_8
* cell instance sg13cmos5l_decap_8_3042 r0 *1 0,0
Xsg13cmos5l_decap_8_3042 \$2 \$1 sg13cmos5l_decap_8
* cell instance sg13cmos5l_decap_8_3043 r0 *1 0,0
Xsg13cmos5l_decap_8_3043 \$2 \$1 sg13cmos5l_decap_8
* cell instance sg13cmos5l_decap_8_3044 r0 *1 0,0
Xsg13cmos5l_decap_8_3044 \$2 \$1 sg13cmos5l_decap_8
* cell instance sg13cmos5l_decap_8_3045 r0 *1 0,0
Xsg13cmos5l_decap_8_3045 \$2 \$1 sg13cmos5l_decap_8
* cell instance sg13cmos5l_decap_8_3046 r0 *1 0,0
Xsg13cmos5l_decap_8_3046 \$2 \$1 sg13cmos5l_decap_8
* cell instance sg13cmos5l_decap_8_3047 r0 *1 0,0
Xsg13cmos5l_decap_8_3047 \$2 \$1 sg13cmos5l_decap_8
* cell instance sg13cmos5l_decap_8_3048 r0 *1 0,0
Xsg13cmos5l_decap_8_3048 \$2 \$1 sg13cmos5l_decap_8
* cell instance sg13cmos5l_decap_8_3049 r0 *1 0,0
Xsg13cmos5l_decap_8_3049 \$2 \$1 sg13cmos5l_decap_8
* cell instance sg13cmos5l_decap_8_3050 r0 *1 0,0
Xsg13cmos5l_decap_8_3050 \$2 \$1 sg13cmos5l_decap_8
* cell instance sg13cmos5l_decap_8_3051 r0 *1 0,0
Xsg13cmos5l_decap_8_3051 \$2 \$1 sg13cmos5l_decap_8
* cell instance sg13cmos5l_decap_8_3052 r0 *1 0,0
Xsg13cmos5l_decap_8_3052 \$2 \$1 sg13cmos5l_decap_8
* cell instance sg13cmos5l_decap_8_3053 r0 *1 0,0
Xsg13cmos5l_decap_8_3053 \$2 \$1 sg13cmos5l_decap_8
* cell instance sg13cmos5l_decap_8_3054 r0 *1 0,0
Xsg13cmos5l_decap_8_3054 \$2 \$1 sg13cmos5l_decap_8
* cell instance sg13cmos5l_decap_8_3055 r0 *1 0,0
Xsg13cmos5l_decap_8_3055 \$2 \$1 sg13cmos5l_decap_8
* cell instance sg13cmos5l_decap_8_3056 r0 *1 0,0
Xsg13cmos5l_decap_8_3056 \$2 \$1 sg13cmos5l_decap_8
* cell instance sg13cmos5l_decap_8_3057 r0 *1 0,0
Xsg13cmos5l_decap_8_3057 \$2 \$1 sg13cmos5l_decap_8
* cell instance sg13cmos5l_decap_8_3058 r0 *1 0,0
Xsg13cmos5l_decap_8_3058 \$2 \$1 sg13cmos5l_decap_8
* cell instance sg13cmos5l_decap_8_3059 r0 *1 0,0
Xsg13cmos5l_decap_8_3059 \$2 \$1 sg13cmos5l_decap_8
* cell instance sg13cmos5l_decap_8_3060 r0 *1 0,0
Xsg13cmos5l_decap_8_3060 \$2 \$1 sg13cmos5l_decap_8
* cell instance sg13cmos5l_decap_8_3061 r0 *1 0,0
Xsg13cmos5l_decap_8_3061 \$2 \$1 sg13cmos5l_decap_8
* cell instance sg13cmos5l_decap_8_3062 r0 *1 0,0
Xsg13cmos5l_decap_8_3062 \$2 \$1 sg13cmos5l_decap_8
* cell instance sg13cmos5l_decap_8_3063 r0 *1 0,0
Xsg13cmos5l_decap_8_3063 \$2 \$1 sg13cmos5l_decap_8
* cell instance sg13cmos5l_decap_8_3064 r0 *1 0,0
Xsg13cmos5l_decap_8_3064 \$2 \$1 sg13cmos5l_decap_8
* cell instance sg13cmos5l_decap_8_3065 r0 *1 0,0
Xsg13cmos5l_decap_8_3065 \$2 \$1 sg13cmos5l_decap_8
* cell instance sg13cmos5l_decap_8_3066 r0 *1 0,0
Xsg13cmos5l_decap_8_3066 \$2 \$1 sg13cmos5l_decap_8
* cell instance sg13cmos5l_decap_8_3067 r0 *1 0,0
Xsg13cmos5l_decap_8_3067 \$2 \$1 sg13cmos5l_decap_8
* cell instance sg13cmos5l_decap_8_3068 r0 *1 0,0
Xsg13cmos5l_decap_8_3068 \$2 \$1 sg13cmos5l_decap_8
* cell instance sg13cmos5l_decap_8_3069 r0 *1 0,0
Xsg13cmos5l_decap_8_3069 \$2 \$1 sg13cmos5l_decap_8
* cell instance sg13cmos5l_decap_8_3070 r0 *1 0,0
Xsg13cmos5l_decap_8_3070 \$2 \$1 sg13cmos5l_decap_8
* cell instance sg13cmos5l_decap_8_3071 r0 *1 0,0
Xsg13cmos5l_decap_8_3071 \$2 \$1 sg13cmos5l_decap_8
* cell instance sg13cmos5l_decap_8_3072 r0 *1 0,0
Xsg13cmos5l_decap_8_3072 \$2 \$1 sg13cmos5l_decap_8
* cell instance sg13cmos5l_decap_8_3073 r0 *1 0,0
Xsg13cmos5l_decap_8_3073 \$2 \$1 sg13cmos5l_decap_8
* cell instance sg13cmos5l_decap_8_3074 r0 *1 0,0
Xsg13cmos5l_decap_8_3074 \$2 \$1 sg13cmos5l_decap_8
* cell instance sg13cmos5l_decap_8_3075 r0 *1 0,0
Xsg13cmos5l_decap_8_3075 \$2 \$1 sg13cmos5l_decap_8
* cell instance sg13cmos5l_decap_8_3076 r0 *1 0,0
Xsg13cmos5l_decap_8_3076 \$2 \$1 sg13cmos5l_decap_8
* cell instance sg13cmos5l_decap_8_3077 r0 *1 0,0
Xsg13cmos5l_decap_8_3077 \$2 \$1 sg13cmos5l_decap_8
* cell instance sg13cmos5l_decap_8_3078 r0 *1 0,0
Xsg13cmos5l_decap_8_3078 \$2 \$1 sg13cmos5l_decap_8
* cell instance sg13cmos5l_decap_8_3079 r0 *1 0,0
Xsg13cmos5l_decap_8_3079 \$2 \$1 sg13cmos5l_decap_8
* cell instance sg13cmos5l_decap_8_3080 r0 *1 0,0
Xsg13cmos5l_decap_8_3080 \$2 \$1 sg13cmos5l_decap_8
* cell instance sg13cmos5l_decap_8_3081 r0 *1 0,0
Xsg13cmos5l_decap_8_3081 \$2 \$1 sg13cmos5l_decap_8
* cell instance sg13cmos5l_decap_8_3082 r0 *1 0,0
Xsg13cmos5l_decap_8_3082 \$2 \$1 sg13cmos5l_decap_8
* cell instance sg13cmos5l_decap_8_3083 r0 *1 0,0
Xsg13cmos5l_decap_8_3083 \$2 \$1 sg13cmos5l_decap_8
* cell instance sg13cmos5l_decap_8_3084 r0 *1 0,0
Xsg13cmos5l_decap_8_3084 \$2 \$1 sg13cmos5l_decap_8
* cell instance sg13cmos5l_decap_8_3085 r0 *1 0,0
Xsg13cmos5l_decap_8_3085 \$2 \$1 sg13cmos5l_decap_8
* cell instance sg13cmos5l_decap_8_3086 r0 *1 0,0
Xsg13cmos5l_decap_8_3086 \$2 \$1 sg13cmos5l_decap_8
* cell instance sg13cmos5l_decap_8_3087 r0 *1 0,0
Xsg13cmos5l_decap_8_3087 \$2 \$1 sg13cmos5l_decap_8
* cell instance sg13cmos5l_decap_8_3088 r0 *1 0,0
Xsg13cmos5l_decap_8_3088 \$2 \$1 sg13cmos5l_decap_8
* cell instance sg13cmos5l_decap_8_3089 r0 *1 0,0
Xsg13cmos5l_decap_8_3089 \$2 \$1 sg13cmos5l_decap_8
* cell instance sg13cmos5l_decap_8_3090 r0 *1 0,0
Xsg13cmos5l_decap_8_3090 \$2 \$1 sg13cmos5l_decap_8
* cell instance sg13cmos5l_decap_8_3091 r0 *1 0,0
Xsg13cmos5l_decap_8_3091 \$2 \$1 sg13cmos5l_decap_8
* cell instance sg13cmos5l_decap_8_3092 r0 *1 0,0
Xsg13cmos5l_decap_8_3092 \$2 \$1 sg13cmos5l_decap_8
* cell instance sg13cmos5l_decap_8_3093 r0 *1 0,0
Xsg13cmos5l_decap_8_3093 \$2 \$1 sg13cmos5l_decap_8
* cell instance sg13cmos5l_decap_8_3094 r0 *1 0,0
Xsg13cmos5l_decap_8_3094 \$2 \$1 sg13cmos5l_decap_8
* cell instance sg13cmos5l_decap_8_3095 r0 *1 0,0
Xsg13cmos5l_decap_8_3095 \$2 \$1 sg13cmos5l_decap_8
* cell instance sg13cmos5l_decap_8_3096 r0 *1 0,0
Xsg13cmos5l_decap_8_3096 \$2 \$1 sg13cmos5l_decap_8
* cell instance sg13cmos5l_decap_8_3097 r0 *1 0,0
Xsg13cmos5l_decap_8_3097 \$2 \$1 sg13cmos5l_decap_8
* cell instance sg13cmos5l_decap_8_3098 r0 *1 0,0
Xsg13cmos5l_decap_8_3098 \$2 \$1 sg13cmos5l_decap_8
* cell instance sg13cmos5l_decap_8_3099 r0 *1 0,0
Xsg13cmos5l_decap_8_3099 \$2 \$1 sg13cmos5l_decap_8
* cell instance sg13cmos5l_decap_8_3100 r0 *1 0,0
Xsg13cmos5l_decap_8_3100 \$2 \$1 sg13cmos5l_decap_8
* cell instance sg13cmos5l_decap_8_3101 r0 *1 0,0
Xsg13cmos5l_decap_8_3101 \$2 \$1 sg13cmos5l_decap_8
* cell instance sg13cmos5l_decap_8_3102 r0 *1 0,0
Xsg13cmos5l_decap_8_3102 \$2 \$1 sg13cmos5l_decap_8
* cell instance sg13cmos5l_decap_8_3103 r0 *1 0,0
Xsg13cmos5l_decap_8_3103 \$2 \$1 sg13cmos5l_decap_8
* cell instance sg13cmos5l_decap_8_3104 r0 *1 0,0
Xsg13cmos5l_decap_8_3104 \$2 \$1 sg13cmos5l_decap_8
* cell instance sg13cmos5l_decap_8_3105 r0 *1 0,0
Xsg13cmos5l_decap_8_3105 \$2 \$1 sg13cmos5l_decap_8
* cell instance sg13cmos5l_decap_8_3106 r0 *1 0,0
Xsg13cmos5l_decap_8_3106 \$2 \$1 sg13cmos5l_decap_8
* cell instance sg13cmos5l_decap_8_3107 r0 *1 0,0
Xsg13cmos5l_decap_8_3107 \$2 \$1 sg13cmos5l_decap_8
* cell instance sg13cmos5l_decap_8_3108 r0 *1 0,0
Xsg13cmos5l_decap_8_3108 \$2 \$1 sg13cmos5l_decap_8
* cell instance sg13cmos5l_decap_8_3109 r0 *1 0,0
Xsg13cmos5l_decap_8_3109 \$2 \$1 sg13cmos5l_decap_8
* cell instance sg13cmos5l_decap_8_3110 r0 *1 0,0
Xsg13cmos5l_decap_8_3110 \$2 \$1 sg13cmos5l_decap_8
* cell instance sg13cmos5l_decap_8_3111 r0 *1 0,0
Xsg13cmos5l_decap_8_3111 \$2 \$1 sg13cmos5l_decap_8
* cell instance sg13cmos5l_decap_8_3112 r0 *1 0,0
Xsg13cmos5l_decap_8_3112 \$2 \$1 sg13cmos5l_decap_8
* cell instance sg13cmos5l_decap_8_3113 r0 *1 0,0
Xsg13cmos5l_decap_8_3113 \$2 \$1 sg13cmos5l_decap_8
* cell instance sg13cmos5l_decap_8_3114 r0 *1 0,0
Xsg13cmos5l_decap_8_3114 \$2 \$1 sg13cmos5l_decap_8
* cell instance sg13cmos5l_decap_8_3115 r0 *1 0,0
Xsg13cmos5l_decap_8_3115 \$2 \$1 sg13cmos5l_decap_8
* cell instance sg13cmos5l_decap_8_3116 r0 *1 0,0
Xsg13cmos5l_decap_8_3116 \$2 \$1 sg13cmos5l_decap_8
* cell instance sg13cmos5l_decap_8_3117 r0 *1 0,0
Xsg13cmos5l_decap_8_3117 \$2 \$1 sg13cmos5l_decap_8
* cell instance sg13cmos5l_decap_8_3118 r0 *1 0,0
Xsg13cmos5l_decap_8_3118 \$2 \$1 sg13cmos5l_decap_8
* cell instance sg13cmos5l_decap_8_3119 r0 *1 0,0
Xsg13cmos5l_decap_8_3119 \$2 \$1 sg13cmos5l_decap_8
* cell instance sg13cmos5l_decap_8_3120 r0 *1 0,0
Xsg13cmos5l_decap_8_3120 \$2 \$1 sg13cmos5l_decap_8
* cell instance sg13cmos5l_decap_8_3121 r0 *1 0,0
Xsg13cmos5l_decap_8_3121 \$2 \$1 sg13cmos5l_decap_8
* cell instance sg13cmos5l_decap_8_3122 r0 *1 0,0
Xsg13cmos5l_decap_8_3122 \$2 \$1 sg13cmos5l_decap_8
* cell instance sg13cmos5l_decap_8_3123 r0 *1 0,0
Xsg13cmos5l_decap_8_3123 \$2 \$1 sg13cmos5l_decap_8
* cell instance sg13cmos5l_decap_8_3124 r0 *1 0,0
Xsg13cmos5l_decap_8_3124 \$2 \$1 sg13cmos5l_decap_8
* cell instance sg13cmos5l_decap_8_3125 r0 *1 0,0
Xsg13cmos5l_decap_8_3125 \$2 \$1 sg13cmos5l_decap_8
* cell instance sg13cmos5l_decap_8_3126 r0 *1 0,0
Xsg13cmos5l_decap_8_3126 \$2 \$1 sg13cmos5l_decap_8
* cell instance sg13cmos5l_decap_8_3127 r0 *1 0,0
Xsg13cmos5l_decap_8_3127 \$2 \$1 sg13cmos5l_decap_8
* cell instance sg13cmos5l_decap_8_3128 r0 *1 0,0
Xsg13cmos5l_decap_8_3128 \$2 \$1 sg13cmos5l_decap_8
* cell instance sg13cmos5l_decap_8_3129 r0 *1 0,0
Xsg13cmos5l_decap_8_3129 \$2 \$1 sg13cmos5l_decap_8
* cell instance sg13cmos5l_decap_8_3130 r0 *1 0,0
Xsg13cmos5l_decap_8_3130 \$2 \$1 sg13cmos5l_decap_8
* cell instance sg13cmos5l_decap_8_3131 r0 *1 0,0
Xsg13cmos5l_decap_8_3131 \$2 \$1 sg13cmos5l_decap_8
* cell instance sg13cmos5l_decap_8_3132 r0 *1 0,0
Xsg13cmos5l_decap_8_3132 \$2 \$1 sg13cmos5l_decap_8
* cell instance sg13cmos5l_decap_8_3133 r0 *1 0,0
Xsg13cmos5l_decap_8_3133 \$2 \$1 sg13cmos5l_decap_8
* cell instance sg13cmos5l_decap_8_3134 r0 *1 0,0
Xsg13cmos5l_decap_8_3134 \$2 \$1 sg13cmos5l_decap_8
* cell instance sg13cmos5l_decap_8_3135 r0 *1 0,0
Xsg13cmos5l_decap_8_3135 \$2 \$1 sg13cmos5l_decap_8
* cell instance sg13cmos5l_decap_8_3136 r0 *1 0,0
Xsg13cmos5l_decap_8_3136 \$2 \$1 sg13cmos5l_decap_8
* cell instance sg13cmos5l_decap_8_3137 r0 *1 0,0
Xsg13cmos5l_decap_8_3137 \$2 \$1 sg13cmos5l_decap_8
* cell instance sg13cmos5l_decap_8_3138 r0 *1 0,0
Xsg13cmos5l_decap_8_3138 \$2 \$1 sg13cmos5l_decap_8
* cell instance sg13cmos5l_decap_8_3139 r0 *1 0,0
Xsg13cmos5l_decap_8_3139 \$2 \$1 sg13cmos5l_decap_8
* cell instance sg13cmos5l_decap_8_3140 r0 *1 0,0
Xsg13cmos5l_decap_8_3140 \$2 \$1 sg13cmos5l_decap_8
* cell instance sg13cmos5l_decap_8_3141 r0 *1 0,0
Xsg13cmos5l_decap_8_3141 \$2 \$1 sg13cmos5l_decap_8
* cell instance sg13cmos5l_decap_8_3142 r0 *1 0,0
Xsg13cmos5l_decap_8_3142 \$2 \$1 sg13cmos5l_decap_8
* cell instance sg13cmos5l_decap_8_3143 r0 *1 0,0
Xsg13cmos5l_decap_8_3143 \$2 \$1 sg13cmos5l_decap_8
* cell instance sg13cmos5l_decap_8_3144 r0 *1 0,0
Xsg13cmos5l_decap_8_3144 \$2 \$1 sg13cmos5l_decap_8
* cell instance sg13cmos5l_decap_8_3145 r0 *1 0,0
Xsg13cmos5l_decap_8_3145 \$2 \$1 sg13cmos5l_decap_8
* cell instance sg13cmos5l_decap_8_3146 r0 *1 0,0
Xsg13cmos5l_decap_8_3146 \$2 \$1 sg13cmos5l_decap_8
* cell instance sg13cmos5l_decap_8_3147 r0 *1 0,0
Xsg13cmos5l_decap_8_3147 \$2 \$1 sg13cmos5l_decap_8
* cell instance sg13cmos5l_decap_8_3148 r0 *1 0,0
Xsg13cmos5l_decap_8_3148 \$2 \$1 sg13cmos5l_decap_8
* cell instance sg13cmos5l_decap_8_3149 r0 *1 0,0
Xsg13cmos5l_decap_8_3149 \$2 \$1 sg13cmos5l_decap_8
* cell instance sg13cmos5l_decap_8_3150 r0 *1 0,0
Xsg13cmos5l_decap_8_3150 \$2 \$1 sg13cmos5l_decap_8
* cell instance sg13cmos5l_decap_8_3151 r0 *1 0,0
Xsg13cmos5l_decap_8_3151 \$2 \$1 sg13cmos5l_decap_8
* cell instance sg13cmos5l_decap_8_3152 r0 *1 0,0
Xsg13cmos5l_decap_8_3152 \$2 \$1 sg13cmos5l_decap_8
* cell instance sg13cmos5l_decap_8_3153 r0 *1 0,0
Xsg13cmos5l_decap_8_3153 \$2 \$1 sg13cmos5l_decap_8
* cell instance sg13cmos5l_decap_8_3154 r0 *1 0,0
Xsg13cmos5l_decap_8_3154 \$2 \$1 sg13cmos5l_decap_8
* cell instance sg13cmos5l_decap_8_3155 r0 *1 0,0
Xsg13cmos5l_decap_8_3155 \$2 \$1 sg13cmos5l_decap_8
* cell instance sg13cmos5l_decap_8_3156 r0 *1 0,0
Xsg13cmos5l_decap_8_3156 \$2 \$1 sg13cmos5l_decap_8
* cell instance sg13cmos5l_decap_8_3157 r0 *1 0,0
Xsg13cmos5l_decap_8_3157 \$2 \$1 sg13cmos5l_decap_8
* cell instance sg13cmos5l_decap_8_3158 r0 *1 0,0
Xsg13cmos5l_decap_8_3158 \$2 \$1 sg13cmos5l_decap_8
* cell instance sg13cmos5l_decap_8_3159 r0 *1 0,0
Xsg13cmos5l_decap_8_3159 \$2 \$1 sg13cmos5l_decap_8
* cell instance sg13cmos5l_decap_8_3160 r0 *1 0,0
Xsg13cmos5l_decap_8_3160 \$2 \$1 sg13cmos5l_decap_8
* cell instance sg13cmos5l_decap_8_3161 r0 *1 0,0
Xsg13cmos5l_decap_8_3161 \$2 \$1 sg13cmos5l_decap_8
* cell instance sg13cmos5l_decap_8_3162 r0 *1 0,0
Xsg13cmos5l_decap_8_3162 \$2 \$1 sg13cmos5l_decap_8
* cell instance sg13cmos5l_decap_8_3163 r0 *1 0,0
Xsg13cmos5l_decap_8_3163 \$2 \$1 sg13cmos5l_decap_8
* cell instance sg13cmos5l_decap_8_3164 r0 *1 0,0
Xsg13cmos5l_decap_8_3164 \$2 \$1 sg13cmos5l_decap_8
* cell instance sg13cmos5l_decap_8_3165 r0 *1 0,0
Xsg13cmos5l_decap_8_3165 \$2 \$1 sg13cmos5l_decap_8
* cell instance sg13cmos5l_decap_8_3166 r0 *1 0,0
Xsg13cmos5l_decap_8_3166 \$2 \$1 sg13cmos5l_decap_8
* cell instance sg13cmos5l_decap_8_3167 r0 *1 0,0
Xsg13cmos5l_decap_8_3167 \$2 \$1 sg13cmos5l_decap_8
* cell instance sg13cmos5l_decap_8_3168 r0 *1 0,0
Xsg13cmos5l_decap_8_3168 \$2 \$1 sg13cmos5l_decap_8
* cell instance sg13cmos5l_decap_8_3169 r0 *1 0,0
Xsg13cmos5l_decap_8_3169 \$2 \$1 sg13cmos5l_decap_8
* cell instance sg13cmos5l_decap_8_3170 r0 *1 0,0
Xsg13cmos5l_decap_8_3170 \$2 \$1 sg13cmos5l_decap_8
* cell instance sg13cmos5l_decap_8_3171 r0 *1 0,0
Xsg13cmos5l_decap_8_3171 \$2 \$1 sg13cmos5l_decap_8
* cell instance sg13cmos5l_decap_8_3172 r0 *1 0,0
Xsg13cmos5l_decap_8_3172 \$2 \$1 sg13cmos5l_decap_8
* cell instance sg13cmos5l_decap_8_3173 r0 *1 0,0
Xsg13cmos5l_decap_8_3173 \$2 \$1 sg13cmos5l_decap_8
* cell instance sg13cmos5l_decap_8_3174 r0 *1 0,0
Xsg13cmos5l_decap_8_3174 \$2 \$1 sg13cmos5l_decap_8
* cell instance sg13cmos5l_decap_8_3175 r0 *1 0,0
Xsg13cmos5l_decap_8_3175 \$2 \$1 sg13cmos5l_decap_8
* cell instance sg13cmos5l_decap_8_3176 r0 *1 0,0
Xsg13cmos5l_decap_8_3176 \$2 \$1 sg13cmos5l_decap_8
* cell instance sg13cmos5l_decap_8_3177 r0 *1 0,0
Xsg13cmos5l_decap_8_3177 \$2 \$1 sg13cmos5l_decap_8
* cell instance sg13cmos5l_decap_8_3178 r0 *1 0,0
Xsg13cmos5l_decap_8_3178 \$2 \$1 sg13cmos5l_decap_8
* cell instance sg13cmos5l_decap_8_3179 r0 *1 0,0
Xsg13cmos5l_decap_8_3179 \$2 \$1 sg13cmos5l_decap_8
* cell instance sg13cmos5l_decap_8_3180 r0 *1 0,0
Xsg13cmos5l_decap_8_3180 \$2 \$1 sg13cmos5l_decap_8
* cell instance sg13cmos5l_decap_8_3181 r0 *1 0,0
Xsg13cmos5l_decap_8_3181 \$2 \$1 sg13cmos5l_decap_8
* cell instance sg13cmos5l_decap_8_3182 r0 *1 0,0
Xsg13cmos5l_decap_8_3182 \$2 \$1 sg13cmos5l_decap_8
* cell instance sg13cmos5l_decap_8_3183 r0 *1 0,0
Xsg13cmos5l_decap_8_3183 \$2 \$1 sg13cmos5l_decap_8
* cell instance sg13cmos5l_decap_8_3184 r0 *1 0,0
Xsg13cmos5l_decap_8_3184 \$2 \$1 sg13cmos5l_decap_8
* cell instance sg13cmos5l_decap_8_3185 r0 *1 0,0
Xsg13cmos5l_decap_8_3185 \$2 \$1 sg13cmos5l_decap_8
* cell instance sg13cmos5l_decap_8_3186 r0 *1 0,0
Xsg13cmos5l_decap_8_3186 \$2 \$1 sg13cmos5l_decap_8
* cell instance sg13cmos5l_decap_8_3187 r0 *1 0,0
Xsg13cmos5l_decap_8_3187 \$2 \$1 sg13cmos5l_decap_8
* cell instance sg13cmos5l_decap_8_3188 r0 *1 0,0
Xsg13cmos5l_decap_8_3188 \$2 \$1 sg13cmos5l_decap_8
* cell instance sg13cmos5l_decap_8_3189 r0 *1 0,0
Xsg13cmos5l_decap_8_3189 \$2 \$1 sg13cmos5l_decap_8
* cell instance sg13cmos5l_decap_8_3190 r0 *1 0,0
Xsg13cmos5l_decap_8_3190 \$2 \$1 sg13cmos5l_decap_8
* cell instance sg13cmos5l_decap_8_3191 r0 *1 0,0
Xsg13cmos5l_decap_8_3191 \$2 \$1 sg13cmos5l_decap_8
* cell instance sg13cmos5l_decap_8_3192 r0 *1 0,0
Xsg13cmos5l_decap_8_3192 \$2 \$1 sg13cmos5l_decap_8
* cell instance sg13cmos5l_decap_8_3193 r0 *1 0,0
Xsg13cmos5l_decap_8_3193 \$2 \$1 sg13cmos5l_decap_8
* cell instance sg13cmos5l_decap_8_3194 r0 *1 0,0
Xsg13cmos5l_decap_8_3194 \$2 \$1 sg13cmos5l_decap_8
* cell instance sg13cmos5l_decap_8_3195 r0 *1 0,0
Xsg13cmos5l_decap_8_3195 \$2 \$1 sg13cmos5l_decap_8
* cell instance sg13cmos5l_decap_8_3196 r0 *1 0,0
Xsg13cmos5l_decap_8_3196 \$2 \$1 sg13cmos5l_decap_8
* cell instance sg13cmos5l_decap_8_3197 r0 *1 0,0
Xsg13cmos5l_decap_8_3197 \$2 \$1 sg13cmos5l_decap_8
* cell instance sg13cmos5l_decap_8_3198 r0 *1 0,0
Xsg13cmos5l_decap_8_3198 \$2 \$1 sg13cmos5l_decap_8
* cell instance sg13cmos5l_decap_8_3199 r0 *1 0,0
Xsg13cmos5l_decap_8_3199 \$2 \$1 sg13cmos5l_decap_8
* cell instance sg13cmos5l_decap_8_3200 r0 *1 0,0
Xsg13cmos5l_decap_8_3200 \$2 \$1 sg13cmos5l_decap_8
* cell instance sg13cmos5l_decap_8_3201 r0 *1 0,0
Xsg13cmos5l_decap_8_3201 \$2 \$1 sg13cmos5l_decap_8
* cell instance sg13cmos5l_decap_8_3202 r0 *1 0,0
Xsg13cmos5l_decap_8_3202 \$2 \$1 sg13cmos5l_decap_8
* cell instance sg13cmos5l_decap_8_3203 r0 *1 0,0
Xsg13cmos5l_decap_8_3203 \$2 \$1 sg13cmos5l_decap_8
* cell instance sg13cmos5l_decap_8_3204 r0 *1 0,0
Xsg13cmos5l_decap_8_3204 \$2 \$1 sg13cmos5l_decap_8
* cell instance sg13cmos5l_decap_8_3205 r0 *1 0,0
Xsg13cmos5l_decap_8_3205 \$2 \$1 sg13cmos5l_decap_8
* cell instance sg13cmos5l_decap_8_3206 r0 *1 0,0
Xsg13cmos5l_decap_8_3206 \$2 \$1 sg13cmos5l_decap_8
* cell instance sg13cmos5l_decap_8_3207 r0 *1 0,0
Xsg13cmos5l_decap_8_3207 \$2 \$1 sg13cmos5l_decap_8
* cell instance sg13cmos5l_decap_8_3208 r0 *1 0,0
Xsg13cmos5l_decap_8_3208 \$2 \$1 sg13cmos5l_decap_8
* cell instance sg13cmos5l_decap_8_3209 r0 *1 0,0
Xsg13cmos5l_decap_8_3209 \$2 \$1 sg13cmos5l_decap_8
* cell instance sg13cmos5l_decap_8_3210 r0 *1 0,0
Xsg13cmos5l_decap_8_3210 \$2 \$1 sg13cmos5l_decap_8
* cell instance sg13cmos5l_decap_8_3211 r0 *1 0,0
Xsg13cmos5l_decap_8_3211 \$2 \$1 sg13cmos5l_decap_8
* cell instance sg13cmos5l_decap_8_3212 r0 *1 0,0
Xsg13cmos5l_decap_8_3212 \$2 \$1 sg13cmos5l_decap_8
* cell instance sg13cmos5l_decap_8_3213 r0 *1 0,0
Xsg13cmos5l_decap_8_3213 \$2 \$1 sg13cmos5l_decap_8
* cell instance sg13cmos5l_decap_8_3214 r0 *1 0,0
Xsg13cmos5l_decap_8_3214 \$2 \$1 sg13cmos5l_decap_8
* cell instance sg13cmos5l_decap_8_3215 r0 *1 0,0
Xsg13cmos5l_decap_8_3215 \$2 \$1 sg13cmos5l_decap_8
* cell instance sg13cmos5l_decap_8_3216 r0 *1 0,0
Xsg13cmos5l_decap_8_3216 \$2 \$1 sg13cmos5l_decap_8
* cell instance sg13cmos5l_decap_8_3217 r0 *1 0,0
Xsg13cmos5l_decap_8_3217 \$2 \$1 sg13cmos5l_decap_8
* cell instance sg13cmos5l_decap_8_3218 r0 *1 0,0
Xsg13cmos5l_decap_8_3218 \$2 \$1 sg13cmos5l_decap_8
* cell instance sg13cmos5l_decap_8_3219 r0 *1 0,0
Xsg13cmos5l_decap_8_3219 \$2 \$1 sg13cmos5l_decap_8
* cell instance sg13cmos5l_decap_8_3220 r0 *1 0,0
Xsg13cmos5l_decap_8_3220 \$2 \$1 sg13cmos5l_decap_8
* cell instance sg13cmos5l_decap_8_3221 r0 *1 0,0
Xsg13cmos5l_decap_8_3221 \$2 \$1 sg13cmos5l_decap_8
* cell instance sg13cmos5l_decap_8_3222 r0 *1 0,0
Xsg13cmos5l_decap_8_3222 \$2 \$1 sg13cmos5l_decap_8
* cell instance sg13cmos5l_decap_8_3223 r0 *1 0,0
Xsg13cmos5l_decap_8_3223 \$2 \$1 sg13cmos5l_decap_8
* cell instance sg13cmos5l_decap_8_3224 r0 *1 0,0
Xsg13cmos5l_decap_8_3224 \$2 \$1 sg13cmos5l_decap_8
* cell instance sg13cmos5l_decap_8_3225 r0 *1 0,0
Xsg13cmos5l_decap_8_3225 \$2 \$1 sg13cmos5l_decap_8
* cell instance sg13cmos5l_decap_8_3226 r0 *1 0,0
Xsg13cmos5l_decap_8_3226 \$2 \$1 sg13cmos5l_decap_8
* cell instance sg13cmos5l_decap_8_3227 r0 *1 0,0
Xsg13cmos5l_decap_8_3227 \$2 \$1 sg13cmos5l_decap_8
* cell instance sg13cmos5l_decap_8_3228 r0 *1 0,0
Xsg13cmos5l_decap_8_3228 \$2 \$1 sg13cmos5l_decap_8
* cell instance sg13cmos5l_decap_8_3229 r0 *1 0,0
Xsg13cmos5l_decap_8_3229 \$2 \$1 sg13cmos5l_decap_8
* cell instance sg13cmos5l_decap_8_3230 r0 *1 0,0
Xsg13cmos5l_decap_8_3230 \$2 \$1 sg13cmos5l_decap_8
* cell instance sg13cmos5l_decap_8_3231 r0 *1 0,0
Xsg13cmos5l_decap_8_3231 \$2 \$1 sg13cmos5l_decap_8
* cell instance sg13cmos5l_decap_8_3232 r0 *1 0,0
Xsg13cmos5l_decap_8_3232 \$2 \$1 sg13cmos5l_decap_8
* cell instance sg13cmos5l_decap_8_3233 r0 *1 0,0
Xsg13cmos5l_decap_8_3233 \$2 \$1 sg13cmos5l_decap_8
* cell instance sg13cmos5l_decap_8_3234 r0 *1 0,0
Xsg13cmos5l_decap_8_3234 \$2 \$1 sg13cmos5l_decap_8
* cell instance sg13cmos5l_decap_8_3235 r0 *1 0,0
Xsg13cmos5l_decap_8_3235 \$2 \$1 sg13cmos5l_decap_8
* cell instance sg13cmos5l_decap_8_3236 r0 *1 0,0
Xsg13cmos5l_decap_8_3236 \$2 \$1 sg13cmos5l_decap_8
* cell instance sg13cmos5l_decap_8_3237 r0 *1 0,0
Xsg13cmos5l_decap_8_3237 \$2 \$1 sg13cmos5l_decap_8
* cell instance sg13cmos5l_decap_8_3238 r0 *1 0,0
Xsg13cmos5l_decap_8_3238 \$2 \$1 sg13cmos5l_decap_8
* cell instance sg13cmos5l_decap_8_3239 r0 *1 0,0
Xsg13cmos5l_decap_8_3239 \$2 \$1 sg13cmos5l_decap_8
* cell instance sg13cmos5l_decap_8_3240 r0 *1 0,0
Xsg13cmos5l_decap_8_3240 \$2 \$1 sg13cmos5l_decap_8
* cell instance sg13cmos5l_decap_8_3241 r0 *1 0,0
Xsg13cmos5l_decap_8_3241 \$2 \$1 sg13cmos5l_decap_8
* cell instance sg13cmos5l_decap_8_3242 r0 *1 0,0
Xsg13cmos5l_decap_8_3242 \$2 \$1 sg13cmos5l_decap_8
* cell instance sg13cmos5l_decap_8_3243 r0 *1 0,0
Xsg13cmos5l_decap_8_3243 \$2 \$1 sg13cmos5l_decap_8
* cell instance sg13cmos5l_decap_8_3244 r0 *1 0,0
Xsg13cmos5l_decap_8_3244 \$2 \$1 sg13cmos5l_decap_8
* cell instance sg13cmos5l_decap_8_3245 r0 *1 0,0
Xsg13cmos5l_decap_8_3245 \$2 \$1 sg13cmos5l_decap_8
* cell instance sg13cmos5l_decap_8_3246 r0 *1 0,0
Xsg13cmos5l_decap_8_3246 \$2 \$1 sg13cmos5l_decap_8
* cell instance sg13cmos5l_decap_8_3247 r0 *1 0,0
Xsg13cmos5l_decap_8_3247 \$2 \$1 sg13cmos5l_decap_8
* cell instance sg13cmos5l_decap_8_3248 r0 *1 0,0
Xsg13cmos5l_decap_8_3248 \$2 \$1 sg13cmos5l_decap_8
* cell instance sg13cmos5l_decap_8_3249 r0 *1 0,0
Xsg13cmos5l_decap_8_3249 \$2 \$1 sg13cmos5l_decap_8
* cell instance sg13cmos5l_decap_8_3250 r0 *1 0,0
Xsg13cmos5l_decap_8_3250 \$2 \$1 sg13cmos5l_decap_8
* cell instance sg13cmos5l_decap_8_3251 r0 *1 0,0
Xsg13cmos5l_decap_8_3251 \$2 \$1 sg13cmos5l_decap_8
* cell instance sg13cmos5l_decap_8_3252 r0 *1 0,0
Xsg13cmos5l_decap_8_3252 \$2 \$1 sg13cmos5l_decap_8
* cell instance sg13cmos5l_decap_8_3253 r0 *1 0,0
Xsg13cmos5l_decap_8_3253 \$2 \$1 sg13cmos5l_decap_8
* cell instance sg13cmos5l_decap_8_3254 r0 *1 0,0
Xsg13cmos5l_decap_8_3254 \$2 \$1 sg13cmos5l_decap_8
* cell instance sg13cmos5l_decap_8_3255 r0 *1 0,0
Xsg13cmos5l_decap_8_3255 \$2 \$1 sg13cmos5l_decap_8
* cell instance sg13cmos5l_decap_8_3256 r0 *1 0,0
Xsg13cmos5l_decap_8_3256 \$2 \$1 sg13cmos5l_decap_8
* cell instance sg13cmos5l_decap_8_3257 r0 *1 0,0
Xsg13cmos5l_decap_8_3257 \$2 \$1 sg13cmos5l_decap_8
* cell instance sg13cmos5l_decap_8_3258 r0 *1 0,0
Xsg13cmos5l_decap_8_3258 \$2 \$1 sg13cmos5l_decap_8
* cell instance sg13cmos5l_decap_8_3259 r0 *1 0,0
Xsg13cmos5l_decap_8_3259 \$2 \$1 sg13cmos5l_decap_8
* cell instance sg13cmos5l_decap_8_3260 r0 *1 0,0
Xsg13cmos5l_decap_8_3260 \$2 \$1 sg13cmos5l_decap_8
* cell instance sg13cmos5l_decap_8_3261 r0 *1 0,0
Xsg13cmos5l_decap_8_3261 \$2 \$1 sg13cmos5l_decap_8
* cell instance sg13cmos5l_decap_8_3262 r0 *1 0,0
Xsg13cmos5l_decap_8_3262 \$2 \$1 sg13cmos5l_decap_8
* cell instance sg13cmos5l_decap_8_3263 r0 *1 0,0
Xsg13cmos5l_decap_8_3263 \$2 \$1 sg13cmos5l_decap_8
* cell instance sg13cmos5l_decap_8_3264 r0 *1 0,0
Xsg13cmos5l_decap_8_3264 \$2 \$1 sg13cmos5l_decap_8
* cell instance sg13cmos5l_decap_8_3265 r0 *1 0,0
Xsg13cmos5l_decap_8_3265 \$2 \$1 sg13cmos5l_decap_8
* cell instance sg13cmos5l_decap_8_3266 r0 *1 0,0
Xsg13cmos5l_decap_8_3266 \$2 \$1 sg13cmos5l_decap_8
* cell instance sg13cmos5l_decap_8_3267 r0 *1 0,0
Xsg13cmos5l_decap_8_3267 \$2 \$1 sg13cmos5l_decap_8
* cell instance sg13cmos5l_decap_8_3268 r0 *1 0,0
Xsg13cmos5l_decap_8_3268 \$2 \$1 sg13cmos5l_decap_8
* cell instance sg13cmos5l_decap_8_3269 r0 *1 0,0
Xsg13cmos5l_decap_8_3269 \$2 \$1 sg13cmos5l_decap_8
* cell instance sg13cmos5l_decap_8_3270 r0 *1 0,0
Xsg13cmos5l_decap_8_3270 \$2 \$1 sg13cmos5l_decap_8
* cell instance sg13cmos5l_decap_8_3271 r0 *1 0,0
Xsg13cmos5l_decap_8_3271 \$2 \$1 sg13cmos5l_decap_8
* cell instance sg13cmos5l_decap_8_3272 r0 *1 0,0
Xsg13cmos5l_decap_8_3272 \$2 \$1 sg13cmos5l_decap_8
* cell instance sg13cmos5l_decap_8_3273 r0 *1 0,0
Xsg13cmos5l_decap_8_3273 \$2 \$1 sg13cmos5l_decap_8
* cell instance sg13cmos5l_decap_8_3274 r0 *1 0,0
Xsg13cmos5l_decap_8_3274 \$2 \$1 sg13cmos5l_decap_8
* cell instance sg13cmos5l_decap_8_3275 r0 *1 0,0
Xsg13cmos5l_decap_8_3275 \$2 \$1 sg13cmos5l_decap_8
* cell instance sg13cmos5l_decap_8_3276 r0 *1 0,0
Xsg13cmos5l_decap_8_3276 \$2 \$1 sg13cmos5l_decap_8
* cell instance sg13cmos5l_decap_8_3277 r0 *1 0,0
Xsg13cmos5l_decap_8_3277 \$2 \$1 sg13cmos5l_decap_8
* cell instance sg13cmos5l_decap_8_3278 r0 *1 0,0
Xsg13cmos5l_decap_8_3278 \$2 \$1 sg13cmos5l_decap_8
* cell instance sg13cmos5l_decap_8_3279 r0 *1 0,0
Xsg13cmos5l_decap_8_3279 \$2 \$1 sg13cmos5l_decap_8
* cell instance sg13cmos5l_decap_8_3280 r0 *1 0,0
Xsg13cmos5l_decap_8_3280 \$2 \$1 sg13cmos5l_decap_8
* cell instance sg13cmos5l_decap_8_3281 r0 *1 0,0
Xsg13cmos5l_decap_8_3281 \$2 \$1 sg13cmos5l_decap_8
* cell instance sg13cmos5l_decap_8_3282 r0 *1 0,0
Xsg13cmos5l_decap_8_3282 \$2 \$1 sg13cmos5l_decap_8
* cell instance sg13cmos5l_decap_8_3283 r0 *1 0,0
Xsg13cmos5l_decap_8_3283 \$2 \$1 sg13cmos5l_decap_8
* cell instance sg13cmos5l_decap_8_3284 r0 *1 0,0
Xsg13cmos5l_decap_8_3284 \$2 \$1 sg13cmos5l_decap_8
* cell instance sg13cmos5l_decap_8_3285 r0 *1 0,0
Xsg13cmos5l_decap_8_3285 \$2 \$1 sg13cmos5l_decap_8
* cell instance sg13cmos5l_decap_8_3286 r0 *1 0,0
Xsg13cmos5l_decap_8_3286 \$2 \$1 sg13cmos5l_decap_8
* cell instance sg13cmos5l_decap_8_3287 r0 *1 0,0
Xsg13cmos5l_decap_8_3287 \$2 \$1 sg13cmos5l_decap_8
* cell instance sg13cmos5l_decap_8_3288 r0 *1 0,0
Xsg13cmos5l_decap_8_3288 \$2 \$1 sg13cmos5l_decap_8
* cell instance sg13cmos5l_decap_8_3289 r0 *1 0,0
Xsg13cmos5l_decap_8_3289 \$2 \$1 sg13cmos5l_decap_8
* cell instance sg13cmos5l_decap_8_3290 r0 *1 0,0
Xsg13cmos5l_decap_8_3290 \$2 \$1 sg13cmos5l_decap_8
* cell instance sg13cmos5l_decap_8_3291 r0 *1 0,0
Xsg13cmos5l_decap_8_3291 \$2 \$1 sg13cmos5l_decap_8
* cell instance sg13cmos5l_decap_8_3292 r0 *1 0,0
Xsg13cmos5l_decap_8_3292 \$2 \$1 sg13cmos5l_decap_8
* cell instance sg13cmos5l_decap_8_3293 r0 *1 0,0
Xsg13cmos5l_decap_8_3293 \$2 \$1 sg13cmos5l_decap_8
* cell instance sg13cmos5l_decap_8_3294 r0 *1 0,0
Xsg13cmos5l_decap_8_3294 \$2 \$1 sg13cmos5l_decap_8
* cell instance sg13cmos5l_decap_8_3295 r0 *1 0,0
Xsg13cmos5l_decap_8_3295 \$2 \$1 sg13cmos5l_decap_8
* cell instance sg13cmos5l_decap_8_3296 r0 *1 0,0
Xsg13cmos5l_decap_8_3296 \$2 \$1 sg13cmos5l_decap_8
* cell instance sg13cmos5l_decap_8_3297 r0 *1 0,0
Xsg13cmos5l_decap_8_3297 \$2 \$1 sg13cmos5l_decap_8
* cell instance sg13cmos5l_decap_8_3298 r0 *1 0,0
Xsg13cmos5l_decap_8_3298 \$2 \$1 sg13cmos5l_decap_8
* cell instance sg13cmos5l_decap_8_3299 r0 *1 0,0
Xsg13cmos5l_decap_8_3299 \$2 \$1 sg13cmos5l_decap_8
* cell instance sg13cmos5l_decap_8_3300 r0 *1 0,0
Xsg13cmos5l_decap_8_3300 \$2 \$1 sg13cmos5l_decap_8
* cell instance sg13cmos5l_decap_8_3301 r0 *1 0,0
Xsg13cmos5l_decap_8_3301 \$2 \$1 sg13cmos5l_decap_8
* cell instance sg13cmos5l_decap_8_3302 r0 *1 0,0
Xsg13cmos5l_decap_8_3302 \$2 \$1 sg13cmos5l_decap_8
* cell instance sg13cmos5l_decap_8_3303 r0 *1 0,0
Xsg13cmos5l_decap_8_3303 \$2 \$1 sg13cmos5l_decap_8
* cell instance sg13cmos5l_decap_8_3304 r0 *1 0,0
Xsg13cmos5l_decap_8_3304 \$2 \$1 sg13cmos5l_decap_8
* cell instance sg13cmos5l_decap_8_3305 r0 *1 0,0
Xsg13cmos5l_decap_8_3305 \$2 \$1 sg13cmos5l_decap_8
* cell instance sg13cmos5l_decap_8_3306 r0 *1 0,0
Xsg13cmos5l_decap_8_3306 \$2 \$1 sg13cmos5l_decap_8
* cell instance sg13cmos5l_decap_8_3307 r0 *1 0,0
Xsg13cmos5l_decap_8_3307 \$2 \$1 sg13cmos5l_decap_8
* cell instance sg13cmos5l_decap_8_3308 r0 *1 0,0
Xsg13cmos5l_decap_8_3308 \$2 \$1 sg13cmos5l_decap_8
* cell instance sg13cmos5l_decap_8_3309 r0 *1 0,0
Xsg13cmos5l_decap_8_3309 \$2 \$1 sg13cmos5l_decap_8
* cell instance sg13cmos5l_decap_8_3310 r0 *1 0,0
Xsg13cmos5l_decap_8_3310 \$2 \$1 sg13cmos5l_decap_8
* cell instance sg13cmos5l_decap_8_3311 r0 *1 0,0
Xsg13cmos5l_decap_8_3311 \$2 \$1 sg13cmos5l_decap_8
* cell instance sg13cmos5l_decap_8_3312 r0 *1 0,0
Xsg13cmos5l_decap_8_3312 \$2 \$1 sg13cmos5l_decap_8
* cell instance sg13cmos5l_decap_8_3313 r0 *1 0,0
Xsg13cmos5l_decap_8_3313 \$2 \$1 sg13cmos5l_decap_8
* cell instance sg13cmos5l_decap_8_3314 r0 *1 0,0
Xsg13cmos5l_decap_8_3314 \$2 \$1 sg13cmos5l_decap_8
* cell instance sg13cmos5l_decap_8_3315 r0 *1 0,0
Xsg13cmos5l_decap_8_3315 \$2 \$1 sg13cmos5l_decap_8
* cell instance sg13cmos5l_decap_8_3316 r0 *1 0,0
Xsg13cmos5l_decap_8_3316 \$2 \$1 sg13cmos5l_decap_8
* cell instance sg13cmos5l_decap_8_3317 r0 *1 0,0
Xsg13cmos5l_decap_8_3317 \$2 \$1 sg13cmos5l_decap_8
* cell instance sg13cmos5l_decap_8_3318 r0 *1 0,0
Xsg13cmos5l_decap_8_3318 \$2 \$1 sg13cmos5l_decap_8
* cell instance sg13cmos5l_decap_8_3319 r0 *1 0,0
Xsg13cmos5l_decap_8_3319 \$2 \$1 sg13cmos5l_decap_8
* cell instance sg13cmos5l_decap_8_3320 r0 *1 0,0
Xsg13cmos5l_decap_8_3320 \$2 \$1 sg13cmos5l_decap_8
* cell instance sg13cmos5l_decap_8_3321 r0 *1 0,0
Xsg13cmos5l_decap_8_3321 \$2 \$1 sg13cmos5l_decap_8
* cell instance sg13cmos5l_decap_8_3322 r0 *1 0,0
Xsg13cmos5l_decap_8_3322 \$2 \$1 sg13cmos5l_decap_8
* cell instance sg13cmos5l_decap_8_3323 r0 *1 0,0
Xsg13cmos5l_decap_8_3323 \$2 \$1 sg13cmos5l_decap_8
* cell instance sg13cmos5l_decap_8_3324 r0 *1 0,0
Xsg13cmos5l_decap_8_3324 \$2 \$1 sg13cmos5l_decap_8
* cell instance sg13cmos5l_decap_8_3325 r0 *1 0,0
Xsg13cmos5l_decap_8_3325 \$2 \$1 sg13cmos5l_decap_8
* cell instance sg13cmos5l_decap_8_3326 r0 *1 0,0
Xsg13cmos5l_decap_8_3326 \$2 \$1 sg13cmos5l_decap_8
* cell instance sg13cmos5l_decap_8_3327 r0 *1 0,0
Xsg13cmos5l_decap_8_3327 \$2 \$1 sg13cmos5l_decap_8
* cell instance sg13cmos5l_decap_8_3328 r0 *1 0,0
Xsg13cmos5l_decap_8_3328 \$2 \$1 sg13cmos5l_decap_8
* cell instance sg13cmos5l_decap_8_3329 r0 *1 0,0
Xsg13cmos5l_decap_8_3329 \$2 \$1 sg13cmos5l_decap_8
* cell instance sg13cmos5l_decap_8_3330 r0 *1 0,0
Xsg13cmos5l_decap_8_3330 \$2 \$1 sg13cmos5l_decap_8
* cell instance sg13cmos5l_decap_8_3331 r0 *1 0,0
Xsg13cmos5l_decap_8_3331 \$2 \$1 sg13cmos5l_decap_8
* cell instance sg13cmos5l_decap_8_3332 r0 *1 0,0
Xsg13cmos5l_decap_8_3332 \$2 \$1 sg13cmos5l_decap_8
* cell instance sg13cmos5l_decap_8_3333 r0 *1 0,0
Xsg13cmos5l_decap_8_3333 \$2 \$1 sg13cmos5l_decap_8
* cell instance sg13cmos5l_decap_8_3334 r0 *1 0,0
Xsg13cmos5l_decap_8_3334 \$2 \$1 sg13cmos5l_decap_8
* cell instance sg13cmos5l_decap_8_3335 r0 *1 0,0
Xsg13cmos5l_decap_8_3335 \$2 \$1 sg13cmos5l_decap_8
* cell instance sg13cmos5l_decap_8_3336 r0 *1 0,0
Xsg13cmos5l_decap_8_3336 \$2 \$1 sg13cmos5l_decap_8
* cell instance sg13cmos5l_decap_8_3337 r0 *1 0,0
Xsg13cmos5l_decap_8_3337 \$2 \$1 sg13cmos5l_decap_8
* cell instance sg13cmos5l_decap_8_3338 r0 *1 0,0
Xsg13cmos5l_decap_8_3338 \$2 \$1 sg13cmos5l_decap_8
* cell instance sg13cmos5l_decap_8_3339 r0 *1 0,0
Xsg13cmos5l_decap_8_3339 \$2 \$1 sg13cmos5l_decap_8
* cell instance sg13cmos5l_decap_8_3340 r0 *1 0,0
Xsg13cmos5l_decap_8_3340 \$2 \$1 sg13cmos5l_decap_8
* cell instance sg13cmos5l_decap_8_3341 r0 *1 0,0
Xsg13cmos5l_decap_8_3341 \$2 \$1 sg13cmos5l_decap_8
* cell instance sg13cmos5l_decap_8_3342 r0 *1 0,0
Xsg13cmos5l_decap_8_3342 \$2 \$1 sg13cmos5l_decap_8
* cell instance sg13cmos5l_decap_8_3343 r0 *1 0,0
Xsg13cmos5l_decap_8_3343 \$2 \$1 sg13cmos5l_decap_8
* cell instance sg13cmos5l_decap_8_3344 r0 *1 0,0
Xsg13cmos5l_decap_8_3344 \$2 \$1 sg13cmos5l_decap_8
* cell instance sg13cmos5l_decap_8_3345 r0 *1 0,0
Xsg13cmos5l_decap_8_3345 \$2 \$1 sg13cmos5l_decap_8
* cell instance sg13cmos5l_decap_8_3346 r0 *1 0,0
Xsg13cmos5l_decap_8_3346 \$2 \$1 sg13cmos5l_decap_8
* cell instance sg13cmos5l_decap_8_3347 r0 *1 0,0
Xsg13cmos5l_decap_8_3347 \$2 \$1 sg13cmos5l_decap_8
* cell instance sg13cmos5l_decap_8_3348 r0 *1 0,0
Xsg13cmos5l_decap_8_3348 \$2 \$1 sg13cmos5l_decap_8
* cell instance sg13cmos5l_decap_8_3349 r0 *1 0,0
Xsg13cmos5l_decap_8_3349 \$2 \$1 sg13cmos5l_decap_8
* cell instance sg13cmos5l_decap_8_3350 r0 *1 0,0
Xsg13cmos5l_decap_8_3350 \$2 \$1 sg13cmos5l_decap_8
* cell instance sg13cmos5l_decap_8_3351 r0 *1 0,0
Xsg13cmos5l_decap_8_3351 \$2 \$1 sg13cmos5l_decap_8
* cell instance sg13cmos5l_decap_8_3352 r0 *1 0,0
Xsg13cmos5l_decap_8_3352 \$2 \$1 sg13cmos5l_decap_8
* cell instance sg13cmos5l_decap_8_3353 r0 *1 0,0
Xsg13cmos5l_decap_8_3353 \$2 \$1 sg13cmos5l_decap_8
* cell instance sg13cmos5l_decap_8_3354 r0 *1 0,0
Xsg13cmos5l_decap_8_3354 \$2 \$1 sg13cmos5l_decap_8
* cell instance sg13cmos5l_decap_8_3355 r0 *1 0,0
Xsg13cmos5l_decap_8_3355 \$2 \$1 sg13cmos5l_decap_8
* cell instance sg13cmos5l_decap_8_3356 r0 *1 0,0
Xsg13cmos5l_decap_8_3356 \$2 \$1 sg13cmos5l_decap_8
* cell instance sg13cmos5l_decap_8_3357 r0 *1 0,0
Xsg13cmos5l_decap_8_3357 \$2 \$1 sg13cmos5l_decap_8
* cell instance sg13cmos5l_decap_8_3358 r0 *1 0,0
Xsg13cmos5l_decap_8_3358 \$2 \$1 sg13cmos5l_decap_8
* cell instance sg13cmos5l_decap_8_3359 r0 *1 0,0
Xsg13cmos5l_decap_8_3359 \$2 \$1 sg13cmos5l_decap_8
* cell instance sg13cmos5l_decap_8_3360 r0 *1 0,0
Xsg13cmos5l_decap_8_3360 \$2 \$1 sg13cmos5l_decap_8
* cell instance sg13cmos5l_decap_8_3361 r0 *1 0,0
Xsg13cmos5l_decap_8_3361 \$2 \$1 sg13cmos5l_decap_8
* cell instance sg13cmos5l_decap_8_3362 r0 *1 0,0
Xsg13cmos5l_decap_8_3362 \$2 \$1 sg13cmos5l_decap_8
* cell instance sg13cmos5l_decap_8_3363 r0 *1 0,0
Xsg13cmos5l_decap_8_3363 \$2 \$1 sg13cmos5l_decap_8
* cell instance sg13cmos5l_decap_8_3364 r0 *1 0,0
Xsg13cmos5l_decap_8_3364 \$2 \$1 sg13cmos5l_decap_8
* cell instance sg13cmos5l_decap_8_3365 r0 *1 0,0
Xsg13cmos5l_decap_8_3365 \$2 \$1 sg13cmos5l_decap_8
* cell instance sg13cmos5l_decap_8_3366 r0 *1 0,0
Xsg13cmos5l_decap_8_3366 \$2 \$1 sg13cmos5l_decap_8
* cell instance sg13cmos5l_decap_8_3367 r0 *1 0,0
Xsg13cmos5l_decap_8_3367 \$2 \$1 sg13cmos5l_decap_8
* cell instance sg13cmos5l_decap_8_3368 r0 *1 0,0
Xsg13cmos5l_decap_8_3368 \$2 \$1 sg13cmos5l_decap_8
* cell instance sg13cmos5l_decap_8_3369 r0 *1 0,0
Xsg13cmos5l_decap_8_3369 \$2 \$1 sg13cmos5l_decap_8
* cell instance sg13cmos5l_decap_8_3370 r0 *1 0,0
Xsg13cmos5l_decap_8_3370 \$2 \$1 sg13cmos5l_decap_8
* cell instance sg13cmos5l_decap_8_3371 r0 *1 0,0
Xsg13cmos5l_decap_8_3371 \$2 \$1 sg13cmos5l_decap_8
* cell instance sg13cmos5l_decap_8_3372 r0 *1 0,0
Xsg13cmos5l_decap_8_3372 \$2 \$1 sg13cmos5l_decap_8
* cell instance sg13cmos5l_decap_8_3373 r0 *1 0,0
Xsg13cmos5l_decap_8_3373 \$2 \$1 sg13cmos5l_decap_8
* cell instance sg13cmos5l_decap_8_3374 r0 *1 0,0
Xsg13cmos5l_decap_8_3374 \$2 \$1 sg13cmos5l_decap_8
* cell instance sg13cmos5l_decap_8_3375 r0 *1 0,0
Xsg13cmos5l_decap_8_3375 \$2 \$1 sg13cmos5l_decap_8
* cell instance sg13cmos5l_decap_8_3376 r0 *1 0,0
Xsg13cmos5l_decap_8_3376 \$2 \$1 sg13cmos5l_decap_8
* cell instance sg13cmos5l_decap_8_3377 r0 *1 0,0
Xsg13cmos5l_decap_8_3377 \$2 \$1 sg13cmos5l_decap_8
* cell instance sg13cmos5l_decap_8_3378 r0 *1 0,0
Xsg13cmos5l_decap_8_3378 \$2 \$1 sg13cmos5l_decap_8
* cell instance sg13cmos5l_decap_8_3379 r0 *1 0,0
Xsg13cmos5l_decap_8_3379 \$2 \$1 sg13cmos5l_decap_8
* cell instance sg13cmos5l_decap_8_3380 r0 *1 0,0
Xsg13cmos5l_decap_8_3380 \$2 \$1 sg13cmos5l_decap_8
* cell instance sg13cmos5l_decap_8_3381 r0 *1 0,0
Xsg13cmos5l_decap_8_3381 \$2 \$1 sg13cmos5l_decap_8
* cell instance sg13cmos5l_decap_8_3382 r0 *1 0,0
Xsg13cmos5l_decap_8_3382 \$2 \$1 sg13cmos5l_decap_8
* cell instance sg13cmos5l_decap_8_3383 r0 *1 0,0
Xsg13cmos5l_decap_8_3383 \$2 \$1 sg13cmos5l_decap_8
* cell instance sg13cmos5l_decap_8_3384 r0 *1 0,0
Xsg13cmos5l_decap_8_3384 \$2 \$1 sg13cmos5l_decap_8
* cell instance sg13cmos5l_decap_8_3385 r0 *1 0,0
Xsg13cmos5l_decap_8_3385 \$2 \$1 sg13cmos5l_decap_8
* cell instance sg13cmos5l_decap_8_3386 r0 *1 0,0
Xsg13cmos5l_decap_8_3386 \$2 \$1 sg13cmos5l_decap_8
* cell instance sg13cmos5l_decap_8_3387 r0 *1 0,0
Xsg13cmos5l_decap_8_3387 \$2 \$1 sg13cmos5l_decap_8
* cell instance sg13cmos5l_decap_8_3388 r0 *1 0,0
Xsg13cmos5l_decap_8_3388 \$2 \$1 sg13cmos5l_decap_8
* cell instance sg13cmos5l_decap_8_3389 r0 *1 0,0
Xsg13cmos5l_decap_8_3389 \$2 \$1 sg13cmos5l_decap_8
* cell instance sg13cmos5l_decap_8_3390 r0 *1 0,0
Xsg13cmos5l_decap_8_3390 \$2 \$1 sg13cmos5l_decap_8
* cell instance sg13cmos5l_decap_8_3391 r0 *1 0,0
Xsg13cmos5l_decap_8_3391 \$2 \$1 sg13cmos5l_decap_8
* cell instance sg13cmos5l_decap_8_3392 r0 *1 0,0
Xsg13cmos5l_decap_8_3392 \$2 \$1 sg13cmos5l_decap_8
* cell instance sg13cmos5l_decap_8_3393 r0 *1 0,0
Xsg13cmos5l_decap_8_3393 \$2 \$1 sg13cmos5l_decap_8
* cell instance sg13cmos5l_decap_8_3394 r0 *1 0,0
Xsg13cmos5l_decap_8_3394 \$2 \$1 sg13cmos5l_decap_8
* cell instance sg13cmos5l_decap_8_3395 r0 *1 0,0
Xsg13cmos5l_decap_8_3395 \$2 \$1 sg13cmos5l_decap_8
* cell instance sg13cmos5l_decap_8_3396 r0 *1 0,0
Xsg13cmos5l_decap_8_3396 \$2 \$1 sg13cmos5l_decap_8
* cell instance sg13cmos5l_decap_8_3397 r0 *1 0,0
Xsg13cmos5l_decap_8_3397 \$2 \$1 sg13cmos5l_decap_8
* cell instance sg13cmos5l_decap_8_3398 r0 *1 0,0
Xsg13cmos5l_decap_8_3398 \$2 \$1 sg13cmos5l_decap_8
* cell instance sg13cmos5l_decap_8_3399 r0 *1 0,0
Xsg13cmos5l_decap_8_3399 \$2 \$1 sg13cmos5l_decap_8
* cell instance sg13cmos5l_decap_8_3400 r0 *1 0,0
Xsg13cmos5l_decap_8_3400 \$2 \$1 sg13cmos5l_decap_8
* cell instance sg13cmos5l_decap_8_3401 r0 *1 0,0
Xsg13cmos5l_decap_8_3401 \$2 \$1 sg13cmos5l_decap_8
* cell instance sg13cmos5l_decap_8_3402 r0 *1 0,0
Xsg13cmos5l_decap_8_3402 \$2 \$1 sg13cmos5l_decap_8
* cell instance sg13cmos5l_decap_8_3403 r0 *1 0,0
Xsg13cmos5l_decap_8_3403 \$2 \$1 sg13cmos5l_decap_8
* cell instance sg13cmos5l_decap_8_3404 r0 *1 0,0
Xsg13cmos5l_decap_8_3404 \$2 \$1 sg13cmos5l_decap_8
* cell instance sg13cmos5l_decap_8_3405 r0 *1 0,0
Xsg13cmos5l_decap_8_3405 \$2 \$1 sg13cmos5l_decap_8
* cell instance sg13cmos5l_decap_8_3406 r0 *1 0,0
Xsg13cmos5l_decap_8_3406 \$2 \$1 sg13cmos5l_decap_8
* cell instance sg13cmos5l_decap_8_3407 r0 *1 0,0
Xsg13cmos5l_decap_8_3407 \$2 \$1 sg13cmos5l_decap_8
* cell instance sg13cmos5l_decap_8_3408 r0 *1 0,0
Xsg13cmos5l_decap_8_3408 \$2 \$1 sg13cmos5l_decap_8
* cell instance sg13cmos5l_decap_8_3409 r0 *1 0,0
Xsg13cmos5l_decap_8_3409 \$2 \$1 sg13cmos5l_decap_8
* cell instance sg13cmos5l_decap_8_3410 r0 *1 0,0
Xsg13cmos5l_decap_8_3410 \$2 \$1 sg13cmos5l_decap_8
* cell instance sg13cmos5l_decap_8_3411 r0 *1 0,0
Xsg13cmos5l_decap_8_3411 \$2 \$1 sg13cmos5l_decap_8
* cell instance sg13cmos5l_decap_8_3412 r0 *1 0,0
Xsg13cmos5l_decap_8_3412 \$2 \$1 sg13cmos5l_decap_8
* cell instance sg13cmos5l_decap_8_3413 r0 *1 0,0
Xsg13cmos5l_decap_8_3413 \$2 \$1 sg13cmos5l_decap_8
* cell instance sg13cmos5l_decap_8_3414 r0 *1 0,0
Xsg13cmos5l_decap_8_3414 \$2 \$1 sg13cmos5l_decap_8
* cell instance sg13cmos5l_decap_8_3415 r0 *1 0,0
Xsg13cmos5l_decap_8_3415 \$2 \$1 sg13cmos5l_decap_8
* cell instance sg13cmos5l_decap_8_3416 r0 *1 0,0
Xsg13cmos5l_decap_8_3416 \$2 \$1 sg13cmos5l_decap_8
* cell instance sg13cmos5l_decap_8_3417 r0 *1 0,0
Xsg13cmos5l_decap_8_3417 \$2 \$1 sg13cmos5l_decap_8
* cell instance sg13cmos5l_decap_8_3418 r0 *1 0,0
Xsg13cmos5l_decap_8_3418 \$2 \$1 sg13cmos5l_decap_8
* cell instance sg13cmos5l_decap_8_3419 r0 *1 0,0
Xsg13cmos5l_decap_8_3419 \$2 \$1 sg13cmos5l_decap_8
* cell instance sg13cmos5l_decap_8_3420 r0 *1 0,0
Xsg13cmos5l_decap_8_3420 \$2 \$1 sg13cmos5l_decap_8
* cell instance sg13cmos5l_decap_8_3421 r0 *1 0,0
Xsg13cmos5l_decap_8_3421 \$2 \$1 sg13cmos5l_decap_8
* cell instance sg13cmos5l_decap_8_3422 r0 *1 0,0
Xsg13cmos5l_decap_8_3422 \$2 \$1 sg13cmos5l_decap_8
* cell instance sg13cmos5l_decap_8_3423 r0 *1 0,0
Xsg13cmos5l_decap_8_3423 \$2 \$1 sg13cmos5l_decap_8
* cell instance sg13cmos5l_decap_8_3424 r0 *1 0,0
Xsg13cmos5l_decap_8_3424 \$2 \$1 sg13cmos5l_decap_8
* cell instance sg13cmos5l_decap_8_3425 r0 *1 0,0
Xsg13cmos5l_decap_8_3425 \$2 \$1 sg13cmos5l_decap_8
* cell instance sg13cmos5l_decap_8_3426 r0 *1 0,0
Xsg13cmos5l_decap_8_3426 \$2 \$1 sg13cmos5l_decap_8
* cell instance sg13cmos5l_decap_8_3427 r0 *1 0,0
Xsg13cmos5l_decap_8_3427 \$2 \$1 sg13cmos5l_decap_8
* cell instance sg13cmos5l_decap_8_3428 r0 *1 0,0
Xsg13cmos5l_decap_8_3428 \$2 \$1 sg13cmos5l_decap_8
* cell instance sg13cmos5l_decap_8_3429 r0 *1 0,0
Xsg13cmos5l_decap_8_3429 \$2 \$1 sg13cmos5l_decap_8
* cell instance sg13cmos5l_decap_8_3430 r0 *1 0,0
Xsg13cmos5l_decap_8_3430 \$2 \$1 sg13cmos5l_decap_8
* cell instance sg13cmos5l_decap_8_3431 r0 *1 0,0
Xsg13cmos5l_decap_8_3431 \$2 \$1 sg13cmos5l_decap_8
* cell instance sg13cmos5l_decap_8_3432 r0 *1 0,0
Xsg13cmos5l_decap_8_3432 \$2 \$1 sg13cmos5l_decap_8
* cell instance sg13cmos5l_decap_8_3433 r0 *1 0,0
Xsg13cmos5l_decap_8_3433 \$2 \$1 sg13cmos5l_decap_8
* cell instance sg13cmos5l_decap_8_3434 r0 *1 0,0
Xsg13cmos5l_decap_8_3434 \$2 \$1 sg13cmos5l_decap_8
* cell instance sg13cmos5l_decap_8_3435 r0 *1 0,0
Xsg13cmos5l_decap_8_3435 \$2 \$1 sg13cmos5l_decap_8
* cell instance sg13cmos5l_decap_8_3436 r0 *1 0,0
Xsg13cmos5l_decap_8_3436 \$2 \$1 sg13cmos5l_decap_8
* cell instance sg13cmos5l_decap_8_3437 r0 *1 0,0
Xsg13cmos5l_decap_8_3437 \$2 \$1 sg13cmos5l_decap_8
* cell instance sg13cmos5l_decap_8_3438 r0 *1 0,0
Xsg13cmos5l_decap_8_3438 \$2 \$1 sg13cmos5l_decap_8
* cell instance sg13cmos5l_decap_8_3439 r0 *1 0,0
Xsg13cmos5l_decap_8_3439 \$2 \$1 sg13cmos5l_decap_8
* cell instance sg13cmos5l_decap_8_3440 r0 *1 0,0
Xsg13cmos5l_decap_8_3440 \$2 \$1 sg13cmos5l_decap_8
* cell instance sg13cmos5l_decap_8_3441 r0 *1 0,0
Xsg13cmos5l_decap_8_3441 \$2 \$1 sg13cmos5l_decap_8
* cell instance sg13cmos5l_decap_8_3442 r0 *1 0,0
Xsg13cmos5l_decap_8_3442 \$2 \$1 sg13cmos5l_decap_8
* cell instance sg13cmos5l_decap_8_3443 r0 *1 0,0
Xsg13cmos5l_decap_8_3443 \$2 \$1 sg13cmos5l_decap_8
* cell instance sg13cmos5l_decap_8_3444 r0 *1 0,0
Xsg13cmos5l_decap_8_3444 \$2 \$1 sg13cmos5l_decap_8
* cell instance sg13cmos5l_decap_8_3445 r0 *1 0,0
Xsg13cmos5l_decap_8_3445 \$2 \$1 sg13cmos5l_decap_8
* cell instance sg13cmos5l_decap_8_3446 r0 *1 0,0
Xsg13cmos5l_decap_8_3446 \$2 \$1 sg13cmos5l_decap_8
* cell instance sg13cmos5l_decap_8_3447 r0 *1 0,0
Xsg13cmos5l_decap_8_3447 \$2 \$1 sg13cmos5l_decap_8
* cell instance sg13cmos5l_decap_8_3448 r0 *1 0,0
Xsg13cmos5l_decap_8_3448 \$2 \$1 sg13cmos5l_decap_8
* cell instance sg13cmos5l_decap_8_3449 r0 *1 0,0
Xsg13cmos5l_decap_8_3449 \$2 \$1 sg13cmos5l_decap_8
* cell instance sg13cmos5l_decap_8_3450 r0 *1 0,0
Xsg13cmos5l_decap_8_3450 \$2 \$1 sg13cmos5l_decap_8
* cell instance sg13cmos5l_decap_8_3451 r0 *1 0,0
Xsg13cmos5l_decap_8_3451 \$2 \$1 sg13cmos5l_decap_8
* cell instance sg13cmos5l_decap_8_3452 r0 *1 0,0
Xsg13cmos5l_decap_8_3452 \$2 \$1 sg13cmos5l_decap_8
* cell instance sg13cmos5l_decap_8_3453 r0 *1 0,0
Xsg13cmos5l_decap_8_3453 \$2 \$1 sg13cmos5l_decap_8
* cell instance sg13cmos5l_decap_8_3454 r0 *1 0,0
Xsg13cmos5l_decap_8_3454 \$2 \$1 sg13cmos5l_decap_8
* cell instance sg13cmos5l_decap_8_3455 r0 *1 0,0
Xsg13cmos5l_decap_8_3455 \$2 \$1 sg13cmos5l_decap_8
* cell instance sg13cmos5l_decap_8_3456 r0 *1 0,0
Xsg13cmos5l_decap_8_3456 \$2 \$1 sg13cmos5l_decap_8
* cell instance sg13cmos5l_decap_8_3457 r0 *1 0,0
Xsg13cmos5l_decap_8_3457 \$2 \$1 sg13cmos5l_decap_8
* cell instance sg13cmos5l_decap_8_3458 r0 *1 0,0
Xsg13cmos5l_decap_8_3458 \$2 \$1 sg13cmos5l_decap_8
* cell instance sg13cmos5l_decap_8_3459 r0 *1 0,0
Xsg13cmos5l_decap_8_3459 \$2 \$1 sg13cmos5l_decap_8
* cell instance sg13cmos5l_decap_8_3460 r0 *1 0,0
Xsg13cmos5l_decap_8_3460 \$2 \$1 sg13cmos5l_decap_8
* cell instance sg13cmos5l_decap_8_3461 r0 *1 0,0
Xsg13cmos5l_decap_8_3461 \$2 \$1 sg13cmos5l_decap_8
* cell instance sg13cmos5l_decap_8_3462 r0 *1 0,0
Xsg13cmos5l_decap_8_3462 \$2 \$1 sg13cmos5l_decap_8
* cell instance sg13cmos5l_decap_8_3463 r0 *1 0,0
Xsg13cmos5l_decap_8_3463 \$2 \$1 sg13cmos5l_decap_8
* cell instance sg13cmos5l_decap_8_3464 r0 *1 0,0
Xsg13cmos5l_decap_8_3464 \$2 \$1 sg13cmos5l_decap_8
* cell instance sg13cmos5l_decap_8_3465 r0 *1 0,0
Xsg13cmos5l_decap_8_3465 \$2 \$1 sg13cmos5l_decap_8
* cell instance sg13cmos5l_decap_8_3466 r0 *1 0,0
Xsg13cmos5l_decap_8_3466 \$2 \$1 sg13cmos5l_decap_8
* cell instance sg13cmos5l_decap_8_3467 r0 *1 0,0
Xsg13cmos5l_decap_8_3467 \$2 \$1 sg13cmos5l_decap_8
* cell instance sg13cmos5l_decap_8_3468 r0 *1 0,0
Xsg13cmos5l_decap_8_3468 \$2 \$1 sg13cmos5l_decap_8
* cell instance sg13cmos5l_decap_8_3469 r0 *1 0,0
Xsg13cmos5l_decap_8_3469 \$2 \$1 sg13cmos5l_decap_8
* cell instance sg13cmos5l_decap_8_3470 r0 *1 0,0
Xsg13cmos5l_decap_8_3470 \$2 \$1 sg13cmos5l_decap_8
* cell instance sg13cmos5l_decap_8_3471 r0 *1 0,0
Xsg13cmos5l_decap_8_3471 \$2 \$1 sg13cmos5l_decap_8
* cell instance sg13cmos5l_decap_8_3472 r0 *1 0,0
Xsg13cmos5l_decap_8_3472 \$2 \$1 sg13cmos5l_decap_8
* cell instance sg13cmos5l_decap_8_3473 r0 *1 0,0
Xsg13cmos5l_decap_8_3473 \$2 \$1 sg13cmos5l_decap_8
* cell instance sg13cmos5l_decap_8_3474 r0 *1 0,0
Xsg13cmos5l_decap_8_3474 \$2 \$1 sg13cmos5l_decap_8
* cell instance sg13cmos5l_decap_8_3475 r0 *1 0,0
Xsg13cmos5l_decap_8_3475 \$2 \$1 sg13cmos5l_decap_8
* cell instance sg13cmos5l_decap_8_3476 r0 *1 0,0
Xsg13cmos5l_decap_8_3476 \$2 \$1 sg13cmos5l_decap_8
* cell instance sg13cmos5l_decap_8_3477 r0 *1 0,0
Xsg13cmos5l_decap_8_3477 \$2 \$1 sg13cmos5l_decap_8
* cell instance sg13cmos5l_decap_8_3478 r0 *1 0,0
Xsg13cmos5l_decap_8_3478 \$2 \$1 sg13cmos5l_decap_8
* cell instance sg13cmos5l_decap_8_3479 r0 *1 0,0
Xsg13cmos5l_decap_8_3479 \$2 \$1 sg13cmos5l_decap_8
* cell instance sg13cmos5l_decap_8_3480 r0 *1 0,0
Xsg13cmos5l_decap_8_3480 \$2 \$1 sg13cmos5l_decap_8
* cell instance sg13cmos5l_decap_8_3481 r0 *1 0,0
Xsg13cmos5l_decap_8_3481 \$2 \$1 sg13cmos5l_decap_8
* cell instance sg13cmos5l_decap_8_3482 r0 *1 0,0
Xsg13cmos5l_decap_8_3482 \$2 \$1 sg13cmos5l_decap_8
* cell instance sg13cmos5l_decap_8_3483 r0 *1 0,0
Xsg13cmos5l_decap_8_3483 \$2 \$1 sg13cmos5l_decap_8
* cell instance sg13cmos5l_decap_8_3484 r0 *1 0,0
Xsg13cmos5l_decap_8_3484 \$2 \$1 sg13cmos5l_decap_8
* cell instance sg13cmos5l_decap_8_3485 r0 *1 0,0
Xsg13cmos5l_decap_8_3485 \$2 \$1 sg13cmos5l_decap_8
* cell instance sg13cmos5l_decap_8_3486 r0 *1 0,0
Xsg13cmos5l_decap_8_3486 \$2 \$1 sg13cmos5l_decap_8
* cell instance sg13cmos5l_decap_8_3487 r0 *1 0,0
Xsg13cmos5l_decap_8_3487 \$2 \$1 sg13cmos5l_decap_8
* cell instance sg13cmos5l_decap_8_3488 r0 *1 0,0
Xsg13cmos5l_decap_8_3488 \$2 \$1 sg13cmos5l_decap_8
* cell instance sg13cmos5l_decap_8_3489 r0 *1 0,0
Xsg13cmos5l_decap_8_3489 \$2 \$1 sg13cmos5l_decap_8
* cell instance sg13cmos5l_decap_8_3490 r0 *1 0,0
Xsg13cmos5l_decap_8_3490 \$2 \$1 sg13cmos5l_decap_8
* cell instance sg13cmos5l_decap_8_3491 r0 *1 0,0
Xsg13cmos5l_decap_8_3491 \$2 \$1 sg13cmos5l_decap_8
* cell instance sg13cmos5l_decap_8_3492 r0 *1 0,0
Xsg13cmos5l_decap_8_3492 \$2 \$1 sg13cmos5l_decap_8
* cell instance sg13cmos5l_decap_8_3493 r0 *1 0,0
Xsg13cmos5l_decap_8_3493 \$2 \$1 sg13cmos5l_decap_8
* cell instance sg13cmos5l_decap_8_3494 r0 *1 0,0
Xsg13cmos5l_decap_8_3494 \$2 \$1 sg13cmos5l_decap_8
* cell instance sg13cmos5l_decap_8_3495 r0 *1 0,0
Xsg13cmos5l_decap_8_3495 \$2 \$1 sg13cmos5l_decap_8
* cell instance sg13cmos5l_decap_8_3496 r0 *1 0,0
Xsg13cmos5l_decap_8_3496 \$2 \$1 sg13cmos5l_decap_8
* cell instance sg13cmos5l_decap_8_3497 r0 *1 0,0
Xsg13cmos5l_decap_8_3497 \$2 \$1 sg13cmos5l_decap_8
* cell instance sg13cmos5l_decap_8_3498 r0 *1 0,0
Xsg13cmos5l_decap_8_3498 \$2 \$1 sg13cmos5l_decap_8
* cell instance sg13cmos5l_decap_8_3499 r0 *1 0,0
Xsg13cmos5l_decap_8_3499 \$2 \$1 sg13cmos5l_decap_8
* cell instance sg13cmos5l_decap_8_3500 r0 *1 0,0
Xsg13cmos5l_decap_8_3500 \$2 \$1 sg13cmos5l_decap_8
* cell instance sg13cmos5l_decap_8_3501 r0 *1 0,0
Xsg13cmos5l_decap_8_3501 \$2 \$1 sg13cmos5l_decap_8
* cell instance sg13cmos5l_decap_8_3502 r0 *1 0,0
Xsg13cmos5l_decap_8_3502 \$2 \$1 sg13cmos5l_decap_8
* cell instance sg13cmos5l_decap_8_3503 r0 *1 0,0
Xsg13cmos5l_decap_8_3503 \$2 \$1 sg13cmos5l_decap_8
* cell instance sg13cmos5l_decap_8_3504 r0 *1 0,0
Xsg13cmos5l_decap_8_3504 \$2 \$1 sg13cmos5l_decap_8
* cell instance sg13cmos5l_decap_8_3505 r0 *1 0,0
Xsg13cmos5l_decap_8_3505 \$2 \$1 sg13cmos5l_decap_8
* cell instance sg13cmos5l_decap_8_3506 r0 *1 0,0
Xsg13cmos5l_decap_8_3506 \$2 \$1 sg13cmos5l_decap_8
* cell instance sg13cmos5l_decap_8_3507 r0 *1 0,0
Xsg13cmos5l_decap_8_3507 \$2 \$1 sg13cmos5l_decap_8
* cell instance sg13cmos5l_decap_8_3508 r0 *1 0,0
Xsg13cmos5l_decap_8_3508 \$2 \$1 sg13cmos5l_decap_8
* cell instance sg13cmos5l_decap_8_3509 r0 *1 0,0
Xsg13cmos5l_decap_8_3509 \$2 \$1 sg13cmos5l_decap_8
* cell instance sg13cmos5l_decap_8_3510 r0 *1 0,0
Xsg13cmos5l_decap_8_3510 \$2 \$1 sg13cmos5l_decap_8
* cell instance sg13cmos5l_decap_8_3511 r0 *1 0,0
Xsg13cmos5l_decap_8_3511 \$2 \$1 sg13cmos5l_decap_8
* cell instance sg13cmos5l_decap_8_3512 r0 *1 0,0
Xsg13cmos5l_decap_8_3512 \$2 \$1 sg13cmos5l_decap_8
* cell instance sg13cmos5l_decap_8_3513 r0 *1 0,0
Xsg13cmos5l_decap_8_3513 \$2 \$1 sg13cmos5l_decap_8
* cell instance sg13cmos5l_decap_8_3514 r0 *1 0,0
Xsg13cmos5l_decap_8_3514 \$2 \$1 sg13cmos5l_decap_8
* cell instance sg13cmos5l_decap_8_3515 r0 *1 0,0
Xsg13cmos5l_decap_8_3515 \$2 \$1 sg13cmos5l_decap_8
* cell instance sg13cmos5l_decap_8_3516 r0 *1 0,0
Xsg13cmos5l_decap_8_3516 \$2 \$1 sg13cmos5l_decap_8
* cell instance sg13cmos5l_decap_8_3517 r0 *1 0,0
Xsg13cmos5l_decap_8_3517 \$2 \$1 sg13cmos5l_decap_8
* cell instance sg13cmos5l_decap_8_3518 r0 *1 0,0
Xsg13cmos5l_decap_8_3518 \$2 \$1 sg13cmos5l_decap_8
* cell instance sg13cmos5l_decap_8_3519 r0 *1 0,0
Xsg13cmos5l_decap_8_3519 \$2 \$1 sg13cmos5l_decap_8
* cell instance sg13cmos5l_decap_8_3520 r0 *1 0,0
Xsg13cmos5l_decap_8_3520 \$2 \$1 sg13cmos5l_decap_8
* cell instance sg13cmos5l_decap_8_3521 r0 *1 0,0
Xsg13cmos5l_decap_8_3521 \$2 \$1 sg13cmos5l_decap_8
* cell instance sg13cmos5l_decap_8_3522 r0 *1 0,0
Xsg13cmos5l_decap_8_3522 \$2 \$1 sg13cmos5l_decap_8
* cell instance sg13cmos5l_decap_8_3523 r0 *1 0,0
Xsg13cmos5l_decap_8_3523 \$2 \$1 sg13cmos5l_decap_8
* cell instance sg13cmos5l_decap_8_3524 r0 *1 0,0
Xsg13cmos5l_decap_8_3524 \$2 \$1 sg13cmos5l_decap_8
* cell instance sg13cmos5l_decap_8_3525 r0 *1 0,0
Xsg13cmos5l_decap_8_3525 \$2 \$1 sg13cmos5l_decap_8
* cell instance sg13cmos5l_decap_8_3526 r0 *1 0,0
Xsg13cmos5l_decap_8_3526 \$2 \$1 sg13cmos5l_decap_8
* cell instance sg13cmos5l_decap_8_3527 r0 *1 0,0
Xsg13cmos5l_decap_8_3527 \$2 \$1 sg13cmos5l_decap_8
* cell instance sg13cmos5l_decap_8_3528 r0 *1 0,0
Xsg13cmos5l_decap_8_3528 \$2 \$1 sg13cmos5l_decap_8
* cell instance sg13cmos5l_decap_8_3529 r0 *1 0,0
Xsg13cmos5l_decap_8_3529 \$2 \$1 sg13cmos5l_decap_8
* cell instance sg13cmos5l_decap_8_3530 r0 *1 0,0
Xsg13cmos5l_decap_8_3530 \$2 \$1 sg13cmos5l_decap_8
* cell instance sg13cmos5l_decap_8_3531 r0 *1 0,0
Xsg13cmos5l_decap_8_3531 \$2 \$1 sg13cmos5l_decap_8
* cell instance sg13cmos5l_decap_8_3532 r0 *1 0,0
Xsg13cmos5l_decap_8_3532 \$2 \$1 sg13cmos5l_decap_8
* cell instance sg13cmos5l_decap_8_3533 r0 *1 0,0
Xsg13cmos5l_decap_8_3533 \$2 \$1 sg13cmos5l_decap_8
* cell instance sg13cmos5l_decap_8_3534 r0 *1 0,0
Xsg13cmos5l_decap_8_3534 \$2 \$1 sg13cmos5l_decap_8
* cell instance sg13cmos5l_decap_8_3535 r0 *1 0,0
Xsg13cmos5l_decap_8_3535 \$2 \$1 sg13cmos5l_decap_8
* cell instance sg13cmos5l_decap_8_3536 r0 *1 0,0
Xsg13cmos5l_decap_8_3536 \$2 \$1 sg13cmos5l_decap_8
* cell instance sg13cmos5l_decap_8_3537 r0 *1 0,0
Xsg13cmos5l_decap_8_3537 \$2 \$1 sg13cmos5l_decap_8
* cell instance sg13cmos5l_decap_8_3538 r0 *1 0,0
Xsg13cmos5l_decap_8_3538 \$2 \$1 sg13cmos5l_decap_8
* cell instance sg13cmos5l_decap_8_3539 r0 *1 0,0
Xsg13cmos5l_decap_8_3539 \$2 \$1 sg13cmos5l_decap_8
* cell instance sg13cmos5l_decap_8_3540 r0 *1 0,0
Xsg13cmos5l_decap_8_3540 \$2 \$1 sg13cmos5l_decap_8
* cell instance sg13cmos5l_decap_8_3541 r0 *1 0,0
Xsg13cmos5l_decap_8_3541 \$2 \$1 sg13cmos5l_decap_8
* cell instance sg13cmos5l_decap_8_3542 r0 *1 0,0
Xsg13cmos5l_decap_8_3542 \$2 \$1 sg13cmos5l_decap_8
* cell instance sg13cmos5l_decap_8_3543 r0 *1 0,0
Xsg13cmos5l_decap_8_3543 \$2 \$1 sg13cmos5l_decap_8
* cell instance sg13cmos5l_decap_8_3544 r0 *1 0,0
Xsg13cmos5l_decap_8_3544 \$2 \$1 sg13cmos5l_decap_8
* cell instance sg13cmos5l_decap_8_3545 r0 *1 0,0
Xsg13cmos5l_decap_8_3545 \$2 \$1 sg13cmos5l_decap_8
* cell instance sg13cmos5l_decap_8_3546 r0 *1 0,0
Xsg13cmos5l_decap_8_3546 \$2 \$1 sg13cmos5l_decap_8
* cell instance sg13cmos5l_decap_8_3547 r0 *1 0,0
Xsg13cmos5l_decap_8_3547 \$2 \$1 sg13cmos5l_decap_8
* cell instance sg13cmos5l_decap_8_3548 r0 *1 0,0
Xsg13cmos5l_decap_8_3548 \$2 \$1 sg13cmos5l_decap_8
* cell instance sg13cmos5l_decap_8_3549 r0 *1 0,0
Xsg13cmos5l_decap_8_3549 \$2 \$1 sg13cmos5l_decap_8
* cell instance sg13cmos5l_decap_8_3550 r0 *1 0,0
Xsg13cmos5l_decap_8_3550 \$2 \$1 sg13cmos5l_decap_8
* cell instance sg13cmos5l_decap_8_3551 r0 *1 0,0
Xsg13cmos5l_decap_8_3551 \$2 \$1 sg13cmos5l_decap_8
* cell instance sg13cmos5l_decap_8_3552 r0 *1 0,0
Xsg13cmos5l_decap_8_3552 \$2 \$1 sg13cmos5l_decap_8
* cell instance sg13cmos5l_decap_8_3553 r0 *1 0,0
Xsg13cmos5l_decap_8_3553 \$2 \$1 sg13cmos5l_decap_8
* cell instance sg13cmos5l_decap_8_3554 r0 *1 0,0
Xsg13cmos5l_decap_8_3554 \$2 \$1 sg13cmos5l_decap_8
* cell instance sg13cmos5l_decap_8_3555 r0 *1 0,0
Xsg13cmos5l_decap_8_3555 \$2 \$1 sg13cmos5l_decap_8
* cell instance sg13cmos5l_decap_8_3556 r0 *1 0,0
Xsg13cmos5l_decap_8_3556 \$2 \$1 sg13cmos5l_decap_8
* cell instance sg13cmos5l_decap_8_3557 r0 *1 0,0
Xsg13cmos5l_decap_8_3557 \$2 \$1 sg13cmos5l_decap_8
* cell instance sg13cmos5l_decap_8_3558 r0 *1 0,0
Xsg13cmos5l_decap_8_3558 \$2 \$1 sg13cmos5l_decap_8
* cell instance sg13cmos5l_decap_8_3559 r0 *1 0,0
Xsg13cmos5l_decap_8_3559 \$2 \$1 sg13cmos5l_decap_8
* cell instance sg13cmos5l_decap_8_3560 r0 *1 0,0
Xsg13cmos5l_decap_8_3560 \$2 \$1 sg13cmos5l_decap_8
* cell instance sg13cmos5l_decap_8_3561 r0 *1 0,0
Xsg13cmos5l_decap_8_3561 \$2 \$1 sg13cmos5l_decap_8
* cell instance sg13cmos5l_decap_8_3562 r0 *1 0,0
Xsg13cmos5l_decap_8_3562 \$2 \$1 sg13cmos5l_decap_8
* cell instance sg13cmos5l_decap_8_3563 r0 *1 0,0
Xsg13cmos5l_decap_8_3563 \$2 \$1 sg13cmos5l_decap_8
* cell instance sg13cmos5l_decap_8_3564 r0 *1 0,0
Xsg13cmos5l_decap_8_3564 \$2 \$1 sg13cmos5l_decap_8
* cell instance sg13cmos5l_decap_8_3565 r0 *1 0,0
Xsg13cmos5l_decap_8_3565 \$2 \$1 sg13cmos5l_decap_8
* cell instance sg13cmos5l_decap_8_3566 r0 *1 0,0
Xsg13cmos5l_decap_8_3566 \$2 \$1 sg13cmos5l_decap_8
* cell instance sg13cmos5l_decap_8_3567 r0 *1 0,0
Xsg13cmos5l_decap_8_3567 \$2 \$1 sg13cmos5l_decap_8
* cell instance sg13cmos5l_decap_8_3568 r0 *1 0,0
Xsg13cmos5l_decap_8_3568 \$2 \$1 sg13cmos5l_decap_8
* cell instance sg13cmos5l_decap_8_3569 r0 *1 0,0
Xsg13cmos5l_decap_8_3569 \$2 \$1 sg13cmos5l_decap_8
* cell instance sg13cmos5l_decap_8_3570 r0 *1 0,0
Xsg13cmos5l_decap_8_3570 \$2 \$1 sg13cmos5l_decap_8
* cell instance sg13cmos5l_decap_8_3571 r0 *1 0,0
Xsg13cmos5l_decap_8_3571 \$2 \$1 sg13cmos5l_decap_8
* cell instance sg13cmos5l_decap_8_3572 r0 *1 0,0
Xsg13cmos5l_decap_8_3572 \$2 \$1 sg13cmos5l_decap_8
* cell instance sg13cmos5l_decap_8_3573 r0 *1 0,0
Xsg13cmos5l_decap_8_3573 \$2 \$1 sg13cmos5l_decap_8
* cell instance sg13cmos5l_decap_8_3574 r0 *1 0,0
Xsg13cmos5l_decap_8_3574 \$2 \$1 sg13cmos5l_decap_8
* cell instance sg13cmos5l_decap_8_3575 r0 *1 0,0
Xsg13cmos5l_decap_8_3575 \$2 \$1 sg13cmos5l_decap_8
* cell instance sg13cmos5l_decap_8_3576 r0 *1 0,0
Xsg13cmos5l_decap_8_3576 \$2 \$1 sg13cmos5l_decap_8
* cell instance sg13cmos5l_decap_8_3577 r0 *1 0,0
Xsg13cmos5l_decap_8_3577 \$2 \$1 sg13cmos5l_decap_8
* cell instance sg13cmos5l_decap_8_3578 r0 *1 0,0
Xsg13cmos5l_decap_8_3578 \$2 \$1 sg13cmos5l_decap_8
* cell instance sg13cmos5l_decap_8_3579 r0 *1 0,0
Xsg13cmos5l_decap_8_3579 \$2 \$1 sg13cmos5l_decap_8
* cell instance sg13cmos5l_decap_8_3580 r0 *1 0,0
Xsg13cmos5l_decap_8_3580 \$2 \$1 sg13cmos5l_decap_8
* cell instance sg13cmos5l_decap_8_3581 r0 *1 0,0
Xsg13cmos5l_decap_8_3581 \$2 \$1 sg13cmos5l_decap_8
* cell instance sg13cmos5l_decap_8_3582 r0 *1 0,0
Xsg13cmos5l_decap_8_3582 \$2 \$1 sg13cmos5l_decap_8
* cell instance sg13cmos5l_decap_8_3583 r0 *1 0,0
Xsg13cmos5l_decap_8_3583 \$2 \$1 sg13cmos5l_decap_8
* cell instance sg13cmos5l_decap_8_3584 r0 *1 0,0
Xsg13cmos5l_decap_8_3584 \$2 \$1 sg13cmos5l_decap_8
* cell instance sg13cmos5l_decap_8_3585 r0 *1 0,0
Xsg13cmos5l_decap_8_3585 \$2 \$1 sg13cmos5l_decap_8
* cell instance sg13cmos5l_decap_8_3586 r0 *1 0,0
Xsg13cmos5l_decap_8_3586 \$2 \$1 sg13cmos5l_decap_8
* cell instance sg13cmos5l_decap_8_3587 r0 *1 0,0
Xsg13cmos5l_decap_8_3587 \$2 \$1 sg13cmos5l_decap_8
* cell instance sg13cmos5l_decap_8_3588 r0 *1 0,0
Xsg13cmos5l_decap_8_3588 \$2 \$1 sg13cmos5l_decap_8
* cell instance sg13cmos5l_decap_8_3589 r0 *1 0,0
Xsg13cmos5l_decap_8_3589 \$2 \$1 sg13cmos5l_decap_8
* cell instance sg13cmos5l_decap_8_3590 r0 *1 0,0
Xsg13cmos5l_decap_8_3590 \$2 \$1 sg13cmos5l_decap_8
* cell instance sg13cmos5l_decap_8_3591 r0 *1 0,0
Xsg13cmos5l_decap_8_3591 \$2 \$1 sg13cmos5l_decap_8
* cell instance sg13cmos5l_decap_8_3592 r0 *1 0,0
Xsg13cmos5l_decap_8_3592 \$2 \$1 sg13cmos5l_decap_8
* cell instance sg13cmos5l_decap_8_3593 r0 *1 0,0
Xsg13cmos5l_decap_8_3593 \$2 \$1 sg13cmos5l_decap_8
* cell instance sg13cmos5l_decap_8_3594 r0 *1 0,0
Xsg13cmos5l_decap_8_3594 \$2 \$1 sg13cmos5l_decap_8
* cell instance sg13cmos5l_decap_8_3595 r0 *1 0,0
Xsg13cmos5l_decap_8_3595 \$2 \$1 sg13cmos5l_decap_8
* cell instance sg13cmos5l_decap_8_3596 r0 *1 0,0
Xsg13cmos5l_decap_8_3596 \$2 \$1 sg13cmos5l_decap_8
* cell instance sg13cmos5l_decap_8_3597 r0 *1 0,0
Xsg13cmos5l_decap_8_3597 \$2 \$1 sg13cmos5l_decap_8
* cell instance sg13cmos5l_decap_8_3598 r0 *1 0,0
Xsg13cmos5l_decap_8_3598 \$2 \$1 sg13cmos5l_decap_8
* cell instance sg13cmos5l_decap_8_3599 r0 *1 0,0
Xsg13cmos5l_decap_8_3599 \$2 \$1 sg13cmos5l_decap_8
* cell instance sg13cmos5l_decap_8_3600 r0 *1 0,0
Xsg13cmos5l_decap_8_3600 \$2 \$1 sg13cmos5l_decap_8
* cell instance sg13cmos5l_decap_8_3601 r0 *1 0,0
Xsg13cmos5l_decap_8_3601 \$2 \$1 sg13cmos5l_decap_8
* cell instance sg13cmos5l_decap_8_3602 r0 *1 0,0
Xsg13cmos5l_decap_8_3602 \$2 \$1 sg13cmos5l_decap_8
* cell instance sg13cmos5l_decap_8_3603 r0 *1 0,0
Xsg13cmos5l_decap_8_3603 \$2 \$1 sg13cmos5l_decap_8
* cell instance sg13cmos5l_decap_8_3604 r0 *1 0,0
Xsg13cmos5l_decap_8_3604 \$2 \$1 sg13cmos5l_decap_8
* cell instance sg13cmos5l_decap_8_3605 r0 *1 0,0
Xsg13cmos5l_decap_8_3605 \$2 \$1 sg13cmos5l_decap_8
* cell instance sg13cmos5l_decap_8_3606 r0 *1 0,0
Xsg13cmos5l_decap_8_3606 \$2 \$1 sg13cmos5l_decap_8
* cell instance sg13cmos5l_decap_8_3607 r0 *1 0,0
Xsg13cmos5l_decap_8_3607 \$2 \$1 sg13cmos5l_decap_8
* cell instance sg13cmos5l_decap_8_3608 r0 *1 0,0
Xsg13cmos5l_decap_8_3608 \$2 \$1 sg13cmos5l_decap_8
* cell instance sg13cmos5l_decap_8_3609 r0 *1 0,0
Xsg13cmos5l_decap_8_3609 \$2 \$1 sg13cmos5l_decap_8
* cell instance sg13cmos5l_decap_8_3610 r0 *1 0,0
Xsg13cmos5l_decap_8_3610 \$2 \$1 sg13cmos5l_decap_8
* cell instance sg13cmos5l_decap_8_3611 r0 *1 0,0
Xsg13cmos5l_decap_8_3611 \$2 \$1 sg13cmos5l_decap_8
* cell instance sg13cmos5l_decap_8_3612 r0 *1 0,0
Xsg13cmos5l_decap_8_3612 \$2 \$1 sg13cmos5l_decap_8
* cell instance sg13cmos5l_decap_8_3613 r0 *1 0,0
Xsg13cmos5l_decap_8_3613 \$2 \$1 sg13cmos5l_decap_8
* cell instance sg13cmos5l_decap_8_3614 r0 *1 0,0
Xsg13cmos5l_decap_8_3614 \$2 \$1 sg13cmos5l_decap_8
* cell instance sg13cmos5l_decap_8_3615 r0 *1 0,0
Xsg13cmos5l_decap_8_3615 \$2 \$1 sg13cmos5l_decap_8
* cell instance sg13cmos5l_decap_8_3616 r0 *1 0,0
Xsg13cmos5l_decap_8_3616 \$2 \$1 sg13cmos5l_decap_8
* cell instance sg13cmos5l_decap_8_3617 r0 *1 0,0
Xsg13cmos5l_decap_8_3617 \$2 \$1 sg13cmos5l_decap_8
* cell instance sg13cmos5l_decap_8_3618 r0 *1 0,0
Xsg13cmos5l_decap_8_3618 \$2 \$1 sg13cmos5l_decap_8
* cell instance sg13cmos5l_decap_8_3619 r0 *1 0,0
Xsg13cmos5l_decap_8_3619 \$2 \$1 sg13cmos5l_decap_8
* cell instance sg13cmos5l_decap_8_3620 r0 *1 0,0
Xsg13cmos5l_decap_8_3620 \$2 \$1 sg13cmos5l_decap_8
* cell instance sg13cmos5l_decap_8_3621 r0 *1 0,0
Xsg13cmos5l_decap_8_3621 \$2 \$1 sg13cmos5l_decap_8
* cell instance sg13cmos5l_decap_8_3622 r0 *1 0,0
Xsg13cmos5l_decap_8_3622 \$2 \$1 sg13cmos5l_decap_8
* cell instance sg13cmos5l_decap_8_3623 r0 *1 0,0
Xsg13cmos5l_decap_8_3623 \$2 \$1 sg13cmos5l_decap_8
* cell instance sg13cmos5l_decap_8_3624 r0 *1 0,0
Xsg13cmos5l_decap_8_3624 \$2 \$1 sg13cmos5l_decap_8
* cell instance sg13cmos5l_decap_8_3625 r0 *1 0,0
Xsg13cmos5l_decap_8_3625 \$2 \$1 sg13cmos5l_decap_8
* cell instance sg13cmos5l_decap_8_3626 r0 *1 0,0
Xsg13cmos5l_decap_8_3626 \$2 \$1 sg13cmos5l_decap_8
* cell instance sg13cmos5l_decap_8_3627 r0 *1 0,0
Xsg13cmos5l_decap_8_3627 \$2 \$1 sg13cmos5l_decap_8
* cell instance sg13cmos5l_decap_8_3628 r0 *1 0,0
Xsg13cmos5l_decap_8_3628 \$2 \$1 sg13cmos5l_decap_8
* cell instance sg13cmos5l_decap_8_3629 r0 *1 0,0
Xsg13cmos5l_decap_8_3629 \$2 \$1 sg13cmos5l_decap_8
* cell instance sg13cmos5l_decap_8_3630 r0 *1 0,0
Xsg13cmos5l_decap_8_3630 \$2 \$1 sg13cmos5l_decap_8
* cell instance sg13cmos5l_decap_8_3631 r0 *1 0,0
Xsg13cmos5l_decap_8_3631 \$2 \$1 sg13cmos5l_decap_8
* cell instance sg13cmos5l_decap_8_3632 r0 *1 0,0
Xsg13cmos5l_decap_8_3632 \$2 \$1 sg13cmos5l_decap_8
* cell instance sg13cmos5l_decap_8_3633 r0 *1 0,0
Xsg13cmos5l_decap_8_3633 \$2 \$1 sg13cmos5l_decap_8
* cell instance sg13cmos5l_decap_8_3634 r0 *1 0,0
Xsg13cmos5l_decap_8_3634 \$2 \$1 sg13cmos5l_decap_8
* cell instance sg13cmos5l_decap_8_3635 r0 *1 0,0
Xsg13cmos5l_decap_8_3635 \$2 \$1 sg13cmos5l_decap_8
* cell instance sg13cmos5l_decap_8_3636 r0 *1 0,0
Xsg13cmos5l_decap_8_3636 \$2 \$1 sg13cmos5l_decap_8
* cell instance sg13cmos5l_decap_8_3637 r0 *1 0,0
Xsg13cmos5l_decap_8_3637 \$2 \$1 sg13cmos5l_decap_8
* cell instance sg13cmos5l_decap_8_3638 r0 *1 0,0
Xsg13cmos5l_decap_8_3638 \$2 \$1 sg13cmos5l_decap_8
* cell instance sg13cmos5l_decap_8_3639 r0 *1 0,0
Xsg13cmos5l_decap_8_3639 \$2 \$1 sg13cmos5l_decap_8
* cell instance sg13cmos5l_decap_8_3640 r0 *1 0,0
Xsg13cmos5l_decap_8_3640 \$2 \$1 sg13cmos5l_decap_8
* cell instance sg13cmos5l_decap_8_3641 r0 *1 0,0
Xsg13cmos5l_decap_8_3641 \$2 \$1 sg13cmos5l_decap_8
* cell instance sg13cmos5l_decap_8_3642 r0 *1 0,0
Xsg13cmos5l_decap_8_3642 \$2 \$1 sg13cmos5l_decap_8
* cell instance sg13cmos5l_decap_8_3643 r0 *1 0,0
Xsg13cmos5l_decap_8_3643 \$2 \$1 sg13cmos5l_decap_8
* cell instance sg13cmos5l_decap_8_3644 r0 *1 0,0
Xsg13cmos5l_decap_8_3644 \$2 \$1 sg13cmos5l_decap_8
* cell instance sg13cmos5l_decap_8_3645 r0 *1 0,0
Xsg13cmos5l_decap_8_3645 \$2 \$1 sg13cmos5l_decap_8
* cell instance sg13cmos5l_decap_8_3646 r0 *1 0,0
Xsg13cmos5l_decap_8_3646 \$2 \$1 sg13cmos5l_decap_8
* cell instance sg13cmos5l_decap_8_3647 r0 *1 0,0
Xsg13cmos5l_decap_8_3647 \$2 \$1 sg13cmos5l_decap_8
* cell instance sg13cmos5l_decap_8_3648 r0 *1 0,0
Xsg13cmos5l_decap_8_3648 \$2 \$1 sg13cmos5l_decap_8
* cell instance sg13cmos5l_decap_8_3649 r0 *1 0,0
Xsg13cmos5l_decap_8_3649 \$2 \$1 sg13cmos5l_decap_8
* cell instance sg13cmos5l_decap_8_3650 r0 *1 0,0
Xsg13cmos5l_decap_8_3650 \$2 \$1 sg13cmos5l_decap_8
* cell instance sg13cmos5l_decap_8_3651 r0 *1 0,0
Xsg13cmos5l_decap_8_3651 \$2 \$1 sg13cmos5l_decap_8
* cell instance sg13cmos5l_decap_8_3652 r0 *1 0,0
Xsg13cmos5l_decap_8_3652 \$2 \$1 sg13cmos5l_decap_8
* cell instance sg13cmos5l_decap_8_3653 r0 *1 0,0
Xsg13cmos5l_decap_8_3653 \$2 \$1 sg13cmos5l_decap_8
* cell instance sg13cmos5l_decap_8_3654 r0 *1 0,0
Xsg13cmos5l_decap_8_3654 \$2 \$1 sg13cmos5l_decap_8
* cell instance sg13cmos5l_decap_8_3655 r0 *1 0,0
Xsg13cmos5l_decap_8_3655 \$2 \$1 sg13cmos5l_decap_8
* cell instance sg13cmos5l_decap_8_3656 r0 *1 0,0
Xsg13cmos5l_decap_8_3656 \$2 \$1 sg13cmos5l_decap_8
* cell instance sg13cmos5l_decap_8_3657 r0 *1 0,0
Xsg13cmos5l_decap_8_3657 \$2 \$1 sg13cmos5l_decap_8
* cell instance sg13cmos5l_decap_8_3658 r0 *1 0,0
Xsg13cmos5l_decap_8_3658 \$2 \$1 sg13cmos5l_decap_8
* cell instance sg13cmos5l_decap_8_3659 r0 *1 0,0
Xsg13cmos5l_decap_8_3659 \$2 \$1 sg13cmos5l_decap_8
* cell instance sg13cmos5l_decap_8_3660 r0 *1 0,0
Xsg13cmos5l_decap_8_3660 \$2 \$1 sg13cmos5l_decap_8
* cell instance sg13cmos5l_decap_8_3661 r0 *1 0,0
Xsg13cmos5l_decap_8_3661 \$2 \$1 sg13cmos5l_decap_8
* cell instance sg13cmos5l_decap_8_3662 r0 *1 0,0
Xsg13cmos5l_decap_8_3662 \$2 \$1 sg13cmos5l_decap_8
* cell instance sg13cmos5l_decap_8_3663 r0 *1 0,0
Xsg13cmos5l_decap_8_3663 \$2 \$1 sg13cmos5l_decap_8
* cell instance sg13cmos5l_decap_8_3664 r0 *1 0,0
Xsg13cmos5l_decap_8_3664 \$2 \$1 sg13cmos5l_decap_8
* cell instance sg13cmos5l_decap_8_3665 r0 *1 0,0
Xsg13cmos5l_decap_8_3665 \$2 \$1 sg13cmos5l_decap_8
* cell instance sg13cmos5l_decap_8_3666 r0 *1 0,0
Xsg13cmos5l_decap_8_3666 \$2 \$1 sg13cmos5l_decap_8
* cell instance sg13cmos5l_decap_8_3667 r0 *1 0,0
Xsg13cmos5l_decap_8_3667 \$2 \$1 sg13cmos5l_decap_8
* cell instance sg13cmos5l_decap_8_3668 r0 *1 0,0
Xsg13cmos5l_decap_8_3668 \$2 \$1 sg13cmos5l_decap_8
* cell instance sg13cmos5l_decap_8_3669 r0 *1 0,0
Xsg13cmos5l_decap_8_3669 \$2 \$1 sg13cmos5l_decap_8
* cell instance sg13cmos5l_decap_8_3670 r0 *1 0,0
Xsg13cmos5l_decap_8_3670 \$2 \$1 sg13cmos5l_decap_8
* cell instance sg13cmos5l_decap_8_3671 r0 *1 0,0
Xsg13cmos5l_decap_8_3671 \$2 \$1 sg13cmos5l_decap_8
* cell instance sg13cmos5l_decap_8_3672 r0 *1 0,0
Xsg13cmos5l_decap_8_3672 \$2 \$1 sg13cmos5l_decap_8
* cell instance sg13cmos5l_decap_8_3673 r0 *1 0,0
Xsg13cmos5l_decap_8_3673 \$2 \$1 sg13cmos5l_decap_8
* cell instance sg13cmos5l_decap_8_3674 r0 *1 0,0
Xsg13cmos5l_decap_8_3674 \$2 \$1 sg13cmos5l_decap_8
* cell instance sg13cmos5l_decap_8_3675 r0 *1 0,0
Xsg13cmos5l_decap_8_3675 \$2 \$1 sg13cmos5l_decap_8
* cell instance sg13cmos5l_decap_8_3676 r0 *1 0,0
Xsg13cmos5l_decap_8_3676 \$2 \$1 sg13cmos5l_decap_8
* cell instance sg13cmos5l_decap_8_3677 r0 *1 0,0
Xsg13cmos5l_decap_8_3677 \$2 \$1 sg13cmos5l_decap_8
* cell instance sg13cmos5l_decap_8_3678 r0 *1 0,0
Xsg13cmos5l_decap_8_3678 \$2 \$1 sg13cmos5l_decap_8
* cell instance sg13cmos5l_decap_8_3679 r0 *1 0,0
Xsg13cmos5l_decap_8_3679 \$2 \$1 sg13cmos5l_decap_8
* cell instance sg13cmos5l_decap_8_3680 r0 *1 0,0
Xsg13cmos5l_decap_8_3680 \$2 \$1 sg13cmos5l_decap_8
* cell instance sg13cmos5l_decap_8_3681 r0 *1 0,0
Xsg13cmos5l_decap_8_3681 \$2 \$1 sg13cmos5l_decap_8
* cell instance sg13cmos5l_decap_8_3682 r0 *1 0,0
Xsg13cmos5l_decap_8_3682 \$2 \$1 sg13cmos5l_decap_8
* cell instance sg13cmos5l_decap_8_3683 r0 *1 0,0
Xsg13cmos5l_decap_8_3683 \$2 \$1 sg13cmos5l_decap_8
* cell instance sg13cmos5l_decap_8_3684 r0 *1 0,0
Xsg13cmos5l_decap_8_3684 \$2 \$1 sg13cmos5l_decap_8
* cell instance sg13cmos5l_decap_8_3685 r0 *1 0,0
Xsg13cmos5l_decap_8_3685 \$2 \$1 sg13cmos5l_decap_8
* cell instance sg13cmos5l_decap_8_3686 r0 *1 0,0
Xsg13cmos5l_decap_8_3686 \$2 \$1 sg13cmos5l_decap_8
* cell instance sg13cmos5l_decap_8_3687 r0 *1 0,0
Xsg13cmos5l_decap_8_3687 \$2 \$1 sg13cmos5l_decap_8
* cell instance sg13cmos5l_decap_8_3688 r0 *1 0,0
Xsg13cmos5l_decap_8_3688 \$2 \$1 sg13cmos5l_decap_8
* cell instance sg13cmos5l_decap_8_3689 r0 *1 0,0
Xsg13cmos5l_decap_8_3689 \$2 \$1 sg13cmos5l_decap_8
* cell instance sg13cmos5l_decap_8_3690 r0 *1 0,0
Xsg13cmos5l_decap_8_3690 \$2 \$1 sg13cmos5l_decap_8
* cell instance sg13cmos5l_decap_8_3691 r0 *1 0,0
Xsg13cmos5l_decap_8_3691 \$2 \$1 sg13cmos5l_decap_8
* cell instance sg13cmos5l_decap_8_3692 r0 *1 0,0
Xsg13cmos5l_decap_8_3692 \$2 \$1 sg13cmos5l_decap_8
* cell instance sg13cmos5l_decap_8_3693 r0 *1 0,0
Xsg13cmos5l_decap_8_3693 \$2 \$1 sg13cmos5l_decap_8
* cell instance sg13cmos5l_decap_8_3694 r0 *1 0,0
Xsg13cmos5l_decap_8_3694 \$2 \$1 sg13cmos5l_decap_8
* cell instance sg13cmos5l_decap_8_3695 r0 *1 0,0
Xsg13cmos5l_decap_8_3695 \$2 \$1 sg13cmos5l_decap_8
* cell instance sg13cmos5l_decap_8_3696 r0 *1 0,0
Xsg13cmos5l_decap_8_3696 \$2 \$1 sg13cmos5l_decap_8
* cell instance sg13cmos5l_decap_8_3697 r0 *1 0,0
Xsg13cmos5l_decap_8_3697 \$2 \$1 sg13cmos5l_decap_8
* cell instance sg13cmos5l_decap_8_3698 r0 *1 0,0
Xsg13cmos5l_decap_8_3698 \$2 \$1 sg13cmos5l_decap_8
* cell instance sg13cmos5l_decap_8_3699 r0 *1 0,0
Xsg13cmos5l_decap_8_3699 \$2 \$1 sg13cmos5l_decap_8
* cell instance sg13cmos5l_decap_8_3700 r0 *1 0,0
Xsg13cmos5l_decap_8_3700 \$2 \$1 sg13cmos5l_decap_8
* cell instance sg13cmos5l_decap_8_3701 r0 *1 0,0
Xsg13cmos5l_decap_8_3701 \$2 \$1 sg13cmos5l_decap_8
* cell instance sg13cmos5l_decap_8_3702 r0 *1 0,0
Xsg13cmos5l_decap_8_3702 \$2 \$1 sg13cmos5l_decap_8
* cell instance sg13cmos5l_decap_8_3703 r0 *1 0,0
Xsg13cmos5l_decap_8_3703 \$2 \$1 sg13cmos5l_decap_8
* cell instance sg13cmos5l_decap_8_3704 r0 *1 0,0
Xsg13cmos5l_decap_8_3704 \$2 \$1 sg13cmos5l_decap_8
* cell instance sg13cmos5l_decap_8_3705 r0 *1 0,0
Xsg13cmos5l_decap_8_3705 \$2 \$1 sg13cmos5l_decap_8
* cell instance sg13cmos5l_decap_8_3706 r0 *1 0,0
Xsg13cmos5l_decap_8_3706 \$2 \$1 sg13cmos5l_decap_8
* cell instance sg13cmos5l_decap_8_3707 r0 *1 0,0
Xsg13cmos5l_decap_8_3707 \$2 \$1 sg13cmos5l_decap_8
* cell instance sg13cmos5l_decap_8_3708 r0 *1 0,0
Xsg13cmos5l_decap_8_3708 \$2 \$1 sg13cmos5l_decap_8
* cell instance sg13cmos5l_decap_8_3709 r0 *1 0,0
Xsg13cmos5l_decap_8_3709 \$2 \$1 sg13cmos5l_decap_8
* cell instance sg13cmos5l_decap_8_3710 r0 *1 0,0
Xsg13cmos5l_decap_8_3710 \$2 \$1 sg13cmos5l_decap_8
* cell instance sg13cmos5l_decap_8_3711 r0 *1 0,0
Xsg13cmos5l_decap_8_3711 \$2 \$1 sg13cmos5l_decap_8
* cell instance sg13cmos5l_decap_8_3712 r0 *1 0,0
Xsg13cmos5l_decap_8_3712 \$2 \$1 sg13cmos5l_decap_8
* cell instance sg13cmos5l_decap_8_3713 r0 *1 0,0
Xsg13cmos5l_decap_8_3713 \$2 \$1 sg13cmos5l_decap_8
* cell instance sg13cmos5l_decap_8_3714 r0 *1 0,0
Xsg13cmos5l_decap_8_3714 \$2 \$1 sg13cmos5l_decap_8
* cell instance sg13cmos5l_decap_8_3715 r0 *1 0,0
Xsg13cmos5l_decap_8_3715 \$2 \$1 sg13cmos5l_decap_8
* cell instance sg13cmos5l_decap_8_3716 r0 *1 0,0
Xsg13cmos5l_decap_8_3716 \$2 \$1 sg13cmos5l_decap_8
* cell instance sg13cmos5l_decap_8_3717 r0 *1 0,0
Xsg13cmos5l_decap_8_3717 \$2 \$1 sg13cmos5l_decap_8
* cell instance sg13cmos5l_decap_8_3718 r0 *1 0,0
Xsg13cmos5l_decap_8_3718 \$2 \$1 sg13cmos5l_decap_8
* cell instance sg13cmos5l_decap_8_3719 r0 *1 0,0
Xsg13cmos5l_decap_8_3719 \$2 \$1 sg13cmos5l_decap_8
* cell instance sg13cmos5l_decap_8_3720 r0 *1 0,0
Xsg13cmos5l_decap_8_3720 \$2 \$1 sg13cmos5l_decap_8
* cell instance sg13cmos5l_decap_8_3721 r0 *1 0,0
Xsg13cmos5l_decap_8_3721 \$2 \$1 sg13cmos5l_decap_8
* cell instance sg13cmos5l_decap_8_3722 r0 *1 0,0
Xsg13cmos5l_decap_8_3722 \$2 \$1 sg13cmos5l_decap_8
* cell instance sg13cmos5l_decap_8_3723 r0 *1 0,0
Xsg13cmos5l_decap_8_3723 \$2 \$1 sg13cmos5l_decap_8
* cell instance sg13cmos5l_decap_8_3724 r0 *1 0,0
Xsg13cmos5l_decap_8_3724 \$2 \$1 sg13cmos5l_decap_8
* cell instance sg13cmos5l_decap_8_3725 r0 *1 0,0
Xsg13cmos5l_decap_8_3725 \$2 \$1 sg13cmos5l_decap_8
* cell instance sg13cmos5l_decap_8_3726 r0 *1 0,0
Xsg13cmos5l_decap_8_3726 \$2 \$1 sg13cmos5l_decap_8
* cell instance sg13cmos5l_decap_8_3727 r0 *1 0,0
Xsg13cmos5l_decap_8_3727 \$2 \$1 sg13cmos5l_decap_8
* cell instance sg13cmos5l_decap_8_3728 r0 *1 0,0
Xsg13cmos5l_decap_8_3728 \$2 \$1 sg13cmos5l_decap_8
* cell instance sg13cmos5l_decap_8_3729 r0 *1 0,0
Xsg13cmos5l_decap_8_3729 \$2 \$1 sg13cmos5l_decap_8
* cell instance sg13cmos5l_decap_8_3730 r0 *1 0,0
Xsg13cmos5l_decap_8_3730 \$2 \$1 sg13cmos5l_decap_8
* cell instance sg13cmos5l_decap_8_3731 r0 *1 0,0
Xsg13cmos5l_decap_8_3731 \$2 \$1 sg13cmos5l_decap_8
* cell instance sg13cmos5l_decap_8_3732 r0 *1 0,0
Xsg13cmos5l_decap_8_3732 \$2 \$1 sg13cmos5l_decap_8
* cell instance sg13cmos5l_decap_8_3733 r0 *1 0,0
Xsg13cmos5l_decap_8_3733 \$2 \$1 sg13cmos5l_decap_8
* cell instance sg13cmos5l_decap_8_3734 r0 *1 0,0
Xsg13cmos5l_decap_8_3734 \$2 \$1 sg13cmos5l_decap_8
* cell instance sg13cmos5l_decap_8_3735 r0 *1 0,0
Xsg13cmos5l_decap_8_3735 \$2 \$1 sg13cmos5l_decap_8
* cell instance sg13cmos5l_decap_8_3736 r0 *1 0,0
Xsg13cmos5l_decap_8_3736 \$2 \$1 sg13cmos5l_decap_8
* cell instance sg13cmos5l_decap_8_3737 r0 *1 0,0
Xsg13cmos5l_decap_8_3737 \$2 \$1 sg13cmos5l_decap_8
* cell instance sg13cmos5l_decap_8_3738 r0 *1 0,0
Xsg13cmos5l_decap_8_3738 \$2 \$1 sg13cmos5l_decap_8
* cell instance sg13cmos5l_decap_8_3739 r0 *1 0,0
Xsg13cmos5l_decap_8_3739 \$2 \$1 sg13cmos5l_decap_8
* cell instance sg13cmos5l_decap_8_3740 r0 *1 0,0
Xsg13cmos5l_decap_8_3740 \$2 \$1 sg13cmos5l_decap_8
* cell instance sg13cmos5l_decap_8_3741 r0 *1 0,0
Xsg13cmos5l_decap_8_3741 \$2 \$1 sg13cmos5l_decap_8
* cell instance sg13cmos5l_decap_8_3742 r0 *1 0,0
Xsg13cmos5l_decap_8_3742 \$2 \$1 sg13cmos5l_decap_8
* cell instance sg13cmos5l_decap_8_3743 r0 *1 0,0
Xsg13cmos5l_decap_8_3743 \$2 \$1 sg13cmos5l_decap_8
* cell instance sg13cmos5l_decap_8_3744 r0 *1 0,0
Xsg13cmos5l_decap_8_3744 \$2 \$1 sg13cmos5l_decap_8
* cell instance sg13cmos5l_decap_8_3745 r0 *1 0,0
Xsg13cmos5l_decap_8_3745 \$2 \$1 sg13cmos5l_decap_8
* cell instance sg13cmos5l_decap_8_3746 r0 *1 0,0
Xsg13cmos5l_decap_8_3746 \$2 \$1 sg13cmos5l_decap_8
* cell instance sg13cmos5l_decap_8_3747 r0 *1 0,0
Xsg13cmos5l_decap_8_3747 \$2 \$1 sg13cmos5l_decap_8
* cell instance sg13cmos5l_decap_8_3748 r0 *1 0,0
Xsg13cmos5l_decap_8_3748 \$2 \$1 sg13cmos5l_decap_8
* cell instance sg13cmos5l_decap_8_3749 r0 *1 0,0
Xsg13cmos5l_decap_8_3749 \$2 \$1 sg13cmos5l_decap_8
* cell instance sg13cmos5l_decap_8_3750 r0 *1 0,0
Xsg13cmos5l_decap_8_3750 \$2 \$1 sg13cmos5l_decap_8
* cell instance sg13cmos5l_decap_8_3751 r0 *1 0,0
Xsg13cmos5l_decap_8_3751 \$2 \$1 sg13cmos5l_decap_8
* cell instance sg13cmos5l_decap_8_3752 r0 *1 0,0
Xsg13cmos5l_decap_8_3752 \$2 \$1 sg13cmos5l_decap_8
* cell instance sg13cmos5l_decap_8_3753 r0 *1 0,0
Xsg13cmos5l_decap_8_3753 \$2 \$1 sg13cmos5l_decap_8
* cell instance sg13cmos5l_decap_8_3754 r0 *1 0,0
Xsg13cmos5l_decap_8_3754 \$2 \$1 sg13cmos5l_decap_8
* cell instance sg13cmos5l_decap_8_3755 r0 *1 0,0
Xsg13cmos5l_decap_8_3755 \$2 \$1 sg13cmos5l_decap_8
* cell instance sg13cmos5l_decap_8_3756 r0 *1 0,0
Xsg13cmos5l_decap_8_3756 \$2 \$1 sg13cmos5l_decap_8
* cell instance sg13cmos5l_decap_8_3757 r0 *1 0,0
Xsg13cmos5l_decap_8_3757 \$2 \$1 sg13cmos5l_decap_8
* cell instance sg13cmos5l_decap_8_3758 r0 *1 0,0
Xsg13cmos5l_decap_8_3758 \$2 \$1 sg13cmos5l_decap_8
* cell instance sg13cmos5l_decap_8_3759 r0 *1 0,0
Xsg13cmos5l_decap_8_3759 \$2 \$1 sg13cmos5l_decap_8
* cell instance sg13cmos5l_decap_8_3760 r0 *1 0,0
Xsg13cmos5l_decap_8_3760 \$2 \$1 sg13cmos5l_decap_8
* cell instance sg13cmos5l_decap_8_3761 r0 *1 0,0
Xsg13cmos5l_decap_8_3761 \$2 \$1 sg13cmos5l_decap_8
* cell instance sg13cmos5l_decap_8_3762 r0 *1 0,0
Xsg13cmos5l_decap_8_3762 \$2 \$1 sg13cmos5l_decap_8
* cell instance sg13cmos5l_decap_8_3763 r0 *1 0,0
Xsg13cmos5l_decap_8_3763 \$2 \$1 sg13cmos5l_decap_8
* cell instance sg13cmos5l_decap_8_3764 r0 *1 0,0
Xsg13cmos5l_decap_8_3764 \$2 \$1 sg13cmos5l_decap_8
* cell instance sg13cmos5l_decap_8_3765 r0 *1 0,0
Xsg13cmos5l_decap_8_3765 \$2 \$1 sg13cmos5l_decap_8
* cell instance sg13cmos5l_decap_8_3766 r0 *1 0,0
Xsg13cmos5l_decap_8_3766 \$2 \$1 sg13cmos5l_decap_8
* cell instance sg13cmos5l_decap_8_3767 r0 *1 0,0
Xsg13cmos5l_decap_8_3767 \$2 \$1 sg13cmos5l_decap_8
* cell instance sg13cmos5l_decap_8_3768 r0 *1 0,0
Xsg13cmos5l_decap_8_3768 \$2 \$1 sg13cmos5l_decap_8
* cell instance sg13cmos5l_decap_8_3769 r0 *1 0,0
Xsg13cmos5l_decap_8_3769 \$2 \$1 sg13cmos5l_decap_8
* cell instance sg13cmos5l_decap_8_3770 r0 *1 0,0
Xsg13cmos5l_decap_8_3770 \$2 \$1 sg13cmos5l_decap_8
* cell instance sg13cmos5l_decap_8_3771 r0 *1 0,0
Xsg13cmos5l_decap_8_3771 \$2 \$1 sg13cmos5l_decap_8
* cell instance sg13cmos5l_decap_8_3772 r0 *1 0,0
Xsg13cmos5l_decap_8_3772 \$2 \$1 sg13cmos5l_decap_8
* cell instance sg13cmos5l_decap_8_3773 r0 *1 0,0
Xsg13cmos5l_decap_8_3773 \$2 \$1 sg13cmos5l_decap_8
* cell instance sg13cmos5l_decap_8_3774 r0 *1 0,0
Xsg13cmos5l_decap_8_3774 \$2 \$1 sg13cmos5l_decap_8
* cell instance sg13cmos5l_decap_8_3775 r0 *1 0,0
Xsg13cmos5l_decap_8_3775 \$2 \$1 sg13cmos5l_decap_8
* cell instance sg13cmos5l_decap_8_3776 r0 *1 0,0
Xsg13cmos5l_decap_8_3776 \$2 \$1 sg13cmos5l_decap_8
* cell instance sg13cmos5l_decap_8_3777 r0 *1 0,0
Xsg13cmos5l_decap_8_3777 \$2 \$1 sg13cmos5l_decap_8
* cell instance sg13cmos5l_decap_8_3778 r0 *1 0,0
Xsg13cmos5l_decap_8_3778 \$2 \$1 sg13cmos5l_decap_8
* cell instance sg13cmos5l_decap_8_3779 r0 *1 0,0
Xsg13cmos5l_decap_8_3779 \$2 \$1 sg13cmos5l_decap_8
* cell instance sg13cmos5l_decap_8_3780 r0 *1 0,0
Xsg13cmos5l_decap_8_3780 \$2 \$1 sg13cmos5l_decap_8
* cell instance sg13cmos5l_decap_8_3781 r0 *1 0,0
Xsg13cmos5l_decap_8_3781 \$2 \$1 sg13cmos5l_decap_8
* cell instance sg13cmos5l_decap_8_3782 r0 *1 0,0
Xsg13cmos5l_decap_8_3782 \$2 \$1 sg13cmos5l_decap_8
* cell instance sg13cmos5l_decap_8_3783 r0 *1 0,0
Xsg13cmos5l_decap_8_3783 \$2 \$1 sg13cmos5l_decap_8
* cell instance sg13cmos5l_decap_8_3784 r0 *1 0,0
Xsg13cmos5l_decap_8_3784 \$2 \$1 sg13cmos5l_decap_8
* cell instance sg13cmos5l_decap_8_3785 r0 *1 0,0
Xsg13cmos5l_decap_8_3785 \$2 \$1 sg13cmos5l_decap_8
* cell instance sg13cmos5l_decap_8_3786 r0 *1 0,0
Xsg13cmos5l_decap_8_3786 \$2 \$1 sg13cmos5l_decap_8
* cell instance sg13cmos5l_decap_8_3787 r0 *1 0,0
Xsg13cmos5l_decap_8_3787 \$2 \$1 sg13cmos5l_decap_8
* cell instance sg13cmos5l_decap_8_3788 r0 *1 0,0
Xsg13cmos5l_decap_8_3788 \$2 \$1 sg13cmos5l_decap_8
* cell instance sg13cmos5l_decap_8_3789 r0 *1 0,0
Xsg13cmos5l_decap_8_3789 \$2 \$1 sg13cmos5l_decap_8
* cell instance sg13cmos5l_decap_8_3790 r0 *1 0,0
Xsg13cmos5l_decap_8_3790 \$2 \$1 sg13cmos5l_decap_8
* cell instance sg13cmos5l_decap_8_3791 r0 *1 0,0
Xsg13cmos5l_decap_8_3791 \$2 \$1 sg13cmos5l_decap_8
* cell instance sg13cmos5l_decap_8_3792 r0 *1 0,0
Xsg13cmos5l_decap_8_3792 \$2 \$1 sg13cmos5l_decap_8
* cell instance sg13cmos5l_decap_8_3793 r0 *1 0,0
Xsg13cmos5l_decap_8_3793 \$2 \$1 sg13cmos5l_decap_8
* cell instance sg13cmos5l_decap_8_3794 r0 *1 0,0
Xsg13cmos5l_decap_8_3794 \$2 \$1 sg13cmos5l_decap_8
* cell instance sg13cmos5l_decap_8_3795 r0 *1 0,0
Xsg13cmos5l_decap_8_3795 \$2 \$1 sg13cmos5l_decap_8
* cell instance sg13cmos5l_decap_8_3796 r0 *1 0,0
Xsg13cmos5l_decap_8_3796 \$2 \$1 sg13cmos5l_decap_8
* cell instance sg13cmos5l_decap_8_3797 r0 *1 0,0
Xsg13cmos5l_decap_8_3797 \$2 \$1 sg13cmos5l_decap_8
* cell instance sg13cmos5l_decap_8_3798 r0 *1 0,0
Xsg13cmos5l_decap_8_3798 \$2 \$1 sg13cmos5l_decap_8
* cell instance sg13cmos5l_decap_8_3799 r0 *1 0,0
Xsg13cmos5l_decap_8_3799 \$2 \$1 sg13cmos5l_decap_8
* cell instance sg13cmos5l_decap_8_3800 r0 *1 0,0
Xsg13cmos5l_decap_8_3800 \$2 \$1 sg13cmos5l_decap_8
* cell instance sg13cmos5l_decap_8_3801 r0 *1 0,0
Xsg13cmos5l_decap_8_3801 \$2 \$1 sg13cmos5l_decap_8
* cell instance sg13cmos5l_decap_8_3802 r0 *1 0,0
Xsg13cmos5l_decap_8_3802 \$2 \$1 sg13cmos5l_decap_8
* cell instance sg13cmos5l_decap_8_3803 r0 *1 0,0
Xsg13cmos5l_decap_8_3803 \$2 \$1 sg13cmos5l_decap_8
* cell instance sg13cmos5l_decap_8_3804 r0 *1 0,0
Xsg13cmos5l_decap_8_3804 \$2 \$1 sg13cmos5l_decap_8
* cell instance sg13cmos5l_decap_8_3805 r0 *1 0,0
Xsg13cmos5l_decap_8_3805 \$2 \$1 sg13cmos5l_decap_8
* cell instance sg13cmos5l_decap_8_3806 r0 *1 0,0
Xsg13cmos5l_decap_8_3806 \$2 \$1 sg13cmos5l_decap_8
* cell instance sg13cmos5l_decap_8_3807 r0 *1 0,0
Xsg13cmos5l_decap_8_3807 \$2 \$1 sg13cmos5l_decap_8
* cell instance sg13cmos5l_decap_8_3808 r0 *1 0,0
Xsg13cmos5l_decap_8_3808 \$2 \$1 sg13cmos5l_decap_8
* cell instance sg13cmos5l_decap_8_3809 r0 *1 0,0
Xsg13cmos5l_decap_8_3809 \$2 \$1 sg13cmos5l_decap_8
* cell instance sg13cmos5l_decap_8_3810 r0 *1 0,0
Xsg13cmos5l_decap_8_3810 \$2 \$1 sg13cmos5l_decap_8
* cell instance sg13cmos5l_decap_8_3811 r0 *1 0,0
Xsg13cmos5l_decap_8_3811 \$2 \$1 sg13cmos5l_decap_8
* cell instance sg13cmos5l_decap_8_3812 r0 *1 0,0
Xsg13cmos5l_decap_8_3812 \$2 \$1 sg13cmos5l_decap_8
* cell instance sg13cmos5l_decap_8_3813 r0 *1 0,0
Xsg13cmos5l_decap_8_3813 \$2 \$1 sg13cmos5l_decap_8
* cell instance sg13cmos5l_decap_8_3814 r0 *1 0,0
Xsg13cmos5l_decap_8_3814 \$2 \$1 sg13cmos5l_decap_8
* cell instance sg13cmos5l_decap_8_3815 r0 *1 0,0
Xsg13cmos5l_decap_8_3815 \$2 \$1 sg13cmos5l_decap_8
* cell instance sg13cmos5l_decap_8_3816 r0 *1 0,0
Xsg13cmos5l_decap_8_3816 \$2 \$1 sg13cmos5l_decap_8
* cell instance sg13cmos5l_decap_8_3817 r0 *1 0,0
Xsg13cmos5l_decap_8_3817 \$2 \$1 sg13cmos5l_decap_8
* cell instance sg13cmos5l_decap_8_3818 r0 *1 0,0
Xsg13cmos5l_decap_8_3818 \$2 \$1 sg13cmos5l_decap_8
* cell instance sg13cmos5l_decap_8_3819 r0 *1 0,0
Xsg13cmos5l_decap_8_3819 \$2 \$1 sg13cmos5l_decap_8
* cell instance sg13cmos5l_decap_8_3820 r0 *1 0,0
Xsg13cmos5l_decap_8_3820 \$2 \$1 sg13cmos5l_decap_8
* cell instance sg13cmos5l_decap_8_3821 r0 *1 0,0
Xsg13cmos5l_decap_8_3821 \$2 \$1 sg13cmos5l_decap_8
* cell instance sg13cmos5l_decap_8_3822 r0 *1 0,0
Xsg13cmos5l_decap_8_3822 \$2 \$1 sg13cmos5l_decap_8
* cell instance sg13cmos5l_decap_8_3823 r0 *1 0,0
Xsg13cmos5l_decap_8_3823 \$2 \$1 sg13cmos5l_decap_8
* cell instance sg13cmos5l_decap_8_3824 r0 *1 0,0
Xsg13cmos5l_decap_8_3824 \$2 \$1 sg13cmos5l_decap_8
* cell instance sg13cmos5l_decap_8_3825 r0 *1 0,0
Xsg13cmos5l_decap_8_3825 \$2 \$1 sg13cmos5l_decap_8
* cell instance sg13cmos5l_decap_8_3826 r0 *1 0,0
Xsg13cmos5l_decap_8_3826 \$2 \$1 sg13cmos5l_decap_8
* cell instance sg13cmos5l_decap_8_3827 r0 *1 0,0
Xsg13cmos5l_decap_8_3827 \$2 \$1 sg13cmos5l_decap_8
* cell instance sg13cmos5l_decap_8_3828 r0 *1 0,0
Xsg13cmos5l_decap_8_3828 \$2 \$1 sg13cmos5l_decap_8
* cell instance sg13cmos5l_decap_8_3829 r0 *1 0,0
Xsg13cmos5l_decap_8_3829 \$2 \$1 sg13cmos5l_decap_8
* cell instance sg13cmos5l_decap_8_3830 r0 *1 0,0
Xsg13cmos5l_decap_8_3830 \$2 \$1 sg13cmos5l_decap_8
* cell instance sg13cmos5l_decap_8_3831 r0 *1 0,0
Xsg13cmos5l_decap_8_3831 \$2 \$1 sg13cmos5l_decap_8
* cell instance sg13cmos5l_decap_8_3832 r0 *1 0,0
Xsg13cmos5l_decap_8_3832 \$2 \$1 sg13cmos5l_decap_8
* cell instance sg13cmos5l_decap_8_3833 r0 *1 0,0
Xsg13cmos5l_decap_8_3833 \$2 \$1 sg13cmos5l_decap_8
* cell instance sg13cmos5l_decap_8_3834 r0 *1 0,0
Xsg13cmos5l_decap_8_3834 \$2 \$1 sg13cmos5l_decap_8
* cell instance sg13cmos5l_decap_8_3835 r0 *1 0,0
Xsg13cmos5l_decap_8_3835 \$2 \$1 sg13cmos5l_decap_8
* cell instance sg13cmos5l_decap_8_3836 r0 *1 0,0
Xsg13cmos5l_decap_8_3836 \$2 \$1 sg13cmos5l_decap_8
* cell instance sg13cmos5l_decap_8_3837 r0 *1 0,0
Xsg13cmos5l_decap_8_3837 \$2 \$1 sg13cmos5l_decap_8
* cell instance sg13cmos5l_decap_8_3838 r0 *1 0,0
Xsg13cmos5l_decap_8_3838 \$2 \$1 sg13cmos5l_decap_8
* cell instance sg13cmos5l_decap_8_3839 r0 *1 0,0
Xsg13cmos5l_decap_8_3839 \$2 \$1 sg13cmos5l_decap_8
* cell instance sg13cmos5l_decap_8_3840 r0 *1 0,0
Xsg13cmos5l_decap_8_3840 \$2 \$1 sg13cmos5l_decap_8
* cell instance sg13cmos5l_decap_8_3841 r0 *1 0,0
Xsg13cmos5l_decap_8_3841 \$2 \$1 sg13cmos5l_decap_8
* cell instance sg13cmos5l_decap_8_3842 r0 *1 0,0
Xsg13cmos5l_decap_8_3842 \$2 \$1 sg13cmos5l_decap_8
* cell instance sg13cmos5l_decap_8_3843 r0 *1 0,0
Xsg13cmos5l_decap_8_3843 \$2 \$1 sg13cmos5l_decap_8
* cell instance sg13cmos5l_decap_8_3844 r0 *1 0,0
Xsg13cmos5l_decap_8_3844 \$2 \$1 sg13cmos5l_decap_8
* cell instance sg13cmos5l_decap_8_3845 r0 *1 0,0
Xsg13cmos5l_decap_8_3845 \$2 \$1 sg13cmos5l_decap_8
* cell instance sg13cmos5l_decap_8_3846 r0 *1 0,0
Xsg13cmos5l_decap_8_3846 \$2 \$1 sg13cmos5l_decap_8
* cell instance sg13cmos5l_decap_8_3847 r0 *1 0,0
Xsg13cmos5l_decap_8_3847 \$2 \$1 sg13cmos5l_decap_8
* cell instance sg13cmos5l_decap_8_3848 r0 *1 0,0
Xsg13cmos5l_decap_8_3848 \$2 \$1 sg13cmos5l_decap_8
* cell instance sg13cmos5l_decap_8_3849 r0 *1 0,0
Xsg13cmos5l_decap_8_3849 \$2 \$1 sg13cmos5l_decap_8
* cell instance sg13cmos5l_decap_8_3850 r0 *1 0,0
Xsg13cmos5l_decap_8_3850 \$2 \$1 sg13cmos5l_decap_8
* cell instance sg13cmos5l_decap_8_3851 r0 *1 0,0
Xsg13cmos5l_decap_8_3851 \$2 \$1 sg13cmos5l_decap_8
* cell instance sg13cmos5l_decap_8_3852 r0 *1 0,0
Xsg13cmos5l_decap_8_3852 \$2 \$1 sg13cmos5l_decap_8
* cell instance sg13cmos5l_decap_8_3853 r0 *1 0,0
Xsg13cmos5l_decap_8_3853 \$2 \$1 sg13cmos5l_decap_8
* cell instance sg13cmos5l_decap_8_3854 r0 *1 0,0
Xsg13cmos5l_decap_8_3854 \$2 \$1 sg13cmos5l_decap_8
* cell instance sg13cmos5l_decap_8_3855 r0 *1 0,0
Xsg13cmos5l_decap_8_3855 \$2 \$1 sg13cmos5l_decap_8
* cell instance sg13cmos5l_decap_8_3856 r0 *1 0,0
Xsg13cmos5l_decap_8_3856 \$2 \$1 sg13cmos5l_decap_8
* cell instance sg13cmos5l_decap_8_3857 r0 *1 0,0
Xsg13cmos5l_decap_8_3857 \$2 \$1 sg13cmos5l_decap_8
* cell instance sg13cmos5l_decap_8_3858 r0 *1 0,0
Xsg13cmos5l_decap_8_3858 \$2 \$1 sg13cmos5l_decap_8
* cell instance sg13cmos5l_decap_8_3859 r0 *1 0,0
Xsg13cmos5l_decap_8_3859 \$2 \$1 sg13cmos5l_decap_8
* cell instance sg13cmos5l_decap_8_3860 r0 *1 0,0
Xsg13cmos5l_decap_8_3860 \$2 \$1 sg13cmos5l_decap_8
* cell instance sg13cmos5l_decap_8_3861 r0 *1 0,0
Xsg13cmos5l_decap_8_3861 \$2 \$1 sg13cmos5l_decap_8
* cell instance sg13cmos5l_decap_8_3862 r0 *1 0,0
Xsg13cmos5l_decap_8_3862 \$2 \$1 sg13cmos5l_decap_8
* cell instance sg13cmos5l_decap_8_3863 r0 *1 0,0
Xsg13cmos5l_decap_8_3863 \$2 \$1 sg13cmos5l_decap_8
* cell instance sg13cmos5l_decap_8_3864 r0 *1 0,0
Xsg13cmos5l_decap_8_3864 \$2 \$1 sg13cmos5l_decap_8
* cell instance sg13cmos5l_decap_8_3865 r0 *1 0,0
Xsg13cmos5l_decap_8_3865 \$2 \$1 sg13cmos5l_decap_8
* cell instance sg13cmos5l_decap_8_3866 r0 *1 0,0
Xsg13cmos5l_decap_8_3866 \$2 \$1 sg13cmos5l_decap_8
* cell instance sg13cmos5l_decap_8_3867 r0 *1 0,0
Xsg13cmos5l_decap_8_3867 \$2 \$1 sg13cmos5l_decap_8
* cell instance sg13cmos5l_decap_8_3868 r0 *1 0,0
Xsg13cmos5l_decap_8_3868 \$2 \$1 sg13cmos5l_decap_8
* cell instance sg13cmos5l_decap_8_3869 r0 *1 0,0
Xsg13cmos5l_decap_8_3869 \$2 \$1 sg13cmos5l_decap_8
* cell instance sg13cmos5l_decap_8_3870 r0 *1 0,0
Xsg13cmos5l_decap_8_3870 \$2 \$1 sg13cmos5l_decap_8
* cell instance sg13cmos5l_decap_8_3871 r0 *1 0,0
Xsg13cmos5l_decap_8_3871 \$2 \$1 sg13cmos5l_decap_8
* cell instance sg13cmos5l_decap_8_3872 r0 *1 0,0
Xsg13cmos5l_decap_8_3872 \$2 \$1 sg13cmos5l_decap_8
* cell instance sg13cmos5l_decap_8_3873 r0 *1 0,0
Xsg13cmos5l_decap_8_3873 \$2 \$1 sg13cmos5l_decap_8
* cell instance sg13cmos5l_decap_8_3874 r0 *1 0,0
Xsg13cmos5l_decap_8_3874 \$2 \$1 sg13cmos5l_decap_8
* cell instance sg13cmos5l_decap_8_3875 r0 *1 0,0
Xsg13cmos5l_decap_8_3875 \$2 \$1 sg13cmos5l_decap_8
* cell instance sg13cmos5l_decap_8_3876 r0 *1 0,0
Xsg13cmos5l_decap_8_3876 \$2 \$1 sg13cmos5l_decap_8
* cell instance sg13cmos5l_decap_8_3877 r0 *1 0,0
Xsg13cmos5l_decap_8_3877 \$2 \$1 sg13cmos5l_decap_8
* cell instance sg13cmos5l_decap_8_3878 r0 *1 0,0
Xsg13cmos5l_decap_8_3878 \$2 \$1 sg13cmos5l_decap_8
* cell instance sg13cmos5l_decap_8_3879 r0 *1 0,0
Xsg13cmos5l_decap_8_3879 \$2 \$1 sg13cmos5l_decap_8
* cell instance sg13cmos5l_decap_8_3880 r0 *1 0,0
Xsg13cmos5l_decap_8_3880 \$2 \$1 sg13cmos5l_decap_8
* cell instance sg13cmos5l_decap_8_3881 r0 *1 0,0
Xsg13cmos5l_decap_8_3881 \$2 \$1 sg13cmos5l_decap_8
* cell instance sg13cmos5l_decap_8_3882 r0 *1 0,0
Xsg13cmos5l_decap_8_3882 \$2 \$1 sg13cmos5l_decap_8
* cell instance sg13cmos5l_decap_8_3883 r0 *1 0,0
Xsg13cmos5l_decap_8_3883 \$2 \$1 sg13cmos5l_decap_8
* cell instance sg13cmos5l_decap_8_3884 r0 *1 0,0
Xsg13cmos5l_decap_8_3884 \$2 \$1 sg13cmos5l_decap_8
* cell instance sg13cmos5l_decap_8_3885 r0 *1 0,0
Xsg13cmos5l_decap_8_3885 \$2 \$1 sg13cmos5l_decap_8
* cell instance sg13cmos5l_decap_8_3886 r0 *1 0,0
Xsg13cmos5l_decap_8_3886 \$2 \$1 sg13cmos5l_decap_8
* cell instance sg13cmos5l_decap_8_3887 r0 *1 0,0
Xsg13cmos5l_decap_8_3887 \$2 \$1 sg13cmos5l_decap_8
* cell instance sg13cmos5l_decap_8_3888 r0 *1 0,0
Xsg13cmos5l_decap_8_3888 \$2 \$1 sg13cmos5l_decap_8
* cell instance sg13cmos5l_decap_8_3889 r0 *1 0,0
Xsg13cmos5l_decap_8_3889 \$2 \$1 sg13cmos5l_decap_8
* cell instance sg13cmos5l_decap_8_3890 r0 *1 0,0
Xsg13cmos5l_decap_8_3890 \$2 \$1 sg13cmos5l_decap_8
* cell instance sg13cmos5l_decap_8_3891 r0 *1 0,0
Xsg13cmos5l_decap_8_3891 \$2 \$1 sg13cmos5l_decap_8
* cell instance sg13cmos5l_decap_8_3892 r0 *1 0,0
Xsg13cmos5l_decap_8_3892 \$2 \$1 sg13cmos5l_decap_8
* cell instance sg13cmos5l_decap_8_3893 r0 *1 0,0
Xsg13cmos5l_decap_8_3893 \$2 \$1 sg13cmos5l_decap_8
* cell instance sg13cmos5l_decap_8_3894 r0 *1 0,0
Xsg13cmos5l_decap_8_3894 \$2 \$1 sg13cmos5l_decap_8
* cell instance sg13cmos5l_decap_8_3895 r0 *1 0,0
Xsg13cmos5l_decap_8_3895 \$2 \$1 sg13cmos5l_decap_8
* cell instance sg13cmos5l_decap_8_3896 r0 *1 0,0
Xsg13cmos5l_decap_8_3896 \$2 \$1 sg13cmos5l_decap_8
* cell instance sg13cmos5l_decap_8_3897 r0 *1 0,0
Xsg13cmos5l_decap_8_3897 \$2 \$1 sg13cmos5l_decap_8
* cell instance sg13cmos5l_decap_8_3898 r0 *1 0,0
Xsg13cmos5l_decap_8_3898 \$2 \$1 sg13cmos5l_decap_8
* cell instance sg13cmos5l_decap_8_3899 r0 *1 0,0
Xsg13cmos5l_decap_8_3899 \$2 \$1 sg13cmos5l_decap_8
* cell instance sg13cmos5l_decap_8_3900 r0 *1 0,0
Xsg13cmos5l_decap_8_3900 \$2 \$1 sg13cmos5l_decap_8
* cell instance sg13cmos5l_decap_8_3901 r0 *1 0,0
Xsg13cmos5l_decap_8_3901 \$2 \$1 sg13cmos5l_decap_8
* cell instance sg13cmos5l_decap_8_3902 r0 *1 0,0
Xsg13cmos5l_decap_8_3902 \$2 \$1 sg13cmos5l_decap_8
* cell instance sg13cmos5l_decap_8_3903 r0 *1 0,0
Xsg13cmos5l_decap_8_3903 \$2 \$1 sg13cmos5l_decap_8
* cell instance sg13cmos5l_decap_8_3904 r0 *1 0,0
Xsg13cmos5l_decap_8_3904 \$2 \$1 sg13cmos5l_decap_8
* cell instance sg13cmos5l_decap_8_3905 r0 *1 0,0
Xsg13cmos5l_decap_8_3905 \$2 \$1 sg13cmos5l_decap_8
* cell instance sg13cmos5l_decap_8_3906 r0 *1 0,0
Xsg13cmos5l_decap_8_3906 \$2 \$1 sg13cmos5l_decap_8
* cell instance sg13cmos5l_decap_8_3907 r0 *1 0,0
Xsg13cmos5l_decap_8_3907 \$2 \$1 sg13cmos5l_decap_8
* cell instance sg13cmos5l_decap_8_3908 r0 *1 0,0
Xsg13cmos5l_decap_8_3908 \$2 \$1 sg13cmos5l_decap_8
* cell instance sg13cmos5l_decap_8_3909 r0 *1 0,0
Xsg13cmos5l_decap_8_3909 \$2 \$1 sg13cmos5l_decap_8
* cell instance sg13cmos5l_decap_8_3910 r0 *1 0,0
Xsg13cmos5l_decap_8_3910 \$2 \$1 sg13cmos5l_decap_8
* cell instance sg13cmos5l_decap_8_3911 r0 *1 0,0
Xsg13cmos5l_decap_8_3911 \$2 \$1 sg13cmos5l_decap_8
* cell instance sg13cmos5l_decap_8_3912 r0 *1 0,0
Xsg13cmos5l_decap_8_3912 \$2 \$1 sg13cmos5l_decap_8
* cell instance sg13cmos5l_decap_8_3913 r0 *1 0,0
Xsg13cmos5l_decap_8_3913 \$2 \$1 sg13cmos5l_decap_8
* cell instance sg13cmos5l_decap_8_3914 r0 *1 0,0
Xsg13cmos5l_decap_8_3914 \$2 \$1 sg13cmos5l_decap_8
* cell instance sg13cmos5l_decap_8_3915 r0 *1 0,0
Xsg13cmos5l_decap_8_3915 \$2 \$1 sg13cmos5l_decap_8
* cell instance sg13cmos5l_decap_8_3916 r0 *1 0,0
Xsg13cmos5l_decap_8_3916 \$2 \$1 sg13cmos5l_decap_8
* cell instance sg13cmos5l_decap_8_3917 r0 *1 0,0
Xsg13cmos5l_decap_8_3917 \$2 \$1 sg13cmos5l_decap_8
* cell instance sg13cmos5l_decap_8_3918 r0 *1 0,0
Xsg13cmos5l_decap_8_3918 \$2 \$1 sg13cmos5l_decap_8
* cell instance sg13cmos5l_decap_8_3919 r0 *1 0,0
Xsg13cmos5l_decap_8_3919 \$2 \$1 sg13cmos5l_decap_8
* cell instance sg13cmos5l_decap_8_3920 r0 *1 0,0
Xsg13cmos5l_decap_8_3920 \$2 \$1 sg13cmos5l_decap_8
* cell instance sg13cmos5l_decap_8_3921 r0 *1 0,0
Xsg13cmos5l_decap_8_3921 \$2 \$1 sg13cmos5l_decap_8
* cell instance sg13cmos5l_decap_8_3922 r0 *1 0,0
Xsg13cmos5l_decap_8_3922 \$2 \$1 sg13cmos5l_decap_8
* cell instance sg13cmos5l_decap_8_3923 r0 *1 0,0
Xsg13cmos5l_decap_8_3923 \$2 \$1 sg13cmos5l_decap_8
* cell instance sg13cmos5l_decap_8_3924 r0 *1 0,0
Xsg13cmos5l_decap_8_3924 \$2 \$1 sg13cmos5l_decap_8
* cell instance sg13cmos5l_decap_8_3925 r0 *1 0,0
Xsg13cmos5l_decap_8_3925 \$2 \$1 sg13cmos5l_decap_8
* cell instance sg13cmos5l_decap_8_3926 r0 *1 0,0
Xsg13cmos5l_decap_8_3926 \$2 \$1 sg13cmos5l_decap_8
* cell instance sg13cmos5l_decap_8_3927 r0 *1 0,0
Xsg13cmos5l_decap_8_3927 \$2 \$1 sg13cmos5l_decap_8
* cell instance sg13cmos5l_decap_8_3928 r0 *1 0,0
Xsg13cmos5l_decap_8_3928 \$2 \$1 sg13cmos5l_decap_8
* cell instance sg13cmos5l_decap_8_3929 r0 *1 0,0
Xsg13cmos5l_decap_8_3929 \$2 \$1 sg13cmos5l_decap_8
* cell instance sg13cmos5l_decap_8_3930 r0 *1 0,0
Xsg13cmos5l_decap_8_3930 \$2 \$1 sg13cmos5l_decap_8
* cell instance sg13cmos5l_decap_8_3931 r0 *1 0,0
Xsg13cmos5l_decap_8_3931 \$2 \$1 sg13cmos5l_decap_8
* cell instance sg13cmos5l_decap_8_3932 r0 *1 0,0
Xsg13cmos5l_decap_8_3932 \$2 \$1 sg13cmos5l_decap_8
* cell instance sg13cmos5l_decap_8_3933 r0 *1 0,0
Xsg13cmos5l_decap_8_3933 \$2 \$1 sg13cmos5l_decap_8
* cell instance sg13cmos5l_decap_8_3934 r0 *1 0,0
Xsg13cmos5l_decap_8_3934 \$2 \$1 sg13cmos5l_decap_8
* cell instance sg13cmos5l_decap_8_3935 r0 *1 0,0
Xsg13cmos5l_decap_8_3935 \$2 \$1 sg13cmos5l_decap_8
* cell instance sg13cmos5l_decap_8_3936 r0 *1 0,0
Xsg13cmos5l_decap_8_3936 \$2 \$1 sg13cmos5l_decap_8
* cell instance sg13cmos5l_decap_8_3937 r0 *1 0,0
Xsg13cmos5l_decap_8_3937 \$2 \$1 sg13cmos5l_decap_8
* cell instance sg13cmos5l_decap_8_3938 r0 *1 0,0
Xsg13cmos5l_decap_8_3938 \$2 \$1 sg13cmos5l_decap_8
* cell instance sg13cmos5l_decap_8_3939 r0 *1 0,0
Xsg13cmos5l_decap_8_3939 \$2 \$1 sg13cmos5l_decap_8
* cell instance sg13cmos5l_decap_8_3940 r0 *1 0,0
Xsg13cmos5l_decap_8_3940 \$2 \$1 sg13cmos5l_decap_8
* cell instance sg13cmos5l_decap_8_3941 r0 *1 0,0
Xsg13cmos5l_decap_8_3941 \$2 \$1 sg13cmos5l_decap_8
* cell instance sg13cmos5l_decap_8_3942 r0 *1 0,0
Xsg13cmos5l_decap_8_3942 \$2 \$1 sg13cmos5l_decap_8
* cell instance sg13cmos5l_decap_8_3943 r0 *1 0,0
Xsg13cmos5l_decap_8_3943 \$2 \$1 sg13cmos5l_decap_8
* cell instance sg13cmos5l_decap_8_3944 r0 *1 0,0
Xsg13cmos5l_decap_8_3944 \$2 \$1 sg13cmos5l_decap_8
* cell instance sg13cmos5l_decap_8_3945 r0 *1 0,0
Xsg13cmos5l_decap_8_3945 \$2 \$1 sg13cmos5l_decap_8
* cell instance sg13cmos5l_decap_8_3946 r0 *1 0,0
Xsg13cmos5l_decap_8_3946 \$2 \$1 sg13cmos5l_decap_8
* cell instance sg13cmos5l_decap_8_3947 r0 *1 0,0
Xsg13cmos5l_decap_8_3947 \$2 \$1 sg13cmos5l_decap_8
* cell instance sg13cmos5l_decap_8_3948 r0 *1 0,0
Xsg13cmos5l_decap_8_3948 \$2 \$1 sg13cmos5l_decap_8
* cell instance sg13cmos5l_decap_8_3949 r0 *1 0,0
Xsg13cmos5l_decap_8_3949 \$2 \$1 sg13cmos5l_decap_8
* cell instance sg13cmos5l_decap_8_3950 r0 *1 0,0
Xsg13cmos5l_decap_8_3950 \$2 \$1 sg13cmos5l_decap_8
* cell instance sg13cmos5l_decap_8_3951 r0 *1 0,0
Xsg13cmos5l_decap_8_3951 \$2 \$1 sg13cmos5l_decap_8
* cell instance sg13cmos5l_decap_8_3952 r0 *1 0,0
Xsg13cmos5l_decap_8_3952 \$2 \$1 sg13cmos5l_decap_8
* cell instance sg13cmos5l_decap_8_3953 r0 *1 0,0
Xsg13cmos5l_decap_8_3953 \$2 \$1 sg13cmos5l_decap_8
* cell instance sg13cmos5l_decap_8_3954 r0 *1 0,0
Xsg13cmos5l_decap_8_3954 \$2 \$1 sg13cmos5l_decap_8
* cell instance sg13cmos5l_decap_8_3955 r0 *1 0,0
Xsg13cmos5l_decap_8_3955 \$2 \$1 sg13cmos5l_decap_8
* cell instance sg13cmos5l_decap_8_3956 r0 *1 0,0
Xsg13cmos5l_decap_8_3956 \$2 \$1 sg13cmos5l_decap_8
* cell instance sg13cmos5l_decap_8_3957 r0 *1 0,0
Xsg13cmos5l_decap_8_3957 \$2 \$1 sg13cmos5l_decap_8
* cell instance sg13cmos5l_decap_8_3958 r0 *1 0,0
Xsg13cmos5l_decap_8_3958 \$2 \$1 sg13cmos5l_decap_8
* cell instance sg13cmos5l_decap_8_3959 r0 *1 0,0
Xsg13cmos5l_decap_8_3959 \$2 \$1 sg13cmos5l_decap_8
* cell instance sg13cmos5l_decap_8_3960 r0 *1 0,0
Xsg13cmos5l_decap_8_3960 \$2 \$1 sg13cmos5l_decap_8
* cell instance sg13cmos5l_decap_8_3961 r0 *1 0,0
Xsg13cmos5l_decap_8_3961 \$2 \$1 sg13cmos5l_decap_8
* cell instance sg13cmos5l_decap_8_3962 r0 *1 0,0
Xsg13cmos5l_decap_8_3962 \$2 \$1 sg13cmos5l_decap_8
* cell instance sg13cmos5l_decap_8_3963 r0 *1 0,0
Xsg13cmos5l_decap_8_3963 \$2 \$1 sg13cmos5l_decap_8
* cell instance sg13cmos5l_decap_8_3964 r0 *1 0,0
Xsg13cmos5l_decap_8_3964 \$2 \$1 sg13cmos5l_decap_8
* cell instance sg13cmos5l_decap_8_3965 r0 *1 0,0
Xsg13cmos5l_decap_8_3965 \$2 \$1 sg13cmos5l_decap_8
* cell instance sg13cmos5l_decap_8_3966 r0 *1 0,0
Xsg13cmos5l_decap_8_3966 \$2 \$1 sg13cmos5l_decap_8
* cell instance sg13cmos5l_decap_8_3967 r0 *1 0,0
Xsg13cmos5l_decap_8_3967 \$2 \$1 sg13cmos5l_decap_8
* cell instance sg13cmos5l_decap_8_3968 r0 *1 0,0
Xsg13cmos5l_decap_8_3968 \$2 \$1 sg13cmos5l_decap_8
* cell instance sg13cmos5l_decap_8_3969 r0 *1 0,0
Xsg13cmos5l_decap_8_3969 \$2 \$1 sg13cmos5l_decap_8
* cell instance sg13cmos5l_decap_8_3970 r0 *1 0,0
Xsg13cmos5l_decap_8_3970 \$2 \$1 sg13cmos5l_decap_8
* cell instance sg13cmos5l_decap_8_3971 r0 *1 0,0
Xsg13cmos5l_decap_8_3971 \$2 \$1 sg13cmos5l_decap_8
* cell instance sg13cmos5l_decap_8_3972 r0 *1 0,0
Xsg13cmos5l_decap_8_3972 \$2 \$1 sg13cmos5l_decap_8
* cell instance sg13cmos5l_decap_8_3973 r0 *1 0,0
Xsg13cmos5l_decap_8_3973 \$2 \$1 sg13cmos5l_decap_8
* cell instance sg13cmos5l_decap_8_3974 r0 *1 0,0
Xsg13cmos5l_decap_8_3974 \$2 \$1 sg13cmos5l_decap_8
* cell instance sg13cmos5l_decap_8_3975 r0 *1 0,0
Xsg13cmos5l_decap_8_3975 \$2 \$1 sg13cmos5l_decap_8
* cell instance sg13cmos5l_decap_8_3976 r0 *1 0,0
Xsg13cmos5l_decap_8_3976 \$2 \$1 sg13cmos5l_decap_8
* cell instance sg13cmos5l_decap_8_3977 r0 *1 0,0
Xsg13cmos5l_decap_8_3977 \$2 \$1 sg13cmos5l_decap_8
* cell instance sg13cmos5l_decap_8_3978 r0 *1 0,0
Xsg13cmos5l_decap_8_3978 \$2 \$1 sg13cmos5l_decap_8
* cell instance sg13cmos5l_decap_8_3979 r0 *1 0,0
Xsg13cmos5l_decap_8_3979 \$2 \$1 sg13cmos5l_decap_8
* cell instance sg13cmos5l_decap_8_3980 r0 *1 0,0
Xsg13cmos5l_decap_8_3980 \$2 \$1 sg13cmos5l_decap_8
* cell instance sg13cmos5l_decap_8_3981 r0 *1 0,0
Xsg13cmos5l_decap_8_3981 \$2 \$1 sg13cmos5l_decap_8
* cell instance sg13cmos5l_decap_8_3982 r0 *1 0,0
Xsg13cmos5l_decap_8_3982 \$2 \$1 sg13cmos5l_decap_8
* cell instance sg13cmos5l_decap_8_3983 r0 *1 0,0
Xsg13cmos5l_decap_8_3983 \$2 \$1 sg13cmos5l_decap_8
* cell instance sg13cmos5l_decap_8_3984 r0 *1 0,0
Xsg13cmos5l_decap_8_3984 \$2 \$1 sg13cmos5l_decap_8
* cell instance sg13cmos5l_decap_8_3985 r0 *1 0,0
Xsg13cmos5l_decap_8_3985 \$2 \$1 sg13cmos5l_decap_8
* cell instance sg13cmos5l_decap_8_3986 r0 *1 0,0
Xsg13cmos5l_decap_8_3986 \$2 \$1 sg13cmos5l_decap_8
* cell instance sg13cmos5l_decap_8_3987 r0 *1 0,0
Xsg13cmos5l_decap_8_3987 \$2 \$1 sg13cmos5l_decap_8
* cell instance sg13cmos5l_decap_8_3988 r0 *1 0,0
Xsg13cmos5l_decap_8_3988 \$2 \$1 sg13cmos5l_decap_8
* cell instance sg13cmos5l_decap_8_3989 r0 *1 0,0
Xsg13cmos5l_decap_8_3989 \$2 \$1 sg13cmos5l_decap_8
* cell instance sg13cmos5l_decap_8_3990 r0 *1 0,0
Xsg13cmos5l_decap_8_3990 \$2 \$1 sg13cmos5l_decap_8
* cell instance sg13cmos5l_decap_8_3991 r0 *1 0,0
Xsg13cmos5l_decap_8_3991 \$2 \$1 sg13cmos5l_decap_8
* cell instance sg13cmos5l_decap_8_3992 r0 *1 0,0
Xsg13cmos5l_decap_8_3992 \$2 \$1 sg13cmos5l_decap_8
* cell instance sg13cmos5l_decap_8_3993 r0 *1 0,0
Xsg13cmos5l_decap_8_3993 \$2 \$1 sg13cmos5l_decap_8
* cell instance sg13cmos5l_decap_8_3994 r0 *1 0,0
Xsg13cmos5l_decap_8_3994 \$2 \$1 sg13cmos5l_decap_8
* cell instance sg13cmos5l_decap_8_3995 r0 *1 0,0
Xsg13cmos5l_decap_8_3995 \$2 \$1 sg13cmos5l_decap_8
* cell instance sg13cmos5l_decap_8_3996 r0 *1 0,0
Xsg13cmos5l_decap_8_3996 \$2 \$1 sg13cmos5l_decap_8
* cell instance sg13cmos5l_decap_8_3997 r0 *1 0,0
Xsg13cmos5l_decap_8_3997 \$2 \$1 sg13cmos5l_decap_8
* cell instance sg13cmos5l_decap_8_3998 r0 *1 0,0
Xsg13cmos5l_decap_8_3998 \$2 \$1 sg13cmos5l_decap_8
* cell instance sg13cmos5l_decap_8_3999 r0 *1 0,0
Xsg13cmos5l_decap_8_3999 \$2 \$1 sg13cmos5l_decap_8
* cell instance sg13cmos5l_decap_8_4000 r0 *1 0,0
Xsg13cmos5l_decap_8_4000 \$2 \$1 sg13cmos5l_decap_8
* cell instance sg13cmos5l_decap_8_4001 r0 *1 0,0
Xsg13cmos5l_decap_8_4001 \$2 \$1 sg13cmos5l_decap_8
* cell instance sg13cmos5l_decap_8_4002 r0 *1 0,0
Xsg13cmos5l_decap_8_4002 \$2 \$1 sg13cmos5l_decap_8
* cell instance sg13cmos5l_decap_8_4003 r0 *1 0,0
Xsg13cmos5l_decap_8_4003 \$2 \$1 sg13cmos5l_decap_8
* cell instance sg13cmos5l_decap_8_4004 r0 *1 0,0
Xsg13cmos5l_decap_8_4004 \$2 \$1 sg13cmos5l_decap_8
* cell instance sg13cmos5l_decap_8_4005 r0 *1 0,0
Xsg13cmos5l_decap_8_4005 \$2 \$1 sg13cmos5l_decap_8
* cell instance sg13cmos5l_decap_8_4006 r0 *1 0,0
Xsg13cmos5l_decap_8_4006 \$2 \$1 sg13cmos5l_decap_8
* cell instance sg13cmos5l_decap_8_4007 r0 *1 0,0
Xsg13cmos5l_decap_8_4007 \$2 \$1 sg13cmos5l_decap_8
* cell instance sg13cmos5l_decap_8_4008 r0 *1 0,0
Xsg13cmos5l_decap_8_4008 \$2 \$1 sg13cmos5l_decap_8
* cell instance sg13cmos5l_decap_8_4009 r0 *1 0,0
Xsg13cmos5l_decap_8_4009 \$2 \$1 sg13cmos5l_decap_8
* cell instance sg13cmos5l_decap_8_4010 r0 *1 0,0
Xsg13cmos5l_decap_8_4010 \$2 \$1 sg13cmos5l_decap_8
* cell instance sg13cmos5l_decap_8_4011 r0 *1 0,0
Xsg13cmos5l_decap_8_4011 \$2 \$1 sg13cmos5l_decap_8
* cell instance sg13cmos5l_decap_8_4012 r0 *1 0,0
Xsg13cmos5l_decap_8_4012 \$2 \$1 sg13cmos5l_decap_8
* cell instance sg13cmos5l_decap_8_4013 r0 *1 0,0
Xsg13cmos5l_decap_8_4013 \$2 \$1 sg13cmos5l_decap_8
* cell instance sg13cmos5l_decap_8_4014 r0 *1 0,0
Xsg13cmos5l_decap_8_4014 \$2 \$1 sg13cmos5l_decap_8
* cell instance sg13cmos5l_decap_8_4015 r0 *1 0,0
Xsg13cmos5l_decap_8_4015 \$2 \$1 sg13cmos5l_decap_8
* cell instance sg13cmos5l_decap_8_4016 r0 *1 0,0
Xsg13cmos5l_decap_8_4016 \$2 \$1 sg13cmos5l_decap_8
* cell instance sg13cmos5l_decap_8_4017 r0 *1 0,0
Xsg13cmos5l_decap_8_4017 \$2 \$1 sg13cmos5l_decap_8
* cell instance sg13cmos5l_decap_8_4018 r0 *1 0,0
Xsg13cmos5l_decap_8_4018 \$2 \$1 sg13cmos5l_decap_8
* cell instance sg13cmos5l_decap_8_4019 r0 *1 0,0
Xsg13cmos5l_decap_8_4019 \$2 \$1 sg13cmos5l_decap_8
* cell instance sg13cmos5l_decap_8_4020 r0 *1 0,0
Xsg13cmos5l_decap_8_4020 \$2 \$1 sg13cmos5l_decap_8
* cell instance sg13cmos5l_decap_8_4021 r0 *1 0,0
Xsg13cmos5l_decap_8_4021 \$2 \$1 sg13cmos5l_decap_8
* cell instance sg13cmos5l_decap_8_4022 r0 *1 0,0
Xsg13cmos5l_decap_8_4022 \$2 \$1 sg13cmos5l_decap_8
* cell instance sg13cmos5l_decap_8_4023 r0 *1 0,0
Xsg13cmos5l_decap_8_4023 \$2 \$1 sg13cmos5l_decap_8
* cell instance sg13cmos5l_decap_8_4024 r0 *1 0,0
Xsg13cmos5l_decap_8_4024 \$2 \$1 sg13cmos5l_decap_8
* cell instance sg13cmos5l_decap_8_4025 r0 *1 0,0
Xsg13cmos5l_decap_8_4025 \$2 \$1 sg13cmos5l_decap_8
* cell instance sg13cmos5l_decap_8_4026 r0 *1 0,0
Xsg13cmos5l_decap_8_4026 \$2 \$1 sg13cmos5l_decap_8
* cell instance sg13cmos5l_decap_8_4027 r0 *1 0,0
Xsg13cmos5l_decap_8_4027 \$2 \$1 sg13cmos5l_decap_8
* cell instance sg13cmos5l_decap_8_4028 r0 *1 0,0
Xsg13cmos5l_decap_8_4028 \$2 \$1 sg13cmos5l_decap_8
* cell instance sg13cmos5l_decap_8_4029 r0 *1 0,0
Xsg13cmos5l_decap_8_4029 \$2 \$1 sg13cmos5l_decap_8
* cell instance sg13cmos5l_decap_8_4030 r0 *1 0,0
Xsg13cmos5l_decap_8_4030 \$2 \$1 sg13cmos5l_decap_8
* cell instance sg13cmos5l_decap_8_4031 r0 *1 0,0
Xsg13cmos5l_decap_8_4031 \$2 \$1 sg13cmos5l_decap_8
* cell instance sg13cmos5l_decap_8_4032 r0 *1 0,0
Xsg13cmos5l_decap_8_4032 \$2 \$1 sg13cmos5l_decap_8
* cell instance sg13cmos5l_decap_8_4033 r0 *1 0,0
Xsg13cmos5l_decap_8_4033 \$2 \$1 sg13cmos5l_decap_8
* cell instance sg13cmos5l_decap_8_4034 r0 *1 0,0
Xsg13cmos5l_decap_8_4034 \$2 \$1 sg13cmos5l_decap_8
* cell instance sg13cmos5l_decap_8_4035 r0 *1 0,0
Xsg13cmos5l_decap_8_4035 \$2 \$1 sg13cmos5l_decap_8
* cell instance sg13cmos5l_decap_8_4036 r0 *1 0,0
Xsg13cmos5l_decap_8_4036 \$2 \$1 sg13cmos5l_decap_8
* cell instance sg13cmos5l_decap_8_4037 r0 *1 0,0
Xsg13cmos5l_decap_8_4037 \$2 \$1 sg13cmos5l_decap_8
* cell instance sg13cmos5l_decap_8_4038 r0 *1 0,0
Xsg13cmos5l_decap_8_4038 \$2 \$1 sg13cmos5l_decap_8
* cell instance sg13cmos5l_decap_8_4039 r0 *1 0,0
Xsg13cmos5l_decap_8_4039 \$2 \$1 sg13cmos5l_decap_8
* cell instance sg13cmos5l_decap_8_4040 r0 *1 0,0
Xsg13cmos5l_decap_8_4040 \$2 \$1 sg13cmos5l_decap_8
* cell instance sg13cmos5l_decap_8_4041 r0 *1 0,0
Xsg13cmos5l_decap_8_4041 \$2 \$1 sg13cmos5l_decap_8
* cell instance sg13cmos5l_decap_8_4042 r0 *1 0,0
Xsg13cmos5l_decap_8_4042 \$2 \$1 sg13cmos5l_decap_8
* cell instance sg13cmos5l_decap_8_4043 r0 *1 0,0
Xsg13cmos5l_decap_8_4043 \$2 \$1 sg13cmos5l_decap_8
* cell instance sg13cmos5l_decap_8_4044 r0 *1 0,0
Xsg13cmos5l_decap_8_4044 \$2 \$1 sg13cmos5l_decap_8
* cell instance sg13cmos5l_decap_8_4045 r0 *1 0,0
Xsg13cmos5l_decap_8_4045 \$2 \$1 sg13cmos5l_decap_8
* cell instance sg13cmos5l_decap_8_4046 r0 *1 0,0
Xsg13cmos5l_decap_8_4046 \$2 \$1 sg13cmos5l_decap_8
* cell instance sg13cmos5l_decap_8_4047 r0 *1 0,0
Xsg13cmos5l_decap_8_4047 \$2 \$1 sg13cmos5l_decap_8
* cell instance sg13cmos5l_decap_8_4048 r0 *1 0,0
Xsg13cmos5l_decap_8_4048 \$2 \$1 sg13cmos5l_decap_8
* cell instance sg13cmos5l_decap_8_4049 r0 *1 0,0
Xsg13cmos5l_decap_8_4049 \$2 \$1 sg13cmos5l_decap_8
* cell instance sg13cmos5l_decap_8_4050 r0 *1 0,0
Xsg13cmos5l_decap_8_4050 \$2 \$1 sg13cmos5l_decap_8
* cell instance sg13cmos5l_decap_8_4051 r0 *1 0,0
Xsg13cmos5l_decap_8_4051 \$2 \$1 sg13cmos5l_decap_8
* cell instance sg13cmos5l_decap_8_4052 r0 *1 0,0
Xsg13cmos5l_decap_8_4052 \$2 \$1 sg13cmos5l_decap_8
* cell instance sg13cmos5l_decap_8_4053 r0 *1 0,0
Xsg13cmos5l_decap_8_4053 \$2 \$1 sg13cmos5l_decap_8
* cell instance sg13cmos5l_decap_8_4054 r0 *1 0,0
Xsg13cmos5l_decap_8_4054 \$2 \$1 sg13cmos5l_decap_8
* cell instance sg13cmos5l_decap_8_4055 r0 *1 0,0
Xsg13cmos5l_decap_8_4055 \$2 \$1 sg13cmos5l_decap_8
* cell instance sg13cmos5l_decap_8_4056 r0 *1 0,0
Xsg13cmos5l_decap_8_4056 \$2 \$1 sg13cmos5l_decap_8
* cell instance sg13cmos5l_decap_8_4057 r0 *1 0,0
Xsg13cmos5l_decap_8_4057 \$2 \$1 sg13cmos5l_decap_8
* cell instance sg13cmos5l_decap_8_4058 r0 *1 0,0
Xsg13cmos5l_decap_8_4058 \$2 \$1 sg13cmos5l_decap_8
* cell instance sg13cmos5l_decap_8_4059 r0 *1 0,0
Xsg13cmos5l_decap_8_4059 \$2 \$1 sg13cmos5l_decap_8
* cell instance sg13cmos5l_decap_8_4060 r0 *1 0,0
Xsg13cmos5l_decap_8_4060 \$2 \$1 sg13cmos5l_decap_8
* cell instance sg13cmos5l_decap_8_4061 r0 *1 0,0
Xsg13cmos5l_decap_8_4061 \$2 \$1 sg13cmos5l_decap_8
* cell instance sg13cmos5l_decap_8_4062 r0 *1 0,0
Xsg13cmos5l_decap_8_4062 \$2 \$1 sg13cmos5l_decap_8
* cell instance sg13cmos5l_decap_8_4063 r0 *1 0,0
Xsg13cmos5l_decap_8_4063 \$2 \$1 sg13cmos5l_decap_8
* cell instance sg13cmos5l_decap_8_4064 r0 *1 0,0
Xsg13cmos5l_decap_8_4064 \$2 \$1 sg13cmos5l_decap_8
* cell instance sg13cmos5l_decap_8_4065 r0 *1 0,0
Xsg13cmos5l_decap_8_4065 \$2 \$1 sg13cmos5l_decap_8
* cell instance sg13cmos5l_decap_8_4066 r0 *1 0,0
Xsg13cmos5l_decap_8_4066 \$2 \$1 sg13cmos5l_decap_8
* cell instance sg13cmos5l_decap_8_4067 r0 *1 0,0
Xsg13cmos5l_decap_8_4067 \$2 \$1 sg13cmos5l_decap_8
* cell instance sg13cmos5l_decap_8_4068 r0 *1 0,0
Xsg13cmos5l_decap_8_4068 \$2 \$1 sg13cmos5l_decap_8
* cell instance sg13cmos5l_decap_8_4069 r0 *1 0,0
Xsg13cmos5l_decap_8_4069 \$2 \$1 sg13cmos5l_decap_8
* cell instance sg13cmos5l_decap_8_4070 r0 *1 0,0
Xsg13cmos5l_decap_8_4070 \$2 \$1 sg13cmos5l_decap_8
* cell instance sg13cmos5l_decap_8_4071 r0 *1 0,0
Xsg13cmos5l_decap_8_4071 \$2 \$1 sg13cmos5l_decap_8
* cell instance sg13cmos5l_decap_8_4072 r0 *1 0,0
Xsg13cmos5l_decap_8_4072 \$2 \$1 sg13cmos5l_decap_8
* cell instance sg13cmos5l_decap_8_4073 r0 *1 0,0
Xsg13cmos5l_decap_8_4073 \$2 \$1 sg13cmos5l_decap_8
* cell instance sg13cmos5l_decap_8_4074 r0 *1 0,0
Xsg13cmos5l_decap_8_4074 \$2 \$1 sg13cmos5l_decap_8
* cell instance sg13cmos5l_decap_8_4075 r0 *1 0,0
Xsg13cmos5l_decap_8_4075 \$2 \$1 sg13cmos5l_decap_8
* cell instance sg13cmos5l_decap_8_4076 r0 *1 0,0
Xsg13cmos5l_decap_8_4076 \$2 \$1 sg13cmos5l_decap_8
* cell instance sg13cmos5l_decap_8_4077 r0 *1 0,0
Xsg13cmos5l_decap_8_4077 \$2 \$1 sg13cmos5l_decap_8
* cell instance sg13cmos5l_decap_8_4078 r0 *1 0,0
Xsg13cmos5l_decap_8_4078 \$2 \$1 sg13cmos5l_decap_8
* cell instance sg13cmos5l_decap_8_4079 r0 *1 0,0
Xsg13cmos5l_decap_8_4079 \$2 \$1 sg13cmos5l_decap_8
* cell instance sg13cmos5l_decap_8_4080 r0 *1 0,0
Xsg13cmos5l_decap_8_4080 \$2 \$1 sg13cmos5l_decap_8
* cell instance sg13cmos5l_decap_8_4081 r0 *1 0,0
Xsg13cmos5l_decap_8_4081 \$2 \$1 sg13cmos5l_decap_8
* cell instance sg13cmos5l_decap_8_4082 r0 *1 0,0
Xsg13cmos5l_decap_8_4082 \$2 \$1 sg13cmos5l_decap_8
* cell instance sg13cmos5l_decap_8_4083 r0 *1 0,0
Xsg13cmos5l_decap_8_4083 \$2 \$1 sg13cmos5l_decap_8
* cell instance sg13cmos5l_decap_8_4084 r0 *1 0,0
Xsg13cmos5l_decap_8_4084 \$2 \$1 sg13cmos5l_decap_8
* cell instance sg13cmos5l_decap_8_4085 r0 *1 0,0
Xsg13cmos5l_decap_8_4085 \$2 \$1 sg13cmos5l_decap_8
* cell instance sg13cmos5l_decap_8_4086 r0 *1 0,0
Xsg13cmos5l_decap_8_4086 \$2 \$1 sg13cmos5l_decap_8
* cell instance sg13cmos5l_decap_8_4087 r0 *1 0,0
Xsg13cmos5l_decap_8_4087 \$2 \$1 sg13cmos5l_decap_8
* cell instance sg13cmos5l_decap_8_4088 r0 *1 0,0
Xsg13cmos5l_decap_8_4088 \$2 \$1 sg13cmos5l_decap_8
* cell instance sg13cmos5l_decap_8_4089 r0 *1 0,0
Xsg13cmos5l_decap_8_4089 \$2 \$1 sg13cmos5l_decap_8
* cell instance sg13cmos5l_decap_8_4090 r0 *1 0,0
Xsg13cmos5l_decap_8_4090 \$2 \$1 sg13cmos5l_decap_8
* cell instance sg13cmos5l_decap_8_4091 r0 *1 0,0
Xsg13cmos5l_decap_8_4091 \$2 \$1 sg13cmos5l_decap_8
* cell instance sg13cmos5l_decap_8_4092 r0 *1 0,0
Xsg13cmos5l_decap_8_4092 \$2 \$1 sg13cmos5l_decap_8
* cell instance sg13cmos5l_decap_8_4093 r0 *1 0,0
Xsg13cmos5l_decap_8_4093 \$2 \$1 sg13cmos5l_decap_8
* cell instance sg13cmos5l_decap_8_4094 r0 *1 0,0
Xsg13cmos5l_decap_8_4094 \$2 \$1 sg13cmos5l_decap_8
* cell instance sg13cmos5l_decap_8_4095 r0 *1 0,0
Xsg13cmos5l_decap_8_4095 \$2 \$1 sg13cmos5l_decap_8
* cell instance sg13cmos5l_decap_8_4096 r0 *1 0,0
Xsg13cmos5l_decap_8_4096 \$2 \$1 sg13cmos5l_decap_8
* cell instance sg13cmos5l_decap_8_4097 r0 *1 0,0
Xsg13cmos5l_decap_8_4097 \$2 \$1 sg13cmos5l_decap_8
* cell instance sg13cmos5l_decap_8_4098 r0 *1 0,0
Xsg13cmos5l_decap_8_4098 \$2 \$1 sg13cmos5l_decap_8
* cell instance sg13cmos5l_decap_8_4099 r0 *1 0,0
Xsg13cmos5l_decap_8_4099 \$2 \$1 sg13cmos5l_decap_8
* cell instance sg13cmos5l_decap_8_4100 r0 *1 0,0
Xsg13cmos5l_decap_8_4100 \$2 \$1 sg13cmos5l_decap_8
* cell instance sg13cmos5l_decap_8_4101 r0 *1 0,0
Xsg13cmos5l_decap_8_4101 \$2 \$1 sg13cmos5l_decap_8
* cell instance sg13cmos5l_decap_8_4102 r0 *1 0,0
Xsg13cmos5l_decap_8_4102 \$2 \$1 sg13cmos5l_decap_8
* cell instance sg13cmos5l_decap_8_4103 r0 *1 0,0
Xsg13cmos5l_decap_8_4103 \$2 \$1 sg13cmos5l_decap_8
* cell instance sg13cmos5l_decap_8_4104 r0 *1 0,0
Xsg13cmos5l_decap_8_4104 \$2 \$1 sg13cmos5l_decap_8
* cell instance sg13cmos5l_decap_8_4105 r0 *1 0,0
Xsg13cmos5l_decap_8_4105 \$2 \$1 sg13cmos5l_decap_8
* cell instance sg13cmos5l_decap_8_4106 r0 *1 0,0
Xsg13cmos5l_decap_8_4106 \$2 \$1 sg13cmos5l_decap_8
* cell instance sg13cmos5l_decap_8_4107 r0 *1 0,0
Xsg13cmos5l_decap_8_4107 \$2 \$1 sg13cmos5l_decap_8
* cell instance sg13cmos5l_decap_8_4108 r0 *1 0,0
Xsg13cmos5l_decap_8_4108 \$2 \$1 sg13cmos5l_decap_8
* cell instance sg13cmos5l_decap_8_4109 r0 *1 0,0
Xsg13cmos5l_decap_8_4109 \$2 \$1 sg13cmos5l_decap_8
* cell instance sg13cmos5l_decap_8_4110 r0 *1 0,0
Xsg13cmos5l_decap_8_4110 \$2 \$1 sg13cmos5l_decap_8
* cell instance sg13cmos5l_decap_8_4111 r0 *1 0,0
Xsg13cmos5l_decap_8_4111 \$2 \$1 sg13cmos5l_decap_8
* cell instance sg13cmos5l_decap_8_4112 r0 *1 0,0
Xsg13cmos5l_decap_8_4112 \$2 \$1 sg13cmos5l_decap_8
* cell instance sg13cmos5l_decap_8_4113 r0 *1 0,0
Xsg13cmos5l_decap_8_4113 \$2 \$1 sg13cmos5l_decap_8
* cell instance sg13cmos5l_decap_8_4114 r0 *1 0,0
Xsg13cmos5l_decap_8_4114 \$2 \$1 sg13cmos5l_decap_8
* cell instance sg13cmos5l_decap_8_4115 r0 *1 0,0
Xsg13cmos5l_decap_8_4115 \$2 \$1 sg13cmos5l_decap_8
* cell instance sg13cmos5l_decap_8_4116 r0 *1 0,0
Xsg13cmos5l_decap_8_4116 \$2 \$1 sg13cmos5l_decap_8
* cell instance sg13cmos5l_decap_8_4117 r0 *1 0,0
Xsg13cmos5l_decap_8_4117 \$2 \$1 sg13cmos5l_decap_8
* cell instance sg13cmos5l_decap_8_4118 r0 *1 0,0
Xsg13cmos5l_decap_8_4118 \$2 \$1 sg13cmos5l_decap_8
* cell instance sg13cmos5l_decap_8_4119 r0 *1 0,0
Xsg13cmos5l_decap_8_4119 \$2 \$1 sg13cmos5l_decap_8
* cell instance sg13cmos5l_decap_8_4120 r0 *1 0,0
Xsg13cmos5l_decap_8_4120 \$2 \$1 sg13cmos5l_decap_8
* cell instance sg13cmos5l_decap_8_4121 r0 *1 0,0
Xsg13cmos5l_decap_8_4121 \$2 \$1 sg13cmos5l_decap_8
* cell instance sg13cmos5l_decap_8_4122 r0 *1 0,0
Xsg13cmos5l_decap_8_4122 \$2 \$1 sg13cmos5l_decap_8
* cell instance sg13cmos5l_decap_8_4123 r0 *1 0,0
Xsg13cmos5l_decap_8_4123 \$2 \$1 sg13cmos5l_decap_8
* cell instance sg13cmos5l_decap_8_4124 r0 *1 0,0
Xsg13cmos5l_decap_8_4124 \$2 \$1 sg13cmos5l_decap_8
* cell instance sg13cmos5l_decap_8_4125 r0 *1 0,0
Xsg13cmos5l_decap_8_4125 \$2 \$1 sg13cmos5l_decap_8
* cell instance sg13cmos5l_decap_8_4126 r0 *1 0,0
Xsg13cmos5l_decap_8_4126 \$2 \$1 sg13cmos5l_decap_8
* cell instance sg13cmos5l_decap_8_4127 r0 *1 0,0
Xsg13cmos5l_decap_8_4127 \$2 \$1 sg13cmos5l_decap_8
* cell instance sg13cmos5l_decap_8_4128 r0 *1 0,0
Xsg13cmos5l_decap_8_4128 \$2 \$1 sg13cmos5l_decap_8
* cell instance sg13cmos5l_decap_8_4129 r0 *1 0,0
Xsg13cmos5l_decap_8_4129 \$2 \$1 sg13cmos5l_decap_8
* cell instance sg13cmos5l_decap_8_4130 r0 *1 0,0
Xsg13cmos5l_decap_8_4130 \$2 \$1 sg13cmos5l_decap_8
* cell instance sg13cmos5l_decap_8_4131 r0 *1 0,0
Xsg13cmos5l_decap_8_4131 \$2 \$1 sg13cmos5l_decap_8
* cell instance sg13cmos5l_decap_8_4132 r0 *1 0,0
Xsg13cmos5l_decap_8_4132 \$2 \$1 sg13cmos5l_decap_8
* cell instance sg13cmos5l_decap_8_4133 r0 *1 0,0
Xsg13cmos5l_decap_8_4133 \$2 \$1 sg13cmos5l_decap_8
* cell instance sg13cmos5l_decap_8_4134 r0 *1 0,0
Xsg13cmos5l_decap_8_4134 \$2 \$1 sg13cmos5l_decap_8
* cell instance sg13cmos5l_decap_8_4135 r0 *1 0,0
Xsg13cmos5l_decap_8_4135 \$2 \$1 sg13cmos5l_decap_8
* cell instance sg13cmos5l_decap_8_4136 r0 *1 0,0
Xsg13cmos5l_decap_8_4136 \$2 \$1 sg13cmos5l_decap_8
* cell instance sg13cmos5l_decap_8_4137 r0 *1 0,0
Xsg13cmos5l_decap_8_4137 \$2 \$1 sg13cmos5l_decap_8
* cell instance sg13cmos5l_decap_8_4138 r0 *1 0,0
Xsg13cmos5l_decap_8_4138 \$2 \$1 sg13cmos5l_decap_8
* cell instance sg13cmos5l_decap_8_4139 r0 *1 0,0
Xsg13cmos5l_decap_8_4139 \$2 \$1 sg13cmos5l_decap_8
* cell instance sg13cmos5l_decap_8_4140 r0 *1 0,0
Xsg13cmos5l_decap_8_4140 \$2 \$1 sg13cmos5l_decap_8
* cell instance sg13cmos5l_decap_8_4141 r0 *1 0,0
Xsg13cmos5l_decap_8_4141 \$2 \$1 sg13cmos5l_decap_8
* cell instance sg13cmos5l_decap_8_4142 r0 *1 0,0
Xsg13cmos5l_decap_8_4142 \$2 \$1 sg13cmos5l_decap_8
* cell instance sg13cmos5l_decap_8_4143 r0 *1 0,0
Xsg13cmos5l_decap_8_4143 \$2 \$1 sg13cmos5l_decap_8
* cell instance sg13cmos5l_decap_8_4144 r0 *1 0,0
Xsg13cmos5l_decap_8_4144 \$2 \$1 sg13cmos5l_decap_8
* cell instance sg13cmos5l_decap_8_4145 r0 *1 0,0
Xsg13cmos5l_decap_8_4145 \$2 \$1 sg13cmos5l_decap_8
* cell instance sg13cmos5l_decap_8_4146 r0 *1 0,0
Xsg13cmos5l_decap_8_4146 \$2 \$1 sg13cmos5l_decap_8
* cell instance sg13cmos5l_decap_8_4147 r0 *1 0,0
Xsg13cmos5l_decap_8_4147 \$2 \$1 sg13cmos5l_decap_8
* cell instance sg13cmos5l_decap_8_4148 r0 *1 0,0
Xsg13cmos5l_decap_8_4148 \$2 \$1 sg13cmos5l_decap_8
* cell instance sg13cmos5l_decap_8_4149 r0 *1 0,0
Xsg13cmos5l_decap_8_4149 \$2 \$1 sg13cmos5l_decap_8
* cell instance sg13cmos5l_decap_8_4150 r0 *1 0,0
Xsg13cmos5l_decap_8_4150 \$2 \$1 sg13cmos5l_decap_8
* cell instance sg13cmos5l_decap_8_4151 r0 *1 0,0
Xsg13cmos5l_decap_8_4151 \$2 \$1 sg13cmos5l_decap_8
* cell instance sg13cmos5l_decap_8_4152 r0 *1 0,0
Xsg13cmos5l_decap_8_4152 \$2 \$1 sg13cmos5l_decap_8
* cell instance sg13cmos5l_decap_8_4153 r0 *1 0,0
Xsg13cmos5l_decap_8_4153 \$2 \$1 sg13cmos5l_decap_8
* cell instance sg13cmos5l_decap_8_4154 r0 *1 0,0
Xsg13cmos5l_decap_8_4154 \$2 \$1 sg13cmos5l_decap_8
* cell instance sg13cmos5l_decap_8_4155 r0 *1 0,0
Xsg13cmos5l_decap_8_4155 \$2 \$1 sg13cmos5l_decap_8
* cell instance sg13cmos5l_decap_8_4156 r0 *1 0,0
Xsg13cmos5l_decap_8_4156 \$2 \$1 sg13cmos5l_decap_8
* cell instance sg13cmos5l_decap_8_4157 r0 *1 0,0
Xsg13cmos5l_decap_8_4157 \$2 \$1 sg13cmos5l_decap_8
* cell instance sg13cmos5l_decap_8_4158 r0 *1 0,0
Xsg13cmos5l_decap_8_4158 \$2 \$1 sg13cmos5l_decap_8
* cell instance sg13cmos5l_decap_8_4159 r0 *1 0,0
Xsg13cmos5l_decap_8_4159 \$2 \$1 sg13cmos5l_decap_8
* cell instance sg13cmos5l_decap_8_4160 r0 *1 0,0
Xsg13cmos5l_decap_8_4160 \$2 \$1 sg13cmos5l_decap_8
* cell instance sg13cmos5l_decap_8_4161 r0 *1 0,0
Xsg13cmos5l_decap_8_4161 \$2 \$1 sg13cmos5l_decap_8
* cell instance sg13cmos5l_decap_8_4162 r0 *1 0,0
Xsg13cmos5l_decap_8_4162 \$2 \$1 sg13cmos5l_decap_8
* cell instance sg13cmos5l_decap_8_4163 r0 *1 0,0
Xsg13cmos5l_decap_8_4163 \$2 \$1 sg13cmos5l_decap_8
* cell instance sg13cmos5l_decap_8_4164 r0 *1 0,0
Xsg13cmos5l_decap_8_4164 \$2 \$1 sg13cmos5l_decap_8
* cell instance sg13cmos5l_decap_8_4165 r0 *1 0,0
Xsg13cmos5l_decap_8_4165 \$2 \$1 sg13cmos5l_decap_8
* cell instance sg13cmos5l_decap_8_4166 r0 *1 0,0
Xsg13cmos5l_decap_8_4166 \$2 \$1 sg13cmos5l_decap_8
* cell instance sg13cmos5l_decap_8_4167 r0 *1 0,0
Xsg13cmos5l_decap_8_4167 \$2 \$1 sg13cmos5l_decap_8
* cell instance sg13cmos5l_decap_8_4168 r0 *1 0,0
Xsg13cmos5l_decap_8_4168 \$2 \$1 sg13cmos5l_decap_8
* cell instance sg13cmos5l_decap_8_4169 r0 *1 0,0
Xsg13cmos5l_decap_8_4169 \$2 \$1 sg13cmos5l_decap_8
* cell instance sg13cmos5l_decap_8_4170 r0 *1 0,0
Xsg13cmos5l_decap_8_4170 \$2 \$1 sg13cmos5l_decap_8
* cell instance sg13cmos5l_decap_8_4171 r0 *1 0,0
Xsg13cmos5l_decap_8_4171 \$2 \$1 sg13cmos5l_decap_8
* cell instance sg13cmos5l_decap_8_4172 r0 *1 0,0
Xsg13cmos5l_decap_8_4172 \$2 \$1 sg13cmos5l_decap_8
* cell instance sg13cmos5l_decap_8_4173 r0 *1 0,0
Xsg13cmos5l_decap_8_4173 \$2 \$1 sg13cmos5l_decap_8
* cell instance sg13cmos5l_decap_8_4174 r0 *1 0,0
Xsg13cmos5l_decap_8_4174 \$2 \$1 sg13cmos5l_decap_8
* cell instance sg13cmos5l_decap_8_4175 r0 *1 0,0
Xsg13cmos5l_decap_8_4175 \$2 \$1 sg13cmos5l_decap_8
* cell instance sg13cmos5l_decap_8_4176 r0 *1 0,0
Xsg13cmos5l_decap_8_4176 \$2 \$1 sg13cmos5l_decap_8
* cell instance sg13cmos5l_decap_8_4177 r0 *1 0,0
Xsg13cmos5l_decap_8_4177 \$2 \$1 sg13cmos5l_decap_8
* cell instance sg13cmos5l_decap_8_4178 r0 *1 0,0
Xsg13cmos5l_decap_8_4178 \$2 \$1 sg13cmos5l_decap_8
* cell instance sg13cmos5l_decap_8_4179 r0 *1 0,0
Xsg13cmos5l_decap_8_4179 \$2 \$1 sg13cmos5l_decap_8
* cell instance sg13cmos5l_decap_8_4180 r0 *1 0,0
Xsg13cmos5l_decap_8_4180 \$2 \$1 sg13cmos5l_decap_8
* cell instance sg13cmos5l_decap_8_4181 r0 *1 0,0
Xsg13cmos5l_decap_8_4181 \$2 \$1 sg13cmos5l_decap_8
* cell instance sg13cmos5l_decap_8_4182 r0 *1 0,0
Xsg13cmos5l_decap_8_4182 \$2 \$1 sg13cmos5l_decap_8
* cell instance sg13cmos5l_decap_8_4183 r0 *1 0,0
Xsg13cmos5l_decap_8_4183 \$2 \$1 sg13cmos5l_decap_8
* cell instance sg13cmos5l_decap_8_4184 r0 *1 0,0
Xsg13cmos5l_decap_8_4184 \$2 \$1 sg13cmos5l_decap_8
* cell instance sg13cmos5l_decap_8_4185 r0 *1 0,0
Xsg13cmos5l_decap_8_4185 \$2 \$1 sg13cmos5l_decap_8
* cell instance sg13cmos5l_decap_8_4186 r0 *1 0,0
Xsg13cmos5l_decap_8_4186 \$2 \$1 sg13cmos5l_decap_8
* cell instance sg13cmos5l_decap_8_4187 r0 *1 0,0
Xsg13cmos5l_decap_8_4187 \$2 \$1 sg13cmos5l_decap_8
* cell instance sg13cmos5l_decap_8_4188 r0 *1 0,0
Xsg13cmos5l_decap_8_4188 \$2 \$1 sg13cmos5l_decap_8
* cell instance sg13cmos5l_decap_8_4189 r0 *1 0,0
Xsg13cmos5l_decap_8_4189 \$2 \$1 sg13cmos5l_decap_8
* cell instance sg13cmos5l_decap_8_4190 r0 *1 0,0
Xsg13cmos5l_decap_8_4190 \$2 \$1 sg13cmos5l_decap_8
* cell instance sg13cmos5l_decap_8_4191 r0 *1 0,0
Xsg13cmos5l_decap_8_4191 \$2 \$1 sg13cmos5l_decap_8
* cell instance sg13cmos5l_decap_8_4192 r0 *1 0,0
Xsg13cmos5l_decap_8_4192 \$2 \$1 sg13cmos5l_decap_8
* cell instance sg13cmos5l_decap_8_4193 r0 *1 0,0
Xsg13cmos5l_decap_8_4193 \$2 \$1 sg13cmos5l_decap_8
* cell instance sg13cmos5l_decap_8_4194 r0 *1 0,0
Xsg13cmos5l_decap_8_4194 \$2 \$1 sg13cmos5l_decap_8
* cell instance sg13cmos5l_decap_8_4195 r0 *1 0,0
Xsg13cmos5l_decap_8_4195 \$2 \$1 sg13cmos5l_decap_8
* cell instance sg13cmos5l_decap_8_4196 r0 *1 0,0
Xsg13cmos5l_decap_8_4196 \$2 \$1 sg13cmos5l_decap_8
* cell instance sg13cmos5l_decap_8_4197 r0 *1 0,0
Xsg13cmos5l_decap_8_4197 \$2 \$1 sg13cmos5l_decap_8
* cell instance sg13cmos5l_decap_8_4198 r0 *1 0,0
Xsg13cmos5l_decap_8_4198 \$2 \$1 sg13cmos5l_decap_8
* cell instance sg13cmos5l_decap_8_4199 r0 *1 0,0
Xsg13cmos5l_decap_8_4199 \$2 \$1 sg13cmos5l_decap_8
* cell instance sg13cmos5l_decap_8_4200 r0 *1 0,0
Xsg13cmos5l_decap_8_4200 \$2 \$1 sg13cmos5l_decap_8
* cell instance sg13cmos5l_decap_8_4201 r0 *1 0,0
Xsg13cmos5l_decap_8_4201 \$2 \$1 sg13cmos5l_decap_8
* cell instance sg13cmos5l_decap_8_4202 r0 *1 0,0
Xsg13cmos5l_decap_8_4202 \$2 \$1 sg13cmos5l_decap_8
* cell instance sg13cmos5l_decap_8_4203 r0 *1 0,0
Xsg13cmos5l_decap_8_4203 \$2 \$1 sg13cmos5l_decap_8
* cell instance sg13cmos5l_decap_8_4204 r0 *1 0,0
Xsg13cmos5l_decap_8_4204 \$2 \$1 sg13cmos5l_decap_8
* cell instance sg13cmos5l_decap_8_4205 r0 *1 0,0
Xsg13cmos5l_decap_8_4205 \$2 \$1 sg13cmos5l_decap_8
* cell instance sg13cmos5l_decap_8_4206 r0 *1 0,0
Xsg13cmos5l_decap_8_4206 \$2 \$1 sg13cmos5l_decap_8
* cell instance sg13cmos5l_decap_8_4207 r0 *1 0,0
Xsg13cmos5l_decap_8_4207 \$2 \$1 sg13cmos5l_decap_8
* cell instance sg13cmos5l_decap_8_4208 r0 *1 0,0
Xsg13cmos5l_decap_8_4208 \$2 \$1 sg13cmos5l_decap_8
* cell instance sg13cmos5l_decap_8_4209 r0 *1 0,0
Xsg13cmos5l_decap_8_4209 \$2 \$1 sg13cmos5l_decap_8
* cell instance sg13cmos5l_decap_8_4210 r0 *1 0,0
Xsg13cmos5l_decap_8_4210 \$2 \$1 sg13cmos5l_decap_8
* cell instance sg13cmos5l_decap_8_4211 r0 *1 0,0
Xsg13cmos5l_decap_8_4211 \$2 \$1 sg13cmos5l_decap_8
* cell instance sg13cmos5l_decap_8_4212 r0 *1 0,0
Xsg13cmos5l_decap_8_4212 \$2 \$1 sg13cmos5l_decap_8
* cell instance sg13cmos5l_decap_8_4213 r0 *1 0,0
Xsg13cmos5l_decap_8_4213 \$2 \$1 sg13cmos5l_decap_8
* cell instance sg13cmos5l_decap_8_4214 r0 *1 0,0
Xsg13cmos5l_decap_8_4214 \$2 \$1 sg13cmos5l_decap_8
* cell instance sg13cmos5l_decap_8_4215 r0 *1 0,0
Xsg13cmos5l_decap_8_4215 \$2 \$1 sg13cmos5l_decap_8
* cell instance sg13cmos5l_decap_8_4216 r0 *1 0,0
Xsg13cmos5l_decap_8_4216 \$2 \$1 sg13cmos5l_decap_8
* cell instance sg13cmos5l_decap_8_4217 r0 *1 0,0
Xsg13cmos5l_decap_8_4217 \$2 \$1 sg13cmos5l_decap_8
* cell instance sg13cmos5l_decap_8_4218 r0 *1 0,0
Xsg13cmos5l_decap_8_4218 \$2 \$1 sg13cmos5l_decap_8
* cell instance sg13cmos5l_decap_8_4219 r0 *1 0,0
Xsg13cmos5l_decap_8_4219 \$2 \$1 sg13cmos5l_decap_8
* cell instance sg13cmos5l_decap_8_4220 r0 *1 0,0
Xsg13cmos5l_decap_8_4220 \$2 \$1 sg13cmos5l_decap_8
* cell instance sg13cmos5l_decap_8_4221 r0 *1 0,0
Xsg13cmos5l_decap_8_4221 \$2 \$1 sg13cmos5l_decap_8
* cell instance sg13cmos5l_decap_8_4222 r0 *1 0,0
Xsg13cmos5l_decap_8_4222 \$2 \$1 sg13cmos5l_decap_8
* cell instance sg13cmos5l_decap_8_4223 r0 *1 0,0
Xsg13cmos5l_decap_8_4223 \$2 \$1 sg13cmos5l_decap_8
* cell instance sg13cmos5l_decap_8_4224 r0 *1 0,0
Xsg13cmos5l_decap_8_4224 \$2 \$1 sg13cmos5l_decap_8
* cell instance sg13cmos5l_decap_8_4225 r0 *1 0,0
Xsg13cmos5l_decap_8_4225 \$2 \$1 sg13cmos5l_decap_8
* cell instance sg13cmos5l_decap_8_4226 r0 *1 0,0
Xsg13cmos5l_decap_8_4226 \$2 \$1 sg13cmos5l_decap_8
* cell instance sg13cmos5l_decap_8_4227 r0 *1 0,0
Xsg13cmos5l_decap_8_4227 \$2 \$1 sg13cmos5l_decap_8
* cell instance sg13cmos5l_decap_8_4228 r0 *1 0,0
Xsg13cmos5l_decap_8_4228 \$2 \$1 sg13cmos5l_decap_8
* cell instance sg13cmos5l_decap_8_4229 r0 *1 0,0
Xsg13cmos5l_decap_8_4229 \$2 \$1 sg13cmos5l_decap_8
* cell instance sg13cmos5l_decap_8_4230 r0 *1 0,0
Xsg13cmos5l_decap_8_4230 \$2 \$1 sg13cmos5l_decap_8
* cell instance sg13cmos5l_decap_8_4231 r0 *1 0,0
Xsg13cmos5l_decap_8_4231 \$2 \$1 sg13cmos5l_decap_8
* cell instance sg13cmos5l_decap_8_4232 r0 *1 0,0
Xsg13cmos5l_decap_8_4232 \$2 \$1 sg13cmos5l_decap_8
* cell instance sg13cmos5l_decap_8_4233 r0 *1 0,0
Xsg13cmos5l_decap_8_4233 \$2 \$1 sg13cmos5l_decap_8
* cell instance sg13cmos5l_decap_8_4234 r0 *1 0,0
Xsg13cmos5l_decap_8_4234 \$2 \$1 sg13cmos5l_decap_8
* cell instance sg13cmos5l_decap_8_4235 r0 *1 0,0
Xsg13cmos5l_decap_8_4235 \$2 \$1 sg13cmos5l_decap_8
* cell instance sg13cmos5l_decap_8_4236 r0 *1 0,0
Xsg13cmos5l_decap_8_4236 \$2 \$1 sg13cmos5l_decap_8
* cell instance sg13cmos5l_decap_8_4237 r0 *1 0,0
Xsg13cmos5l_decap_8_4237 \$2 \$1 sg13cmos5l_decap_8
* cell instance sg13cmos5l_decap_8_4238 r0 *1 0,0
Xsg13cmos5l_decap_8_4238 \$2 \$1 sg13cmos5l_decap_8
* cell instance sg13cmos5l_decap_8_4239 r0 *1 0,0
Xsg13cmos5l_decap_8_4239 \$2 \$1 sg13cmos5l_decap_8
* cell instance sg13cmos5l_decap_8_4240 r0 *1 0,0
Xsg13cmos5l_decap_8_4240 \$2 \$1 sg13cmos5l_decap_8
* cell instance sg13cmos5l_decap_8_4241 r0 *1 0,0
Xsg13cmos5l_decap_8_4241 \$2 \$1 sg13cmos5l_decap_8
* cell instance sg13cmos5l_decap_8_4242 r0 *1 0,0
Xsg13cmos5l_decap_8_4242 \$2 \$1 sg13cmos5l_decap_8
* cell instance sg13cmos5l_decap_8_4243 r0 *1 0,0
Xsg13cmos5l_decap_8_4243 \$2 \$1 sg13cmos5l_decap_8
* cell instance sg13cmos5l_decap_8_4244 r0 *1 0,0
Xsg13cmos5l_decap_8_4244 \$2 \$1 sg13cmos5l_decap_8
* cell instance sg13cmos5l_decap_8_4245 r0 *1 0,0
Xsg13cmos5l_decap_8_4245 \$2 \$1 sg13cmos5l_decap_8
* cell instance sg13cmos5l_decap_8_4246 r0 *1 0,0
Xsg13cmos5l_decap_8_4246 \$2 \$1 sg13cmos5l_decap_8
* cell instance sg13cmos5l_decap_8_4247 r0 *1 0,0
Xsg13cmos5l_decap_8_4247 \$2 \$1 sg13cmos5l_decap_8
* cell instance sg13cmos5l_decap_8_4248 r0 *1 0,0
Xsg13cmos5l_decap_8_4248 \$2 \$1 sg13cmos5l_decap_8
* cell instance sg13cmos5l_decap_8_4249 r0 *1 0,0
Xsg13cmos5l_decap_8_4249 \$2 \$1 sg13cmos5l_decap_8
* cell instance sg13cmos5l_decap_8_4250 r0 *1 0,0
Xsg13cmos5l_decap_8_4250 \$2 \$1 sg13cmos5l_decap_8
* cell instance sg13cmos5l_decap_8_4251 r0 *1 0,0
Xsg13cmos5l_decap_8_4251 \$2 \$1 sg13cmos5l_decap_8
* cell instance sg13cmos5l_decap_8_4252 r0 *1 0,0
Xsg13cmos5l_decap_8_4252 \$2 \$1 sg13cmos5l_decap_8
* cell instance sg13cmos5l_decap_8_4253 r0 *1 0,0
Xsg13cmos5l_decap_8_4253 \$2 \$1 sg13cmos5l_decap_8
* cell instance sg13cmos5l_decap_8_4254 r0 *1 0,0
Xsg13cmos5l_decap_8_4254 \$2 \$1 sg13cmos5l_decap_8
* cell instance sg13cmos5l_decap_8_4255 r0 *1 0,0
Xsg13cmos5l_decap_8_4255 \$2 \$1 sg13cmos5l_decap_8
* cell instance sg13cmos5l_decap_8_4256 r0 *1 0,0
Xsg13cmos5l_decap_8_4256 \$2 \$1 sg13cmos5l_decap_8
* cell instance sg13cmos5l_decap_8_4257 r0 *1 0,0
Xsg13cmos5l_decap_8_4257 \$2 \$1 sg13cmos5l_decap_8
* cell instance sg13cmos5l_decap_8_4258 r0 *1 0,0
Xsg13cmos5l_decap_8_4258 \$2 \$1 sg13cmos5l_decap_8
* cell instance sg13cmos5l_decap_8_4259 r0 *1 0,0
Xsg13cmos5l_decap_8_4259 \$2 \$1 sg13cmos5l_decap_8
* cell instance sg13cmos5l_decap_8_4260 r0 *1 0,0
Xsg13cmos5l_decap_8_4260 \$2 \$1 sg13cmos5l_decap_8
* cell instance sg13cmos5l_decap_8_4261 r0 *1 0,0
Xsg13cmos5l_decap_8_4261 \$2 \$1 sg13cmos5l_decap_8
* cell instance sg13cmos5l_decap_8_4262 r0 *1 0,0
Xsg13cmos5l_decap_8_4262 \$2 \$1 sg13cmos5l_decap_8
* cell instance sg13cmos5l_decap_8_4263 r0 *1 0,0
Xsg13cmos5l_decap_8_4263 \$2 \$1 sg13cmos5l_decap_8
* cell instance sg13cmos5l_decap_8_4264 r0 *1 0,0
Xsg13cmos5l_decap_8_4264 \$2 \$1 sg13cmos5l_decap_8
* cell instance sg13cmos5l_decap_8_4265 r0 *1 0,0
Xsg13cmos5l_decap_8_4265 \$2 \$1 sg13cmos5l_decap_8
* cell instance sg13cmos5l_decap_8_4266 r0 *1 0,0
Xsg13cmos5l_decap_8_4266 \$2 \$1 sg13cmos5l_decap_8
* cell instance sg13cmos5l_decap_8_4267 r0 *1 0,0
Xsg13cmos5l_decap_8_4267 \$2 \$1 sg13cmos5l_decap_8
* cell instance sg13cmos5l_decap_8_4268 r0 *1 0,0
Xsg13cmos5l_decap_8_4268 \$2 \$1 sg13cmos5l_decap_8
* cell instance sg13cmos5l_decap_8_4269 r0 *1 0,0
Xsg13cmos5l_decap_8_4269 \$2 \$1 sg13cmos5l_decap_8
* cell instance sg13cmos5l_decap_8_4270 r0 *1 0,0
Xsg13cmos5l_decap_8_4270 \$2 \$1 sg13cmos5l_decap_8
* cell instance sg13cmos5l_decap_8_4271 r0 *1 0,0
Xsg13cmos5l_decap_8_4271 \$2 \$1 sg13cmos5l_decap_8
* cell instance sg13cmos5l_decap_8_4272 r0 *1 0,0
Xsg13cmos5l_decap_8_4272 \$2 \$1 sg13cmos5l_decap_8
* cell instance sg13cmos5l_decap_8_4273 r0 *1 0,0
Xsg13cmos5l_decap_8_4273 \$2 \$1 sg13cmos5l_decap_8
* cell instance sg13cmos5l_decap_8_4274 r0 *1 0,0
Xsg13cmos5l_decap_8_4274 \$2 \$1 sg13cmos5l_decap_8
* cell instance sg13cmos5l_decap_8_4275 r0 *1 0,0
Xsg13cmos5l_decap_8_4275 \$2 \$1 sg13cmos5l_decap_8
* cell instance sg13cmos5l_decap_8_4276 r0 *1 0,0
Xsg13cmos5l_decap_8_4276 \$2 \$1 sg13cmos5l_decap_8
* cell instance sg13cmos5l_decap_8_4277 r0 *1 0,0
Xsg13cmos5l_decap_8_4277 \$2 \$1 sg13cmos5l_decap_8
* cell instance sg13cmos5l_decap_8_4278 r0 *1 0,0
Xsg13cmos5l_decap_8_4278 \$2 \$1 sg13cmos5l_decap_8
* cell instance sg13cmos5l_decap_8_4279 r0 *1 0,0
Xsg13cmos5l_decap_8_4279 \$2 \$1 sg13cmos5l_decap_8
* cell instance sg13cmos5l_decap_8_4280 r0 *1 0,0
Xsg13cmos5l_decap_8_4280 \$2 \$1 sg13cmos5l_decap_8
* cell instance sg13cmos5l_decap_8_4281 r0 *1 0,0
Xsg13cmos5l_decap_8_4281 \$2 \$1 sg13cmos5l_decap_8
* cell instance sg13cmos5l_decap_8_4282 r0 *1 0,0
Xsg13cmos5l_decap_8_4282 \$2 \$1 sg13cmos5l_decap_8
* cell instance sg13cmos5l_decap_8_4283 r0 *1 0,0
Xsg13cmos5l_decap_8_4283 \$2 \$1 sg13cmos5l_decap_8
* cell instance sg13cmos5l_decap_8_4284 r0 *1 0,0
Xsg13cmos5l_decap_8_4284 \$2 \$1 sg13cmos5l_decap_8
* cell instance sg13cmos5l_decap_8_4285 r0 *1 0,0
Xsg13cmos5l_decap_8_4285 \$2 \$1 sg13cmos5l_decap_8
* cell instance sg13cmos5l_decap_8_4286 r0 *1 0,0
Xsg13cmos5l_decap_8_4286 \$2 \$1 sg13cmos5l_decap_8
* cell instance sg13cmos5l_decap_8_4287 r0 *1 0,0
Xsg13cmos5l_decap_8_4287 \$2 \$1 sg13cmos5l_decap_8
* cell instance sg13cmos5l_decap_8_4288 r0 *1 0,0
Xsg13cmos5l_decap_8_4288 \$2 \$1 sg13cmos5l_decap_8
* cell instance sg13cmos5l_decap_8_4289 r0 *1 0,0
Xsg13cmos5l_decap_8_4289 \$2 \$1 sg13cmos5l_decap_8
* cell instance sg13cmos5l_decap_8_4290 r0 *1 0,0
Xsg13cmos5l_decap_8_4290 \$2 \$1 sg13cmos5l_decap_8
* cell instance sg13cmos5l_decap_8_4291 r0 *1 0,0
Xsg13cmos5l_decap_8_4291 \$2 \$1 sg13cmos5l_decap_8
* cell instance sg13cmos5l_decap_8_4292 r0 *1 0,0
Xsg13cmos5l_decap_8_4292 \$2 \$1 sg13cmos5l_decap_8
* cell instance sg13cmos5l_decap_8_4293 r0 *1 0,0
Xsg13cmos5l_decap_8_4293 \$2 \$1 sg13cmos5l_decap_8
* cell instance sg13cmos5l_decap_8_4294 r0 *1 0,0
Xsg13cmos5l_decap_8_4294 \$2 \$1 sg13cmos5l_decap_8
* cell instance sg13cmos5l_decap_8_4295 r0 *1 0,0
Xsg13cmos5l_decap_8_4295 \$2 \$1 sg13cmos5l_decap_8
* cell instance sg13cmos5l_decap_8_4296 r0 *1 0,0
Xsg13cmos5l_decap_8_4296 \$2 \$1 sg13cmos5l_decap_8
* cell instance sg13cmos5l_decap_8_4297 r0 *1 0,0
Xsg13cmos5l_decap_8_4297 \$2 \$1 sg13cmos5l_decap_8
* cell instance sg13cmos5l_decap_8_4298 r0 *1 0,0
Xsg13cmos5l_decap_8_4298 \$2 \$1 sg13cmos5l_decap_8
* cell instance sg13cmos5l_decap_8_4299 r0 *1 0,0
Xsg13cmos5l_decap_8_4299 \$2 \$1 sg13cmos5l_decap_8
* cell instance sg13cmos5l_decap_8_4300 r0 *1 0,0
Xsg13cmos5l_decap_8_4300 \$2 \$1 sg13cmos5l_decap_8
* cell instance sg13cmos5l_decap_8_4301 r0 *1 0,0
Xsg13cmos5l_decap_8_4301 \$2 \$1 sg13cmos5l_decap_8
* cell instance sg13cmos5l_decap_8_4302 r0 *1 0,0
Xsg13cmos5l_decap_8_4302 \$2 \$1 sg13cmos5l_decap_8
* cell instance sg13cmos5l_decap_8_4303 r0 *1 0,0
Xsg13cmos5l_decap_8_4303 \$2 \$1 sg13cmos5l_decap_8
* cell instance sg13cmos5l_decap_8_4304 r0 *1 0,0
Xsg13cmos5l_decap_8_4304 \$2 \$1 sg13cmos5l_decap_8
* cell instance sg13cmos5l_decap_8_4305 r0 *1 0,0
Xsg13cmos5l_decap_8_4305 \$2 \$1 sg13cmos5l_decap_8
* cell instance sg13cmos5l_decap_8_4306 r0 *1 0,0
Xsg13cmos5l_decap_8_4306 \$2 \$1 sg13cmos5l_decap_8
* cell instance sg13cmos5l_decap_8_4307 r0 *1 0,0
Xsg13cmos5l_decap_8_4307 \$2 \$1 sg13cmos5l_decap_8
* cell instance sg13cmos5l_decap_8_4308 r0 *1 0,0
Xsg13cmos5l_decap_8_4308 \$2 \$1 sg13cmos5l_decap_8
* cell instance sg13cmos5l_decap_8_4309 r0 *1 0,0
Xsg13cmos5l_decap_8_4309 \$2 \$1 sg13cmos5l_decap_8
* cell instance sg13cmos5l_decap_8_4310 r0 *1 0,0
Xsg13cmos5l_decap_8_4310 \$2 \$1 sg13cmos5l_decap_8
* cell instance sg13cmos5l_decap_8_4311 r0 *1 0,0
Xsg13cmos5l_decap_8_4311 \$2 \$1 sg13cmos5l_decap_8
* cell instance sg13cmos5l_decap_8_4312 r0 *1 0,0
Xsg13cmos5l_decap_8_4312 \$2 \$1 sg13cmos5l_decap_8
* cell instance sg13cmos5l_decap_8_4313 r0 *1 0,0
Xsg13cmos5l_decap_8_4313 \$2 \$1 sg13cmos5l_decap_8
* cell instance sg13cmos5l_decap_8_4314 r0 *1 0,0
Xsg13cmos5l_decap_8_4314 \$2 \$1 sg13cmos5l_decap_8
* cell instance sg13cmos5l_decap_8_4315 r0 *1 0,0
Xsg13cmos5l_decap_8_4315 \$2 \$1 sg13cmos5l_decap_8
* cell instance sg13cmos5l_decap_8_4316 r0 *1 0,0
Xsg13cmos5l_decap_8_4316 \$2 \$1 sg13cmos5l_decap_8
* cell instance sg13cmos5l_decap_8_4317 r0 *1 0,0
Xsg13cmos5l_decap_8_4317 \$2 \$1 sg13cmos5l_decap_8
* cell instance sg13cmos5l_decap_8_4318 r0 *1 0,0
Xsg13cmos5l_decap_8_4318 \$2 \$1 sg13cmos5l_decap_8
* cell instance sg13cmos5l_decap_8_4319 r0 *1 0,0
Xsg13cmos5l_decap_8_4319 \$2 \$1 sg13cmos5l_decap_8
* cell instance sg13cmos5l_decap_8_4320 r0 *1 0,0
Xsg13cmos5l_decap_8_4320 \$2 \$1 sg13cmos5l_decap_8
* cell instance sg13cmos5l_decap_8_4321 r0 *1 0,0
Xsg13cmos5l_decap_8_4321 \$2 \$1 sg13cmos5l_decap_8
* cell instance sg13cmos5l_decap_8_4322 r0 *1 0,0
Xsg13cmos5l_decap_8_4322 \$2 \$1 sg13cmos5l_decap_8
* cell instance sg13cmos5l_decap_8_4323 r0 *1 0,0
Xsg13cmos5l_decap_8_4323 \$2 \$1 sg13cmos5l_decap_8
* cell instance sg13cmos5l_decap_8_4324 r0 *1 0,0
Xsg13cmos5l_decap_8_4324 \$2 \$1 sg13cmos5l_decap_8
* cell instance sg13cmos5l_decap_8_4325 r0 *1 0,0
Xsg13cmos5l_decap_8_4325 \$2 \$1 sg13cmos5l_decap_8
* cell instance sg13cmos5l_decap_8_4326 r0 *1 0,0
Xsg13cmos5l_decap_8_4326 \$2 \$1 sg13cmos5l_decap_8
* cell instance sg13cmos5l_decap_8_4327 r0 *1 0,0
Xsg13cmos5l_decap_8_4327 \$2 \$1 sg13cmos5l_decap_8
* cell instance sg13cmos5l_decap_8_4328 r0 *1 0,0
Xsg13cmos5l_decap_8_4328 \$2 \$1 sg13cmos5l_decap_8
* cell instance sg13cmos5l_decap_8_4329 r0 *1 0,0
Xsg13cmos5l_decap_8_4329 \$2 \$1 sg13cmos5l_decap_8
* cell instance sg13cmos5l_decap_8_4330 r0 *1 0,0
Xsg13cmos5l_decap_8_4330 \$2 \$1 sg13cmos5l_decap_8
* cell instance sg13cmos5l_decap_8_4331 r0 *1 0,0
Xsg13cmos5l_decap_8_4331 \$2 \$1 sg13cmos5l_decap_8
* cell instance sg13cmos5l_decap_8_4332 r0 *1 0,0
Xsg13cmos5l_decap_8_4332 \$2 \$1 sg13cmos5l_decap_8
* cell instance sg13cmos5l_decap_8_4333 r0 *1 0,0
Xsg13cmos5l_decap_8_4333 \$2 \$1 sg13cmos5l_decap_8
* cell instance sg13cmos5l_decap_8_4334 r0 *1 0,0
Xsg13cmos5l_decap_8_4334 \$2 \$1 sg13cmos5l_decap_8
* cell instance sg13cmos5l_decap_8_4335 r0 *1 0,0
Xsg13cmos5l_decap_8_4335 \$2 \$1 sg13cmos5l_decap_8
* cell instance sg13cmos5l_decap_8_4336 r0 *1 0,0
Xsg13cmos5l_decap_8_4336 \$2 \$1 sg13cmos5l_decap_8
* cell instance sg13cmos5l_decap_8_4337 r0 *1 0,0
Xsg13cmos5l_decap_8_4337 \$2 \$1 sg13cmos5l_decap_8
* cell instance sg13cmos5l_decap_8_4338 r0 *1 0,0
Xsg13cmos5l_decap_8_4338 \$2 \$1 sg13cmos5l_decap_8
* cell instance sg13cmos5l_decap_8_4339 r0 *1 0,0
Xsg13cmos5l_decap_8_4339 \$2 \$1 sg13cmos5l_decap_8
* cell instance sg13cmos5l_decap_8_4340 r0 *1 0,0
Xsg13cmos5l_decap_8_4340 \$2 \$1 sg13cmos5l_decap_8
* cell instance sg13cmos5l_decap_8_4341 r0 *1 0,0
Xsg13cmos5l_decap_8_4341 \$2 \$1 sg13cmos5l_decap_8
* cell instance sg13cmos5l_decap_8_4342 r0 *1 0,0
Xsg13cmos5l_decap_8_4342 \$2 \$1 sg13cmos5l_decap_8
* cell instance sg13cmos5l_decap_8_4343 r0 *1 0,0
Xsg13cmos5l_decap_8_4343 \$2 \$1 sg13cmos5l_decap_8
* cell instance sg13cmos5l_decap_8_4344 r0 *1 0,0
Xsg13cmos5l_decap_8_4344 \$2 \$1 sg13cmos5l_decap_8
* cell instance sg13cmos5l_decap_8_4345 r0 *1 0,0
Xsg13cmos5l_decap_8_4345 \$2 \$1 sg13cmos5l_decap_8
* cell instance sg13cmos5l_decap_8_4346 r0 *1 0,0
Xsg13cmos5l_decap_8_4346 \$2 \$1 sg13cmos5l_decap_8
* cell instance sg13cmos5l_decap_8_4347 r0 *1 0,0
Xsg13cmos5l_decap_8_4347 \$2 \$1 sg13cmos5l_decap_8
* cell instance sg13cmos5l_decap_8_4348 r0 *1 0,0
Xsg13cmos5l_decap_8_4348 \$2 \$1 sg13cmos5l_decap_8
* cell instance sg13cmos5l_decap_8_4349 r0 *1 0,0
Xsg13cmos5l_decap_8_4349 \$2 \$1 sg13cmos5l_decap_8
* cell instance sg13cmos5l_decap_8_4350 r0 *1 0,0
Xsg13cmos5l_decap_8_4350 \$2 \$1 sg13cmos5l_decap_8
* cell instance sg13cmos5l_decap_8_4351 r0 *1 0,0
Xsg13cmos5l_decap_8_4351 \$2 \$1 sg13cmos5l_decap_8
* cell instance sg13cmos5l_decap_8_4352 r0 *1 0,0
Xsg13cmos5l_decap_8_4352 \$2 \$1 sg13cmos5l_decap_8
* cell instance sg13cmos5l_decap_8_4353 r0 *1 0,0
Xsg13cmos5l_decap_8_4353 \$2 \$1 sg13cmos5l_decap_8
* cell instance sg13cmos5l_decap_8_4354 r0 *1 0,0
Xsg13cmos5l_decap_8_4354 \$2 \$1 sg13cmos5l_decap_8
* cell instance sg13cmos5l_decap_8_4355 r0 *1 0,0
Xsg13cmos5l_decap_8_4355 \$2 \$1 sg13cmos5l_decap_8
* cell instance sg13cmos5l_decap_8_4356 r0 *1 0,0
Xsg13cmos5l_decap_8_4356 \$2 \$1 sg13cmos5l_decap_8
* cell instance sg13cmos5l_decap_8_4357 r0 *1 0,0
Xsg13cmos5l_decap_8_4357 \$2 \$1 sg13cmos5l_decap_8
* cell instance sg13cmos5l_decap_8_4358 r0 *1 0,0
Xsg13cmos5l_decap_8_4358 \$2 \$1 sg13cmos5l_decap_8
* cell instance sg13cmos5l_decap_8_4359 r0 *1 0,0
Xsg13cmos5l_decap_8_4359 \$2 \$1 sg13cmos5l_decap_8
* cell instance sg13cmos5l_decap_8_4360 r0 *1 0,0
Xsg13cmos5l_decap_8_4360 \$2 \$1 sg13cmos5l_decap_8
* cell instance sg13cmos5l_decap_8_4361 r0 *1 0,0
Xsg13cmos5l_decap_8_4361 \$2 \$1 sg13cmos5l_decap_8
* cell instance sg13cmos5l_decap_8_4362 r0 *1 0,0
Xsg13cmos5l_decap_8_4362 \$2 \$1 sg13cmos5l_decap_8
* cell instance sg13cmos5l_decap_8_4363 r0 *1 0,0
Xsg13cmos5l_decap_8_4363 \$2 \$1 sg13cmos5l_decap_8
* cell instance sg13cmos5l_decap_8_4364 r0 *1 0,0
Xsg13cmos5l_decap_8_4364 \$2 \$1 sg13cmos5l_decap_8
* cell instance sg13cmos5l_decap_8_4365 r0 *1 0,0
Xsg13cmos5l_decap_8_4365 \$2 \$1 sg13cmos5l_decap_8
* cell instance sg13cmos5l_decap_8_4366 r0 *1 0,0
Xsg13cmos5l_decap_8_4366 \$2 \$1 sg13cmos5l_decap_8
* cell instance sg13cmos5l_decap_8_4367 r0 *1 0,0
Xsg13cmos5l_decap_8_4367 \$2 \$1 sg13cmos5l_decap_8
* cell instance sg13cmos5l_decap_8_4368 r0 *1 0,0
Xsg13cmos5l_decap_8_4368 \$2 \$1 sg13cmos5l_decap_8
* cell instance sg13cmos5l_decap_8_4369 r0 *1 0,0
Xsg13cmos5l_decap_8_4369 \$2 \$1 sg13cmos5l_decap_8
* cell instance sg13cmos5l_decap_8_4370 r0 *1 0,0
Xsg13cmos5l_decap_8_4370 \$2 \$1 sg13cmos5l_decap_8
* cell instance sg13cmos5l_decap_8_4371 r0 *1 0,0
Xsg13cmos5l_decap_8_4371 \$2 \$1 sg13cmos5l_decap_8
* cell instance sg13cmos5l_decap_8_4372 r0 *1 0,0
Xsg13cmos5l_decap_8_4372 \$2 \$1 sg13cmos5l_decap_8
* cell instance sg13cmos5l_decap_8_4373 r0 *1 0,0
Xsg13cmos5l_decap_8_4373 \$2 \$1 sg13cmos5l_decap_8
* cell instance sg13cmos5l_decap_8_4374 r0 *1 0,0
Xsg13cmos5l_decap_8_4374 \$2 \$1 sg13cmos5l_decap_8
* cell instance sg13cmos5l_decap_8_4375 r0 *1 0,0
Xsg13cmos5l_decap_8_4375 \$2 \$1 sg13cmos5l_decap_8
* cell instance sg13cmos5l_decap_8_4376 r0 *1 0,0
Xsg13cmos5l_decap_8_4376 \$2 \$1 sg13cmos5l_decap_8
* cell instance sg13cmos5l_decap_8_4377 r0 *1 0,0
Xsg13cmos5l_decap_8_4377 \$2 \$1 sg13cmos5l_decap_8
* cell instance sg13cmos5l_decap_8_4378 r0 *1 0,0
Xsg13cmos5l_decap_8_4378 \$2 \$1 sg13cmos5l_decap_8
* cell instance sg13cmos5l_decap_8_4379 r0 *1 0,0
Xsg13cmos5l_decap_8_4379 \$2 \$1 sg13cmos5l_decap_8
* cell instance sg13cmos5l_decap_8_4380 r0 *1 0,0
Xsg13cmos5l_decap_8_4380 \$2 \$1 sg13cmos5l_decap_8
* cell instance sg13cmos5l_decap_8_4381 r0 *1 0,0
Xsg13cmos5l_decap_8_4381 \$2 \$1 sg13cmos5l_decap_8
* cell instance sg13cmos5l_decap_8_4382 r0 *1 0,0
Xsg13cmos5l_decap_8_4382 \$2 \$1 sg13cmos5l_decap_8
* cell instance sg13cmos5l_decap_8_4383 r0 *1 0,0
Xsg13cmos5l_decap_8_4383 \$2 \$1 sg13cmos5l_decap_8
* cell instance sg13cmos5l_decap_8_4384 r0 *1 0,0
Xsg13cmos5l_decap_8_4384 \$2 \$1 sg13cmos5l_decap_8
* cell instance sg13cmos5l_decap_8_4385 r0 *1 0,0
Xsg13cmos5l_decap_8_4385 \$2 \$1 sg13cmos5l_decap_8
* cell instance sg13cmos5l_decap_8_4386 r0 *1 0,0
Xsg13cmos5l_decap_8_4386 \$2 \$1 sg13cmos5l_decap_8
* cell instance sg13cmos5l_decap_8_4387 r0 *1 0,0
Xsg13cmos5l_decap_8_4387 \$2 \$1 sg13cmos5l_decap_8
* cell instance sg13cmos5l_decap_8_4388 r0 *1 0,0
Xsg13cmos5l_decap_8_4388 \$2 \$1 sg13cmos5l_decap_8
* cell instance sg13cmos5l_decap_8_4389 r0 *1 0,0
Xsg13cmos5l_decap_8_4389 \$2 \$1 sg13cmos5l_decap_8
* cell instance sg13cmos5l_decap_8_4390 r0 *1 0,0
Xsg13cmos5l_decap_8_4390 \$2 \$1 sg13cmos5l_decap_8
* cell instance sg13cmos5l_decap_8_4391 r0 *1 0,0
Xsg13cmos5l_decap_8_4391 \$2 \$1 sg13cmos5l_decap_8
* cell instance sg13cmos5l_decap_8_4392 r0 *1 0,0
Xsg13cmos5l_decap_8_4392 \$2 \$1 sg13cmos5l_decap_8
* cell instance sg13cmos5l_decap_8_4393 r0 *1 0,0
Xsg13cmos5l_decap_8_4393 \$2 \$1 sg13cmos5l_decap_8
* cell instance sg13cmos5l_decap_8_4394 r0 *1 0,0
Xsg13cmos5l_decap_8_4394 \$2 \$1 sg13cmos5l_decap_8
* cell instance sg13cmos5l_decap_8_4395 r0 *1 0,0
Xsg13cmos5l_decap_8_4395 \$2 \$1 sg13cmos5l_decap_8
* cell instance sg13cmos5l_decap_8_4396 r0 *1 0,0
Xsg13cmos5l_decap_8_4396 \$2 \$1 sg13cmos5l_decap_8
* cell instance sg13cmos5l_decap_8_4397 r0 *1 0,0
Xsg13cmos5l_decap_8_4397 \$2 \$1 sg13cmos5l_decap_8
* cell instance sg13cmos5l_decap_8_4398 r0 *1 0,0
Xsg13cmos5l_decap_8_4398 \$2 \$1 sg13cmos5l_decap_8
* cell instance sg13cmos5l_decap_8_4399 r0 *1 0,0
Xsg13cmos5l_decap_8_4399 \$2 \$1 sg13cmos5l_decap_8
* cell instance sg13cmos5l_decap_8_4400 r0 *1 0,0
Xsg13cmos5l_decap_8_4400 \$2 \$1 sg13cmos5l_decap_8
* cell instance sg13cmos5l_decap_8_4401 r0 *1 0,0
Xsg13cmos5l_decap_8_4401 \$2 \$1 sg13cmos5l_decap_8
* cell instance sg13cmos5l_decap_8_4402 r0 *1 0,0
Xsg13cmos5l_decap_8_4402 \$2 \$1 sg13cmos5l_decap_8
* cell instance sg13cmos5l_decap_8_4403 r0 *1 0,0
Xsg13cmos5l_decap_8_4403 \$2 \$1 sg13cmos5l_decap_8
* cell instance sg13cmos5l_decap_8_4404 r0 *1 0,0
Xsg13cmos5l_decap_8_4404 \$2 \$1 sg13cmos5l_decap_8
* cell instance sg13cmos5l_decap_8_4405 r0 *1 0,0
Xsg13cmos5l_decap_8_4405 \$2 \$1 sg13cmos5l_decap_8
* cell instance sg13cmos5l_decap_8_4406 r0 *1 0,0
Xsg13cmos5l_decap_8_4406 \$2 \$1 sg13cmos5l_decap_8
* cell instance sg13cmos5l_decap_8_4407 r0 *1 0,0
Xsg13cmos5l_decap_8_4407 \$2 \$1 sg13cmos5l_decap_8
* cell instance sg13cmos5l_decap_8_4408 r0 *1 0,0
Xsg13cmos5l_decap_8_4408 \$2 \$1 sg13cmos5l_decap_8
* cell instance sg13cmos5l_decap_8_4409 r0 *1 0,0
Xsg13cmos5l_decap_8_4409 \$2 \$1 sg13cmos5l_decap_8
* cell instance sg13cmos5l_decap_8_4410 r0 *1 0,0
Xsg13cmos5l_decap_8_4410 \$2 \$1 sg13cmos5l_decap_8
* cell instance sg13cmos5l_decap_8_4411 r0 *1 0,0
Xsg13cmos5l_decap_8_4411 \$2 \$1 sg13cmos5l_decap_8
* cell instance sg13cmos5l_decap_8_4412 r0 *1 0,0
Xsg13cmos5l_decap_8_4412 \$2 \$1 sg13cmos5l_decap_8
* cell instance sg13cmos5l_decap_8_4413 r0 *1 0,0
Xsg13cmos5l_decap_8_4413 \$2 \$1 sg13cmos5l_decap_8
* cell instance sg13cmos5l_decap_8_4414 r0 *1 0,0
Xsg13cmos5l_decap_8_4414 \$2 \$1 sg13cmos5l_decap_8
* cell instance sg13cmos5l_decap_8_4415 r0 *1 0,0
Xsg13cmos5l_decap_8_4415 \$2 \$1 sg13cmos5l_decap_8
* cell instance sg13cmos5l_decap_8_4416 r0 *1 0,0
Xsg13cmos5l_decap_8_4416 \$2 \$1 sg13cmos5l_decap_8
* cell instance sg13cmos5l_decap_8_4417 r0 *1 0,0
Xsg13cmos5l_decap_8_4417 \$2 \$1 sg13cmos5l_decap_8
* cell instance sg13cmos5l_decap_8_4418 r0 *1 0,0
Xsg13cmos5l_decap_8_4418 \$2 \$1 sg13cmos5l_decap_8
* cell instance sg13cmos5l_decap_8_4419 r0 *1 0,0
Xsg13cmos5l_decap_8_4419 \$2 \$1 sg13cmos5l_decap_8
* cell instance sg13cmos5l_decap_8_4420 r0 *1 0,0
Xsg13cmos5l_decap_8_4420 \$2 \$1 sg13cmos5l_decap_8
* cell instance sg13cmos5l_decap_8_4421 r0 *1 0,0
Xsg13cmos5l_decap_8_4421 \$2 \$1 sg13cmos5l_decap_8
* cell instance sg13cmos5l_decap_8_4422 r0 *1 0,0
Xsg13cmos5l_decap_8_4422 \$2 \$1 sg13cmos5l_decap_8
* cell instance sg13cmos5l_decap_8_4423 r0 *1 0,0
Xsg13cmos5l_decap_8_4423 \$2 \$1 sg13cmos5l_decap_8
* cell instance sg13cmos5l_decap_8_4424 r0 *1 0,0
Xsg13cmos5l_decap_8_4424 \$2 \$1 sg13cmos5l_decap_8
* cell instance sg13cmos5l_decap_8_4425 r0 *1 0,0
Xsg13cmos5l_decap_8_4425 \$2 \$1 sg13cmos5l_decap_8
* cell instance sg13cmos5l_decap_8_4426 r0 *1 0,0
Xsg13cmos5l_decap_8_4426 \$2 \$1 sg13cmos5l_decap_8
* cell instance sg13cmos5l_decap_8_4427 r0 *1 0,0
Xsg13cmos5l_decap_8_4427 \$2 \$1 sg13cmos5l_decap_8
* cell instance sg13cmos5l_decap_8_4428 r0 *1 0,0
Xsg13cmos5l_decap_8_4428 \$2 \$1 sg13cmos5l_decap_8
* cell instance sg13cmos5l_decap_8_4429 r0 *1 0,0
Xsg13cmos5l_decap_8_4429 \$2 \$1 sg13cmos5l_decap_8
* cell instance sg13cmos5l_decap_8_4430 r0 *1 0,0
Xsg13cmos5l_decap_8_4430 \$2 \$1 sg13cmos5l_decap_8
* cell instance sg13cmos5l_decap_8_4431 r0 *1 0,0
Xsg13cmos5l_decap_8_4431 \$2 \$1 sg13cmos5l_decap_8
* cell instance sg13cmos5l_decap_8_4432 r0 *1 0,0
Xsg13cmos5l_decap_8_4432 \$2 \$1 sg13cmos5l_decap_8
* cell instance sg13cmos5l_decap_8_4433 r0 *1 0,0
Xsg13cmos5l_decap_8_4433 \$2 \$1 sg13cmos5l_decap_8
* cell instance sg13cmos5l_decap_8_4434 r0 *1 0,0
Xsg13cmos5l_decap_8_4434 \$2 \$1 sg13cmos5l_decap_8
* cell instance sg13cmos5l_decap_8_4435 r0 *1 0,0
Xsg13cmos5l_decap_8_4435 \$2 \$1 sg13cmos5l_decap_8
* cell instance sg13cmos5l_decap_8_4436 r0 *1 0,0
Xsg13cmos5l_decap_8_4436 \$2 \$1 sg13cmos5l_decap_8
* cell instance sg13cmos5l_decap_8_4437 r0 *1 0,0
Xsg13cmos5l_decap_8_4437 \$2 \$1 sg13cmos5l_decap_8
* cell instance sg13cmos5l_decap_8_4438 r0 *1 0,0
Xsg13cmos5l_decap_8_4438 \$2 \$1 sg13cmos5l_decap_8
* cell instance sg13cmos5l_decap_8_4439 r0 *1 0,0
Xsg13cmos5l_decap_8_4439 \$2 \$1 sg13cmos5l_decap_8
* cell instance sg13cmos5l_decap_8_4440 r0 *1 0,0
Xsg13cmos5l_decap_8_4440 \$2 \$1 sg13cmos5l_decap_8
* cell instance sg13cmos5l_decap_8_4441 r0 *1 0,0
Xsg13cmos5l_decap_8_4441 \$2 \$1 sg13cmos5l_decap_8
* cell instance sg13cmos5l_decap_8_4442 r0 *1 0,0
Xsg13cmos5l_decap_8_4442 \$2 \$1 sg13cmos5l_decap_8
* cell instance sg13cmos5l_decap_8_4443 r0 *1 0,0
Xsg13cmos5l_decap_8_4443 \$2 \$1 sg13cmos5l_decap_8
* cell instance sg13cmos5l_decap_8_4444 r0 *1 0,0
Xsg13cmos5l_decap_8_4444 \$2 \$1 sg13cmos5l_decap_8
* cell instance sg13cmos5l_decap_8_4445 r0 *1 0,0
Xsg13cmos5l_decap_8_4445 \$2 \$1 sg13cmos5l_decap_8
* cell instance sg13cmos5l_decap_8_4446 r0 *1 0,0
Xsg13cmos5l_decap_8_4446 \$2 \$1 sg13cmos5l_decap_8
* cell instance sg13cmos5l_decap_8_4447 r0 *1 0,0
Xsg13cmos5l_decap_8_4447 \$2 \$1 sg13cmos5l_decap_8
* cell instance sg13cmos5l_decap_8_4448 r0 *1 0,0
Xsg13cmos5l_decap_8_4448 \$2 \$1 sg13cmos5l_decap_8
* cell instance sg13cmos5l_decap_8_4449 r0 *1 0,0
Xsg13cmos5l_decap_8_4449 \$2 \$1 sg13cmos5l_decap_8
* cell instance sg13cmos5l_decap_8_4450 r0 *1 0,0
Xsg13cmos5l_decap_8_4450 \$2 \$1 sg13cmos5l_decap_8
* cell instance sg13cmos5l_decap_8_4451 r0 *1 0,0
Xsg13cmos5l_decap_8_4451 \$2 \$1 sg13cmos5l_decap_8
* cell instance sg13cmos5l_decap_8_4452 r0 *1 0,0
Xsg13cmos5l_decap_8_4452 \$2 \$1 sg13cmos5l_decap_8
* cell instance sg13cmos5l_decap_8_4453 r0 *1 0,0
Xsg13cmos5l_decap_8_4453 \$2 \$1 sg13cmos5l_decap_8
* cell instance sg13cmos5l_decap_8_4454 r0 *1 0,0
Xsg13cmos5l_decap_8_4454 \$2 \$1 sg13cmos5l_decap_8
* cell instance sg13cmos5l_decap_8_4455 r0 *1 0,0
Xsg13cmos5l_decap_8_4455 \$2 \$1 sg13cmos5l_decap_8
* cell instance sg13cmos5l_decap_8_4456 r0 *1 0,0
Xsg13cmos5l_decap_8_4456 \$2 \$1 sg13cmos5l_decap_8
* cell instance sg13cmos5l_decap_8_4457 r0 *1 0,0
Xsg13cmos5l_decap_8_4457 \$2 \$1 sg13cmos5l_decap_8
* cell instance sg13cmos5l_decap_8_4458 r0 *1 0,0
Xsg13cmos5l_decap_8_4458 \$2 \$1 sg13cmos5l_decap_8
* cell instance sg13cmos5l_decap_8_4459 r0 *1 0,0
Xsg13cmos5l_decap_8_4459 \$2 \$1 sg13cmos5l_decap_8
* cell instance sg13cmos5l_decap_8_4460 r0 *1 0,0
Xsg13cmos5l_decap_8_4460 \$2 \$1 sg13cmos5l_decap_8
* cell instance sg13cmos5l_decap_8_4461 r0 *1 0,0
Xsg13cmos5l_decap_8_4461 \$2 \$1 sg13cmos5l_decap_8
* cell instance sg13cmos5l_decap_8_4462 r0 *1 0,0
Xsg13cmos5l_decap_8_4462 \$2 \$1 sg13cmos5l_decap_8
* cell instance sg13cmos5l_decap_8_4463 r0 *1 0,0
Xsg13cmos5l_decap_8_4463 \$2 \$1 sg13cmos5l_decap_8
* cell instance sg13cmos5l_decap_8_4464 r0 *1 0,0
Xsg13cmos5l_decap_8_4464 \$2 \$1 sg13cmos5l_decap_8
* cell instance sg13cmos5l_decap_8_4465 r0 *1 0,0
Xsg13cmos5l_decap_8_4465 \$2 \$1 sg13cmos5l_decap_8
* cell instance sg13cmos5l_decap_8_4466 r0 *1 0,0
Xsg13cmos5l_decap_8_4466 \$2 \$1 sg13cmos5l_decap_8
* cell instance sg13cmos5l_decap_8_4467 r0 *1 0,0
Xsg13cmos5l_decap_8_4467 \$2 \$1 sg13cmos5l_decap_8
* cell instance sg13cmos5l_decap_8_4468 r0 *1 0,0
Xsg13cmos5l_decap_8_4468 \$2 \$1 sg13cmos5l_decap_8
* cell instance sg13cmos5l_decap_8_4469 r0 *1 0,0
Xsg13cmos5l_decap_8_4469 \$2 \$1 sg13cmos5l_decap_8
* cell instance sg13cmos5l_decap_8_4470 r0 *1 0,0
Xsg13cmos5l_decap_8_4470 \$2 \$1 sg13cmos5l_decap_8
* cell instance sg13cmos5l_decap_8_4471 r0 *1 0,0
Xsg13cmos5l_decap_8_4471 \$2 \$1 sg13cmos5l_decap_8
* cell instance sg13cmos5l_decap_8_4472 r0 *1 0,0
Xsg13cmos5l_decap_8_4472 \$2 \$1 sg13cmos5l_decap_8
* cell instance sg13cmos5l_decap_8_4473 r0 *1 0,0
Xsg13cmos5l_decap_8_4473 \$2 \$1 sg13cmos5l_decap_8
* cell instance sg13cmos5l_decap_8_4474 r0 *1 0,0
Xsg13cmos5l_decap_8_4474 \$2 \$1 sg13cmos5l_decap_8
* cell instance sg13cmos5l_decap_8_4475 r0 *1 0,0
Xsg13cmos5l_decap_8_4475 \$2 \$1 sg13cmos5l_decap_8
* cell instance sg13cmos5l_decap_8_4476 r0 *1 0,0
Xsg13cmos5l_decap_8_4476 \$2 \$1 sg13cmos5l_decap_8
* cell instance sg13cmos5l_decap_8_4477 r0 *1 0,0
Xsg13cmos5l_decap_8_4477 \$2 \$1 sg13cmos5l_decap_8
* cell instance sg13cmos5l_decap_8_4478 r0 *1 0,0
Xsg13cmos5l_decap_8_4478 \$2 \$1 sg13cmos5l_decap_8
* cell instance sg13cmos5l_decap_8_4479 r0 *1 0,0
Xsg13cmos5l_decap_8_4479 \$2 \$1 sg13cmos5l_decap_8
* cell instance sg13cmos5l_decap_8_4480 r0 *1 0,0
Xsg13cmos5l_decap_8_4480 \$2 \$1 sg13cmos5l_decap_8
* cell instance sg13cmos5l_decap_8_4481 r0 *1 0,0
Xsg13cmos5l_decap_8_4481 \$2 \$1 sg13cmos5l_decap_8
* cell instance sg13cmos5l_decap_8_4482 r0 *1 0,0
Xsg13cmos5l_decap_8_4482 \$2 \$1 sg13cmos5l_decap_8
* cell instance sg13cmos5l_decap_8_4483 r0 *1 0,0
Xsg13cmos5l_decap_8_4483 \$2 \$1 sg13cmos5l_decap_8
* cell instance sg13cmos5l_decap_8_4484 r0 *1 0,0
Xsg13cmos5l_decap_8_4484 \$2 \$1 sg13cmos5l_decap_8
* cell instance sg13cmos5l_decap_8_4485 r0 *1 0,0
Xsg13cmos5l_decap_8_4485 \$2 \$1 sg13cmos5l_decap_8
* cell instance sg13cmos5l_decap_8_4486 r0 *1 0,0
Xsg13cmos5l_decap_8_4486 \$2 \$1 sg13cmos5l_decap_8
* cell instance sg13cmos5l_decap_8_4487 r0 *1 0,0
Xsg13cmos5l_decap_8_4487 \$2 \$1 sg13cmos5l_decap_8
* cell instance sg13cmos5l_decap_8_4488 r0 *1 0,0
Xsg13cmos5l_decap_8_4488 \$2 \$1 sg13cmos5l_decap_8
* cell instance sg13cmos5l_decap_8_4489 r0 *1 0,0
Xsg13cmos5l_decap_8_4489 \$2 \$1 sg13cmos5l_decap_8
* cell instance sg13cmos5l_decap_8_4490 r0 *1 0,0
Xsg13cmos5l_decap_8_4490 \$2 \$1 sg13cmos5l_decap_8
* cell instance sg13cmos5l_decap_8_4491 r0 *1 0,0
Xsg13cmos5l_decap_8_4491 \$2 \$1 sg13cmos5l_decap_8
* cell instance sg13cmos5l_decap_8_4492 r0 *1 0,0
Xsg13cmos5l_decap_8_4492 \$2 \$1 sg13cmos5l_decap_8
* cell instance sg13cmos5l_decap_8_4493 r0 *1 0,0
Xsg13cmos5l_decap_8_4493 \$2 \$1 sg13cmos5l_decap_8
* cell instance sg13cmos5l_decap_8_4494 r0 *1 0,0
Xsg13cmos5l_decap_8_4494 \$2 \$1 sg13cmos5l_decap_8
* cell instance sg13cmos5l_decap_8_4495 r0 *1 0,0
Xsg13cmos5l_decap_8_4495 \$2 \$1 sg13cmos5l_decap_8
* cell instance sg13cmos5l_decap_8_4496 r0 *1 0,0
Xsg13cmos5l_decap_8_4496 \$2 \$1 sg13cmos5l_decap_8
* cell instance sg13cmos5l_decap_8_4497 r0 *1 0,0
Xsg13cmos5l_decap_8_4497 \$2 \$1 sg13cmos5l_decap_8
* cell instance sg13cmos5l_decap_8_4498 r0 *1 0,0
Xsg13cmos5l_decap_8_4498 \$2 \$1 sg13cmos5l_decap_8
* cell instance sg13cmos5l_decap_8_4499 r0 *1 0,0
Xsg13cmos5l_decap_8_4499 \$2 \$1 sg13cmos5l_decap_8
* cell instance sg13cmos5l_decap_8_4500 r0 *1 0,0
Xsg13cmos5l_decap_8_4500 \$2 \$1 sg13cmos5l_decap_8
* cell instance sg13cmos5l_decap_8_4501 r0 *1 0,0
Xsg13cmos5l_decap_8_4501 \$2 \$1 sg13cmos5l_decap_8
* cell instance sg13cmos5l_decap_8_4502 r0 *1 0,0
Xsg13cmos5l_decap_8_4502 \$2 \$1 sg13cmos5l_decap_8
* cell instance sg13cmos5l_decap_8_4503 r0 *1 0,0
Xsg13cmos5l_decap_8_4503 \$2 \$1 sg13cmos5l_decap_8
* cell instance sg13cmos5l_decap_8_4504 r0 *1 0,0
Xsg13cmos5l_decap_8_4504 \$2 \$1 sg13cmos5l_decap_8
* cell instance sg13cmos5l_decap_8_4505 r0 *1 0,0
Xsg13cmos5l_decap_8_4505 \$2 \$1 sg13cmos5l_decap_8
* cell instance sg13cmos5l_decap_8_4506 r0 *1 0,0
Xsg13cmos5l_decap_8_4506 \$2 \$1 sg13cmos5l_decap_8
* cell instance sg13cmos5l_decap_8_4507 r0 *1 0,0
Xsg13cmos5l_decap_8_4507 \$2 \$1 sg13cmos5l_decap_8
* cell instance sg13cmos5l_decap_8_4508 r0 *1 0,0
Xsg13cmos5l_decap_8_4508 \$2 \$1 sg13cmos5l_decap_8
* cell instance sg13cmos5l_decap_8_4509 r0 *1 0,0
Xsg13cmos5l_decap_8_4509 \$2 \$1 sg13cmos5l_decap_8
* cell instance sg13cmos5l_decap_8_4510 r0 *1 0,0
Xsg13cmos5l_decap_8_4510 \$2 \$1 sg13cmos5l_decap_8
* cell instance sg13cmos5l_decap_8_4511 r0 *1 0,0
Xsg13cmos5l_decap_8_4511 \$2 \$1 sg13cmos5l_decap_8
* cell instance sg13cmos5l_decap_8_4512 r0 *1 0,0
Xsg13cmos5l_decap_8_4512 \$2 \$1 sg13cmos5l_decap_8
* cell instance sg13cmos5l_decap_8_4513 r0 *1 0,0
Xsg13cmos5l_decap_8_4513 \$2 \$1 sg13cmos5l_decap_8
* cell instance sg13cmos5l_decap_8_4514 r0 *1 0,0
Xsg13cmos5l_decap_8_4514 \$2 \$1 sg13cmos5l_decap_8
* cell instance sg13cmos5l_decap_8_4515 r0 *1 0,0
Xsg13cmos5l_decap_8_4515 \$2 \$1 sg13cmos5l_decap_8
* cell instance sg13cmos5l_decap_8_4516 r0 *1 0,0
Xsg13cmos5l_decap_8_4516 \$2 \$1 sg13cmos5l_decap_8
* cell instance sg13cmos5l_decap_8_4517 r0 *1 0,0
Xsg13cmos5l_decap_8_4517 \$2 \$1 sg13cmos5l_decap_8
* cell instance sg13cmos5l_decap_8_4518 r0 *1 0,0
Xsg13cmos5l_decap_8_4518 \$2 \$1 sg13cmos5l_decap_8
* cell instance sg13cmos5l_decap_8_4519 r0 *1 0,0
Xsg13cmos5l_decap_8_4519 \$2 \$1 sg13cmos5l_decap_8
* cell instance sg13cmos5l_decap_8_4520 r0 *1 0,0
Xsg13cmos5l_decap_8_4520 \$2 \$1 sg13cmos5l_decap_8
* cell instance sg13cmos5l_decap_8_4521 r0 *1 0,0
Xsg13cmos5l_decap_8_4521 \$2 \$1 sg13cmos5l_decap_8
* cell instance sg13cmos5l_decap_8_4522 r0 *1 0,0
Xsg13cmos5l_decap_8_4522 \$2 \$1 sg13cmos5l_decap_8
* cell instance sg13cmos5l_decap_8_4523 r0 *1 0,0
Xsg13cmos5l_decap_8_4523 \$2 \$1 sg13cmos5l_decap_8
* cell instance sg13cmos5l_decap_8_4524 r0 *1 0,0
Xsg13cmos5l_decap_8_4524 \$2 \$1 sg13cmos5l_decap_8
* cell instance sg13cmos5l_decap_8_4525 r0 *1 0,0
Xsg13cmos5l_decap_8_4525 \$2 \$1 sg13cmos5l_decap_8
* cell instance sg13cmos5l_decap_8_4526 r0 *1 0,0
Xsg13cmos5l_decap_8_4526 \$2 \$1 sg13cmos5l_decap_8
* cell instance sg13cmos5l_decap_8_4527 r0 *1 0,0
Xsg13cmos5l_decap_8_4527 \$2 \$1 sg13cmos5l_decap_8
* cell instance sg13cmos5l_decap_8_4528 r0 *1 0,0
Xsg13cmos5l_decap_8_4528 \$2 \$1 sg13cmos5l_decap_8
* cell instance sg13cmos5l_decap_8_4529 r0 *1 0,0
Xsg13cmos5l_decap_8_4529 \$2 \$1 sg13cmos5l_decap_8
* cell instance sg13cmos5l_decap_8_4530 r0 *1 0,0
Xsg13cmos5l_decap_8_4530 \$2 \$1 sg13cmos5l_decap_8
* cell instance sg13cmos5l_decap_8_4531 r0 *1 0,0
Xsg13cmos5l_decap_8_4531 \$2 \$1 sg13cmos5l_decap_8
* cell instance sg13cmos5l_decap_8_4532 r0 *1 0,0
Xsg13cmos5l_decap_8_4532 \$2 \$1 sg13cmos5l_decap_8
* cell instance sg13cmos5l_decap_8_4533 r0 *1 0,0
Xsg13cmos5l_decap_8_4533 \$2 \$1 sg13cmos5l_decap_8
* cell instance sg13cmos5l_decap_8_4534 r0 *1 0,0
Xsg13cmos5l_decap_8_4534 \$2 \$1 sg13cmos5l_decap_8
* cell instance sg13cmos5l_decap_8_4535 r0 *1 0,0
Xsg13cmos5l_decap_8_4535 \$2 \$1 sg13cmos5l_decap_8
* cell instance sg13cmos5l_decap_8_4536 r0 *1 0,0
Xsg13cmos5l_decap_8_4536 \$2 \$1 sg13cmos5l_decap_8
* cell instance sg13cmos5l_decap_8_4537 r0 *1 0,0
Xsg13cmos5l_decap_8_4537 \$2 \$1 sg13cmos5l_decap_8
* cell instance sg13cmos5l_decap_8_4538 r0 *1 0,0
Xsg13cmos5l_decap_8_4538 \$2 \$1 sg13cmos5l_decap_8
* cell instance sg13cmos5l_decap_8_4539 r0 *1 0,0
Xsg13cmos5l_decap_8_4539 \$2 \$1 sg13cmos5l_decap_8
* cell instance sg13cmos5l_decap_8_4540 r0 *1 0,0
Xsg13cmos5l_decap_8_4540 \$2 \$1 sg13cmos5l_decap_8
* cell instance sg13cmos5l_decap_8_4541 r0 *1 0,0
Xsg13cmos5l_decap_8_4541 \$2 \$1 sg13cmos5l_decap_8
* cell instance sg13cmos5l_decap_8_4542 r0 *1 0,0
Xsg13cmos5l_decap_8_4542 \$2 \$1 sg13cmos5l_decap_8
* cell instance sg13cmos5l_decap_8_4543 r0 *1 0,0
Xsg13cmos5l_decap_8_4543 \$2 \$1 sg13cmos5l_decap_8
* cell instance sg13cmos5l_decap_8_4544 r0 *1 0,0
Xsg13cmos5l_decap_8_4544 \$2 \$1 sg13cmos5l_decap_8
* cell instance sg13cmos5l_decap_8_4545 r0 *1 0,0
Xsg13cmos5l_decap_8_4545 \$2 \$1 sg13cmos5l_decap_8
* cell instance sg13cmos5l_decap_8_4546 r0 *1 0,0
Xsg13cmos5l_decap_8_4546 \$2 \$1 sg13cmos5l_decap_8
* cell instance sg13cmos5l_decap_8_4547 r0 *1 0,0
Xsg13cmos5l_decap_8_4547 \$2 \$1 sg13cmos5l_decap_8
* cell instance sg13cmos5l_decap_8_4548 r0 *1 0,0
Xsg13cmos5l_decap_8_4548 \$2 \$1 sg13cmos5l_decap_8
* cell instance sg13cmos5l_decap_8_4549 r0 *1 0,0
Xsg13cmos5l_decap_8_4549 \$2 \$1 sg13cmos5l_decap_8
* cell instance sg13cmos5l_decap_8_4550 r0 *1 0,0
Xsg13cmos5l_decap_8_4550 \$2 \$1 sg13cmos5l_decap_8
* cell instance sg13cmos5l_decap_8_4551 r0 *1 0,0
Xsg13cmos5l_decap_8_4551 \$2 \$1 sg13cmos5l_decap_8
* cell instance sg13cmos5l_decap_8_4552 r0 *1 0,0
Xsg13cmos5l_decap_8_4552 \$2 \$1 sg13cmos5l_decap_8
* cell instance sg13cmos5l_decap_8_4553 r0 *1 0,0
Xsg13cmos5l_decap_8_4553 \$2 \$1 sg13cmos5l_decap_8
* cell instance sg13cmos5l_decap_8_4554 r0 *1 0,0
Xsg13cmos5l_decap_8_4554 \$2 \$1 sg13cmos5l_decap_8
* cell instance sg13cmos5l_decap_8_4555 r0 *1 0,0
Xsg13cmos5l_decap_8_4555 \$2 \$1 sg13cmos5l_decap_8
* cell instance sg13cmos5l_decap_8_4556 r0 *1 0,0
Xsg13cmos5l_decap_8_4556 \$2 \$1 sg13cmos5l_decap_8
* cell instance sg13cmos5l_decap_8_4557 r0 *1 0,0
Xsg13cmos5l_decap_8_4557 \$2 \$1 sg13cmos5l_decap_8
* cell instance sg13cmos5l_decap_8_4558 r0 *1 0,0
Xsg13cmos5l_decap_8_4558 \$2 \$1 sg13cmos5l_decap_8
* cell instance sg13cmos5l_decap_8_4559 r0 *1 0,0
Xsg13cmos5l_decap_8_4559 \$2 \$1 sg13cmos5l_decap_8
* cell instance sg13cmos5l_decap_8_4560 r0 *1 0,0
Xsg13cmos5l_decap_8_4560 \$2 \$1 sg13cmos5l_decap_8
* cell instance sg13cmos5l_decap_8_4561 r0 *1 0,0
Xsg13cmos5l_decap_8_4561 \$2 \$1 sg13cmos5l_decap_8
* cell instance sg13cmos5l_decap_8_4562 r0 *1 0,0
Xsg13cmos5l_decap_8_4562 \$2 \$1 sg13cmos5l_decap_8
* cell instance sg13cmos5l_decap_8_4563 r0 *1 0,0
Xsg13cmos5l_decap_8_4563 \$2 \$1 sg13cmos5l_decap_8
* cell instance sg13cmos5l_decap_8_4564 r0 *1 0,0
Xsg13cmos5l_decap_8_4564 \$2 \$1 sg13cmos5l_decap_8
* cell instance sg13cmos5l_decap_8_4565 r0 *1 0,0
Xsg13cmos5l_decap_8_4565 \$2 \$1 sg13cmos5l_decap_8
* cell instance sg13cmos5l_decap_8_4566 r0 *1 0,0
Xsg13cmos5l_decap_8_4566 \$2 \$1 sg13cmos5l_decap_8
* cell instance sg13cmos5l_decap_8_4567 r0 *1 0,0
Xsg13cmos5l_decap_8_4567 \$2 \$1 sg13cmos5l_decap_8
* cell instance sg13cmos5l_decap_8_4568 r0 *1 0,0
Xsg13cmos5l_decap_8_4568 \$2 \$1 sg13cmos5l_decap_8
* cell instance sg13cmos5l_decap_8_4569 r0 *1 0,0
Xsg13cmos5l_decap_8_4569 \$2 \$1 sg13cmos5l_decap_8
* cell instance sg13cmos5l_decap_8_4570 r0 *1 0,0
Xsg13cmos5l_decap_8_4570 \$2 \$1 sg13cmos5l_decap_8
* cell instance sg13cmos5l_decap_8_4571 r0 *1 0,0
Xsg13cmos5l_decap_8_4571 \$2 \$1 sg13cmos5l_decap_8
* cell instance sg13cmos5l_decap_8_4572 r0 *1 0,0
Xsg13cmos5l_decap_8_4572 \$2 \$1 sg13cmos5l_decap_8
* cell instance sg13cmos5l_decap_8_4573 r0 *1 0,0
Xsg13cmos5l_decap_8_4573 \$2 \$1 sg13cmos5l_decap_8
* cell instance sg13cmos5l_decap_8_4574 r0 *1 0,0
Xsg13cmos5l_decap_8_4574 \$2 \$1 sg13cmos5l_decap_8
* cell instance sg13cmos5l_decap_8_4575 r0 *1 0,0
Xsg13cmos5l_decap_8_4575 \$2 \$1 sg13cmos5l_decap_8
* cell instance sg13cmos5l_decap_8_4576 r0 *1 0,0
Xsg13cmos5l_decap_8_4576 \$2 \$1 sg13cmos5l_decap_8
* cell instance sg13cmos5l_decap_8_4577 r0 *1 0,0
Xsg13cmos5l_decap_8_4577 \$2 \$1 sg13cmos5l_decap_8
* cell instance sg13cmos5l_decap_8_4578 r0 *1 0,0
Xsg13cmos5l_decap_8_4578 \$2 \$1 sg13cmos5l_decap_8
* cell instance sg13cmos5l_decap_8_4579 r0 *1 0,0
Xsg13cmos5l_decap_8_4579 \$2 \$1 sg13cmos5l_decap_8
* cell instance sg13cmos5l_decap_8_4580 r0 *1 0,0
Xsg13cmos5l_decap_8_4580 \$2 \$1 sg13cmos5l_decap_8
* cell instance sg13cmos5l_decap_8_4581 r0 *1 0,0
Xsg13cmos5l_decap_8_4581 \$2 \$1 sg13cmos5l_decap_8
* cell instance sg13cmos5l_decap_8_4582 r0 *1 0,0
Xsg13cmos5l_decap_8_4582 \$2 \$1 sg13cmos5l_decap_8
* cell instance sg13cmos5l_decap_8_4583 r0 *1 0,0
Xsg13cmos5l_decap_8_4583 \$2 \$1 sg13cmos5l_decap_8
* cell instance sg13cmos5l_decap_8_4584 r0 *1 0,0
Xsg13cmos5l_decap_8_4584 \$2 \$1 sg13cmos5l_decap_8
* cell instance sg13cmos5l_decap_8_4585 r0 *1 0,0
Xsg13cmos5l_decap_8_4585 \$2 \$1 sg13cmos5l_decap_8
* cell instance sg13cmos5l_decap_8_4586 r0 *1 0,0
Xsg13cmos5l_decap_8_4586 \$2 \$1 sg13cmos5l_decap_8
* cell instance sg13cmos5l_decap_8_4587 r0 *1 0,0
Xsg13cmos5l_decap_8_4587 \$2 \$1 sg13cmos5l_decap_8
* cell instance sg13cmos5l_decap_8_4588 r0 *1 0,0
Xsg13cmos5l_decap_8_4588 \$2 \$1 sg13cmos5l_decap_8
* cell instance sg13cmos5l_decap_8_4589 r0 *1 0,0
Xsg13cmos5l_decap_8_4589 \$2 \$1 sg13cmos5l_decap_8
* cell instance sg13cmos5l_decap_8_4590 r0 *1 0,0
Xsg13cmos5l_decap_8_4590 \$2 \$1 sg13cmos5l_decap_8
* cell instance sg13cmos5l_decap_8_4591 r0 *1 0,0
Xsg13cmos5l_decap_8_4591 \$2 \$1 sg13cmos5l_decap_8
* cell instance sg13cmos5l_decap_8_4592 r0 *1 0,0
Xsg13cmos5l_decap_8_4592 \$2 \$1 sg13cmos5l_decap_8
* cell instance sg13cmos5l_decap_8_4593 r0 *1 0,0
Xsg13cmos5l_decap_8_4593 \$2 \$1 sg13cmos5l_decap_8
* cell instance sg13cmos5l_decap_8_4594 r0 *1 0,0
Xsg13cmos5l_decap_8_4594 \$2 \$1 sg13cmos5l_decap_8
* cell instance sg13cmos5l_decap_8_4595 r0 *1 0,0
Xsg13cmos5l_decap_8_4595 \$2 \$1 sg13cmos5l_decap_8
* cell instance sg13cmos5l_decap_8_4596 r0 *1 0,0
Xsg13cmos5l_decap_8_4596 \$2 \$1 sg13cmos5l_decap_8
* cell instance sg13cmos5l_decap_8_4597 r0 *1 0,0
Xsg13cmos5l_decap_8_4597 \$2 \$1 sg13cmos5l_decap_8
* cell instance sg13cmos5l_decap_8_4598 r0 *1 0,0
Xsg13cmos5l_decap_8_4598 \$2 \$1 sg13cmos5l_decap_8
* cell instance sg13cmos5l_decap_8_4599 r0 *1 0,0
Xsg13cmos5l_decap_8_4599 \$2 \$1 sg13cmos5l_decap_8
* cell instance sg13cmos5l_decap_8_4600 r0 *1 0,0
Xsg13cmos5l_decap_8_4600 \$2 \$1 sg13cmos5l_decap_8
* cell instance sg13cmos5l_decap_8_4601 r0 *1 0,0
Xsg13cmos5l_decap_8_4601 \$2 \$1 sg13cmos5l_decap_8
* cell instance sg13cmos5l_decap_8_4602 r0 *1 0,0
Xsg13cmos5l_decap_8_4602 \$2 \$1 sg13cmos5l_decap_8
* cell instance sg13cmos5l_decap_8_4603 r0 *1 0,0
Xsg13cmos5l_decap_8_4603 \$2 \$1 sg13cmos5l_decap_8
* cell instance sg13cmos5l_decap_8_4604 r0 *1 0,0
Xsg13cmos5l_decap_8_4604 \$2 \$1 sg13cmos5l_decap_8
* cell instance sg13cmos5l_decap_8_4605 r0 *1 0,0
Xsg13cmos5l_decap_8_4605 \$2 \$1 sg13cmos5l_decap_8
* cell instance sg13cmos5l_decap_8_4606 r0 *1 0,0
Xsg13cmos5l_decap_8_4606 \$2 \$1 sg13cmos5l_decap_8
* cell instance sg13cmos5l_decap_8_4607 r0 *1 0,0
Xsg13cmos5l_decap_8_4607 \$2 \$1 sg13cmos5l_decap_8
* cell instance sg13cmos5l_decap_8_4608 r0 *1 0,0
Xsg13cmos5l_decap_8_4608 \$2 \$1 sg13cmos5l_decap_8
* cell instance sg13cmos5l_decap_8_4609 r0 *1 0,0
Xsg13cmos5l_decap_8_4609 \$2 \$1 sg13cmos5l_decap_8
* cell instance sg13cmos5l_decap_8_4610 r0 *1 0,0
Xsg13cmos5l_decap_8_4610 \$2 \$1 sg13cmos5l_decap_8
* cell instance sg13cmos5l_decap_8_4611 r0 *1 0,0
Xsg13cmos5l_decap_8_4611 \$2 \$1 sg13cmos5l_decap_8
* cell instance sg13cmos5l_decap_8_4612 r0 *1 0,0
Xsg13cmos5l_decap_8_4612 \$2 \$1 sg13cmos5l_decap_8
* cell instance sg13cmos5l_decap_8_4613 r0 *1 0,0
Xsg13cmos5l_decap_8_4613 \$2 \$1 sg13cmos5l_decap_8
* cell instance sg13cmos5l_decap_8_4614 r0 *1 0,0
Xsg13cmos5l_decap_8_4614 \$2 \$1 sg13cmos5l_decap_8
* cell instance sg13cmos5l_decap_8_4615 r0 *1 0,0
Xsg13cmos5l_decap_8_4615 \$2 \$1 sg13cmos5l_decap_8
* cell instance sg13cmos5l_decap_8_4616 r0 *1 0,0
Xsg13cmos5l_decap_8_4616 \$2 \$1 sg13cmos5l_decap_8
* cell instance sg13cmos5l_decap_8_4617 r0 *1 0,0
Xsg13cmos5l_decap_8_4617 \$2 \$1 sg13cmos5l_decap_8
* cell instance sg13cmos5l_decap_8_4618 r0 *1 0,0
Xsg13cmos5l_decap_8_4618 \$2 \$1 sg13cmos5l_decap_8
* cell instance sg13cmos5l_decap_8_4619 r0 *1 0,0
Xsg13cmos5l_decap_8_4619 \$2 \$1 sg13cmos5l_decap_8
* cell instance sg13cmos5l_decap_8_4620 r0 *1 0,0
Xsg13cmos5l_decap_8_4620 \$2 \$1 sg13cmos5l_decap_8
* cell instance sg13cmos5l_decap_8_4621 r0 *1 0,0
Xsg13cmos5l_decap_8_4621 \$2 \$1 sg13cmos5l_decap_8
* cell instance sg13cmos5l_decap_8_4622 r0 *1 0,0
Xsg13cmos5l_decap_8_4622 \$2 \$1 sg13cmos5l_decap_8
* cell instance sg13cmos5l_decap_8_4623 r0 *1 0,0
Xsg13cmos5l_decap_8_4623 \$2 \$1 sg13cmos5l_decap_8
* cell instance sg13cmos5l_decap_8_4624 r0 *1 0,0
Xsg13cmos5l_decap_8_4624 \$2 \$1 sg13cmos5l_decap_8
* cell instance sg13cmos5l_decap_8_4625 r0 *1 0,0
Xsg13cmos5l_decap_8_4625 \$2 \$1 sg13cmos5l_decap_8
* cell instance sg13cmos5l_decap_8_4626 r0 *1 0,0
Xsg13cmos5l_decap_8_4626 \$2 \$1 sg13cmos5l_decap_8
* cell instance sg13cmos5l_decap_8_4627 r0 *1 0,0
Xsg13cmos5l_decap_8_4627 \$2 \$1 sg13cmos5l_decap_8
* cell instance sg13cmos5l_decap_8_4628 r0 *1 0,0
Xsg13cmos5l_decap_8_4628 \$2 \$1 sg13cmos5l_decap_8
* cell instance sg13cmos5l_decap_8_4629 r0 *1 0,0
Xsg13cmos5l_decap_8_4629 \$2 \$1 sg13cmos5l_decap_8
* cell instance sg13cmos5l_decap_8_4630 r0 *1 0,0
Xsg13cmos5l_decap_8_4630 \$2 \$1 sg13cmos5l_decap_8
* cell instance sg13cmos5l_decap_8_4631 r0 *1 0,0
Xsg13cmos5l_decap_8_4631 \$2 \$1 sg13cmos5l_decap_8
* cell instance sg13cmos5l_decap_8_4632 r0 *1 0,0
Xsg13cmos5l_decap_8_4632 \$2 \$1 sg13cmos5l_decap_8
* cell instance sg13cmos5l_decap_8_4633 r0 *1 0,0
Xsg13cmos5l_decap_8_4633 \$2 \$1 sg13cmos5l_decap_8
* cell instance sg13cmos5l_decap_8_4634 r0 *1 0,0
Xsg13cmos5l_decap_8_4634 \$2 \$1 sg13cmos5l_decap_8
* cell instance sg13cmos5l_decap_8_4635 r0 *1 0,0
Xsg13cmos5l_decap_8_4635 \$2 \$1 sg13cmos5l_decap_8
* cell instance sg13cmos5l_decap_8_4636 r0 *1 0,0
Xsg13cmos5l_decap_8_4636 \$2 \$1 sg13cmos5l_decap_8
* cell instance sg13cmos5l_decap_8_4637 r0 *1 0,0
Xsg13cmos5l_decap_8_4637 \$2 \$1 sg13cmos5l_decap_8
* cell instance sg13cmos5l_decap_8_4638 r0 *1 0,0
Xsg13cmos5l_decap_8_4638 \$2 \$1 sg13cmos5l_decap_8
* cell instance sg13cmos5l_decap_8_4639 r0 *1 0,0
Xsg13cmos5l_decap_8_4639 \$2 \$1 sg13cmos5l_decap_8
* cell instance sg13cmos5l_decap_8_4640 r0 *1 0,0
Xsg13cmos5l_decap_8_4640 \$2 \$1 sg13cmos5l_decap_8
* cell instance sg13cmos5l_decap_8_4641 r0 *1 0,0
Xsg13cmos5l_decap_8_4641 \$2 \$1 sg13cmos5l_decap_8
* cell instance sg13cmos5l_decap_8_4642 r0 *1 0,0
Xsg13cmos5l_decap_8_4642 \$2 \$1 sg13cmos5l_decap_8
* cell instance sg13cmos5l_decap_8_4643 r0 *1 0,0
Xsg13cmos5l_decap_8_4643 \$2 \$1 sg13cmos5l_decap_8
* cell instance sg13cmos5l_decap_8_4644 r0 *1 0,0
Xsg13cmos5l_decap_8_4644 \$2 \$1 sg13cmos5l_decap_8
* cell instance sg13cmos5l_decap_8_4645 r0 *1 0,0
Xsg13cmos5l_decap_8_4645 \$2 \$1 sg13cmos5l_decap_8
* cell instance sg13cmos5l_decap_8_4646 r0 *1 0,0
Xsg13cmos5l_decap_8_4646 \$2 \$1 sg13cmos5l_decap_8
* cell instance sg13cmos5l_decap_8_4647 r0 *1 0,0
Xsg13cmos5l_decap_8_4647 \$2 \$1 sg13cmos5l_decap_8
* cell instance sg13cmos5l_decap_8_4648 r0 *1 0,0
Xsg13cmos5l_decap_8_4648 \$2 \$1 sg13cmos5l_decap_8
* cell instance sg13cmos5l_decap_8_4649 r0 *1 0,0
Xsg13cmos5l_decap_8_4649 \$2 \$1 sg13cmos5l_decap_8
* cell instance sg13cmos5l_decap_8_4650 r0 *1 0,0
Xsg13cmos5l_decap_8_4650 \$2 \$1 sg13cmos5l_decap_8
* cell instance sg13cmos5l_decap_8_4651 r0 *1 0,0
Xsg13cmos5l_decap_8_4651 \$2 \$1 sg13cmos5l_decap_8
* cell instance sg13cmos5l_decap_8_4652 r0 *1 0,0
Xsg13cmos5l_decap_8_4652 \$2 \$1 sg13cmos5l_decap_8
* cell instance sg13cmos5l_decap_8_4653 r0 *1 0,0
Xsg13cmos5l_decap_8_4653 \$2 \$1 sg13cmos5l_decap_8
* cell instance sg13cmos5l_decap_8_4654 r0 *1 0,0
Xsg13cmos5l_decap_8_4654 \$2 \$1 sg13cmos5l_decap_8
* cell instance sg13cmos5l_decap_8_4655 r0 *1 0,0
Xsg13cmos5l_decap_8_4655 \$2 \$1 sg13cmos5l_decap_8
* cell instance sg13cmos5l_decap_8_4656 r0 *1 0,0
Xsg13cmos5l_decap_8_4656 \$2 \$1 sg13cmos5l_decap_8
* cell instance sg13cmos5l_decap_8_4657 r0 *1 0,0
Xsg13cmos5l_decap_8_4657 \$2 \$1 sg13cmos5l_decap_8
* cell instance sg13cmos5l_decap_8_4658 r0 *1 0,0
Xsg13cmos5l_decap_8_4658 \$2 \$1 sg13cmos5l_decap_8
* cell instance sg13cmos5l_decap_8_4659 r0 *1 0,0
Xsg13cmos5l_decap_8_4659 \$2 \$1 sg13cmos5l_decap_8
* cell instance sg13cmos5l_decap_8_4660 r0 *1 0,0
Xsg13cmos5l_decap_8_4660 \$2 \$1 sg13cmos5l_decap_8
* cell instance sg13cmos5l_decap_8_4661 r0 *1 0,0
Xsg13cmos5l_decap_8_4661 \$2 \$1 sg13cmos5l_decap_8
* cell instance sg13cmos5l_decap_8_4662 r0 *1 0,0
Xsg13cmos5l_decap_8_4662 \$2 \$1 sg13cmos5l_decap_8
* cell instance sg13cmos5l_decap_8_4663 r0 *1 0,0
Xsg13cmos5l_decap_8_4663 \$2 \$1 sg13cmos5l_decap_8
* cell instance sg13cmos5l_decap_8_4664 r0 *1 0,0
Xsg13cmos5l_decap_8_4664 \$2 \$1 sg13cmos5l_decap_8
* cell instance sg13cmos5l_decap_8_4665 r0 *1 0,0
Xsg13cmos5l_decap_8_4665 \$2 \$1 sg13cmos5l_decap_8
* cell instance sg13cmos5l_decap_8_4666 r0 *1 0,0
Xsg13cmos5l_decap_8_4666 \$2 \$1 sg13cmos5l_decap_8
* cell instance sg13cmos5l_decap_8_4667 r0 *1 0,0
Xsg13cmos5l_decap_8_4667 \$2 \$1 sg13cmos5l_decap_8
* cell instance sg13cmos5l_decap_8_4668 r0 *1 0,0
Xsg13cmos5l_decap_8_4668 \$2 \$1 sg13cmos5l_decap_8
* cell instance sg13cmos5l_decap_8_4669 r0 *1 0,0
Xsg13cmos5l_decap_8_4669 \$2 \$1 sg13cmos5l_decap_8
* cell instance sg13cmos5l_decap_8_4670 r0 *1 0,0
Xsg13cmos5l_decap_8_4670 \$2 \$1 sg13cmos5l_decap_8
* cell instance sg13cmos5l_decap_8_4671 r0 *1 0,0
Xsg13cmos5l_decap_8_4671 \$2 \$1 sg13cmos5l_decap_8
* cell instance sg13cmos5l_decap_8_4672 r0 *1 0,0
Xsg13cmos5l_decap_8_4672 \$2 \$1 sg13cmos5l_decap_8
* cell instance sg13cmos5l_decap_8_4673 r0 *1 0,0
Xsg13cmos5l_decap_8_4673 \$2 \$1 sg13cmos5l_decap_8
* cell instance sg13cmos5l_decap_8_4674 r0 *1 0,0
Xsg13cmos5l_decap_8_4674 \$2 \$1 sg13cmos5l_decap_8
* cell instance sg13cmos5l_decap_8_4675 r0 *1 0,0
Xsg13cmos5l_decap_8_4675 \$2 \$1 sg13cmos5l_decap_8
* cell instance sg13cmos5l_decap_8_4676 r0 *1 0,0
Xsg13cmos5l_decap_8_4676 \$2 \$1 sg13cmos5l_decap_8
* cell instance sg13cmos5l_decap_8_4677 r0 *1 0,0
Xsg13cmos5l_decap_8_4677 \$2 \$1 sg13cmos5l_decap_8
* cell instance sg13cmos5l_decap_8_4678 r0 *1 0,0
Xsg13cmos5l_decap_8_4678 \$2 \$1 sg13cmos5l_decap_8
* cell instance sg13cmos5l_decap_8_4679 r0 *1 0,0
Xsg13cmos5l_decap_8_4679 \$2 \$1 sg13cmos5l_decap_8
* cell instance sg13cmos5l_decap_8_4680 r0 *1 0,0
Xsg13cmos5l_decap_8_4680 \$2 \$1 sg13cmos5l_decap_8
* cell instance sg13cmos5l_decap_8_4681 r0 *1 0,0
Xsg13cmos5l_decap_8_4681 \$2 \$1 sg13cmos5l_decap_8
* cell instance sg13cmos5l_decap_8_4682 r0 *1 0,0
Xsg13cmos5l_decap_8_4682 \$2 \$1 sg13cmos5l_decap_8
* cell instance sg13cmos5l_decap_8_4683 r0 *1 0,0
Xsg13cmos5l_decap_8_4683 \$2 \$1 sg13cmos5l_decap_8
* cell instance sg13cmos5l_decap_8_4684 r0 *1 0,0
Xsg13cmos5l_decap_8_4684 \$2 \$1 sg13cmos5l_decap_8
* cell instance sg13cmos5l_decap_8_4685 r0 *1 0,0
Xsg13cmos5l_decap_8_4685 \$2 \$1 sg13cmos5l_decap_8
* cell instance sg13cmos5l_decap_8_4686 r0 *1 0,0
Xsg13cmos5l_decap_8_4686 \$2 \$1 sg13cmos5l_decap_8
* cell instance sg13cmos5l_decap_8_4687 r0 *1 0,0
Xsg13cmos5l_decap_8_4687 \$2 \$1 sg13cmos5l_decap_8
* cell instance sg13cmos5l_decap_8_4688 r0 *1 0,0
Xsg13cmos5l_decap_8_4688 \$2 \$1 sg13cmos5l_decap_8
* cell instance sg13cmos5l_decap_8_4689 r0 *1 0,0
Xsg13cmos5l_decap_8_4689 \$2 \$1 sg13cmos5l_decap_8
* cell instance sg13cmos5l_decap_8_4690 r0 *1 0,0
Xsg13cmos5l_decap_8_4690 \$2 \$1 sg13cmos5l_decap_8
* cell instance sg13cmos5l_decap_8_4691 r0 *1 0,0
Xsg13cmos5l_decap_8_4691 \$2 \$1 sg13cmos5l_decap_8
* cell instance sg13cmos5l_decap_8_4692 r0 *1 0,0
Xsg13cmos5l_decap_8_4692 \$2 \$1 sg13cmos5l_decap_8
* cell instance sg13cmos5l_decap_8_4693 r0 *1 0,0
Xsg13cmos5l_decap_8_4693 \$2 \$1 sg13cmos5l_decap_8
* cell instance sg13cmos5l_decap_8_4694 r0 *1 0,0
Xsg13cmos5l_decap_8_4694 \$2 \$1 sg13cmos5l_decap_8
* cell instance sg13cmos5l_decap_8_4695 r0 *1 0,0
Xsg13cmos5l_decap_8_4695 \$2 \$1 sg13cmos5l_decap_8
* cell instance sg13cmos5l_decap_8_4696 r0 *1 0,0
Xsg13cmos5l_decap_8_4696 \$2 \$1 sg13cmos5l_decap_8
* cell instance sg13cmos5l_decap_8_4697 r0 *1 0,0
Xsg13cmos5l_decap_8_4697 \$2 \$1 sg13cmos5l_decap_8
* cell instance sg13cmos5l_decap_8_4698 r0 *1 0,0
Xsg13cmos5l_decap_8_4698 \$2 \$1 sg13cmos5l_decap_8
* cell instance sg13cmos5l_decap_8_4699 r0 *1 0,0
Xsg13cmos5l_decap_8_4699 \$2 \$1 sg13cmos5l_decap_8
* cell instance sg13cmos5l_decap_8_4700 r0 *1 0,0
Xsg13cmos5l_decap_8_4700 \$2 \$1 sg13cmos5l_decap_8
* cell instance sg13cmos5l_decap_8_4701 r0 *1 0,0
Xsg13cmos5l_decap_8_4701 \$2 \$1 sg13cmos5l_decap_8
* cell instance sg13cmos5l_decap_8_4702 r0 *1 0,0
Xsg13cmos5l_decap_8_4702 \$2 \$1 sg13cmos5l_decap_8
* cell instance sg13cmos5l_decap_8_4703 r0 *1 0,0
Xsg13cmos5l_decap_8_4703 \$2 \$1 sg13cmos5l_decap_8
* cell instance sg13cmos5l_decap_8_4704 r0 *1 0,0
Xsg13cmos5l_decap_8_4704 \$2 \$1 sg13cmos5l_decap_8
* cell instance sg13cmos5l_decap_8_4705 r0 *1 0,0
Xsg13cmos5l_decap_8_4705 \$2 \$1 sg13cmos5l_decap_8
* cell instance sg13cmos5l_decap_8_4706 r0 *1 0,0
Xsg13cmos5l_decap_8_4706 \$2 \$1 sg13cmos5l_decap_8
* cell instance sg13cmos5l_decap_8_4707 r0 *1 0,0
Xsg13cmos5l_decap_8_4707 \$2 \$1 sg13cmos5l_decap_8
* cell instance sg13cmos5l_decap_8_4708 r0 *1 0,0
Xsg13cmos5l_decap_8_4708 \$2 \$1 sg13cmos5l_decap_8
* cell instance sg13cmos5l_decap_8_4709 r0 *1 0,0
Xsg13cmos5l_decap_8_4709 \$2 \$1 sg13cmos5l_decap_8
* cell instance sg13cmos5l_decap_8_4710 r0 *1 0,0
Xsg13cmos5l_decap_8_4710 \$2 \$1 sg13cmos5l_decap_8
* cell instance sg13cmos5l_decap_8_4711 r0 *1 0,0
Xsg13cmos5l_decap_8_4711 \$2 \$1 sg13cmos5l_decap_8
* cell instance sg13cmos5l_decap_8_4712 r0 *1 0,0
Xsg13cmos5l_decap_8_4712 \$2 \$1 sg13cmos5l_decap_8
* cell instance sg13cmos5l_decap_8_4713 r0 *1 0,0
Xsg13cmos5l_decap_8_4713 \$2 \$1 sg13cmos5l_decap_8
* cell instance sg13cmos5l_decap_8_4714 r0 *1 0,0
Xsg13cmos5l_decap_8_4714 \$2 \$1 sg13cmos5l_decap_8
* cell instance sg13cmos5l_decap_8_4715 r0 *1 0,0
Xsg13cmos5l_decap_8_4715 \$2 \$1 sg13cmos5l_decap_8
* cell instance sg13cmos5l_decap_8_4716 r0 *1 0,0
Xsg13cmos5l_decap_8_4716 \$2 \$1 sg13cmos5l_decap_8
* cell instance sg13cmos5l_decap_8_4717 r0 *1 0,0
Xsg13cmos5l_decap_8_4717 \$2 \$1 sg13cmos5l_decap_8
* cell instance sg13cmos5l_decap_8_4718 r0 *1 0,0
Xsg13cmos5l_decap_8_4718 \$2 \$1 sg13cmos5l_decap_8
* cell instance sg13cmos5l_decap_8_4719 r0 *1 0,0
Xsg13cmos5l_decap_8_4719 \$2 \$1 sg13cmos5l_decap_8
* cell instance sg13cmos5l_decap_8_4720 r0 *1 0,0
Xsg13cmos5l_decap_8_4720 \$2 \$1 sg13cmos5l_decap_8
* cell instance sg13cmos5l_decap_8_4721 r0 *1 0,0
Xsg13cmos5l_decap_8_4721 \$2 \$1 sg13cmos5l_decap_8
* cell instance sg13cmos5l_decap_8_4722 r0 *1 0,0
Xsg13cmos5l_decap_8_4722 \$2 \$1 sg13cmos5l_decap_8
* cell instance sg13cmos5l_decap_8_4723 r0 *1 0,0
Xsg13cmos5l_decap_8_4723 \$2 \$1 sg13cmos5l_decap_8
* cell instance sg13cmos5l_decap_8_4724 r0 *1 0,0
Xsg13cmos5l_decap_8_4724 \$2 \$1 sg13cmos5l_decap_8
* cell instance sg13cmos5l_decap_8_4725 r0 *1 0,0
Xsg13cmos5l_decap_8_4725 \$2 \$1 sg13cmos5l_decap_8
* cell instance sg13cmos5l_decap_8_4726 r0 *1 0,0
Xsg13cmos5l_decap_8_4726 \$2 \$1 sg13cmos5l_decap_8
* cell instance sg13cmos5l_decap_8_4727 r0 *1 0,0
Xsg13cmos5l_decap_8_4727 \$2 \$1 sg13cmos5l_decap_8
* cell instance sg13cmos5l_decap_8_4728 r0 *1 0,0
Xsg13cmos5l_decap_8_4728 \$2 \$1 sg13cmos5l_decap_8
* cell instance sg13cmos5l_decap_8_4729 r0 *1 0,0
Xsg13cmos5l_decap_8_4729 \$2 \$1 sg13cmos5l_decap_8
* cell instance sg13cmos5l_decap_8_4730 r0 *1 0,0
Xsg13cmos5l_decap_8_4730 \$2 \$1 sg13cmos5l_decap_8
* cell instance sg13cmos5l_decap_8_4731 r0 *1 0,0
Xsg13cmos5l_decap_8_4731 \$2 \$1 sg13cmos5l_decap_8
* cell instance sg13cmos5l_decap_8_4732 r0 *1 0,0
Xsg13cmos5l_decap_8_4732 \$2 \$1 sg13cmos5l_decap_8
* cell instance sg13cmos5l_decap_8_4733 r0 *1 0,0
Xsg13cmos5l_decap_8_4733 \$2 \$1 sg13cmos5l_decap_8
* cell instance sg13cmos5l_decap_8_4734 r0 *1 0,0
Xsg13cmos5l_decap_8_4734 \$2 \$1 sg13cmos5l_decap_8
* cell instance sg13cmos5l_decap_8_4735 r0 *1 0,0
Xsg13cmos5l_decap_8_4735 \$2 \$1 sg13cmos5l_decap_8
* cell instance sg13cmos5l_decap_8_4736 r0 *1 0,0
Xsg13cmos5l_decap_8_4736 \$2 \$1 sg13cmos5l_decap_8
* cell instance sg13cmos5l_decap_8_4737 r0 *1 0,0
Xsg13cmos5l_decap_8_4737 \$2 \$1 sg13cmos5l_decap_8
* cell instance sg13cmos5l_decap_8_4738 r0 *1 0,0
Xsg13cmos5l_decap_8_4738 \$2 \$1 sg13cmos5l_decap_8
* cell instance sg13cmos5l_decap_8_4739 r0 *1 0,0
Xsg13cmos5l_decap_8_4739 \$2 \$1 sg13cmos5l_decap_8
* cell instance sg13cmos5l_decap_8_4740 r0 *1 0,0
Xsg13cmos5l_decap_8_4740 \$2 \$1 sg13cmos5l_decap_8
* cell instance sg13cmos5l_decap_8_4741 r0 *1 0,0
Xsg13cmos5l_decap_8_4741 \$2 \$1 sg13cmos5l_decap_8
* cell instance sg13cmos5l_decap_8_4742 r0 *1 0,0
Xsg13cmos5l_decap_8_4742 \$2 \$1 sg13cmos5l_decap_8
* cell instance sg13cmos5l_decap_8_4743 r0 *1 0,0
Xsg13cmos5l_decap_8_4743 \$2 \$1 sg13cmos5l_decap_8
* cell instance sg13cmos5l_decap_8_4744 r0 *1 0,0
Xsg13cmos5l_decap_8_4744 \$2 \$1 sg13cmos5l_decap_8
* cell instance sg13cmos5l_decap_8_4745 r0 *1 0,0
Xsg13cmos5l_decap_8_4745 \$2 \$1 sg13cmos5l_decap_8
* cell instance sg13cmos5l_decap_8_4746 r0 *1 0,0
Xsg13cmos5l_decap_8_4746 \$2 \$1 sg13cmos5l_decap_8
* cell instance sg13cmos5l_decap_8_4747 r0 *1 0,0
Xsg13cmos5l_decap_8_4747 \$2 \$1 sg13cmos5l_decap_8
* cell instance sg13cmos5l_decap_8_4748 r0 *1 0,0
Xsg13cmos5l_decap_8_4748 \$2 \$1 sg13cmos5l_decap_8
* cell instance sg13cmos5l_decap_8_4749 r0 *1 0,0
Xsg13cmos5l_decap_8_4749 \$2 \$1 sg13cmos5l_decap_8
* cell instance sg13cmos5l_decap_8_4750 r0 *1 0,0
Xsg13cmos5l_decap_8_4750 \$2 \$1 sg13cmos5l_decap_8
* cell instance sg13cmos5l_decap_8_4751 r0 *1 0,0
Xsg13cmos5l_decap_8_4751 \$2 \$1 sg13cmos5l_decap_8
* cell instance sg13cmos5l_decap_8_4752 r0 *1 0,0
Xsg13cmos5l_decap_8_4752 \$2 \$1 sg13cmos5l_decap_8
* cell instance sg13cmos5l_decap_8_4753 r0 *1 0,0
Xsg13cmos5l_decap_8_4753 \$2 \$1 sg13cmos5l_decap_8
* cell instance sg13cmos5l_decap_8_4754 r0 *1 0,0
Xsg13cmos5l_decap_8_4754 \$2 \$1 sg13cmos5l_decap_8
* cell instance sg13cmos5l_decap_8_4755 r0 *1 0,0
Xsg13cmos5l_decap_8_4755 \$2 \$1 sg13cmos5l_decap_8
* cell instance sg13cmos5l_decap_8_4756 r0 *1 0,0
Xsg13cmos5l_decap_8_4756 \$2 \$1 sg13cmos5l_decap_8
* cell instance sg13cmos5l_decap_8_4757 r0 *1 0,0
Xsg13cmos5l_decap_8_4757 \$2 \$1 sg13cmos5l_decap_8
* cell instance sg13cmos5l_decap_8_4758 r0 *1 0,0
Xsg13cmos5l_decap_8_4758 \$2 \$1 sg13cmos5l_decap_8
* cell instance sg13cmos5l_decap_8_4759 r0 *1 0,0
Xsg13cmos5l_decap_8_4759 \$2 \$1 sg13cmos5l_decap_8
* cell instance sg13cmos5l_decap_8_4760 r0 *1 0,0
Xsg13cmos5l_decap_8_4760 \$2 \$1 sg13cmos5l_decap_8
* cell instance sg13cmos5l_decap_8_4761 r0 *1 0,0
Xsg13cmos5l_decap_8_4761 \$2 \$1 sg13cmos5l_decap_8
* cell instance sg13cmos5l_decap_8_4762 r0 *1 0,0
Xsg13cmos5l_decap_8_4762 \$2 \$1 sg13cmos5l_decap_8
* cell instance sg13cmos5l_decap_8_4763 r0 *1 0,0
Xsg13cmos5l_decap_8_4763 \$2 \$1 sg13cmos5l_decap_8
* cell instance sg13cmos5l_decap_8_4764 r0 *1 0,0
Xsg13cmos5l_decap_8_4764 \$2 \$1 sg13cmos5l_decap_8
* cell instance sg13cmos5l_decap_8_4765 r0 *1 0,0
Xsg13cmos5l_decap_8_4765 \$2 \$1 sg13cmos5l_decap_8
* cell instance sg13cmos5l_decap_8_4766 r0 *1 0,0
Xsg13cmos5l_decap_8_4766 \$2 \$1 sg13cmos5l_decap_8
* cell instance sg13cmos5l_decap_8_4767 r0 *1 0,0
Xsg13cmos5l_decap_8_4767 \$2 \$1 sg13cmos5l_decap_8
* cell instance sg13cmos5l_decap_8_4768 r0 *1 0,0
Xsg13cmos5l_decap_8_4768 \$2 \$1 sg13cmos5l_decap_8
* cell instance sg13cmos5l_decap_8_4769 r0 *1 0,0
Xsg13cmos5l_decap_8_4769 \$2 \$1 sg13cmos5l_decap_8
* cell instance sg13cmos5l_decap_8_4770 r0 *1 0,0
Xsg13cmos5l_decap_8_4770 \$2 \$1 sg13cmos5l_decap_8
* cell instance sg13cmos5l_decap_8_4771 r0 *1 0,0
Xsg13cmos5l_decap_8_4771 \$2 \$1 sg13cmos5l_decap_8
* cell instance sg13cmos5l_decap_8_4772 r0 *1 0,0
Xsg13cmos5l_decap_8_4772 \$2 \$1 sg13cmos5l_decap_8
* cell instance sg13cmos5l_decap_8_4773 r0 *1 0,0
Xsg13cmos5l_decap_8_4773 \$2 \$1 sg13cmos5l_decap_8
* cell instance sg13cmos5l_decap_8_4774 r0 *1 0,0
Xsg13cmos5l_decap_8_4774 \$2 \$1 sg13cmos5l_decap_8
* cell instance sg13cmos5l_decap_8_4775 r0 *1 0,0
Xsg13cmos5l_decap_8_4775 \$2 \$1 sg13cmos5l_decap_8
* cell instance sg13cmos5l_decap_8_4776 r0 *1 0,0
Xsg13cmos5l_decap_8_4776 \$2 \$1 sg13cmos5l_decap_8
* cell instance sg13cmos5l_decap_8_4777 r0 *1 0,0
Xsg13cmos5l_decap_8_4777 \$2 \$1 sg13cmos5l_decap_8
* cell instance sg13cmos5l_decap_8_4778 r0 *1 0,0
Xsg13cmos5l_decap_8_4778 \$2 \$1 sg13cmos5l_decap_8
* cell instance sg13cmos5l_decap_8_4779 r0 *1 0,0
Xsg13cmos5l_decap_8_4779 \$2 \$1 sg13cmos5l_decap_8
* cell instance sg13cmos5l_decap_8_4780 r0 *1 0,0
Xsg13cmos5l_decap_8_4780 \$2 \$1 sg13cmos5l_decap_8
* cell instance sg13cmos5l_decap_8_4781 r0 *1 0,0
Xsg13cmos5l_decap_8_4781 \$2 \$1 sg13cmos5l_decap_8
* cell instance sg13cmos5l_decap_8_4782 r0 *1 0,0
Xsg13cmos5l_decap_8_4782 \$2 \$1 sg13cmos5l_decap_8
* cell instance sg13cmos5l_decap_8_4783 r0 *1 0,0
Xsg13cmos5l_decap_8_4783 \$2 \$1 sg13cmos5l_decap_8
* cell instance sg13cmos5l_decap_8_4784 r0 *1 0,0
Xsg13cmos5l_decap_8_4784 \$2 \$1 sg13cmos5l_decap_8
* cell instance sg13cmos5l_decap_8_4785 r0 *1 0,0
Xsg13cmos5l_decap_8_4785 \$2 \$1 sg13cmos5l_decap_8
* cell instance sg13cmos5l_decap_8_4786 r0 *1 0,0
Xsg13cmos5l_decap_8_4786 \$2 \$1 sg13cmos5l_decap_8
* cell instance sg13cmos5l_decap_8_4787 r0 *1 0,0
Xsg13cmos5l_decap_8_4787 \$2 \$1 sg13cmos5l_decap_8
* cell instance sg13cmos5l_decap_8_4788 r0 *1 0,0
Xsg13cmos5l_decap_8_4788 \$2 \$1 sg13cmos5l_decap_8
* cell instance sg13cmos5l_decap_8_4789 r0 *1 0,0
Xsg13cmos5l_decap_8_4789 \$2 \$1 sg13cmos5l_decap_8
* cell instance sg13cmos5l_decap_8_4790 r0 *1 0,0
Xsg13cmos5l_decap_8_4790 \$2 \$1 sg13cmos5l_decap_8
* cell instance sg13cmos5l_decap_8_4791 r0 *1 0,0
Xsg13cmos5l_decap_8_4791 \$2 \$1 sg13cmos5l_decap_8
* cell instance sg13cmos5l_decap_8_4792 r0 *1 0,0
Xsg13cmos5l_decap_8_4792 \$2 \$1 sg13cmos5l_decap_8
* cell instance sg13cmos5l_decap_8_4793 r0 *1 0,0
Xsg13cmos5l_decap_8_4793 \$2 \$1 sg13cmos5l_decap_8
* cell instance sg13cmos5l_decap_8_4794 r0 *1 0,0
Xsg13cmos5l_decap_8_4794 \$2 \$1 sg13cmos5l_decap_8
* cell instance sg13cmos5l_decap_8_4795 r0 *1 0,0
Xsg13cmos5l_decap_8_4795 \$2 \$1 sg13cmos5l_decap_8
* cell instance sg13cmos5l_decap_8_4796 r0 *1 0,0
Xsg13cmos5l_decap_8_4796 \$2 \$1 sg13cmos5l_decap_8
* cell instance sg13cmos5l_decap_8_4797 r0 *1 0,0
Xsg13cmos5l_decap_8_4797 \$2 \$1 sg13cmos5l_decap_8
* cell instance sg13cmos5l_decap_8_4798 r0 *1 0,0
Xsg13cmos5l_decap_8_4798 \$2 \$1 sg13cmos5l_decap_8
* cell instance sg13cmos5l_decap_8_4799 r0 *1 0,0
Xsg13cmos5l_decap_8_4799 \$2 \$1 sg13cmos5l_decap_8
* cell instance sg13cmos5l_decap_8_4800 r0 *1 0,0
Xsg13cmos5l_decap_8_4800 \$2 \$1 sg13cmos5l_decap_8
* cell instance sg13cmos5l_decap_8_4801 r0 *1 0,0
Xsg13cmos5l_decap_8_4801 \$2 \$1 sg13cmos5l_decap_8
* cell instance sg13cmos5l_decap_8_4802 r0 *1 0,0
Xsg13cmos5l_decap_8_4802 \$2 \$1 sg13cmos5l_decap_8
* cell instance sg13cmos5l_decap_8_4803 r0 *1 0,0
Xsg13cmos5l_decap_8_4803 \$2 \$1 sg13cmos5l_decap_8
* cell instance sg13cmos5l_decap_8_4804 r0 *1 0,0
Xsg13cmos5l_decap_8_4804 \$2 \$1 sg13cmos5l_decap_8
* cell instance sg13cmos5l_decap_8_4805 r0 *1 0,0
Xsg13cmos5l_decap_8_4805 \$2 \$1 sg13cmos5l_decap_8
* cell instance sg13cmos5l_decap_8_4806 r0 *1 0,0
Xsg13cmos5l_decap_8_4806 \$2 \$1 sg13cmos5l_decap_8
* cell instance sg13cmos5l_decap_8_4807 r0 *1 0,0
Xsg13cmos5l_decap_8_4807 \$2 \$1 sg13cmos5l_decap_8
* cell instance sg13cmos5l_decap_8_4808 r0 *1 0,0
Xsg13cmos5l_decap_8_4808 \$2 \$1 sg13cmos5l_decap_8
* cell instance sg13cmos5l_decap_8_4809 r0 *1 0,0
Xsg13cmos5l_decap_8_4809 \$2 \$1 sg13cmos5l_decap_8
* cell instance sg13cmos5l_decap_8_4810 r0 *1 0,0
Xsg13cmos5l_decap_8_4810 \$2 \$1 sg13cmos5l_decap_8
* cell instance sg13cmos5l_decap_8_4811 r0 *1 0,0
Xsg13cmos5l_decap_8_4811 \$2 \$1 sg13cmos5l_decap_8
* cell instance sg13cmos5l_decap_8_4812 r0 *1 0,0
Xsg13cmos5l_decap_8_4812 \$2 \$1 sg13cmos5l_decap_8
* cell instance sg13cmos5l_decap_8_4813 r0 *1 0,0
Xsg13cmos5l_decap_8_4813 \$2 \$1 sg13cmos5l_decap_8
* cell instance sg13cmos5l_decap_8_4814 r0 *1 0,0
Xsg13cmos5l_decap_8_4814 \$2 \$1 sg13cmos5l_decap_8
* cell instance sg13cmos5l_decap_8_4815 r0 *1 0,0
Xsg13cmos5l_decap_8_4815 \$2 \$1 sg13cmos5l_decap_8
* cell instance sg13cmos5l_decap_8_4816 r0 *1 0,0
Xsg13cmos5l_decap_8_4816 \$2 \$1 sg13cmos5l_decap_8
* cell instance sg13cmos5l_decap_8_4817 r0 *1 0,0
Xsg13cmos5l_decap_8_4817 \$2 \$1 sg13cmos5l_decap_8
* cell instance sg13cmos5l_decap_8_4818 r0 *1 0,0
Xsg13cmos5l_decap_8_4818 \$2 \$1 sg13cmos5l_decap_8
* cell instance sg13cmos5l_decap_8_4819 r0 *1 0,0
Xsg13cmos5l_decap_8_4819 \$2 \$1 sg13cmos5l_decap_8
* cell instance sg13cmos5l_decap_8_4820 r0 *1 0,0
Xsg13cmos5l_decap_8_4820 \$2 \$1 sg13cmos5l_decap_8
* cell instance sg13cmos5l_decap_8_4821 r0 *1 0,0
Xsg13cmos5l_decap_8_4821 \$2 \$1 sg13cmos5l_decap_8
* cell instance sg13cmos5l_decap_8_4822 r0 *1 0,0
Xsg13cmos5l_decap_8_4822 \$2 \$1 sg13cmos5l_decap_8
* cell instance sg13cmos5l_decap_8_4823 r0 *1 0,0
Xsg13cmos5l_decap_8_4823 \$2 \$1 sg13cmos5l_decap_8
* cell instance sg13cmos5l_decap_8_4824 r0 *1 0,0
Xsg13cmos5l_decap_8_4824 \$2 \$1 sg13cmos5l_decap_8
* cell instance sg13cmos5l_decap_8_4825 r0 *1 0,0
Xsg13cmos5l_decap_8_4825 \$2 \$1 sg13cmos5l_decap_8
* cell instance sg13cmos5l_decap_8_4826 r0 *1 0,0
Xsg13cmos5l_decap_8_4826 \$2 \$1 sg13cmos5l_decap_8
* cell instance sg13cmos5l_decap_8_4827 r0 *1 0,0
Xsg13cmos5l_decap_8_4827 \$2 \$1 sg13cmos5l_decap_8
* cell instance sg13cmos5l_decap_8_4828 r0 *1 0,0
Xsg13cmos5l_decap_8_4828 \$2 \$1 sg13cmos5l_decap_8
* cell instance sg13cmos5l_decap_8_4829 r0 *1 0,0
Xsg13cmos5l_decap_8_4829 \$2 \$1 sg13cmos5l_decap_8
* cell instance sg13cmos5l_decap_8_4830 r0 *1 0,0
Xsg13cmos5l_decap_8_4830 \$2 \$1 sg13cmos5l_decap_8
* cell instance sg13cmos5l_decap_8_4831 r0 *1 0,0
Xsg13cmos5l_decap_8_4831 \$2 \$1 sg13cmos5l_decap_8
* cell instance sg13cmos5l_decap_8_4832 r0 *1 0,0
Xsg13cmos5l_decap_8_4832 \$2 \$1 sg13cmos5l_decap_8
* cell instance sg13cmos5l_decap_8_4833 r0 *1 0,0
Xsg13cmos5l_decap_8_4833 \$2 \$1 sg13cmos5l_decap_8
* cell instance sg13cmos5l_decap_8_4834 r0 *1 0,0
Xsg13cmos5l_decap_8_4834 \$2 \$1 sg13cmos5l_decap_8
* cell instance sg13cmos5l_decap_8_4835 r0 *1 0,0
Xsg13cmos5l_decap_8_4835 \$2 \$1 sg13cmos5l_decap_8
* cell instance sg13cmos5l_decap_8_4836 r0 *1 0,0
Xsg13cmos5l_decap_8_4836 \$2 \$1 sg13cmos5l_decap_8
* cell instance sg13cmos5l_decap_8_4837 r0 *1 0,0
Xsg13cmos5l_decap_8_4837 \$2 \$1 sg13cmos5l_decap_8
* cell instance sg13cmos5l_decap_8_4838 r0 *1 0,0
Xsg13cmos5l_decap_8_4838 \$2 \$1 sg13cmos5l_decap_8
* cell instance sg13cmos5l_decap_8_4839 r0 *1 0,0
Xsg13cmos5l_decap_8_4839 \$2 \$1 sg13cmos5l_decap_8
* cell instance sg13cmos5l_decap_8_4840 r0 *1 0,0
Xsg13cmos5l_decap_8_4840 \$2 \$1 sg13cmos5l_decap_8
* cell instance sg13cmos5l_decap_8_4841 r0 *1 0,0
Xsg13cmos5l_decap_8_4841 \$2 \$1 sg13cmos5l_decap_8
* cell instance sg13cmos5l_decap_8_4842 r0 *1 0,0
Xsg13cmos5l_decap_8_4842 \$2 \$1 sg13cmos5l_decap_8
* cell instance sg13cmos5l_decap_8_4843 r0 *1 0,0
Xsg13cmos5l_decap_8_4843 \$2 \$1 sg13cmos5l_decap_8
* cell instance sg13cmos5l_decap_8_4844 r0 *1 0,0
Xsg13cmos5l_decap_8_4844 \$2 \$1 sg13cmos5l_decap_8
* cell instance sg13cmos5l_decap_8_4845 r0 *1 0,0
Xsg13cmos5l_decap_8_4845 \$2 \$1 sg13cmos5l_decap_8
* cell instance sg13cmos5l_decap_8_4846 r0 *1 0,0
Xsg13cmos5l_decap_8_4846 \$2 \$1 sg13cmos5l_decap_8
* cell instance sg13cmos5l_decap_8_4847 r0 *1 0,0
Xsg13cmos5l_decap_8_4847 \$2 \$1 sg13cmos5l_decap_8
* cell instance sg13cmos5l_decap_8_4848 r0 *1 0,0
Xsg13cmos5l_decap_8_4848 \$2 \$1 sg13cmos5l_decap_8
* cell instance sg13cmos5l_decap_8_4849 r0 *1 0,0
Xsg13cmos5l_decap_8_4849 \$2 \$1 sg13cmos5l_decap_8
* cell instance sg13cmos5l_decap_8_4850 r0 *1 0,0
Xsg13cmos5l_decap_8_4850 \$2 \$1 sg13cmos5l_decap_8
* cell instance sg13cmos5l_decap_8_4851 r0 *1 0,0
Xsg13cmos5l_decap_8_4851 \$2 \$1 sg13cmos5l_decap_8
* cell instance sg13cmos5l_decap_8_4852 r0 *1 0,0
Xsg13cmos5l_decap_8_4852 \$2 \$1 sg13cmos5l_decap_8
* cell instance sg13cmos5l_decap_8_4853 r0 *1 0,0
Xsg13cmos5l_decap_8_4853 \$2 \$1 sg13cmos5l_decap_8
* cell instance sg13cmos5l_decap_8_4854 r0 *1 0,0
Xsg13cmos5l_decap_8_4854 \$2 \$1 sg13cmos5l_decap_8
* cell instance sg13cmos5l_decap_8_4855 r0 *1 0,0
Xsg13cmos5l_decap_8_4855 \$2 \$1 sg13cmos5l_decap_8
* cell instance sg13cmos5l_decap_8_4856 r0 *1 0,0
Xsg13cmos5l_decap_8_4856 \$2 \$1 sg13cmos5l_decap_8
* cell instance sg13cmos5l_decap_8_4857 r0 *1 0,0
Xsg13cmos5l_decap_8_4857 \$2 \$1 sg13cmos5l_decap_8
* cell instance sg13cmos5l_decap_8_4858 r0 *1 0,0
Xsg13cmos5l_decap_8_4858 \$2 \$1 sg13cmos5l_decap_8
* cell instance sg13cmos5l_decap_8_4859 r0 *1 0,0
Xsg13cmos5l_decap_8_4859 \$2 \$1 sg13cmos5l_decap_8
* cell instance sg13cmos5l_decap_8_4860 r0 *1 0,0
Xsg13cmos5l_decap_8_4860 \$2 \$1 sg13cmos5l_decap_8
* cell instance sg13cmos5l_decap_8_4861 r0 *1 0,0
Xsg13cmos5l_decap_8_4861 \$2 \$1 sg13cmos5l_decap_8
* cell instance sg13cmos5l_decap_8_4862 r0 *1 0,0
Xsg13cmos5l_decap_8_4862 \$2 \$1 sg13cmos5l_decap_8
* cell instance sg13cmos5l_decap_8_4863 r0 *1 0,0
Xsg13cmos5l_decap_8_4863 \$2 \$1 sg13cmos5l_decap_8
* cell instance sg13cmos5l_decap_8_4864 r0 *1 0,0
Xsg13cmos5l_decap_8_4864 \$2 \$1 sg13cmos5l_decap_8
* cell instance sg13cmos5l_decap_8_4865 r0 *1 0,0
Xsg13cmos5l_decap_8_4865 \$2 \$1 sg13cmos5l_decap_8
* cell instance sg13cmos5l_decap_8_4866 r0 *1 0,0
Xsg13cmos5l_decap_8_4866 \$2 \$1 sg13cmos5l_decap_8
* cell instance sg13cmos5l_decap_8_4867 r0 *1 0,0
Xsg13cmos5l_decap_8_4867 \$2 \$1 sg13cmos5l_decap_8
* cell instance sg13cmos5l_decap_8_4868 r0 *1 0,0
Xsg13cmos5l_decap_8_4868 \$2 \$1 sg13cmos5l_decap_8
* cell instance sg13cmos5l_decap_8_4869 r0 *1 0,0
Xsg13cmos5l_decap_8_4869 \$2 \$1 sg13cmos5l_decap_8
* cell instance sg13cmos5l_decap_8_4870 r0 *1 0,0
Xsg13cmos5l_decap_8_4870 \$2 \$1 sg13cmos5l_decap_8
* cell instance sg13cmos5l_decap_8_4871 r0 *1 0,0
Xsg13cmos5l_decap_8_4871 \$2 \$1 sg13cmos5l_decap_8
* cell instance sg13cmos5l_decap_8_4872 r0 *1 0,0
Xsg13cmos5l_decap_8_4872 \$2 \$1 sg13cmos5l_decap_8
* cell instance sg13cmos5l_decap_8_4873 r0 *1 0,0
Xsg13cmos5l_decap_8_4873 \$2 \$1 sg13cmos5l_decap_8
* cell instance sg13cmos5l_decap_8_4874 r0 *1 0,0
Xsg13cmos5l_decap_8_4874 \$2 \$1 sg13cmos5l_decap_8
* cell instance sg13cmos5l_decap_8_4875 r0 *1 0,0
Xsg13cmos5l_decap_8_4875 \$2 \$1 sg13cmos5l_decap_8
* cell instance sg13cmos5l_decap_8_4876 r0 *1 0,0
Xsg13cmos5l_decap_8_4876 \$2 \$1 sg13cmos5l_decap_8
* cell instance sg13cmos5l_decap_8_4877 r0 *1 0,0
Xsg13cmos5l_decap_8_4877 \$2 \$1 sg13cmos5l_decap_8
* cell instance sg13cmos5l_decap_8_4878 r0 *1 0,0
Xsg13cmos5l_decap_8_4878 \$2 \$1 sg13cmos5l_decap_8
* cell instance sg13cmos5l_decap_8_4879 r0 *1 0,0
Xsg13cmos5l_decap_8_4879 \$2 \$1 sg13cmos5l_decap_8
* cell instance sg13cmos5l_decap_8_4880 r0 *1 0,0
Xsg13cmos5l_decap_8_4880 \$2 \$1 sg13cmos5l_decap_8
* cell instance sg13cmos5l_decap_8_4881 r0 *1 0,0
Xsg13cmos5l_decap_8_4881 \$2 \$1 sg13cmos5l_decap_8
* cell instance sg13cmos5l_decap_8_4882 r0 *1 0,0
Xsg13cmos5l_decap_8_4882 \$2 \$1 sg13cmos5l_decap_8
* cell instance sg13cmos5l_decap_8_4883 r0 *1 0,0
Xsg13cmos5l_decap_8_4883 \$2 \$1 sg13cmos5l_decap_8
* cell instance sg13cmos5l_decap_8_4884 r0 *1 0,0
Xsg13cmos5l_decap_8_4884 \$2 \$1 sg13cmos5l_decap_8
* cell instance sg13cmos5l_decap_8_4885 r0 *1 0,0
Xsg13cmos5l_decap_8_4885 \$2 \$1 sg13cmos5l_decap_8
* cell instance sg13cmos5l_decap_8_4886 r0 *1 0,0
Xsg13cmos5l_decap_8_4886 \$2 \$1 sg13cmos5l_decap_8
* cell instance sg13cmos5l_decap_8_4887 r0 *1 0,0
Xsg13cmos5l_decap_8_4887 \$2 \$1 sg13cmos5l_decap_8
* cell instance sg13cmos5l_decap_8_4888 r0 *1 0,0
Xsg13cmos5l_decap_8_4888 \$2 \$1 sg13cmos5l_decap_8
* cell instance sg13cmos5l_decap_8_4889 r0 *1 0,0
Xsg13cmos5l_decap_8_4889 \$2 \$1 sg13cmos5l_decap_8
* cell instance sg13cmos5l_decap_8_4890 r0 *1 0,0
Xsg13cmos5l_decap_8_4890 \$2 \$1 sg13cmos5l_decap_8
* cell instance sg13cmos5l_decap_8_4891 r0 *1 0,0
Xsg13cmos5l_decap_8_4891 \$2 \$1 sg13cmos5l_decap_8
* cell instance sg13cmos5l_decap_8_4892 r0 *1 0,0
Xsg13cmos5l_decap_8_4892 \$2 \$1 sg13cmos5l_decap_8
* cell instance sg13cmos5l_decap_8_4893 r0 *1 0,0
Xsg13cmos5l_decap_8_4893 \$2 \$1 sg13cmos5l_decap_8
* cell instance sg13cmos5l_decap_8_4894 r0 *1 0,0
Xsg13cmos5l_decap_8_4894 \$2 \$1 sg13cmos5l_decap_8
* cell instance sg13cmos5l_decap_8_4895 r0 *1 0,0
Xsg13cmos5l_decap_8_4895 \$2 \$1 sg13cmos5l_decap_8
* cell instance sg13cmos5l_decap_8_4896 r0 *1 0,0
Xsg13cmos5l_decap_8_4896 \$2 \$1 sg13cmos5l_decap_8
* cell instance sg13cmos5l_decap_8_4897 r0 *1 0,0
Xsg13cmos5l_decap_8_4897 \$2 \$1 sg13cmos5l_decap_8
* cell instance sg13cmos5l_decap_8_4898 r0 *1 0,0
Xsg13cmos5l_decap_8_4898 \$2 \$1 sg13cmos5l_decap_8
* cell instance sg13cmos5l_decap_8_4899 r0 *1 0,0
Xsg13cmos5l_decap_8_4899 \$2 \$1 sg13cmos5l_decap_8
* cell instance sg13cmos5l_decap_8_4900 r0 *1 0,0
Xsg13cmos5l_decap_8_4900 \$2 \$1 sg13cmos5l_decap_8
* cell instance sg13cmos5l_decap_8_4901 r0 *1 0,0
Xsg13cmos5l_decap_8_4901 \$2 \$1 sg13cmos5l_decap_8
* cell instance sg13cmos5l_decap_8_4902 r0 *1 0,0
Xsg13cmos5l_decap_8_4902 \$2 \$1 sg13cmos5l_decap_8
* cell instance sg13cmos5l_decap_8_4903 r0 *1 0,0
Xsg13cmos5l_decap_8_4903 \$2 \$1 sg13cmos5l_decap_8
* cell instance sg13cmos5l_decap_8_4904 r0 *1 0,0
Xsg13cmos5l_decap_8_4904 \$2 \$1 sg13cmos5l_decap_8
* cell instance sg13cmos5l_decap_8_4905 r0 *1 0,0
Xsg13cmos5l_decap_8_4905 \$2 \$1 sg13cmos5l_decap_8
* cell instance sg13cmos5l_decap_8_4906 r0 *1 0,0
Xsg13cmos5l_decap_8_4906 \$2 \$1 sg13cmos5l_decap_8
* cell instance sg13cmos5l_decap_8_4907 r0 *1 0,0
Xsg13cmos5l_decap_8_4907 \$2 \$1 sg13cmos5l_decap_8
* cell instance sg13cmos5l_decap_8_4908 r0 *1 0,0
Xsg13cmos5l_decap_8_4908 \$2 \$1 sg13cmos5l_decap_8
* cell instance sg13cmos5l_decap_8_4909 r0 *1 0,0
Xsg13cmos5l_decap_8_4909 \$2 \$1 sg13cmos5l_decap_8
* cell instance sg13cmos5l_decap_8_4910 r0 *1 0,0
Xsg13cmos5l_decap_8_4910 \$2 \$1 sg13cmos5l_decap_8
* cell instance sg13cmos5l_decap_8_4911 r0 *1 0,0
Xsg13cmos5l_decap_8_4911 \$2 \$1 sg13cmos5l_decap_8
* cell instance sg13cmos5l_decap_8_4912 r0 *1 0,0
Xsg13cmos5l_decap_8_4912 \$2 \$1 sg13cmos5l_decap_8
* cell instance sg13cmos5l_decap_8_4913 r0 *1 0,0
Xsg13cmos5l_decap_8_4913 \$2 \$1 sg13cmos5l_decap_8
* cell instance sg13cmos5l_decap_8_4914 r0 *1 0,0
Xsg13cmos5l_decap_8_4914 \$2 \$1 sg13cmos5l_decap_8
* cell instance sg13cmos5l_decap_8_4915 r0 *1 0,0
Xsg13cmos5l_decap_8_4915 \$2 \$1 sg13cmos5l_decap_8
* cell instance sg13cmos5l_decap_8_4916 r0 *1 0,0
Xsg13cmos5l_decap_8_4916 \$2 \$1 sg13cmos5l_decap_8
* cell instance sg13cmos5l_decap_8_4917 r0 *1 0,0
Xsg13cmos5l_decap_8_4917 \$2 \$1 sg13cmos5l_decap_8
* cell instance sg13cmos5l_decap_8_4918 r0 *1 0,0
Xsg13cmos5l_decap_8_4918 \$2 \$1 sg13cmos5l_decap_8
* cell instance sg13cmos5l_decap_8_4919 r0 *1 0,0
Xsg13cmos5l_decap_8_4919 \$2 \$1 sg13cmos5l_decap_8
* cell instance sg13cmos5l_decap_8_4920 r0 *1 0,0
Xsg13cmos5l_decap_8_4920 \$2 \$1 sg13cmos5l_decap_8
* cell instance sg13cmos5l_decap_8_4921 r0 *1 0,0
Xsg13cmos5l_decap_8_4921 \$2 \$1 sg13cmos5l_decap_8
* cell instance sg13cmos5l_decap_8_4922 r0 *1 0,0
Xsg13cmos5l_decap_8_4922 \$2 \$1 sg13cmos5l_decap_8
* cell instance sg13cmos5l_decap_8_4923 r0 *1 0,0
Xsg13cmos5l_decap_8_4923 \$2 \$1 sg13cmos5l_decap_8
* cell instance sg13cmos5l_decap_8_4924 r0 *1 0,0
Xsg13cmos5l_decap_8_4924 \$2 \$1 sg13cmos5l_decap_8
* cell instance sg13cmos5l_decap_8_4925 r0 *1 0,0
Xsg13cmos5l_decap_8_4925 \$2 \$1 sg13cmos5l_decap_8
* cell instance sg13cmos5l_decap_8_4926 r0 *1 0,0
Xsg13cmos5l_decap_8_4926 \$2 \$1 sg13cmos5l_decap_8
* cell instance sg13cmos5l_decap_8_4927 r0 *1 0,0
Xsg13cmos5l_decap_8_4927 \$2 \$1 sg13cmos5l_decap_8
* cell instance sg13cmos5l_decap_8_4928 r0 *1 0,0
Xsg13cmos5l_decap_8_4928 \$2 \$1 sg13cmos5l_decap_8
* cell instance sg13cmos5l_decap_8_4929 r0 *1 0,0
Xsg13cmos5l_decap_8_4929 \$2 \$1 sg13cmos5l_decap_8
* cell instance sg13cmos5l_decap_8_4930 r0 *1 0,0
Xsg13cmos5l_decap_8_4930 \$2 \$1 sg13cmos5l_decap_8
* cell instance sg13cmos5l_decap_8_4931 r0 *1 0,0
Xsg13cmos5l_decap_8_4931 \$2 \$1 sg13cmos5l_decap_8
* cell instance sg13cmos5l_decap_8_4932 r0 *1 0,0
Xsg13cmos5l_decap_8_4932 \$2 \$1 sg13cmos5l_decap_8
* cell instance sg13cmos5l_decap_8_4933 r0 *1 0,0
Xsg13cmos5l_decap_8_4933 \$2 \$1 sg13cmos5l_decap_8
* cell instance sg13cmos5l_decap_8_4934 r0 *1 0,0
Xsg13cmos5l_decap_8_4934 \$2 \$1 sg13cmos5l_decap_8
* cell instance sg13cmos5l_decap_8_4935 r0 *1 0,0
Xsg13cmos5l_decap_8_4935 \$2 \$1 sg13cmos5l_decap_8
* cell instance sg13cmos5l_decap_8_4936 r0 *1 0,0
Xsg13cmos5l_decap_8_4936 \$2 \$1 sg13cmos5l_decap_8
* cell instance sg13cmos5l_decap_8_4937 r0 *1 0,0
Xsg13cmos5l_decap_8_4937 \$2 \$1 sg13cmos5l_decap_8
* cell instance sg13cmos5l_decap_8_4938 r0 *1 0,0
Xsg13cmos5l_decap_8_4938 \$2 \$1 sg13cmos5l_decap_8
* cell instance sg13cmos5l_decap_8_4939 r0 *1 0,0
Xsg13cmos5l_decap_8_4939 \$2 \$1 sg13cmos5l_decap_8
* cell instance sg13cmos5l_decap_8_4940 r0 *1 0,0
Xsg13cmos5l_decap_8_4940 \$2 \$1 sg13cmos5l_decap_8
* cell instance sg13cmos5l_decap_8_4941 r0 *1 0,0
Xsg13cmos5l_decap_8_4941 \$2 \$1 sg13cmos5l_decap_8
* cell instance sg13cmos5l_decap_8_4942 r0 *1 0,0
Xsg13cmos5l_decap_8_4942 \$2 \$1 sg13cmos5l_decap_8
* cell instance sg13cmos5l_decap_8_4943 r0 *1 0,0
Xsg13cmos5l_decap_8_4943 \$2 \$1 sg13cmos5l_decap_8
* cell instance sg13cmos5l_decap_8_4944 r0 *1 0,0
Xsg13cmos5l_decap_8_4944 \$2 \$1 sg13cmos5l_decap_8
* cell instance sg13cmos5l_decap_8_4945 r0 *1 0,0
Xsg13cmos5l_decap_8_4945 \$2 \$1 sg13cmos5l_decap_8
* cell instance sg13cmos5l_decap_8_4946 r0 *1 0,0
Xsg13cmos5l_decap_8_4946 \$2 \$1 sg13cmos5l_decap_8
* cell instance sg13cmos5l_decap_8_4947 r0 *1 0,0
Xsg13cmos5l_decap_8_4947 \$2 \$1 sg13cmos5l_decap_8
* cell instance sg13cmos5l_decap_8_4948 r0 *1 0,0
Xsg13cmos5l_decap_8_4948 \$2 \$1 sg13cmos5l_decap_8
* cell instance sg13cmos5l_decap_8_4949 r0 *1 0,0
Xsg13cmos5l_decap_8_4949 \$2 \$1 sg13cmos5l_decap_8
* cell instance sg13cmos5l_decap_8_4950 r0 *1 0,0
Xsg13cmos5l_decap_8_4950 \$2 \$1 sg13cmos5l_decap_8
* cell instance sg13cmos5l_decap_8_4951 r0 *1 0,0
Xsg13cmos5l_decap_8_4951 \$2 \$1 sg13cmos5l_decap_8
* cell instance sg13cmos5l_decap_8_4952 r0 *1 0,0
Xsg13cmos5l_decap_8_4952 \$2 \$1 sg13cmos5l_decap_8
* cell instance sg13cmos5l_decap_8_4953 r0 *1 0,0
Xsg13cmos5l_decap_8_4953 \$2 \$1 sg13cmos5l_decap_8
* cell instance sg13cmos5l_decap_8_4954 r0 *1 0,0
Xsg13cmos5l_decap_8_4954 \$2 \$1 sg13cmos5l_decap_8
* cell instance sg13cmos5l_decap_8_4955 r0 *1 0,0
Xsg13cmos5l_decap_8_4955 \$2 \$1 sg13cmos5l_decap_8
* cell instance sg13cmos5l_decap_8_4956 r0 *1 0,0
Xsg13cmos5l_decap_8_4956 \$2 \$1 sg13cmos5l_decap_8
* cell instance sg13cmos5l_decap_8_4957 r0 *1 0,0
Xsg13cmos5l_decap_8_4957 \$2 \$1 sg13cmos5l_decap_8
* cell instance sg13cmos5l_decap_8_4958 r0 *1 0,0
Xsg13cmos5l_decap_8_4958 \$2 \$1 sg13cmos5l_decap_8
* cell instance sg13cmos5l_decap_8_4959 r0 *1 0,0
Xsg13cmos5l_decap_8_4959 \$2 \$1 sg13cmos5l_decap_8
* cell instance sg13cmos5l_decap_8_4960 r0 *1 0,0
Xsg13cmos5l_decap_8_4960 \$2 \$1 sg13cmos5l_decap_8
* cell instance sg13cmos5l_decap_8_4961 r0 *1 0,0
Xsg13cmos5l_decap_8_4961 \$2 \$1 sg13cmos5l_decap_8
* cell instance sg13cmos5l_decap_8_4962 r0 *1 0,0
Xsg13cmos5l_decap_8_4962 \$2 \$1 sg13cmos5l_decap_8
* cell instance sg13cmos5l_decap_8_4963 r0 *1 0,0
Xsg13cmos5l_decap_8_4963 \$2 \$1 sg13cmos5l_decap_8
* cell instance sg13cmos5l_decap_8_4964 r0 *1 0,0
Xsg13cmos5l_decap_8_4964 \$2 \$1 sg13cmos5l_decap_8
* cell instance sg13cmos5l_decap_8_4965 r0 *1 0,0
Xsg13cmos5l_decap_8_4965 \$2 \$1 sg13cmos5l_decap_8
* cell instance sg13cmos5l_decap_8_4966 r0 *1 0,0
Xsg13cmos5l_decap_8_4966 \$2 \$1 sg13cmos5l_decap_8
* cell instance sg13cmos5l_decap_8_4967 r0 *1 0,0
Xsg13cmos5l_decap_8_4967 \$2 \$1 sg13cmos5l_decap_8
* cell instance sg13cmos5l_decap_8_4968 r0 *1 0,0
Xsg13cmos5l_decap_8_4968 \$2 \$1 sg13cmos5l_decap_8
* cell instance sg13cmos5l_decap_8_4969 r0 *1 0,0
Xsg13cmos5l_decap_8_4969 \$2 \$1 sg13cmos5l_decap_8
* cell instance sg13cmos5l_decap_8_4970 r0 *1 0,0
Xsg13cmos5l_decap_8_4970 \$2 \$1 sg13cmos5l_decap_8
* cell instance sg13cmos5l_decap_8_4971 r0 *1 0,0
Xsg13cmos5l_decap_8_4971 \$2 \$1 sg13cmos5l_decap_8
* cell instance sg13cmos5l_decap_8_4972 r0 *1 0,0
Xsg13cmos5l_decap_8_4972 \$2 \$1 sg13cmos5l_decap_8
* cell instance sg13cmos5l_decap_8_4973 r0 *1 0,0
Xsg13cmos5l_decap_8_4973 \$2 \$1 sg13cmos5l_decap_8
* cell instance sg13cmos5l_decap_8_4974 r0 *1 0,0
Xsg13cmos5l_decap_8_4974 \$2 \$1 sg13cmos5l_decap_8
* cell instance sg13cmos5l_decap_8_4975 r0 *1 0,0
Xsg13cmos5l_decap_8_4975 \$2 \$1 sg13cmos5l_decap_8
* cell instance sg13cmos5l_decap_8_4976 r0 *1 0,0
Xsg13cmos5l_decap_8_4976 \$2 \$1 sg13cmos5l_decap_8
* cell instance sg13cmos5l_decap_8_4977 r0 *1 0,0
Xsg13cmos5l_decap_8_4977 \$2 \$1 sg13cmos5l_decap_8
* cell instance sg13cmos5l_decap_8_4978 r0 *1 0,0
Xsg13cmos5l_decap_8_4978 \$2 \$1 sg13cmos5l_decap_8
* cell instance sg13cmos5l_decap_8_4979 r0 *1 0,0
Xsg13cmos5l_decap_8_4979 \$2 \$1 sg13cmos5l_decap_8
* cell instance sg13cmos5l_decap_8_4980 r0 *1 0,0
Xsg13cmos5l_decap_8_4980 \$2 \$1 sg13cmos5l_decap_8
* cell instance sg13cmos5l_decap_8_4981 r0 *1 0,0
Xsg13cmos5l_decap_8_4981 \$2 \$1 sg13cmos5l_decap_8
* cell instance sg13cmos5l_decap_8_4982 r0 *1 0,0
Xsg13cmos5l_decap_8_4982 \$2 \$1 sg13cmos5l_decap_8
* cell instance sg13cmos5l_decap_8_4983 r0 *1 0,0
Xsg13cmos5l_decap_8_4983 \$2 \$1 sg13cmos5l_decap_8
* cell instance sg13cmos5l_decap_8_4984 r0 *1 0,0
Xsg13cmos5l_decap_8_4984 \$2 \$1 sg13cmos5l_decap_8
* cell instance sg13cmos5l_decap_8_4985 r0 *1 0,0
Xsg13cmos5l_decap_8_4985 \$2 \$1 sg13cmos5l_decap_8
* cell instance sg13cmos5l_decap_8_4986 r0 *1 0,0
Xsg13cmos5l_decap_8_4986 \$2 \$1 sg13cmos5l_decap_8
* cell instance sg13cmos5l_decap_8_4987 r0 *1 0,0
Xsg13cmos5l_decap_8_4987 \$2 \$1 sg13cmos5l_decap_8
* cell instance sg13cmos5l_decap_8_4988 r0 *1 0,0
Xsg13cmos5l_decap_8_4988 \$2 \$1 sg13cmos5l_decap_8
* cell instance sg13cmos5l_decap_8_4989 r0 *1 0,0
Xsg13cmos5l_decap_8_4989 \$2 \$1 sg13cmos5l_decap_8
* cell instance sg13cmos5l_decap_8_4990 r0 *1 0,0
Xsg13cmos5l_decap_8_4990 \$2 \$1 sg13cmos5l_decap_8
* cell instance sg13cmos5l_decap_8_4991 r0 *1 0,0
Xsg13cmos5l_decap_8_4991 \$2 \$1 sg13cmos5l_decap_8
* cell instance sg13cmos5l_decap_8_4992 r0 *1 0,0
Xsg13cmos5l_decap_8_4992 \$2 \$1 sg13cmos5l_decap_8
* cell instance sg13cmos5l_decap_8_4993 r0 *1 0,0
Xsg13cmos5l_decap_8_4993 \$2 \$1 sg13cmos5l_decap_8
* cell instance sg13cmos5l_decap_8_4994 r0 *1 0,0
Xsg13cmos5l_decap_8_4994 \$2 \$1 sg13cmos5l_decap_8
* cell instance sg13cmos5l_decap_8_4995 r0 *1 0,0
Xsg13cmos5l_decap_8_4995 \$2 \$1 sg13cmos5l_decap_8
* cell instance sg13cmos5l_decap_8_4996 r0 *1 0,0
Xsg13cmos5l_decap_8_4996 \$2 \$1 sg13cmos5l_decap_8
* cell instance sg13cmos5l_decap_8_4997 r0 *1 0,0
Xsg13cmos5l_decap_8_4997 \$2 \$1 sg13cmos5l_decap_8
* cell instance sg13cmos5l_decap_8_4998 r0 *1 0,0
Xsg13cmos5l_decap_8_4998 \$2 \$1 sg13cmos5l_decap_8
* cell instance sg13cmos5l_decap_8_4999 r0 *1 0,0
Xsg13cmos5l_decap_8_4999 \$2 \$1 sg13cmos5l_decap_8
* cell instance sg13cmos5l_decap_8_5000 r0 *1 0,0
Xsg13cmos5l_decap_8_5000 \$2 \$1 sg13cmos5l_decap_8
* cell instance sg13cmos5l_decap_8_5001 r0 *1 0,0
Xsg13cmos5l_decap_8_5001 \$2 \$1 sg13cmos5l_decap_8
* cell instance sg13cmos5l_decap_8_5002 r0 *1 0,0
Xsg13cmos5l_decap_8_5002 \$2 \$1 sg13cmos5l_decap_8
* cell instance sg13cmos5l_decap_8_5003 r0 *1 0,0
Xsg13cmos5l_decap_8_5003 \$2 \$1 sg13cmos5l_decap_8
* cell instance sg13cmos5l_decap_8_5004 r0 *1 0,0
Xsg13cmos5l_decap_8_5004 \$2 \$1 sg13cmos5l_decap_8
* cell instance sg13cmos5l_decap_8_5005 r0 *1 0,0
Xsg13cmos5l_decap_8_5005 \$2 \$1 sg13cmos5l_decap_8
* cell instance sg13cmos5l_decap_8_5006 r0 *1 0,0
Xsg13cmos5l_decap_8_5006 \$2 \$1 sg13cmos5l_decap_8
* cell instance sg13cmos5l_decap_8_5007 r0 *1 0,0
Xsg13cmos5l_decap_8_5007 \$2 \$1 sg13cmos5l_decap_8
* cell instance sg13cmos5l_decap_8_5008 r0 *1 0,0
Xsg13cmos5l_decap_8_5008 \$2 \$1 sg13cmos5l_decap_8
* cell instance sg13cmos5l_decap_8_5009 r0 *1 0,0
Xsg13cmos5l_decap_8_5009 \$2 \$1 sg13cmos5l_decap_8
* cell instance sg13cmos5l_decap_8_5010 r0 *1 0,0
Xsg13cmos5l_decap_8_5010 \$2 \$1 sg13cmos5l_decap_8
* cell instance sg13cmos5l_decap_8_5011 r0 *1 0,0
Xsg13cmos5l_decap_8_5011 \$2 \$1 sg13cmos5l_decap_8
* cell instance sg13cmos5l_decap_8_5012 r0 *1 0,0
Xsg13cmos5l_decap_8_5012 \$2 \$1 sg13cmos5l_decap_8
* cell instance sg13cmos5l_decap_8_5013 r0 *1 0,0
Xsg13cmos5l_decap_8_5013 \$2 \$1 sg13cmos5l_decap_8
* cell instance sg13cmos5l_decap_8_5014 r0 *1 0,0
Xsg13cmos5l_decap_8_5014 \$2 \$1 sg13cmos5l_decap_8
* cell instance sg13cmos5l_decap_8_5015 r0 *1 0,0
Xsg13cmos5l_decap_8_5015 \$2 \$1 sg13cmos5l_decap_8
* cell instance sg13cmos5l_decap_8_5016 r0 *1 0,0
Xsg13cmos5l_decap_8_5016 \$2 \$1 sg13cmos5l_decap_8
* cell instance sg13cmos5l_decap_8_5017 r0 *1 0,0
Xsg13cmos5l_decap_8_5017 \$2 \$1 sg13cmos5l_decap_8
* cell instance sg13cmos5l_decap_8_5018 r0 *1 0,0
Xsg13cmos5l_decap_8_5018 \$2 \$1 sg13cmos5l_decap_8
* cell instance sg13cmos5l_decap_8_5019 r0 *1 0,0
Xsg13cmos5l_decap_8_5019 \$2 \$1 sg13cmos5l_decap_8
* cell instance sg13cmos5l_decap_8_5020 r0 *1 0,0
Xsg13cmos5l_decap_8_5020 \$2 \$1 sg13cmos5l_decap_8
* cell instance sg13cmos5l_decap_8_5021 r0 *1 0,0
Xsg13cmos5l_decap_8_5021 \$2 \$1 sg13cmos5l_decap_8
* cell instance sg13cmos5l_decap_8_5022 r0 *1 0,0
Xsg13cmos5l_decap_8_5022 \$2 \$1 sg13cmos5l_decap_8
* cell instance sg13cmos5l_decap_8_5023 r0 *1 0,0
Xsg13cmos5l_decap_8_5023 \$2 \$1 sg13cmos5l_decap_8
* cell instance sg13cmos5l_decap_8_5024 r0 *1 0,0
Xsg13cmos5l_decap_8_5024 \$2 \$1 sg13cmos5l_decap_8
* cell instance sg13cmos5l_decap_8_5025 r0 *1 0,0
Xsg13cmos5l_decap_8_5025 \$2 \$1 sg13cmos5l_decap_8
* cell instance sg13cmos5l_decap_8_5026 r0 *1 0,0
Xsg13cmos5l_decap_8_5026 \$2 \$1 sg13cmos5l_decap_8
* cell instance sg13cmos5l_decap_8_5027 r0 *1 0,0
Xsg13cmos5l_decap_8_5027 \$2 \$1 sg13cmos5l_decap_8
* cell instance sg13cmos5l_decap_8_5028 r0 *1 0,0
Xsg13cmos5l_decap_8_5028 \$2 \$1 sg13cmos5l_decap_8
* cell instance sg13cmos5l_decap_8_5029 r0 *1 0,0
Xsg13cmos5l_decap_8_5029 \$2 \$1 sg13cmos5l_decap_8
* cell instance sg13cmos5l_decap_8_5030 r0 *1 0,0
Xsg13cmos5l_decap_8_5030 \$2 \$1 sg13cmos5l_decap_8
* cell instance sg13cmos5l_decap_8_5031 r0 *1 0,0
Xsg13cmos5l_decap_8_5031 \$2 \$1 sg13cmos5l_decap_8
* cell instance sg13cmos5l_decap_8_5032 r0 *1 0,0
Xsg13cmos5l_decap_8_5032 \$2 \$1 sg13cmos5l_decap_8
* cell instance sg13cmos5l_decap_8_5033 r0 *1 0,0
Xsg13cmos5l_decap_8_5033 \$2 \$1 sg13cmos5l_decap_8
* cell instance sg13cmos5l_decap_8_5034 r0 *1 0,0
Xsg13cmos5l_decap_8_5034 \$2 \$1 sg13cmos5l_decap_8
* cell instance sg13cmos5l_decap_8_5035 r0 *1 0,0
Xsg13cmos5l_decap_8_5035 \$2 \$1 sg13cmos5l_decap_8
* cell instance sg13cmos5l_decap_8_5036 r0 *1 0,0
Xsg13cmos5l_decap_8_5036 \$2 \$1 sg13cmos5l_decap_8
* cell instance sg13cmos5l_decap_8_5037 r0 *1 0,0
Xsg13cmos5l_decap_8_5037 \$2 \$1 sg13cmos5l_decap_8
* cell instance sg13cmos5l_decap_8_5038 r0 *1 0,0
Xsg13cmos5l_decap_8_5038 \$2 \$1 sg13cmos5l_decap_8
* cell instance sg13cmos5l_decap_8_5039 r0 *1 0,0
Xsg13cmos5l_decap_8_5039 \$2 \$1 sg13cmos5l_decap_8
* cell instance sg13cmos5l_decap_8_5040 r0 *1 0,0
Xsg13cmos5l_decap_8_5040 \$2 \$1 sg13cmos5l_decap_8
* cell instance sg13cmos5l_decap_8_5041 r0 *1 0,0
Xsg13cmos5l_decap_8_5041 \$2 \$1 sg13cmos5l_decap_8
* cell instance sg13cmos5l_decap_8_5042 r0 *1 0,0
Xsg13cmos5l_decap_8_5042 \$2 \$1 sg13cmos5l_decap_8
* cell instance sg13cmos5l_decap_8_5043 r0 *1 0,0
Xsg13cmos5l_decap_8_5043 \$2 \$1 sg13cmos5l_decap_8
* cell instance sg13cmos5l_decap_8_5044 r0 *1 0,0
Xsg13cmos5l_decap_8_5044 \$2 \$1 sg13cmos5l_decap_8
* cell instance sg13cmos5l_decap_8_5045 r0 *1 0,0
Xsg13cmos5l_decap_8_5045 \$2 \$1 sg13cmos5l_decap_8
* cell instance sg13cmos5l_decap_8_5046 r0 *1 0,0
Xsg13cmos5l_decap_8_5046 \$2 \$1 sg13cmos5l_decap_8
* cell instance sg13cmos5l_decap_8_5047 r0 *1 0,0
Xsg13cmos5l_decap_8_5047 \$2 \$1 sg13cmos5l_decap_8
* cell instance sg13cmos5l_decap_8_5048 r0 *1 0,0
Xsg13cmos5l_decap_8_5048 \$2 \$1 sg13cmos5l_decap_8
* cell instance sg13cmos5l_decap_8_5049 r0 *1 0,0
Xsg13cmos5l_decap_8_5049 \$2 \$1 sg13cmos5l_decap_8
* cell instance sg13cmos5l_decap_8_5050 r0 *1 0,0
Xsg13cmos5l_decap_8_5050 \$2 \$1 sg13cmos5l_decap_8
* cell instance sg13cmos5l_decap_8_5051 r0 *1 0,0
Xsg13cmos5l_decap_8_5051 \$2 \$1 sg13cmos5l_decap_8
* cell instance sg13cmos5l_decap_8_5052 r0 *1 0,0
Xsg13cmos5l_decap_8_5052 \$2 \$1 sg13cmos5l_decap_8
* cell instance sg13cmos5l_decap_8_5053 r0 *1 0,0
Xsg13cmos5l_decap_8_5053 \$2 \$1 sg13cmos5l_decap_8
* cell instance sg13cmos5l_decap_8_5054 r0 *1 0,0
Xsg13cmos5l_decap_8_5054 \$2 \$1 sg13cmos5l_decap_8
* cell instance sg13cmos5l_decap_8_5055 r0 *1 0,0
Xsg13cmos5l_decap_8_5055 \$2 \$1 sg13cmos5l_decap_8
* cell instance sg13cmos5l_decap_8_5056 r0 *1 0,0
Xsg13cmos5l_decap_8_5056 \$2 \$1 sg13cmos5l_decap_8
* cell instance sg13cmos5l_decap_8_5057 r0 *1 0,0
Xsg13cmos5l_decap_8_5057 \$2 \$1 sg13cmos5l_decap_8
* cell instance sg13cmos5l_decap_8_5058 r0 *1 0,0
Xsg13cmos5l_decap_8_5058 \$2 \$1 sg13cmos5l_decap_8
* cell instance sg13cmos5l_decap_8_5059 r0 *1 0,0
Xsg13cmos5l_decap_8_5059 \$2 \$1 sg13cmos5l_decap_8
* cell instance sg13cmos5l_decap_8_5060 r0 *1 0,0
Xsg13cmos5l_decap_8_5060 \$2 \$1 sg13cmos5l_decap_8
* cell instance sg13cmos5l_decap_8_5061 r0 *1 0,0
Xsg13cmos5l_decap_8_5061 \$2 \$1 sg13cmos5l_decap_8
* cell instance sg13cmos5l_decap_8_5062 r0 *1 0,0
Xsg13cmos5l_decap_8_5062 \$2 \$1 sg13cmos5l_decap_8
* cell instance sg13cmos5l_decap_8_5063 r0 *1 0,0
Xsg13cmos5l_decap_8_5063 \$2 \$1 sg13cmos5l_decap_8
* cell instance sg13cmos5l_decap_8_5064 r0 *1 0,0
Xsg13cmos5l_decap_8_5064 \$2 \$1 sg13cmos5l_decap_8
* cell instance sg13cmos5l_decap_8_5065 r0 *1 0,0
Xsg13cmos5l_decap_8_5065 \$2 \$1 sg13cmos5l_decap_8
* cell instance sg13cmos5l_decap_8_5066 r0 *1 0,0
Xsg13cmos5l_decap_8_5066 \$2 \$1 sg13cmos5l_decap_8
* cell instance sg13cmos5l_decap_8_5067 r0 *1 0,0
Xsg13cmos5l_decap_8_5067 \$2 \$1 sg13cmos5l_decap_8
* cell instance sg13cmos5l_decap_8_5068 r0 *1 0,0
Xsg13cmos5l_decap_8_5068 \$2 \$1 sg13cmos5l_decap_8
* cell instance sg13cmos5l_decap_8_5069 r0 *1 0,0
Xsg13cmos5l_decap_8_5069 \$2 \$1 sg13cmos5l_decap_8
* cell instance sg13cmos5l_decap_8_5070 r0 *1 0,0
Xsg13cmos5l_decap_8_5070 \$2 \$1 sg13cmos5l_decap_8
* cell instance sg13cmos5l_decap_8_5071 r0 *1 0,0
Xsg13cmos5l_decap_8_5071 \$2 \$1 sg13cmos5l_decap_8
* cell instance sg13cmos5l_decap_8_5072 r0 *1 0,0
Xsg13cmos5l_decap_8_5072 \$2 \$1 sg13cmos5l_decap_8
* cell instance sg13cmos5l_decap_8_5073 r0 *1 0,0
Xsg13cmos5l_decap_8_5073 \$2 \$1 sg13cmos5l_decap_8
* cell instance sg13cmos5l_decap_8_5074 r0 *1 0,0
Xsg13cmos5l_decap_8_5074 \$2 \$1 sg13cmos5l_decap_8
* cell instance sg13cmos5l_decap_8_5075 r0 *1 0,0
Xsg13cmos5l_decap_8_5075 \$2 \$1 sg13cmos5l_decap_8
* cell instance sg13cmos5l_decap_8_5076 r0 *1 0,0
Xsg13cmos5l_decap_8_5076 \$2 \$1 sg13cmos5l_decap_8
* cell instance sg13cmos5l_decap_8_5077 r0 *1 0,0
Xsg13cmos5l_decap_8_5077 \$2 \$1 sg13cmos5l_decap_8
* cell instance sg13cmos5l_decap_8_5078 r0 *1 0,0
Xsg13cmos5l_decap_8_5078 \$2 \$1 sg13cmos5l_decap_8
* cell instance sg13cmos5l_decap_8_5079 r0 *1 0,0
Xsg13cmos5l_decap_8_5079 \$2 \$1 sg13cmos5l_decap_8
* cell instance sg13cmos5l_decap_8_5080 r0 *1 0,0
Xsg13cmos5l_decap_8_5080 \$2 \$1 sg13cmos5l_decap_8
* cell instance sg13cmos5l_decap_8_5081 r0 *1 0,0
Xsg13cmos5l_decap_8_5081 \$2 \$1 sg13cmos5l_decap_8
* cell instance sg13cmos5l_decap_8_5082 r0 *1 0,0
Xsg13cmos5l_decap_8_5082 \$2 \$1 sg13cmos5l_decap_8
* cell instance sg13cmos5l_decap_8_5083 r0 *1 0,0
Xsg13cmos5l_decap_8_5083 \$2 \$1 sg13cmos5l_decap_8
* cell instance sg13cmos5l_decap_8_5084 r0 *1 0,0
Xsg13cmos5l_decap_8_5084 \$2 \$1 sg13cmos5l_decap_8
* cell instance sg13cmos5l_decap_8_5085 r0 *1 0,0
Xsg13cmos5l_decap_8_5085 \$2 \$1 sg13cmos5l_decap_8
* cell instance sg13cmos5l_decap_8_5086 r0 *1 0,0
Xsg13cmos5l_decap_8_5086 \$2 \$1 sg13cmos5l_decap_8
* cell instance sg13cmos5l_decap_8_5087 r0 *1 0,0
Xsg13cmos5l_decap_8_5087 \$2 \$1 sg13cmos5l_decap_8
* cell instance sg13cmos5l_decap_8_5088 r0 *1 0,0
Xsg13cmos5l_decap_8_5088 \$2 \$1 sg13cmos5l_decap_8
* cell instance sg13cmos5l_decap_8_5089 r0 *1 0,0
Xsg13cmos5l_decap_8_5089 \$2 \$1 sg13cmos5l_decap_8
* cell instance sg13cmos5l_decap_8_5090 r0 *1 0,0
Xsg13cmos5l_decap_8_5090 \$2 \$1 sg13cmos5l_decap_8
* cell instance sg13cmos5l_decap_8_5091 r0 *1 0,0
Xsg13cmos5l_decap_8_5091 \$2 \$1 sg13cmos5l_decap_8
* cell instance sg13cmos5l_decap_8_5092 r0 *1 0,0
Xsg13cmos5l_decap_8_5092 \$2 \$1 sg13cmos5l_decap_8
* cell instance sg13cmos5l_decap_8_5093 r0 *1 0,0
Xsg13cmos5l_decap_8_5093 \$2 \$1 sg13cmos5l_decap_8
* cell instance sg13cmos5l_decap_8_5094 r0 *1 0,0
Xsg13cmos5l_decap_8_5094 \$2 \$1 sg13cmos5l_decap_8
* cell instance sg13cmos5l_decap_8_5095 r0 *1 0,0
Xsg13cmos5l_decap_8_5095 \$2 \$1 sg13cmos5l_decap_8
* cell instance sg13cmos5l_decap_8_5096 r0 *1 0,0
Xsg13cmos5l_decap_8_5096 \$2 \$1 sg13cmos5l_decap_8
* cell instance sg13cmos5l_decap_8_5097 r0 *1 0,0
Xsg13cmos5l_decap_8_5097 \$2 \$1 sg13cmos5l_decap_8
* cell instance sg13cmos5l_decap_8_5098 r0 *1 0,0
Xsg13cmos5l_decap_8_5098 \$2 \$1 sg13cmos5l_decap_8
* cell instance sg13cmos5l_decap_8_5099 r0 *1 0,0
Xsg13cmos5l_decap_8_5099 \$2 \$1 sg13cmos5l_decap_8
* cell instance sg13cmos5l_decap_8_5100 r0 *1 0,0
Xsg13cmos5l_decap_8_5100 \$2 \$1 sg13cmos5l_decap_8
* cell instance sg13cmos5l_decap_8_5101 r0 *1 0,0
Xsg13cmos5l_decap_8_5101 \$2 \$1 sg13cmos5l_decap_8
* cell instance sg13cmos5l_decap_8_5102 r0 *1 0,0
Xsg13cmos5l_decap_8_5102 \$2 \$1 sg13cmos5l_decap_8
* cell instance sg13cmos5l_decap_8_5103 r0 *1 0,0
Xsg13cmos5l_decap_8_5103 \$2 \$1 sg13cmos5l_decap_8
* cell instance sg13cmos5l_decap_8_5104 r0 *1 0,0
Xsg13cmos5l_decap_8_5104 \$2 \$1 sg13cmos5l_decap_8
* cell instance sg13cmos5l_decap_8_5105 r0 *1 0,0
Xsg13cmos5l_decap_8_5105 \$2 \$1 sg13cmos5l_decap_8
* cell instance sg13cmos5l_decap_8_5106 r0 *1 0,0
Xsg13cmos5l_decap_8_5106 \$2 \$1 sg13cmos5l_decap_8
* cell instance sg13cmos5l_decap_8_5107 r0 *1 0,0
Xsg13cmos5l_decap_8_5107 \$2 \$1 sg13cmos5l_decap_8
* cell instance sg13cmos5l_decap_8_5108 r0 *1 0,0
Xsg13cmos5l_decap_8_5108 \$2 \$1 sg13cmos5l_decap_8
* cell instance sg13cmos5l_decap_8_5109 r0 *1 0,0
Xsg13cmos5l_decap_8_5109 \$2 \$1 sg13cmos5l_decap_8
* cell instance sg13cmos5l_decap_8_5110 r0 *1 0,0
Xsg13cmos5l_decap_8_5110 \$2 \$1 sg13cmos5l_decap_8
* cell instance sg13cmos5l_decap_8_5111 r0 *1 0,0
Xsg13cmos5l_decap_8_5111 \$2 \$1 sg13cmos5l_decap_8
* cell instance sg13cmos5l_decap_8_5112 r0 *1 0,0
Xsg13cmos5l_decap_8_5112 \$2 \$1 sg13cmos5l_decap_8
* cell instance sg13cmos5l_decap_8_5113 r0 *1 0,0
Xsg13cmos5l_decap_8_5113 \$2 \$1 sg13cmos5l_decap_8
* cell instance sg13cmos5l_decap_8_5114 r0 *1 0,0
Xsg13cmos5l_decap_8_5114 \$2 \$1 sg13cmos5l_decap_8
* cell instance sg13cmos5l_decap_8_5115 r0 *1 0,0
Xsg13cmos5l_decap_8_5115 \$2 \$1 sg13cmos5l_decap_8
* cell instance sg13cmos5l_decap_8_5116 r0 *1 0,0
Xsg13cmos5l_decap_8_5116 \$2 \$1 sg13cmos5l_decap_8
* cell instance sg13cmos5l_decap_8_5117 r0 *1 0,0
Xsg13cmos5l_decap_8_5117 \$2 \$1 sg13cmos5l_decap_8
* cell instance sg13cmos5l_decap_8_5118 r0 *1 0,0
Xsg13cmos5l_decap_8_5118 \$2 \$1 sg13cmos5l_decap_8
* cell instance sg13cmos5l_decap_8_5119 r0 *1 0,0
Xsg13cmos5l_decap_8_5119 \$2 \$1 sg13cmos5l_decap_8
* cell instance sg13cmos5l_decap_8_5120 r0 *1 0,0
Xsg13cmos5l_decap_8_5120 \$2 \$1 sg13cmos5l_decap_8
* cell instance sg13cmos5l_decap_8_5121 r0 *1 0,0
Xsg13cmos5l_decap_8_5121 \$2 \$1 sg13cmos5l_decap_8
* cell instance sg13cmos5l_decap_8_5122 r0 *1 0,0
Xsg13cmos5l_decap_8_5122 \$2 \$1 sg13cmos5l_decap_8
* cell instance sg13cmos5l_decap_8_5123 r0 *1 0,0
Xsg13cmos5l_decap_8_5123 \$2 \$1 sg13cmos5l_decap_8
* cell instance sg13cmos5l_decap_8_5124 r0 *1 0,0
Xsg13cmos5l_decap_8_5124 \$2 \$1 sg13cmos5l_decap_8
* cell instance sg13cmos5l_decap_8_5125 r0 *1 0,0
Xsg13cmos5l_decap_8_5125 \$2 \$1 sg13cmos5l_decap_8
* cell instance sg13cmos5l_decap_8_5126 r0 *1 0,0
Xsg13cmos5l_decap_8_5126 \$2 \$1 sg13cmos5l_decap_8
* cell instance sg13cmos5l_decap_8_5127 r0 *1 0,0
Xsg13cmos5l_decap_8_5127 \$2 \$1 sg13cmos5l_decap_8
* cell instance sg13cmos5l_decap_8_5128 r0 *1 0,0
Xsg13cmos5l_decap_8_5128 \$2 \$1 sg13cmos5l_decap_8
* cell instance sg13cmos5l_decap_8_5129 r0 *1 0,0
Xsg13cmos5l_decap_8_5129 \$2 \$1 sg13cmos5l_decap_8
* cell instance sg13cmos5l_decap_8_5130 r0 *1 0,0
Xsg13cmos5l_decap_8_5130 \$2 \$1 sg13cmos5l_decap_8
* cell instance sg13cmos5l_decap_8_5131 r0 *1 0,0
Xsg13cmos5l_decap_8_5131 \$2 \$1 sg13cmos5l_decap_8
* cell instance sg13cmos5l_decap_8_5132 r0 *1 0,0
Xsg13cmos5l_decap_8_5132 \$2 \$1 sg13cmos5l_decap_8
* cell instance sg13cmos5l_decap_8_5133 r0 *1 0,0
Xsg13cmos5l_decap_8_5133 \$2 \$1 sg13cmos5l_decap_8
* cell instance sg13cmos5l_decap_8_5134 r0 *1 0,0
Xsg13cmos5l_decap_8_5134 \$2 \$1 sg13cmos5l_decap_8
* cell instance sg13cmos5l_decap_8_5135 r0 *1 0,0
Xsg13cmos5l_decap_8_5135 \$2 \$1 sg13cmos5l_decap_8
* cell instance sg13cmos5l_decap_8_5136 r0 *1 0,0
Xsg13cmos5l_decap_8_5136 \$2 \$1 sg13cmos5l_decap_8
* cell instance sg13cmos5l_decap_8_5137 r0 *1 0,0
Xsg13cmos5l_decap_8_5137 \$2 \$1 sg13cmos5l_decap_8
* cell instance sg13cmos5l_decap_8_5138 r0 *1 0,0
Xsg13cmos5l_decap_8_5138 \$2 \$1 sg13cmos5l_decap_8
* cell instance sg13cmos5l_decap_8_5139 r0 *1 0,0
Xsg13cmos5l_decap_8_5139 \$2 \$1 sg13cmos5l_decap_8
* cell instance sg13cmos5l_decap_8_5140 r0 *1 0,0
Xsg13cmos5l_decap_8_5140 \$2 \$1 sg13cmos5l_decap_8
* cell instance sg13cmos5l_decap_8_5141 r0 *1 0,0
Xsg13cmos5l_decap_8_5141 \$2 \$1 sg13cmos5l_decap_8
* cell instance sg13cmos5l_decap_8_5142 r0 *1 0,0
Xsg13cmos5l_decap_8_5142 \$2 \$1 sg13cmos5l_decap_8
* cell instance sg13cmos5l_decap_8_5143 r0 *1 0,0
Xsg13cmos5l_decap_8_5143 \$2 \$1 sg13cmos5l_decap_8
* cell instance sg13cmos5l_decap_8_5144 r0 *1 0,0
Xsg13cmos5l_decap_8_5144 \$2 \$1 sg13cmos5l_decap_8
* cell instance sg13cmos5l_decap_8_5145 r0 *1 0,0
Xsg13cmos5l_decap_8_5145 \$2 \$1 sg13cmos5l_decap_8
* cell instance sg13cmos5l_decap_8_5146 r0 *1 0,0
Xsg13cmos5l_decap_8_5146 \$2 \$1 sg13cmos5l_decap_8
* cell instance sg13cmos5l_decap_8_5147 r0 *1 0,0
Xsg13cmos5l_decap_8_5147 \$2 \$1 sg13cmos5l_decap_8
* cell instance sg13cmos5l_decap_8_5148 r0 *1 0,0
Xsg13cmos5l_decap_8_5148 \$2 \$1 sg13cmos5l_decap_8
* cell instance sg13cmos5l_decap_8_5149 r0 *1 0,0
Xsg13cmos5l_decap_8_5149 \$2 \$1 sg13cmos5l_decap_8
* cell instance sg13cmos5l_decap_8_5150 r0 *1 0,0
Xsg13cmos5l_decap_8_5150 \$2 \$1 sg13cmos5l_decap_8
* cell instance sg13cmos5l_decap_8_5151 r0 *1 0,0
Xsg13cmos5l_decap_8_5151 \$2 \$1 sg13cmos5l_decap_8
* cell instance sg13cmos5l_decap_8_5152 r0 *1 0,0
Xsg13cmos5l_decap_8_5152 \$2 \$1 sg13cmos5l_decap_8
* cell instance sg13cmos5l_decap_8_5153 r0 *1 0,0
Xsg13cmos5l_decap_8_5153 \$2 \$1 sg13cmos5l_decap_8
* cell instance sg13cmos5l_decap_8_5154 r0 *1 0,0
Xsg13cmos5l_decap_8_5154 \$2 \$1 sg13cmos5l_decap_8
* cell instance sg13cmos5l_decap_8_5155 r0 *1 0,0
Xsg13cmos5l_decap_8_5155 \$2 \$1 sg13cmos5l_decap_8
* cell instance sg13cmos5l_decap_8_5156 r0 *1 0,0
Xsg13cmos5l_decap_8_5156 \$2 \$1 sg13cmos5l_decap_8
* cell instance sg13cmos5l_decap_8_5157 r0 *1 0,0
Xsg13cmos5l_decap_8_5157 \$2 \$1 sg13cmos5l_decap_8
* cell instance sg13cmos5l_decap_8_5158 r0 *1 0,0
Xsg13cmos5l_decap_8_5158 \$2 \$1 sg13cmos5l_decap_8
* cell instance sg13cmos5l_decap_8_5159 r0 *1 0,0
Xsg13cmos5l_decap_8_5159 \$2 \$1 sg13cmos5l_decap_8
* cell instance sg13cmos5l_decap_8_5160 r0 *1 0,0
Xsg13cmos5l_decap_8_5160 \$2 \$1 sg13cmos5l_decap_8
* cell instance sg13cmos5l_decap_8_5161 r0 *1 0,0
Xsg13cmos5l_decap_8_5161 \$2 \$1 sg13cmos5l_decap_8
* cell instance sg13cmos5l_decap_8_5162 r0 *1 0,0
Xsg13cmos5l_decap_8_5162 \$2 \$1 sg13cmos5l_decap_8
* cell instance sg13cmos5l_decap_8_5163 r0 *1 0,0
Xsg13cmos5l_decap_8_5163 \$2 \$1 sg13cmos5l_decap_8
* cell instance sg13cmos5l_decap_8_5164 r0 *1 0,0
Xsg13cmos5l_decap_8_5164 \$2 \$1 sg13cmos5l_decap_8
* cell instance sg13cmos5l_decap_8_5165 r0 *1 0,0
Xsg13cmos5l_decap_8_5165 \$2 \$1 sg13cmos5l_decap_8
* cell instance sg13cmos5l_decap_8_5166 r0 *1 0,0
Xsg13cmos5l_decap_8_5166 \$2 \$1 sg13cmos5l_decap_8
* cell instance sg13cmos5l_decap_8_5167 r0 *1 0,0
Xsg13cmos5l_decap_8_5167 \$2 \$1 sg13cmos5l_decap_8
* cell instance sg13cmos5l_decap_8_5168 r0 *1 0,0
Xsg13cmos5l_decap_8_5168 \$2 \$1 sg13cmos5l_decap_8
* cell instance sg13cmos5l_decap_8_5169 r0 *1 0,0
Xsg13cmos5l_decap_8_5169 \$2 \$1 sg13cmos5l_decap_8
* cell instance sg13cmos5l_decap_8_5170 r0 *1 0,0
Xsg13cmos5l_decap_8_5170 \$2 \$1 sg13cmos5l_decap_8
* cell instance sg13cmos5l_decap_8_5171 r0 *1 0,0
Xsg13cmos5l_decap_8_5171 \$2 \$1 sg13cmos5l_decap_8
* cell instance sg13cmos5l_decap_8_5172 r0 *1 0,0
Xsg13cmos5l_decap_8_5172 \$2 \$1 sg13cmos5l_decap_8
* cell instance sg13cmos5l_decap_8_5173 r0 *1 0,0
Xsg13cmos5l_decap_8_5173 \$2 \$1 sg13cmos5l_decap_8
* cell instance sg13cmos5l_decap_8_5174 r0 *1 0,0
Xsg13cmos5l_decap_8_5174 \$2 \$1 sg13cmos5l_decap_8
* cell instance sg13cmos5l_decap_8_5175 r0 *1 0,0
Xsg13cmos5l_decap_8_5175 \$2 \$1 sg13cmos5l_decap_8
* cell instance sg13cmos5l_decap_8_5176 r0 *1 0,0
Xsg13cmos5l_decap_8_5176 \$2 \$1 sg13cmos5l_decap_8
* cell instance sg13cmos5l_decap_8_5177 r0 *1 0,0
Xsg13cmos5l_decap_8_5177 \$2 \$1 sg13cmos5l_decap_8
* cell instance sg13cmos5l_decap_8_5178 r0 *1 0,0
Xsg13cmos5l_decap_8_5178 \$2 \$1 sg13cmos5l_decap_8
* cell instance sg13cmos5l_decap_8_5179 r0 *1 0,0
Xsg13cmos5l_decap_8_5179 \$2 \$1 sg13cmos5l_decap_8
* cell instance sg13cmos5l_decap_8_5180 r0 *1 0,0
Xsg13cmos5l_decap_8_5180 \$2 \$1 sg13cmos5l_decap_8
* cell instance sg13cmos5l_decap_8_5181 r0 *1 0,0
Xsg13cmos5l_decap_8_5181 \$2 \$1 sg13cmos5l_decap_8
* cell instance sg13cmos5l_decap_8_5182 r0 *1 0,0
Xsg13cmos5l_decap_8_5182 \$2 \$1 sg13cmos5l_decap_8
* cell instance sg13cmos5l_decap_8_5183 r0 *1 0,0
Xsg13cmos5l_decap_8_5183 \$2 \$1 sg13cmos5l_decap_8
* cell instance sg13cmos5l_decap_8_5184 r0 *1 0,0
Xsg13cmos5l_decap_8_5184 \$2 \$1 sg13cmos5l_decap_8
* cell instance sg13cmos5l_decap_8_5185 r0 *1 0,0
Xsg13cmos5l_decap_8_5185 \$2 \$1 sg13cmos5l_decap_8
* cell instance sg13cmos5l_decap_8_5186 r0 *1 0,0
Xsg13cmos5l_decap_8_5186 \$2 \$1 sg13cmos5l_decap_8
* cell instance sg13cmos5l_decap_8_5187 r0 *1 0,0
Xsg13cmos5l_decap_8_5187 \$2 \$1 sg13cmos5l_decap_8
* cell instance sg13cmos5l_decap_8_5188 r0 *1 0,0
Xsg13cmos5l_decap_8_5188 \$2 \$1 sg13cmos5l_decap_8
* cell instance sg13cmos5l_decap_8_5189 r0 *1 0,0
Xsg13cmos5l_decap_8_5189 \$2 \$1 sg13cmos5l_decap_8
* cell instance sg13cmos5l_decap_8_5190 r0 *1 0,0
Xsg13cmos5l_decap_8_5190 \$2 \$1 sg13cmos5l_decap_8
* cell instance sg13cmos5l_decap_8_5191 r0 *1 0,0
Xsg13cmos5l_decap_8_5191 \$2 \$1 sg13cmos5l_decap_8
* cell instance sg13cmos5l_decap_8_5192 r0 *1 0,0
Xsg13cmos5l_decap_8_5192 \$2 \$1 sg13cmos5l_decap_8
* cell instance sg13cmos5l_decap_8_5193 r0 *1 0,0
Xsg13cmos5l_decap_8_5193 \$2 \$1 sg13cmos5l_decap_8
* cell instance sg13cmos5l_decap_8_5194 r0 *1 0,0
Xsg13cmos5l_decap_8_5194 \$2 \$1 sg13cmos5l_decap_8
* cell instance sg13cmos5l_decap_8_5195 r0 *1 0,0
Xsg13cmos5l_decap_8_5195 \$2 \$1 sg13cmos5l_decap_8
* cell instance sg13cmos5l_decap_8_5196 r0 *1 0,0
Xsg13cmos5l_decap_8_5196 \$2 \$1 sg13cmos5l_decap_8
* cell instance sg13cmos5l_decap_8_5197 r0 *1 0,0
Xsg13cmos5l_decap_8_5197 \$2 \$1 sg13cmos5l_decap_8
* cell instance sg13cmos5l_decap_8_5198 r0 *1 0,0
Xsg13cmos5l_decap_8_5198 \$2 \$1 sg13cmos5l_decap_8
* cell instance sg13cmos5l_decap_8_5199 r0 *1 0,0
Xsg13cmos5l_decap_8_5199 \$2 \$1 sg13cmos5l_decap_8
* cell instance sg13cmos5l_decap_8_5200 r0 *1 0,0
Xsg13cmos5l_decap_8_5200 \$2 \$1 sg13cmos5l_decap_8
* cell instance sg13cmos5l_decap_8_5201 r0 *1 0,0
Xsg13cmos5l_decap_8_5201 \$2 \$1 sg13cmos5l_decap_8
* cell instance sg13cmos5l_decap_8_5202 r0 *1 0,0
Xsg13cmos5l_decap_8_5202 \$2 \$1 sg13cmos5l_decap_8
* cell instance sg13cmos5l_decap_8_5203 r0 *1 0,0
Xsg13cmos5l_decap_8_5203 \$2 \$1 sg13cmos5l_decap_8
* cell instance sg13cmos5l_decap_8_5204 r0 *1 0,0
Xsg13cmos5l_decap_8_5204 \$2 \$1 sg13cmos5l_decap_8
* cell instance sg13cmos5l_decap_8_5205 r0 *1 0,0
Xsg13cmos5l_decap_8_5205 \$2 \$1 sg13cmos5l_decap_8
* cell instance sg13cmos5l_decap_8_5206 r0 *1 0,0
Xsg13cmos5l_decap_8_5206 \$2 \$1 sg13cmos5l_decap_8
* cell instance sg13cmos5l_decap_8_5207 r0 *1 0,0
Xsg13cmos5l_decap_8_5207 \$2 \$1 sg13cmos5l_decap_8
* cell instance sg13cmos5l_decap_8_5208 r0 *1 0,0
Xsg13cmos5l_decap_8_5208 \$2 \$1 sg13cmos5l_decap_8
* cell instance sg13cmos5l_decap_8_5209 r0 *1 0,0
Xsg13cmos5l_decap_8_5209 \$2 \$1 sg13cmos5l_decap_8
* cell instance sg13cmos5l_decap_8_5210 r0 *1 0,0
Xsg13cmos5l_decap_8_5210 \$2 \$1 sg13cmos5l_decap_8
* cell instance sg13cmos5l_decap_8_5211 r0 *1 0,0
Xsg13cmos5l_decap_8_5211 \$2 \$1 sg13cmos5l_decap_8
* cell instance sg13cmos5l_decap_8_5212 r0 *1 0,0
Xsg13cmos5l_decap_8_5212 \$2 \$1 sg13cmos5l_decap_8
* cell instance sg13cmos5l_decap_8_5213 r0 *1 0,0
Xsg13cmos5l_decap_8_5213 \$2 \$1 sg13cmos5l_decap_8
* cell instance sg13cmos5l_decap_8_5214 r0 *1 0,0
Xsg13cmos5l_decap_8_5214 \$2 \$1 sg13cmos5l_decap_8
* cell instance sg13cmos5l_decap_8_5215 r0 *1 0,0
Xsg13cmos5l_decap_8_5215 \$2 \$1 sg13cmos5l_decap_8
* cell instance sg13cmos5l_decap_8_5216 r0 *1 0,0
Xsg13cmos5l_decap_8_5216 \$2 \$1 sg13cmos5l_decap_8
* cell instance sg13cmos5l_decap_8_5217 r0 *1 0,0
Xsg13cmos5l_decap_8_5217 \$2 \$1 sg13cmos5l_decap_8
* cell instance sg13cmos5l_decap_8_5218 r0 *1 0,0
Xsg13cmos5l_decap_8_5218 \$2 \$1 sg13cmos5l_decap_8
* cell instance sg13cmos5l_decap_8_5219 r0 *1 0,0
Xsg13cmos5l_decap_8_5219 \$2 \$1 sg13cmos5l_decap_8
* cell instance sg13cmos5l_decap_8_5220 r0 *1 0,0
Xsg13cmos5l_decap_8_5220 \$2 \$1 sg13cmos5l_decap_8
* cell instance sg13cmos5l_decap_8_5221 r0 *1 0,0
Xsg13cmos5l_decap_8_5221 \$2 \$1 sg13cmos5l_decap_8
* cell instance sg13cmos5l_decap_8_5222 r0 *1 0,0
Xsg13cmos5l_decap_8_5222 \$2 \$1 sg13cmos5l_decap_8
* cell instance sg13cmos5l_decap_8_5223 r0 *1 0,0
Xsg13cmos5l_decap_8_5223 \$2 \$1 sg13cmos5l_decap_8
* cell instance sg13cmos5l_decap_8_5224 r0 *1 0,0
Xsg13cmos5l_decap_8_5224 \$2 \$1 sg13cmos5l_decap_8
* cell instance sg13cmos5l_decap_8_5225 r0 *1 0,0
Xsg13cmos5l_decap_8_5225 \$2 \$1 sg13cmos5l_decap_8
* cell instance sg13cmos5l_decap_8_5226 r0 *1 0,0
Xsg13cmos5l_decap_8_5226 \$2 \$1 sg13cmos5l_decap_8
* cell instance sg13cmos5l_decap_8_5227 r0 *1 0,0
Xsg13cmos5l_decap_8_5227 \$2 \$1 sg13cmos5l_decap_8
* cell instance sg13cmos5l_decap_8_5228 r0 *1 0,0
Xsg13cmos5l_decap_8_5228 \$2 \$1 sg13cmos5l_decap_8
* cell instance sg13cmos5l_decap_8_5229 r0 *1 0,0
Xsg13cmos5l_decap_8_5229 \$2 \$1 sg13cmos5l_decap_8
* cell instance sg13cmos5l_decap_8_5230 r0 *1 0,0
Xsg13cmos5l_decap_8_5230 \$2 \$1 sg13cmos5l_decap_8
* cell instance sg13cmos5l_decap_8_5231 r0 *1 0,0
Xsg13cmos5l_decap_8_5231 \$2 \$1 sg13cmos5l_decap_8
* cell instance sg13cmos5l_decap_8_5232 r0 *1 0,0
Xsg13cmos5l_decap_8_5232 \$2 \$1 sg13cmos5l_decap_8
* cell instance sg13cmos5l_decap_8_5233 r0 *1 0,0
Xsg13cmos5l_decap_8_5233 \$2 \$1 sg13cmos5l_decap_8
* cell instance sg13cmos5l_decap_8_5234 r0 *1 0,0
Xsg13cmos5l_decap_8_5234 \$2 \$1 sg13cmos5l_decap_8
* cell instance sg13cmos5l_decap_8_5235 r0 *1 0,0
Xsg13cmos5l_decap_8_5235 \$2 \$1 sg13cmos5l_decap_8
* cell instance sg13cmos5l_decap_8_5236 r0 *1 0,0
Xsg13cmos5l_decap_8_5236 \$2 \$1 sg13cmos5l_decap_8
* cell instance sg13cmos5l_decap_8_5237 r0 *1 0,0
Xsg13cmos5l_decap_8_5237 \$2 \$1 sg13cmos5l_decap_8
* cell instance sg13cmos5l_decap_8_5238 r0 *1 0,0
Xsg13cmos5l_decap_8_5238 \$2 \$1 sg13cmos5l_decap_8
* cell instance sg13cmos5l_decap_8_5239 r0 *1 0,0
Xsg13cmos5l_decap_8_5239 \$2 \$1 sg13cmos5l_decap_8
* cell instance sg13cmos5l_decap_8_5240 r0 *1 0,0
Xsg13cmos5l_decap_8_5240 \$2 \$1 sg13cmos5l_decap_8
* cell instance sg13cmos5l_decap_8_5241 r0 *1 0,0
Xsg13cmos5l_decap_8_5241 \$2 \$1 sg13cmos5l_decap_8
* cell instance sg13cmos5l_decap_8_5242 r0 *1 0,0
Xsg13cmos5l_decap_8_5242 \$2 \$1 sg13cmos5l_decap_8
* cell instance sg13cmos5l_decap_8_5243 r0 *1 0,0
Xsg13cmos5l_decap_8_5243 \$2 \$1 sg13cmos5l_decap_8
* cell instance sg13cmos5l_decap_8_5244 r0 *1 0,0
Xsg13cmos5l_decap_8_5244 \$2 \$1 sg13cmos5l_decap_8
* cell instance sg13cmos5l_decap_8_5245 r0 *1 0,0
Xsg13cmos5l_decap_8_5245 \$2 \$1 sg13cmos5l_decap_8
* cell instance sg13cmos5l_decap_8_5246 r0 *1 0,0
Xsg13cmos5l_decap_8_5246 \$2 \$1 sg13cmos5l_decap_8
* cell instance sg13cmos5l_decap_8_5247 r0 *1 0,0
Xsg13cmos5l_decap_8_5247 \$2 \$1 sg13cmos5l_decap_8
* cell instance sg13cmos5l_decap_8_5248 r0 *1 0,0
Xsg13cmos5l_decap_8_5248 \$2 \$1 sg13cmos5l_decap_8
* cell instance sg13cmos5l_decap_8_5249 r0 *1 0,0
Xsg13cmos5l_decap_8_5249 \$2 \$1 sg13cmos5l_decap_8
* cell instance sg13cmos5l_decap_8_5250 r0 *1 0,0
Xsg13cmos5l_decap_8_5250 \$2 \$1 sg13cmos5l_decap_8
* cell instance sg13cmos5l_decap_8_5251 r0 *1 0,0
Xsg13cmos5l_decap_8_5251 \$2 \$1 sg13cmos5l_decap_8
* cell instance sg13cmos5l_decap_8_5252 r0 *1 0,0
Xsg13cmos5l_decap_8_5252 \$2 \$1 sg13cmos5l_decap_8
* cell instance sg13cmos5l_decap_8_5253 r0 *1 0,0
Xsg13cmos5l_decap_8_5253 \$2 \$1 sg13cmos5l_decap_8
* cell instance sg13cmos5l_decap_8_5254 r0 *1 0,0
Xsg13cmos5l_decap_8_5254 \$2 \$1 sg13cmos5l_decap_8
* cell instance sg13cmos5l_decap_8_5255 r0 *1 0,0
Xsg13cmos5l_decap_8_5255 \$2 \$1 sg13cmos5l_decap_8
* cell instance sg13cmos5l_decap_8_5256 r0 *1 0,0
Xsg13cmos5l_decap_8_5256 \$2 \$1 sg13cmos5l_decap_8
* cell instance sg13cmos5l_decap_8_5257 r0 *1 0,0
Xsg13cmos5l_decap_8_5257 \$2 \$1 sg13cmos5l_decap_8
* cell instance sg13cmos5l_decap_8_5258 r0 *1 0,0
Xsg13cmos5l_decap_8_5258 \$2 \$1 sg13cmos5l_decap_8
* cell instance sg13cmos5l_decap_8_5259 r0 *1 0,0
Xsg13cmos5l_decap_8_5259 \$2 \$1 sg13cmos5l_decap_8
* cell instance sg13cmos5l_decap_8_5260 r0 *1 0,0
Xsg13cmos5l_decap_8_5260 \$2 \$1 sg13cmos5l_decap_8
* cell instance sg13cmos5l_decap_8_5261 r0 *1 0,0
Xsg13cmos5l_decap_8_5261 \$2 \$1 sg13cmos5l_decap_8
* cell instance sg13cmos5l_decap_8_5262 r0 *1 0,0
Xsg13cmos5l_decap_8_5262 \$2 \$1 sg13cmos5l_decap_8
* cell instance sg13cmos5l_decap_8_5263 r0 *1 0,0
Xsg13cmos5l_decap_8_5263 \$2 \$1 sg13cmos5l_decap_8
* cell instance sg13cmos5l_decap_8_5264 r0 *1 0,0
Xsg13cmos5l_decap_8_5264 \$2 \$1 sg13cmos5l_decap_8
* cell instance sg13cmos5l_decap_8_5265 r0 *1 0,0
Xsg13cmos5l_decap_8_5265 \$2 \$1 sg13cmos5l_decap_8
* cell instance sg13cmos5l_decap_8_5266 r0 *1 0,0
Xsg13cmos5l_decap_8_5266 \$2 \$1 sg13cmos5l_decap_8
* cell instance sg13cmos5l_decap_8_5267 r0 *1 0,0
Xsg13cmos5l_decap_8_5267 \$2 \$1 sg13cmos5l_decap_8
* cell instance sg13cmos5l_decap_8_5268 r0 *1 0,0
Xsg13cmos5l_decap_8_5268 \$2 \$1 sg13cmos5l_decap_8
* cell instance sg13cmos5l_decap_8_5269 r0 *1 0,0
Xsg13cmos5l_decap_8_5269 \$2 \$1 sg13cmos5l_decap_8
* cell instance sg13cmos5l_decap_8_5270 r0 *1 0,0
Xsg13cmos5l_decap_8_5270 \$2 \$1 sg13cmos5l_decap_8
* cell instance sg13cmos5l_decap_8_5271 r0 *1 0,0
Xsg13cmos5l_decap_8_5271 \$2 \$1 sg13cmos5l_decap_8
* cell instance sg13cmos5l_decap_8_5272 r0 *1 0,0
Xsg13cmos5l_decap_8_5272 \$2 \$1 sg13cmos5l_decap_8
* cell instance sg13cmos5l_decap_8_5273 r0 *1 0,0
Xsg13cmos5l_decap_8_5273 \$2 \$1 sg13cmos5l_decap_8
* cell instance sg13cmos5l_decap_8_5274 r0 *1 0,0
Xsg13cmos5l_decap_8_5274 \$2 \$1 sg13cmos5l_decap_8
* cell instance sg13cmos5l_decap_8_5275 r0 *1 0,0
Xsg13cmos5l_decap_8_5275 \$2 \$1 sg13cmos5l_decap_8
* cell instance sg13cmos5l_decap_8_5276 r0 *1 0,0
Xsg13cmos5l_decap_8_5276 \$2 \$1 sg13cmos5l_decap_8
* cell instance sg13cmos5l_decap_8_5277 r0 *1 0,0
Xsg13cmos5l_decap_8_5277 \$2 \$1 sg13cmos5l_decap_8
* cell instance sg13cmos5l_decap_8_5278 r0 *1 0,0
Xsg13cmos5l_decap_8_5278 \$2 \$1 sg13cmos5l_decap_8
* cell instance sg13cmos5l_decap_8_5279 r0 *1 0,0
Xsg13cmos5l_decap_8_5279 \$2 \$1 sg13cmos5l_decap_8
* cell instance sg13cmos5l_decap_8_5280 r0 *1 0,0
Xsg13cmos5l_decap_8_5280 \$2 \$1 sg13cmos5l_decap_8
* cell instance sg13cmos5l_decap_8_5281 r0 *1 0,0
Xsg13cmos5l_decap_8_5281 \$2 \$1 sg13cmos5l_decap_8
* cell instance sg13cmos5l_decap_8_5282 r0 *1 0,0
Xsg13cmos5l_decap_8_5282 \$2 \$1 sg13cmos5l_decap_8
* cell instance sg13cmos5l_decap_8_5283 r0 *1 0,0
Xsg13cmos5l_decap_8_5283 \$2 \$1 sg13cmos5l_decap_8
* cell instance sg13cmos5l_decap_8_5284 r0 *1 0,0
Xsg13cmos5l_decap_8_5284 \$2 \$1 sg13cmos5l_decap_8
* cell instance sg13cmos5l_decap_8_5285 r0 *1 0,0
Xsg13cmos5l_decap_8_5285 \$2 \$1 sg13cmos5l_decap_8
* cell instance sg13cmos5l_decap_8_5286 r0 *1 0,0
Xsg13cmos5l_decap_8_5286 \$2 \$1 sg13cmos5l_decap_8
* cell instance sg13cmos5l_decap_8_5287 r0 *1 0,0
Xsg13cmos5l_decap_8_5287 \$2 \$1 sg13cmos5l_decap_8
* cell instance sg13cmos5l_decap_8_5288 r0 *1 0,0
Xsg13cmos5l_decap_8_5288 \$2 \$1 sg13cmos5l_decap_8
* cell instance sg13cmos5l_decap_8_5289 r0 *1 0,0
Xsg13cmos5l_decap_8_5289 \$2 \$1 sg13cmos5l_decap_8
* cell instance sg13cmos5l_decap_8_5290 r0 *1 0,0
Xsg13cmos5l_decap_8_5290 \$2 \$1 sg13cmos5l_decap_8
* cell instance sg13cmos5l_decap_8_5291 r0 *1 0,0
Xsg13cmos5l_decap_8_5291 \$2 \$1 sg13cmos5l_decap_8
* cell instance sg13cmos5l_decap_8_5292 r0 *1 0,0
Xsg13cmos5l_decap_8_5292 \$2 \$1 sg13cmos5l_decap_8
* cell instance sg13cmos5l_decap_8_5293 r0 *1 0,0
Xsg13cmos5l_decap_8_5293 \$2 \$1 sg13cmos5l_decap_8
* cell instance sg13cmos5l_decap_8_5294 r0 *1 0,0
Xsg13cmos5l_decap_8_5294 \$2 \$1 sg13cmos5l_decap_8
* cell instance sg13cmos5l_decap_8_5295 r0 *1 0,0
Xsg13cmos5l_decap_8_5295 \$2 \$1 sg13cmos5l_decap_8
* cell instance sg13cmos5l_decap_8_5296 r0 *1 0,0
Xsg13cmos5l_decap_8_5296 \$2 \$1 sg13cmos5l_decap_8
* cell instance sg13cmos5l_decap_8_5297 r0 *1 0,0
Xsg13cmos5l_decap_8_5297 \$2 \$1 sg13cmos5l_decap_8
* cell instance sg13cmos5l_decap_8_5298 r0 *1 0,0
Xsg13cmos5l_decap_8_5298 \$2 \$1 sg13cmos5l_decap_8
* cell instance sg13cmos5l_decap_8_5299 r0 *1 0,0
Xsg13cmos5l_decap_8_5299 \$2 \$1 sg13cmos5l_decap_8
* cell instance sg13cmos5l_decap_8_5300 r0 *1 0,0
Xsg13cmos5l_decap_8_5300 \$2 \$1 sg13cmos5l_decap_8
* cell instance sg13cmos5l_decap_8_5301 r0 *1 0,0
Xsg13cmos5l_decap_8_5301 \$2 \$1 sg13cmos5l_decap_8
* cell instance sg13cmos5l_decap_8_5302 r0 *1 0,0
Xsg13cmos5l_decap_8_5302 \$2 \$1 sg13cmos5l_decap_8
* cell instance sg13cmos5l_decap_8_5303 r0 *1 0,0
Xsg13cmos5l_decap_8_5303 \$2 \$1 sg13cmos5l_decap_8
* cell instance sg13cmos5l_decap_8_5304 r0 *1 0,0
Xsg13cmos5l_decap_8_5304 \$2 \$1 sg13cmos5l_decap_8
* cell instance sg13cmos5l_decap_8_5305 r0 *1 0,0
Xsg13cmos5l_decap_8_5305 \$2 \$1 sg13cmos5l_decap_8
* cell instance sg13cmos5l_decap_8_5306 r0 *1 0,0
Xsg13cmos5l_decap_8_5306 \$2 \$1 sg13cmos5l_decap_8
* cell instance sg13cmos5l_decap_8_5307 r0 *1 0,0
Xsg13cmos5l_decap_8_5307 \$2 \$1 sg13cmos5l_decap_8
* cell instance sg13cmos5l_decap_8_5308 r0 *1 0,0
Xsg13cmos5l_decap_8_5308 \$2 \$1 sg13cmos5l_decap_8
* cell instance sg13cmos5l_decap_8_5309 r0 *1 0,0
Xsg13cmos5l_decap_8_5309 \$2 \$1 sg13cmos5l_decap_8
* cell instance sg13cmos5l_decap_8_5310 r0 *1 0,0
Xsg13cmos5l_decap_8_5310 \$2 \$1 sg13cmos5l_decap_8
* cell instance sg13cmos5l_decap_8_5311 r0 *1 0,0
Xsg13cmos5l_decap_8_5311 \$2 \$1 sg13cmos5l_decap_8
* cell instance sg13cmos5l_decap_8_5312 r0 *1 0,0
Xsg13cmos5l_decap_8_5312 \$2 \$1 sg13cmos5l_decap_8
* cell instance sg13cmos5l_decap_8_5313 r0 *1 0,0
Xsg13cmos5l_decap_8_5313 \$2 \$1 sg13cmos5l_decap_8
* cell instance sg13cmos5l_decap_8_5314 r0 *1 0,0
Xsg13cmos5l_decap_8_5314 \$2 \$1 sg13cmos5l_decap_8
* cell instance sg13cmos5l_decap_8_5315 r0 *1 0,0
Xsg13cmos5l_decap_8_5315 \$2 \$1 sg13cmos5l_decap_8
* cell instance sg13cmos5l_decap_8_5316 r0 *1 0,0
Xsg13cmos5l_decap_8_5316 \$2 \$1 sg13cmos5l_decap_8
* cell instance sg13cmos5l_decap_8_5317 r0 *1 0,0
Xsg13cmos5l_decap_8_5317 \$2 \$1 sg13cmos5l_decap_8
* cell instance sg13cmos5l_decap_8_5318 r0 *1 0,0
Xsg13cmos5l_decap_8_5318 \$2 \$1 sg13cmos5l_decap_8
* cell instance sg13cmos5l_decap_8_5319 r0 *1 0,0
Xsg13cmos5l_decap_8_5319 \$2 \$1 sg13cmos5l_decap_8
* cell instance sg13cmos5l_decap_8_5320 r0 *1 0,0
Xsg13cmos5l_decap_8_5320 \$2 \$1 sg13cmos5l_decap_8
* cell instance sg13cmos5l_decap_8_5321 r0 *1 0,0
Xsg13cmos5l_decap_8_5321 \$2 \$1 sg13cmos5l_decap_8
* cell instance sg13cmos5l_decap_8_5322 r0 *1 0,0
Xsg13cmos5l_decap_8_5322 \$2 \$1 sg13cmos5l_decap_8
* cell instance sg13cmos5l_decap_8_5323 r0 *1 0,0
Xsg13cmos5l_decap_8_5323 \$2 \$1 sg13cmos5l_decap_8
* cell instance sg13cmos5l_decap_8_5324 r0 *1 0,0
Xsg13cmos5l_decap_8_5324 \$2 \$1 sg13cmos5l_decap_8
* cell instance sg13cmos5l_decap_8_5325 r0 *1 0,0
Xsg13cmos5l_decap_8_5325 \$2 \$1 sg13cmos5l_decap_8
* cell instance sg13cmos5l_decap_8_5326 r0 *1 0,0
Xsg13cmos5l_decap_8_5326 \$2 \$1 sg13cmos5l_decap_8
* cell instance sg13cmos5l_decap_8_5327 r0 *1 0,0
Xsg13cmos5l_decap_8_5327 \$2 \$1 sg13cmos5l_decap_8
* cell instance sg13cmos5l_decap_8_5328 r0 *1 0,0
Xsg13cmos5l_decap_8_5328 \$2 \$1 sg13cmos5l_decap_8
* cell instance sg13cmos5l_decap_8_5329 r0 *1 0,0
Xsg13cmos5l_decap_8_5329 \$2 \$1 sg13cmos5l_decap_8
* cell instance sg13cmos5l_decap_8_5330 r0 *1 0,0
Xsg13cmos5l_decap_8_5330 \$2 \$1 sg13cmos5l_decap_8
* cell instance sg13cmos5l_decap_8_5331 r0 *1 0,0
Xsg13cmos5l_decap_8_5331 \$2 \$1 sg13cmos5l_decap_8
* cell instance sg13cmos5l_decap_8_5332 r0 *1 0,0
Xsg13cmos5l_decap_8_5332 \$2 \$1 sg13cmos5l_decap_8
* cell instance sg13cmos5l_decap_8_5333 r0 *1 0,0
Xsg13cmos5l_decap_8_5333 \$2 \$1 sg13cmos5l_decap_8
* cell instance sg13cmos5l_decap_8_5334 r0 *1 0,0
Xsg13cmos5l_decap_8_5334 \$2 \$1 sg13cmos5l_decap_8
* cell instance sg13cmos5l_decap_8_5335 r0 *1 0,0
Xsg13cmos5l_decap_8_5335 \$2 \$1 sg13cmos5l_decap_8
* cell instance sg13cmos5l_decap_8_5336 r0 *1 0,0
Xsg13cmos5l_decap_8_5336 \$2 \$1 sg13cmos5l_decap_8
* cell instance sg13cmos5l_decap_8_5337 r0 *1 0,0
Xsg13cmos5l_decap_8_5337 \$2 \$1 sg13cmos5l_decap_8
* cell instance sg13cmos5l_decap_8_5338 r0 *1 0,0
Xsg13cmos5l_decap_8_5338 \$2 \$1 sg13cmos5l_decap_8
* cell instance sg13cmos5l_decap_8_5339 r0 *1 0,0
Xsg13cmos5l_decap_8_5339 \$2 \$1 sg13cmos5l_decap_8
* cell instance sg13cmos5l_decap_8_5340 r0 *1 0,0
Xsg13cmos5l_decap_8_5340 \$2 \$1 sg13cmos5l_decap_8
* cell instance sg13cmos5l_decap_8_5341 r0 *1 0,0
Xsg13cmos5l_decap_8_5341 \$2 \$1 sg13cmos5l_decap_8
* cell instance sg13cmos5l_decap_8_5342 r0 *1 0,0
Xsg13cmos5l_decap_8_5342 \$2 \$1 sg13cmos5l_decap_8
* cell instance sg13cmos5l_decap_8_5343 r0 *1 0,0
Xsg13cmos5l_decap_8_5343 \$2 \$1 sg13cmos5l_decap_8
* cell instance sg13cmos5l_decap_8_5344 r0 *1 0,0
Xsg13cmos5l_decap_8_5344 \$2 \$1 sg13cmos5l_decap_8
* cell instance sg13cmos5l_decap_8_5345 r0 *1 0,0
Xsg13cmos5l_decap_8_5345 \$2 \$1 sg13cmos5l_decap_8
* cell instance sg13cmos5l_decap_8_5346 r0 *1 0,0
Xsg13cmos5l_decap_8_5346 \$2 \$1 sg13cmos5l_decap_8
* cell instance sg13cmos5l_decap_8_5347 r0 *1 0,0
Xsg13cmos5l_decap_8_5347 \$2 \$1 sg13cmos5l_decap_8
* cell instance sg13cmos5l_decap_8_5348 r0 *1 0,0
Xsg13cmos5l_decap_8_5348 \$2 \$1 sg13cmos5l_decap_8
* cell instance sg13cmos5l_decap_8_5349 r0 *1 0,0
Xsg13cmos5l_decap_8_5349 \$2 \$1 sg13cmos5l_decap_8
* cell instance sg13cmos5l_decap_8_5350 r0 *1 0,0
Xsg13cmos5l_decap_8_5350 \$2 \$1 sg13cmos5l_decap_8
* cell instance sg13cmos5l_decap_8_5351 r0 *1 0,0
Xsg13cmos5l_decap_8_5351 \$2 \$1 sg13cmos5l_decap_8
* cell instance sg13cmos5l_decap_8_5352 r0 *1 0,0
Xsg13cmos5l_decap_8_5352 \$2 \$1 sg13cmos5l_decap_8
* cell instance sg13cmos5l_decap_8_5353 r0 *1 0,0
Xsg13cmos5l_decap_8_5353 \$2 \$1 sg13cmos5l_decap_8
* cell instance sg13cmos5l_decap_8_5354 r0 *1 0,0
Xsg13cmos5l_decap_8_5354 \$2 \$1 sg13cmos5l_decap_8
* cell instance sg13cmos5l_decap_8_5355 r0 *1 0,0
Xsg13cmos5l_decap_8_5355 \$2 \$1 sg13cmos5l_decap_8
* cell instance sg13cmos5l_decap_8_5356 r0 *1 0,0
Xsg13cmos5l_decap_8_5356 \$2 \$1 sg13cmos5l_decap_8
* cell instance sg13cmos5l_decap_8_5357 r0 *1 0,0
Xsg13cmos5l_decap_8_5357 \$2 \$1 sg13cmos5l_decap_8
* cell instance sg13cmos5l_decap_8_5358 r0 *1 0,0
Xsg13cmos5l_decap_8_5358 \$2 \$1 sg13cmos5l_decap_8
* cell instance sg13cmos5l_decap_8_5359 r0 *1 0,0
Xsg13cmos5l_decap_8_5359 \$2 \$1 sg13cmos5l_decap_8
* cell instance sg13cmos5l_decap_8_5360 r0 *1 0,0
Xsg13cmos5l_decap_8_5360 \$2 \$1 sg13cmos5l_decap_8
* cell instance sg13cmos5l_decap_8_5361 r0 *1 0,0
Xsg13cmos5l_decap_8_5361 \$2 \$1 sg13cmos5l_decap_8
* cell instance sg13cmos5l_decap_8_5362 r0 *1 0,0
Xsg13cmos5l_decap_8_5362 \$2 \$1 sg13cmos5l_decap_8
* cell instance sg13cmos5l_decap_8_5363 r0 *1 0,0
Xsg13cmos5l_decap_8_5363 \$2 \$1 sg13cmos5l_decap_8
* cell instance sg13cmos5l_decap_8_5364 r0 *1 0,0
Xsg13cmos5l_decap_8_5364 \$2 \$1 sg13cmos5l_decap_8
* cell instance sg13cmos5l_decap_8_5365 r0 *1 0,0
Xsg13cmos5l_decap_8_5365 \$2 \$1 sg13cmos5l_decap_8
* cell instance sg13cmos5l_decap_8_5366 r0 *1 0,0
Xsg13cmos5l_decap_8_5366 \$2 \$1 sg13cmos5l_decap_8
* cell instance sg13cmos5l_decap_8_5367 r0 *1 0,0
Xsg13cmos5l_decap_8_5367 \$2 \$1 sg13cmos5l_decap_8
* cell instance sg13cmos5l_decap_8_5368 r0 *1 0,0
Xsg13cmos5l_decap_8_5368 \$2 \$1 sg13cmos5l_decap_8
* cell instance sg13cmos5l_decap_8_5369 r0 *1 0,0
Xsg13cmos5l_decap_8_5369 \$2 \$1 sg13cmos5l_decap_8
* cell instance sg13cmos5l_decap_8_5370 r0 *1 0,0
Xsg13cmos5l_decap_8_5370 \$2 \$1 sg13cmos5l_decap_8
* cell instance sg13cmos5l_decap_8_5371 r0 *1 0,0
Xsg13cmos5l_decap_8_5371 \$2 \$1 sg13cmos5l_decap_8
* cell instance sg13cmos5l_decap_8_5372 r0 *1 0,0
Xsg13cmos5l_decap_8_5372 \$2 \$1 sg13cmos5l_decap_8
* cell instance sg13cmos5l_decap_8_5373 r0 *1 0,0
Xsg13cmos5l_decap_8_5373 \$2 \$1 sg13cmos5l_decap_8
* cell instance sg13cmos5l_decap_8_5374 r0 *1 0,0
Xsg13cmos5l_decap_8_5374 \$2 \$1 sg13cmos5l_decap_8
* cell instance sg13cmos5l_decap_8_5375 r0 *1 0,0
Xsg13cmos5l_decap_8_5375 \$2 \$1 sg13cmos5l_decap_8
* cell instance sg13cmos5l_decap_8_5376 r0 *1 0,0
Xsg13cmos5l_decap_8_5376 \$2 \$1 sg13cmos5l_decap_8
* cell instance sg13cmos5l_decap_8_5377 r0 *1 0,0
Xsg13cmos5l_decap_8_5377 \$2 \$1 sg13cmos5l_decap_8
* cell instance sg13cmos5l_decap_8_5378 r0 *1 0,0
Xsg13cmos5l_decap_8_5378 \$2 \$1 sg13cmos5l_decap_8
* cell instance sg13cmos5l_decap_8_5379 r0 *1 0,0
Xsg13cmos5l_decap_8_5379 \$2 \$1 sg13cmos5l_decap_8
* cell instance sg13cmos5l_decap_8_5380 r0 *1 0,0
Xsg13cmos5l_decap_8_5380 \$2 \$1 sg13cmos5l_decap_8
* cell instance sg13cmos5l_decap_8_5381 r0 *1 0,0
Xsg13cmos5l_decap_8_5381 \$2 \$1 sg13cmos5l_decap_8
* cell instance sg13cmos5l_decap_8_5382 r0 *1 0,0
Xsg13cmos5l_decap_8_5382 \$2 \$1 sg13cmos5l_decap_8
* cell instance sg13cmos5l_decap_8_5383 r0 *1 0,0
Xsg13cmos5l_decap_8_5383 \$2 \$1 sg13cmos5l_decap_8
* cell instance sg13cmos5l_decap_8_5384 r0 *1 0,0
Xsg13cmos5l_decap_8_5384 \$2 \$1 sg13cmos5l_decap_8
* cell instance sg13cmos5l_decap_8_5385 r0 *1 0,0
Xsg13cmos5l_decap_8_5385 \$2 \$1 sg13cmos5l_decap_8
* cell instance sg13cmos5l_decap_8_5386 r0 *1 0,0
Xsg13cmos5l_decap_8_5386 \$2 \$1 sg13cmos5l_decap_8
* cell instance sg13cmos5l_decap_8_5387 r0 *1 0,0
Xsg13cmos5l_decap_8_5387 \$2 \$1 sg13cmos5l_decap_8
* cell instance sg13cmos5l_decap_8_5388 r0 *1 0,0
Xsg13cmos5l_decap_8_5388 \$2 \$1 sg13cmos5l_decap_8
* cell instance sg13cmos5l_decap_8_5389 r0 *1 0,0
Xsg13cmos5l_decap_8_5389 \$2 \$1 sg13cmos5l_decap_8
* cell instance sg13cmos5l_decap_8_5390 r0 *1 0,0
Xsg13cmos5l_decap_8_5390 \$2 \$1 sg13cmos5l_decap_8
* cell instance sg13cmos5l_decap_8_5391 r0 *1 0,0
Xsg13cmos5l_decap_8_5391 \$2 \$1 sg13cmos5l_decap_8
* cell instance sg13cmos5l_decap_8_5392 r0 *1 0,0
Xsg13cmos5l_decap_8_5392 \$2 \$1 sg13cmos5l_decap_8
* cell instance sg13cmos5l_decap_8_5393 r0 *1 0,0
Xsg13cmos5l_decap_8_5393 \$2 \$1 sg13cmos5l_decap_8
* cell instance sg13cmos5l_decap_8_5394 r0 *1 0,0
Xsg13cmos5l_decap_8_5394 \$2 \$1 sg13cmos5l_decap_8
* cell instance sg13cmos5l_decap_8_5395 r0 *1 0,0
Xsg13cmos5l_decap_8_5395 \$2 \$1 sg13cmos5l_decap_8
* cell instance sg13cmos5l_decap_8_5396 r0 *1 0,0
Xsg13cmos5l_decap_8_5396 \$2 \$1 sg13cmos5l_decap_8
* cell instance sg13cmos5l_decap_8_5397 r0 *1 0,0
Xsg13cmos5l_decap_8_5397 \$2 \$1 sg13cmos5l_decap_8
* cell instance sg13cmos5l_decap_8_5398 r0 *1 0,0
Xsg13cmos5l_decap_8_5398 \$2 \$1 sg13cmos5l_decap_8
* cell instance sg13cmos5l_decap_8_5399 r0 *1 0,0
Xsg13cmos5l_decap_8_5399 \$2 \$1 sg13cmos5l_decap_8
* cell instance sg13cmos5l_decap_8_5400 r0 *1 0,0
Xsg13cmos5l_decap_8_5400 \$2 \$1 sg13cmos5l_decap_8
* cell instance sg13cmos5l_decap_8_5401 r0 *1 0,0
Xsg13cmos5l_decap_8_5401 \$2 \$1 sg13cmos5l_decap_8
* cell instance sg13cmos5l_decap_8_5402 r0 *1 0,0
Xsg13cmos5l_decap_8_5402 \$2 \$1 sg13cmos5l_decap_8
* cell instance sg13cmos5l_decap_8_5403 r0 *1 0,0
Xsg13cmos5l_decap_8_5403 \$2 \$1 sg13cmos5l_decap_8
* cell instance sg13cmos5l_decap_8_5404 r0 *1 0,0
Xsg13cmos5l_decap_8_5404 \$2 \$1 sg13cmos5l_decap_8
* cell instance sg13cmos5l_decap_8_5405 r0 *1 0,0
Xsg13cmos5l_decap_8_5405 \$2 \$1 sg13cmos5l_decap_8
* cell instance sg13cmos5l_decap_8_5406 r0 *1 0,0
Xsg13cmos5l_decap_8_5406 \$2 \$1 sg13cmos5l_decap_8
* cell instance sg13cmos5l_decap_8_5407 r0 *1 0,0
Xsg13cmos5l_decap_8_5407 \$2 \$1 sg13cmos5l_decap_8
* cell instance sg13cmos5l_decap_8_5408 r0 *1 0,0
Xsg13cmos5l_decap_8_5408 \$2 \$1 sg13cmos5l_decap_8
* cell instance sg13cmos5l_decap_8_5409 r0 *1 0,0
Xsg13cmos5l_decap_8_5409 \$2 \$1 sg13cmos5l_decap_8
* cell instance sg13cmos5l_decap_8_5410 r0 *1 0,0
Xsg13cmos5l_decap_8_5410 \$2 \$1 sg13cmos5l_decap_8
* cell instance sg13cmos5l_decap_8_5411 r0 *1 0,0
Xsg13cmos5l_decap_8_5411 \$2 \$1 sg13cmos5l_decap_8
* cell instance sg13cmos5l_decap_8_5412 r0 *1 0,0
Xsg13cmos5l_decap_8_5412 \$2 \$1 sg13cmos5l_decap_8
* cell instance sg13cmos5l_decap_8_5413 r0 *1 0,0
Xsg13cmos5l_decap_8_5413 \$2 \$1 sg13cmos5l_decap_8
* cell instance sg13cmos5l_decap_8_5414 r0 *1 0,0
Xsg13cmos5l_decap_8_5414 \$2 \$1 sg13cmos5l_decap_8
* cell instance sg13cmos5l_decap_8_5415 r0 *1 0,0
Xsg13cmos5l_decap_8_5415 \$2 \$1 sg13cmos5l_decap_8
* cell instance sg13cmos5l_decap_8_5416 r0 *1 0,0
Xsg13cmos5l_decap_8_5416 \$2 \$1 sg13cmos5l_decap_8
* cell instance sg13cmos5l_decap_8_5417 r0 *1 0,0
Xsg13cmos5l_decap_8_5417 \$2 \$1 sg13cmos5l_decap_8
* cell instance sg13cmos5l_decap_8_5418 r0 *1 0,0
Xsg13cmos5l_decap_8_5418 \$2 \$1 sg13cmos5l_decap_8
* cell instance sg13cmos5l_decap_8_5419 r0 *1 0,0
Xsg13cmos5l_decap_8_5419 \$2 \$1 sg13cmos5l_decap_8
* cell instance sg13cmos5l_decap_8_5420 r0 *1 0,0
Xsg13cmos5l_decap_8_5420 \$2 \$1 sg13cmos5l_decap_8
* cell instance sg13cmos5l_decap_8_5421 r0 *1 0,0
Xsg13cmos5l_decap_8_5421 \$2 \$1 sg13cmos5l_decap_8
* cell instance sg13cmos5l_decap_8_5422 r0 *1 0,0
Xsg13cmos5l_decap_8_5422 \$2 \$1 sg13cmos5l_decap_8
* cell instance sg13cmos5l_decap_8_5423 r0 *1 0,0
Xsg13cmos5l_decap_8_5423 \$2 \$1 sg13cmos5l_decap_8
* cell instance sg13cmos5l_decap_8_5424 r0 *1 0,0
Xsg13cmos5l_decap_8_5424 \$2 \$1 sg13cmos5l_decap_8
* cell instance sg13cmos5l_decap_8_5425 r0 *1 0,0
Xsg13cmos5l_decap_8_5425 \$2 \$1 sg13cmos5l_decap_8
* cell instance sg13cmos5l_decap_8_5426 r0 *1 0,0
Xsg13cmos5l_decap_8_5426 \$2 \$1 sg13cmos5l_decap_8
* cell instance sg13cmos5l_decap_8_5427 r0 *1 0,0
Xsg13cmos5l_decap_8_5427 \$2 \$1 sg13cmos5l_decap_8
* cell instance sg13cmos5l_decap_8_5428 r0 *1 0,0
Xsg13cmos5l_decap_8_5428 \$2 \$1 sg13cmos5l_decap_8
* cell instance sg13cmos5l_decap_8_5429 r0 *1 0,0
Xsg13cmos5l_decap_8_5429 \$2 \$1 sg13cmos5l_decap_8
* cell instance sg13cmos5l_decap_8_5430 r0 *1 0,0
Xsg13cmos5l_decap_8_5430 \$2 \$1 sg13cmos5l_decap_8
* cell instance sg13cmos5l_decap_8_5431 r0 *1 0,0
Xsg13cmos5l_decap_8_5431 \$2 \$1 sg13cmos5l_decap_8
* cell instance sg13cmos5l_decap_8_5432 r0 *1 0,0
Xsg13cmos5l_decap_8_5432 \$2 \$1 sg13cmos5l_decap_8
* cell instance sg13cmos5l_decap_8_5433 r0 *1 0,0
Xsg13cmos5l_decap_8_5433 \$2 \$1 sg13cmos5l_decap_8
* cell instance sg13cmos5l_decap_8_5434 r0 *1 0,0
Xsg13cmos5l_decap_8_5434 \$2 \$1 sg13cmos5l_decap_8
* cell instance sg13cmos5l_decap_8_5435 r0 *1 0,0
Xsg13cmos5l_decap_8_5435 \$2 \$1 sg13cmos5l_decap_8
* cell instance sg13cmos5l_decap_8_5436 r0 *1 0,0
Xsg13cmos5l_decap_8_5436 \$2 \$1 sg13cmos5l_decap_8
* cell instance sg13cmos5l_decap_8_5437 r0 *1 0,0
Xsg13cmos5l_decap_8_5437 \$2 \$1 sg13cmos5l_decap_8
* cell instance sg13cmos5l_decap_8_5438 r0 *1 0,0
Xsg13cmos5l_decap_8_5438 \$2 \$1 sg13cmos5l_decap_8
* cell instance sg13cmos5l_decap_8_5439 r0 *1 0,0
Xsg13cmos5l_decap_8_5439 \$2 \$1 sg13cmos5l_decap_8
* cell instance sg13cmos5l_decap_8_5440 r0 *1 0,0
Xsg13cmos5l_decap_8_5440 \$2 \$1 sg13cmos5l_decap_8
* cell instance sg13cmos5l_decap_8_5441 r0 *1 0,0
Xsg13cmos5l_decap_8_5441 \$2 \$1 sg13cmos5l_decap_8
* cell instance sg13cmos5l_decap_8_5442 r0 *1 0,0
Xsg13cmos5l_decap_8_5442 \$2 \$1 sg13cmos5l_decap_8
* cell instance sg13cmos5l_decap_8_5443 r0 *1 0,0
Xsg13cmos5l_decap_8_5443 \$2 \$1 sg13cmos5l_decap_8
* cell instance sg13cmos5l_decap_8_5444 r0 *1 0,0
Xsg13cmos5l_decap_8_5444 \$2 \$1 sg13cmos5l_decap_8
* cell instance sg13cmos5l_decap_8_5445 r0 *1 0,0
Xsg13cmos5l_decap_8_5445 \$2 \$1 sg13cmos5l_decap_8
* cell instance sg13cmos5l_decap_8_5446 r0 *1 0,0
Xsg13cmos5l_decap_8_5446 \$2 \$1 sg13cmos5l_decap_8
* cell instance sg13cmos5l_decap_8_5447 r0 *1 0,0
Xsg13cmos5l_decap_8_5447 \$2 \$1 sg13cmos5l_decap_8
* cell instance sg13cmos5l_decap_8_5448 r0 *1 0,0
Xsg13cmos5l_decap_8_5448 \$2 \$1 sg13cmos5l_decap_8
* cell instance sg13cmos5l_decap_8_5449 r0 *1 0,0
Xsg13cmos5l_decap_8_5449 \$2 \$1 sg13cmos5l_decap_8
* cell instance sg13cmos5l_decap_8_5450 r0 *1 0,0
Xsg13cmos5l_decap_8_5450 \$2 \$1 sg13cmos5l_decap_8
* cell instance sg13cmos5l_decap_8_5451 r0 *1 0,0
Xsg13cmos5l_decap_8_5451 \$2 \$1 sg13cmos5l_decap_8
* cell instance sg13cmos5l_decap_8_5452 r0 *1 0,0
Xsg13cmos5l_decap_8_5452 \$2 \$1 sg13cmos5l_decap_8
* cell instance sg13cmos5l_decap_8_5453 r0 *1 0,0
Xsg13cmos5l_decap_8_5453 \$2 \$1 sg13cmos5l_decap_8
* cell instance sg13cmos5l_decap_8_5454 r0 *1 0,0
Xsg13cmos5l_decap_8_5454 \$2 \$1 sg13cmos5l_decap_8
* cell instance sg13cmos5l_decap_8_5455 r0 *1 0,0
Xsg13cmos5l_decap_8_5455 \$2 \$1 sg13cmos5l_decap_8
* cell instance sg13cmos5l_decap_8_5456 r0 *1 0,0
Xsg13cmos5l_decap_8_5456 \$2 \$1 sg13cmos5l_decap_8
* cell instance sg13cmos5l_decap_8_5457 r0 *1 0,0
Xsg13cmos5l_decap_8_5457 \$2 \$1 sg13cmos5l_decap_8
* cell instance sg13cmos5l_decap_8_5458 r0 *1 0,0
Xsg13cmos5l_decap_8_5458 \$2 \$1 sg13cmos5l_decap_8
* cell instance sg13cmos5l_decap_8_5459 r0 *1 0,0
Xsg13cmos5l_decap_8_5459 \$2 \$1 sg13cmos5l_decap_8
* cell instance sg13cmos5l_decap_8_5460 r0 *1 0,0
Xsg13cmos5l_decap_8_5460 \$2 \$1 sg13cmos5l_decap_8
* cell instance sg13cmos5l_decap_8_5461 r0 *1 0,0
Xsg13cmos5l_decap_8_5461 \$2 \$1 sg13cmos5l_decap_8
* cell instance sg13cmos5l_decap_8_5462 r0 *1 0,0
Xsg13cmos5l_decap_8_5462 \$2 \$1 sg13cmos5l_decap_8
* cell instance sg13cmos5l_decap_8_5463 r0 *1 0,0
Xsg13cmos5l_decap_8_5463 \$2 \$1 sg13cmos5l_decap_8
* cell instance sg13cmos5l_decap_8_5464 r0 *1 0,0
Xsg13cmos5l_decap_8_5464 \$2 \$1 sg13cmos5l_decap_8
* cell instance sg13cmos5l_decap_8_5465 r0 *1 0,0
Xsg13cmos5l_decap_8_5465 \$2 \$1 sg13cmos5l_decap_8
* cell instance sg13cmos5l_decap_8_5466 r0 *1 0,0
Xsg13cmos5l_decap_8_5466 \$2 \$1 sg13cmos5l_decap_8
* cell instance sg13cmos5l_decap_8_5467 r0 *1 0,0
Xsg13cmos5l_decap_8_5467 \$2 \$1 sg13cmos5l_decap_8
* cell instance sg13cmos5l_decap_8_5468 r0 *1 0,0
Xsg13cmos5l_decap_8_5468 \$2 \$1 sg13cmos5l_decap_8
* cell instance sg13cmos5l_decap_8_5469 r0 *1 0,0
Xsg13cmos5l_decap_8_5469 \$2 \$1 sg13cmos5l_decap_8
* cell instance sg13cmos5l_decap_8_5470 r0 *1 0,0
Xsg13cmos5l_decap_8_5470 \$2 \$1 sg13cmos5l_decap_8
* cell instance sg13cmos5l_decap_8_5471 r0 *1 0,0
Xsg13cmos5l_decap_8_5471 \$2 \$1 sg13cmos5l_decap_8
* cell instance sg13cmos5l_decap_8_5472 r0 *1 0,0
Xsg13cmos5l_decap_8_5472 \$2 \$1 sg13cmos5l_decap_8
* cell instance sg13cmos5l_decap_8_5473 r0 *1 0,0
Xsg13cmos5l_decap_8_5473 \$2 \$1 sg13cmos5l_decap_8
* cell instance sg13cmos5l_decap_8_5474 r0 *1 0,0
Xsg13cmos5l_decap_8_5474 \$2 \$1 sg13cmos5l_decap_8
* cell instance sg13cmos5l_decap_8_5475 r0 *1 0,0
Xsg13cmos5l_decap_8_5475 \$2 \$1 sg13cmos5l_decap_8
* cell instance sg13cmos5l_decap_8_5476 r0 *1 0,0
Xsg13cmos5l_decap_8_5476 \$2 \$1 sg13cmos5l_decap_8
* cell instance sg13cmos5l_decap_8_5477 r0 *1 0,0
Xsg13cmos5l_decap_8_5477 \$2 \$1 sg13cmos5l_decap_8
* cell instance sg13cmos5l_decap_8_5478 r0 *1 0,0
Xsg13cmos5l_decap_8_5478 \$2 \$1 sg13cmos5l_decap_8
* cell instance sg13cmos5l_decap_8_5479 r0 *1 0,0
Xsg13cmos5l_decap_8_5479 \$2 \$1 sg13cmos5l_decap_8
* cell instance sg13cmos5l_decap_8_5480 r0 *1 0,0
Xsg13cmos5l_decap_8_5480 \$2 \$1 sg13cmos5l_decap_8
* cell instance sg13cmos5l_decap_8_5481 r0 *1 0,0
Xsg13cmos5l_decap_8_5481 \$2 \$1 sg13cmos5l_decap_8
* cell instance sg13cmos5l_decap_8_5482 r0 *1 0,0
Xsg13cmos5l_decap_8_5482 \$2 \$1 sg13cmos5l_decap_8
* cell instance sg13cmos5l_decap_8_5483 r0 *1 0,0
Xsg13cmos5l_decap_8_5483 \$2 \$1 sg13cmos5l_decap_8
* cell instance sg13cmos5l_decap_8_5484 r0 *1 0,0
Xsg13cmos5l_decap_8_5484 \$2 \$1 sg13cmos5l_decap_8
* cell instance sg13cmos5l_decap_8_5485 r0 *1 0,0
Xsg13cmos5l_decap_8_5485 \$2 \$1 sg13cmos5l_decap_8
* cell instance sg13cmos5l_decap_8_5486 r0 *1 0,0
Xsg13cmos5l_decap_8_5486 \$2 \$1 sg13cmos5l_decap_8
* cell instance sg13cmos5l_decap_8_5487 r0 *1 0,0
Xsg13cmos5l_decap_8_5487 \$2 \$1 sg13cmos5l_decap_8
* cell instance sg13cmos5l_decap_8_5488 r0 *1 0,0
Xsg13cmos5l_decap_8_5488 \$2 \$1 sg13cmos5l_decap_8
* cell instance sg13cmos5l_decap_8_5489 r0 *1 0,0
Xsg13cmos5l_decap_8_5489 \$2 \$1 sg13cmos5l_decap_8
* cell instance sg13cmos5l_decap_8_5490 r0 *1 0,0
Xsg13cmos5l_decap_8_5490 \$2 \$1 sg13cmos5l_decap_8
* cell instance sg13cmos5l_decap_8_5491 r0 *1 0,0
Xsg13cmos5l_decap_8_5491 \$2 \$1 sg13cmos5l_decap_8
* cell instance sg13cmos5l_decap_8_5492 r0 *1 0,0
Xsg13cmos5l_decap_8_5492 \$2 \$1 sg13cmos5l_decap_8
* cell instance sg13cmos5l_decap_8_5493 r0 *1 0,0
Xsg13cmos5l_decap_8_5493 \$2 \$1 sg13cmos5l_decap_8
* cell instance sg13cmos5l_decap_8_5494 r0 *1 0,0
Xsg13cmos5l_decap_8_5494 \$2 \$1 sg13cmos5l_decap_8
* cell instance sg13cmos5l_decap_8_5495 r0 *1 0,0
Xsg13cmos5l_decap_8_5495 \$2 \$1 sg13cmos5l_decap_8
* cell instance sg13cmos5l_decap_8_5496 r0 *1 0,0
Xsg13cmos5l_decap_8_5496 \$2 \$1 sg13cmos5l_decap_8
* cell instance sg13cmos5l_decap_8_5497 r0 *1 0,0
Xsg13cmos5l_decap_8_5497 \$2 \$1 sg13cmos5l_decap_8
* cell instance sg13cmos5l_decap_8_5498 r0 *1 0,0
Xsg13cmos5l_decap_8_5498 \$2 \$1 sg13cmos5l_decap_8
* cell instance sg13cmos5l_decap_8_5499 r0 *1 0,0
Xsg13cmos5l_decap_8_5499 \$2 \$1 sg13cmos5l_decap_8
* cell instance sg13cmos5l_decap_8_5500 r0 *1 0,0
Xsg13cmos5l_decap_8_5500 \$2 \$1 sg13cmos5l_decap_8
* cell instance sg13cmos5l_decap_8_5501 r0 *1 0,0
Xsg13cmos5l_decap_8_5501 \$2 \$1 sg13cmos5l_decap_8
* cell instance sg13cmos5l_decap_8_5502 r0 *1 0,0
Xsg13cmos5l_decap_8_5502 \$2 \$1 sg13cmos5l_decap_8
* cell instance sg13cmos5l_decap_8_5503 r0 *1 0,0
Xsg13cmos5l_decap_8_5503 \$2 \$1 sg13cmos5l_decap_8
* cell instance sg13cmos5l_decap_8_5504 r0 *1 0,0
Xsg13cmos5l_decap_8_5504 \$2 \$1 sg13cmos5l_decap_8
* cell instance sg13cmos5l_decap_8_5505 r0 *1 0,0
Xsg13cmos5l_decap_8_5505 \$2 \$1 sg13cmos5l_decap_8
* cell instance sg13cmos5l_decap_8_5506 r0 *1 0,0
Xsg13cmos5l_decap_8_5506 \$2 \$1 sg13cmos5l_decap_8
* cell instance sg13cmos5l_decap_8_5507 r0 *1 0,0
Xsg13cmos5l_decap_8_5507 \$2 \$1 sg13cmos5l_decap_8
* cell instance sg13cmos5l_decap_8_5508 r0 *1 0,0
Xsg13cmos5l_decap_8_5508 \$2 \$1 sg13cmos5l_decap_8
* cell instance sg13cmos5l_decap_8_5509 r0 *1 0,0
Xsg13cmos5l_decap_8_5509 \$2 \$1 sg13cmos5l_decap_8
* cell instance sg13cmos5l_decap_8_5510 r0 *1 0,0
Xsg13cmos5l_decap_8_5510 \$2 \$1 sg13cmos5l_decap_8
* cell instance sg13cmos5l_decap_8_5511 r0 *1 0,0
Xsg13cmos5l_decap_8_5511 \$2 \$1 sg13cmos5l_decap_8
* cell instance sg13cmos5l_decap_8_5512 r0 *1 0,0
Xsg13cmos5l_decap_8_5512 \$2 \$1 sg13cmos5l_decap_8
* cell instance sg13cmos5l_decap_8_5513 r0 *1 0,0
Xsg13cmos5l_decap_8_5513 \$2 \$1 sg13cmos5l_decap_8
* cell instance sg13cmos5l_decap_8_5514 r0 *1 0,0
Xsg13cmos5l_decap_8_5514 \$2 \$1 sg13cmos5l_decap_8
* cell instance sg13cmos5l_decap_8_5515 r0 *1 0,0
Xsg13cmos5l_decap_8_5515 \$2 \$1 sg13cmos5l_decap_8
* cell instance sg13cmos5l_decap_8_5516 r0 *1 0,0
Xsg13cmos5l_decap_8_5516 \$2 \$1 sg13cmos5l_decap_8
* cell instance sg13cmos5l_decap_8_5517 r0 *1 0,0
Xsg13cmos5l_decap_8_5517 \$2 \$1 sg13cmos5l_decap_8
* cell instance sg13cmos5l_decap_8_5518 r0 *1 0,0
Xsg13cmos5l_decap_8_5518 \$2 \$1 sg13cmos5l_decap_8
* cell instance sg13cmos5l_decap_8_5519 r0 *1 0,0
Xsg13cmos5l_decap_8_5519 \$2 \$1 sg13cmos5l_decap_8
* cell instance sg13cmos5l_decap_8_5520 r0 *1 0,0
Xsg13cmos5l_decap_8_5520 \$2 \$1 sg13cmos5l_decap_8
* cell instance sg13cmos5l_decap_8_5521 r0 *1 0,0
Xsg13cmos5l_decap_8_5521 \$2 \$1 sg13cmos5l_decap_8
* cell instance sg13cmos5l_decap_8_5522 r0 *1 0,0
Xsg13cmos5l_decap_8_5522 \$2 \$1 sg13cmos5l_decap_8
* cell instance sg13cmos5l_decap_8_5523 r0 *1 0,0
Xsg13cmos5l_decap_8_5523 \$2 \$1 sg13cmos5l_decap_8
* cell instance sg13cmos5l_decap_8_5524 r0 *1 0,0
Xsg13cmos5l_decap_8_5524 \$2 \$1 sg13cmos5l_decap_8
* cell instance sg13cmos5l_decap_8_5525 r0 *1 0,0
Xsg13cmos5l_decap_8_5525 \$2 \$1 sg13cmos5l_decap_8
* cell instance sg13cmos5l_decap_8_5526 r0 *1 0,0
Xsg13cmos5l_decap_8_5526 \$2 \$1 sg13cmos5l_decap_8
* cell instance sg13cmos5l_decap_8_5527 r0 *1 0,0
Xsg13cmos5l_decap_8_5527 \$2 \$1 sg13cmos5l_decap_8
* cell instance sg13cmos5l_decap_8_5528 r0 *1 0,0
Xsg13cmos5l_decap_8_5528 \$2 \$1 sg13cmos5l_decap_8
* cell instance sg13cmos5l_decap_8_5529 r0 *1 0,0
Xsg13cmos5l_decap_8_5529 \$2 \$1 sg13cmos5l_decap_8
* cell instance sg13cmos5l_decap_8_5530 r0 *1 0,0
Xsg13cmos5l_decap_8_5530 \$2 \$1 sg13cmos5l_decap_8
* cell instance sg13cmos5l_decap_8_5531 r0 *1 0,0
Xsg13cmos5l_decap_8_5531 \$2 \$1 sg13cmos5l_decap_8
* cell instance sg13cmos5l_decap_8_5532 r0 *1 0,0
Xsg13cmos5l_decap_8_5532 \$2 \$1 sg13cmos5l_decap_8
* cell instance sg13cmos5l_decap_8_5533 r0 *1 0,0
Xsg13cmos5l_decap_8_5533 \$2 \$1 sg13cmos5l_decap_8
* cell instance sg13cmos5l_decap_8_5534 r0 *1 0,0
Xsg13cmos5l_decap_8_5534 \$2 \$1 sg13cmos5l_decap_8
* cell instance sg13cmos5l_decap_8_5535 r0 *1 0,0
Xsg13cmos5l_decap_8_5535 \$2 \$1 sg13cmos5l_decap_8
* cell instance sg13cmos5l_decap_8_5536 r0 *1 0,0
Xsg13cmos5l_decap_8_5536 \$2 \$1 sg13cmos5l_decap_8
* cell instance sg13cmos5l_decap_8_5537 r0 *1 0,0
Xsg13cmos5l_decap_8_5537 \$2 \$1 sg13cmos5l_decap_8
* cell instance sg13cmos5l_decap_8_5538 r0 *1 0,0
Xsg13cmos5l_decap_8_5538 \$2 \$1 sg13cmos5l_decap_8
* cell instance sg13cmos5l_decap_8_5539 r0 *1 0,0
Xsg13cmos5l_decap_8_5539 \$2 \$1 sg13cmos5l_decap_8
* cell instance sg13cmos5l_decap_8_5540 r0 *1 0,0
Xsg13cmos5l_decap_8_5540 \$2 \$1 sg13cmos5l_decap_8
* cell instance sg13cmos5l_decap_8_5541 r0 *1 0,0
Xsg13cmos5l_decap_8_5541 \$2 \$1 sg13cmos5l_decap_8
* cell instance sg13cmos5l_decap_8_5542 r0 *1 0,0
Xsg13cmos5l_decap_8_5542 \$2 \$1 sg13cmos5l_decap_8
* cell instance sg13cmos5l_decap_8_5543 r0 *1 0,0
Xsg13cmos5l_decap_8_5543 \$2 \$1 sg13cmos5l_decap_8
* cell instance sg13cmos5l_decap_8_5544 r0 *1 0,0
Xsg13cmos5l_decap_8_5544 \$2 \$1 sg13cmos5l_decap_8
* cell instance sg13cmos5l_decap_8_5545 r0 *1 0,0
Xsg13cmos5l_decap_8_5545 \$2 \$1 sg13cmos5l_decap_8
* cell instance sg13cmos5l_decap_8_5546 r0 *1 0,0
Xsg13cmos5l_decap_8_5546 \$2 \$1 sg13cmos5l_decap_8
* cell instance sg13cmos5l_decap_8_5547 r0 *1 0,0
Xsg13cmos5l_decap_8_5547 \$2 \$1 sg13cmos5l_decap_8
* cell instance sg13cmos5l_decap_8_5548 r0 *1 0,0
Xsg13cmos5l_decap_8_5548 \$2 \$1 sg13cmos5l_decap_8
* cell instance sg13cmos5l_decap_8_5549 r0 *1 0,0
Xsg13cmos5l_decap_8_5549 \$2 \$1 sg13cmos5l_decap_8
* cell instance sg13cmos5l_decap_8_5550 r0 *1 0,0
Xsg13cmos5l_decap_8_5550 \$2 \$1 sg13cmos5l_decap_8
* cell instance sg13cmos5l_decap_8_5551 r0 *1 0,0
Xsg13cmos5l_decap_8_5551 \$2 \$1 sg13cmos5l_decap_8
* cell instance sg13cmos5l_decap_8_5552 r0 *1 0,0
Xsg13cmos5l_decap_8_5552 \$2 \$1 sg13cmos5l_decap_8
* cell instance sg13cmos5l_decap_8_5553 r0 *1 0,0
Xsg13cmos5l_decap_8_5553 \$2 \$1 sg13cmos5l_decap_8
* cell instance sg13cmos5l_decap_8_5554 r0 *1 0,0
Xsg13cmos5l_decap_8_5554 \$2 \$1 sg13cmos5l_decap_8
* cell instance sg13cmos5l_decap_8_5555 r0 *1 0,0
Xsg13cmos5l_decap_8_5555 \$2 \$1 sg13cmos5l_decap_8
* cell instance sg13cmos5l_decap_8_5556 r0 *1 0,0
Xsg13cmos5l_decap_8_5556 \$2 \$1 sg13cmos5l_decap_8
* cell instance sg13cmos5l_decap_8_5557 r0 *1 0,0
Xsg13cmos5l_decap_8_5557 \$2 \$1 sg13cmos5l_decap_8
* cell instance sg13cmos5l_decap_8_5558 r0 *1 0,0
Xsg13cmos5l_decap_8_5558 \$2 \$1 sg13cmos5l_decap_8
* cell instance sg13cmos5l_decap_8_5559 r0 *1 0,0
Xsg13cmos5l_decap_8_5559 \$2 \$1 sg13cmos5l_decap_8
* cell instance sg13cmos5l_decap_8_5560 r0 *1 0,0
Xsg13cmos5l_decap_8_5560 \$2 \$1 sg13cmos5l_decap_8
* cell instance sg13cmos5l_decap_8_5561 r0 *1 0,0
Xsg13cmos5l_decap_8_5561 \$2 \$1 sg13cmos5l_decap_8
* cell instance sg13cmos5l_decap_8_5562 r0 *1 0,0
Xsg13cmos5l_decap_8_5562 \$2 \$1 sg13cmos5l_decap_8
* cell instance sg13cmos5l_decap_8_5563 r0 *1 0,0
Xsg13cmos5l_decap_8_5563 \$2 \$1 sg13cmos5l_decap_8
* cell instance sg13cmos5l_decap_8_5564 r0 *1 0,0
Xsg13cmos5l_decap_8_5564 \$2 \$1 sg13cmos5l_decap_8
* cell instance sg13cmos5l_decap_8_5565 r0 *1 0,0
Xsg13cmos5l_decap_8_5565 \$2 \$1 sg13cmos5l_decap_8
* cell instance sg13cmos5l_decap_8_5566 r0 *1 0,0
Xsg13cmos5l_decap_8_5566 \$2 \$1 sg13cmos5l_decap_8
* cell instance sg13cmos5l_decap_8_5567 r0 *1 0,0
Xsg13cmos5l_decap_8_5567 \$2 \$1 sg13cmos5l_decap_8
* cell instance sg13cmos5l_decap_8_5568 r0 *1 0,0
Xsg13cmos5l_decap_8_5568 \$2 \$1 sg13cmos5l_decap_8
* cell instance sg13cmos5l_decap_8_5569 r0 *1 0,0
Xsg13cmos5l_decap_8_5569 \$2 \$1 sg13cmos5l_decap_8
* cell instance sg13cmos5l_decap_8_5570 r0 *1 0,0
Xsg13cmos5l_decap_8_5570 \$2 \$1 sg13cmos5l_decap_8
* cell instance sg13cmos5l_decap_8_5571 r0 *1 0,0
Xsg13cmos5l_decap_8_5571 \$2 \$1 sg13cmos5l_decap_8
* cell instance sg13cmos5l_decap_8_5572 r0 *1 0,0
Xsg13cmos5l_decap_8_5572 \$2 \$1 sg13cmos5l_decap_8
* cell instance sg13cmos5l_decap_8_5573 r0 *1 0,0
Xsg13cmos5l_decap_8_5573 \$2 \$1 sg13cmos5l_decap_8
* cell instance sg13cmos5l_decap_8_5574 r0 *1 0,0
Xsg13cmos5l_decap_8_5574 \$2 \$1 sg13cmos5l_decap_8
* cell instance sg13cmos5l_decap_8_5575 r0 *1 0,0
Xsg13cmos5l_decap_8_5575 \$2 \$1 sg13cmos5l_decap_8
* cell instance sg13cmos5l_decap_8_5576 r0 *1 0,0
Xsg13cmos5l_decap_8_5576 \$2 \$1 sg13cmos5l_decap_8
* cell instance sg13cmos5l_decap_8_5577 r0 *1 0,0
Xsg13cmos5l_decap_8_5577 \$2 \$1 sg13cmos5l_decap_8
* cell instance sg13cmos5l_decap_8_5578 r0 *1 0,0
Xsg13cmos5l_decap_8_5578 \$2 \$1 sg13cmos5l_decap_8
* cell instance sg13cmos5l_decap_8_5579 r0 *1 0,0
Xsg13cmos5l_decap_8_5579 \$2 \$1 sg13cmos5l_decap_8
* cell instance sg13cmos5l_decap_8_5580 r0 *1 0,0
Xsg13cmos5l_decap_8_5580 \$2 \$1 sg13cmos5l_decap_8
* cell instance sg13cmos5l_decap_8_5581 r0 *1 0,0
Xsg13cmos5l_decap_8_5581 \$2 \$1 sg13cmos5l_decap_8
* cell instance sg13cmos5l_decap_8_5582 r0 *1 0,0
Xsg13cmos5l_decap_8_5582 \$2 \$1 sg13cmos5l_decap_8
* cell instance sg13cmos5l_decap_8_5583 r0 *1 0,0
Xsg13cmos5l_decap_8_5583 \$2 \$1 sg13cmos5l_decap_8
* cell instance sg13cmos5l_decap_8_5584 r0 *1 0,0
Xsg13cmos5l_decap_8_5584 \$2 \$1 sg13cmos5l_decap_8
* cell instance sg13cmos5l_decap_8_5585 r0 *1 0,0
Xsg13cmos5l_decap_8_5585 \$2 \$1 sg13cmos5l_decap_8
* cell instance sg13cmos5l_decap_8_5586 r0 *1 0,0
Xsg13cmos5l_decap_8_5586 \$2 \$1 sg13cmos5l_decap_8
* cell instance sg13cmos5l_decap_8_5587 r0 *1 0,0
Xsg13cmos5l_decap_8_5587 \$2 \$1 sg13cmos5l_decap_8
* cell instance sg13cmos5l_decap_8_5588 r0 *1 0,0
Xsg13cmos5l_decap_8_5588 \$2 \$1 sg13cmos5l_decap_8
* cell instance sg13cmos5l_decap_8_5589 r0 *1 0,0
Xsg13cmos5l_decap_8_5589 \$2 \$1 sg13cmos5l_decap_8
* cell instance sg13cmos5l_decap_8_5590 r0 *1 0,0
Xsg13cmos5l_decap_8_5590 \$2 \$1 sg13cmos5l_decap_8
* cell instance sg13cmos5l_decap_8_5591 r0 *1 0,0
Xsg13cmos5l_decap_8_5591 \$2 \$1 sg13cmos5l_decap_8
* cell instance sg13cmos5l_decap_8_5592 r0 *1 0,0
Xsg13cmos5l_decap_8_5592 \$2 \$1 sg13cmos5l_decap_8
* cell instance sg13cmos5l_decap_8_5593 r0 *1 0,0
Xsg13cmos5l_decap_8_5593 \$2 \$1 sg13cmos5l_decap_8
* cell instance sg13cmos5l_decap_8_5594 r0 *1 0,0
Xsg13cmos5l_decap_8_5594 \$2 \$1 sg13cmos5l_decap_8
* cell instance sg13cmos5l_decap_8_5595 r0 *1 0,0
Xsg13cmos5l_decap_8_5595 \$2 \$1 sg13cmos5l_decap_8
* cell instance sg13cmos5l_decap_8_5596 r0 *1 0,0
Xsg13cmos5l_decap_8_5596 \$2 \$1 sg13cmos5l_decap_8
* cell instance sg13cmos5l_decap_8_5597 r0 *1 0,0
Xsg13cmos5l_decap_8_5597 \$2 \$1 sg13cmos5l_decap_8
* cell instance sg13cmos5l_decap_8_5598 r0 *1 0,0
Xsg13cmos5l_decap_8_5598 \$2 \$1 sg13cmos5l_decap_8
* cell instance sg13cmos5l_decap_8_5599 r0 *1 0,0
Xsg13cmos5l_decap_8_5599 \$2 \$1 sg13cmos5l_decap_8
* cell instance sg13cmos5l_decap_8_5600 r0 *1 0,0
Xsg13cmos5l_decap_8_5600 \$2 \$1 sg13cmos5l_decap_8
* cell instance sg13cmos5l_decap_8_5601 r0 *1 0,0
Xsg13cmos5l_decap_8_5601 \$2 \$1 sg13cmos5l_decap_8
* cell instance sg13cmos5l_decap_8_5602 r0 *1 0,0
Xsg13cmos5l_decap_8_5602 \$2 \$1 sg13cmos5l_decap_8
* cell instance sg13cmos5l_decap_8_5603 r0 *1 0,0
Xsg13cmos5l_decap_8_5603 \$2 \$1 sg13cmos5l_decap_8
* cell instance sg13cmos5l_decap_8_5604 r0 *1 0,0
Xsg13cmos5l_decap_8_5604 \$2 \$1 sg13cmos5l_decap_8
* cell instance sg13cmos5l_decap_8_5605 r0 *1 0,0
Xsg13cmos5l_decap_8_5605 \$2 \$1 sg13cmos5l_decap_8
* cell instance sg13cmos5l_decap_8_5606 r0 *1 0,0
Xsg13cmos5l_decap_8_5606 \$2 \$1 sg13cmos5l_decap_8
* cell instance sg13cmos5l_decap_8_5607 r0 *1 0,0
Xsg13cmos5l_decap_8_5607 \$2 \$1 sg13cmos5l_decap_8
* cell instance sg13cmos5l_decap_8_5608 r0 *1 0,0
Xsg13cmos5l_decap_8_5608 \$2 \$1 sg13cmos5l_decap_8
* cell instance sg13cmos5l_decap_8_5609 r0 *1 0,0
Xsg13cmos5l_decap_8_5609 \$2 \$1 sg13cmos5l_decap_8
* cell instance sg13cmos5l_decap_8_5610 r0 *1 0,0
Xsg13cmos5l_decap_8_5610 \$2 \$1 sg13cmos5l_decap_8
* cell instance sg13cmos5l_decap_8_5611 r0 *1 0,0
Xsg13cmos5l_decap_8_5611 \$2 \$1 sg13cmos5l_decap_8
* cell instance sg13cmos5l_decap_8_5612 r0 *1 0,0
Xsg13cmos5l_decap_8_5612 \$2 \$1 sg13cmos5l_decap_8
* cell instance sg13cmos5l_decap_8_5613 r0 *1 0,0
Xsg13cmos5l_decap_8_5613 \$2 \$1 sg13cmos5l_decap_8
* cell instance sg13cmos5l_decap_8_5614 r0 *1 0,0
Xsg13cmos5l_decap_8_5614 \$2 \$1 sg13cmos5l_decap_8
* cell instance sg13cmos5l_decap_8_5615 r0 *1 0,0
Xsg13cmos5l_decap_8_5615 \$2 \$1 sg13cmos5l_decap_8
* cell instance sg13cmos5l_decap_8_5616 r0 *1 0,0
Xsg13cmos5l_decap_8_5616 \$2 \$1 sg13cmos5l_decap_8
* cell instance sg13cmos5l_decap_8_5617 r0 *1 0,0
Xsg13cmos5l_decap_8_5617 \$2 \$1 sg13cmos5l_decap_8
* cell instance sg13cmos5l_decap_8_5618 r0 *1 0,0
Xsg13cmos5l_decap_8_5618 \$2 \$1 sg13cmos5l_decap_8
* cell instance sg13cmos5l_decap_8_5619 r0 *1 0,0
Xsg13cmos5l_decap_8_5619 \$2 \$1 sg13cmos5l_decap_8
* cell instance sg13cmos5l_decap_8_5620 r0 *1 0,0
Xsg13cmos5l_decap_8_5620 \$2 \$1 sg13cmos5l_decap_8
* cell instance sg13cmos5l_decap_8_5621 r0 *1 0,0
Xsg13cmos5l_decap_8_5621 \$2 \$1 sg13cmos5l_decap_8
* cell instance sg13cmos5l_decap_8_5622 r0 *1 0,0
Xsg13cmos5l_decap_8_5622 \$2 \$1 sg13cmos5l_decap_8
* cell instance sg13cmos5l_decap_8_5623 r0 *1 0,0
Xsg13cmos5l_decap_8_5623 \$2 \$1 sg13cmos5l_decap_8
* cell instance sg13cmos5l_decap_8_5624 r0 *1 0,0
Xsg13cmos5l_decap_8_5624 \$2 \$1 sg13cmos5l_decap_8
* cell instance sg13cmos5l_decap_8_5625 r0 *1 0,0
Xsg13cmos5l_decap_8_5625 \$2 \$1 sg13cmos5l_decap_8
* cell instance sg13cmos5l_decap_8_5626 r0 *1 0,0
Xsg13cmos5l_decap_8_5626 \$2 \$1 sg13cmos5l_decap_8
* cell instance sg13cmos5l_decap_8_5627 r0 *1 0,0
Xsg13cmos5l_decap_8_5627 \$2 \$1 sg13cmos5l_decap_8
* cell instance sg13cmos5l_decap_8_5628 r0 *1 0,0
Xsg13cmos5l_decap_8_5628 \$2 \$1 sg13cmos5l_decap_8
* cell instance sg13cmos5l_decap_8_5629 r0 *1 0,0
Xsg13cmos5l_decap_8_5629 \$2 \$1 sg13cmos5l_decap_8
* cell instance sg13cmos5l_decap_8_5630 r0 *1 0,0
Xsg13cmos5l_decap_8_5630 \$2 \$1 sg13cmos5l_decap_8
* cell instance sg13cmos5l_decap_8_5631 r0 *1 0,0
Xsg13cmos5l_decap_8_5631 \$2 \$1 sg13cmos5l_decap_8
* cell instance sg13cmos5l_decap_8_5632 r0 *1 0,0
Xsg13cmos5l_decap_8_5632 \$2 \$1 sg13cmos5l_decap_8
* cell instance sg13cmos5l_decap_8_5633 r0 *1 0,0
Xsg13cmos5l_decap_8_5633 \$2 \$1 sg13cmos5l_decap_8
* cell instance sg13cmos5l_decap_8_5634 r0 *1 0,0
Xsg13cmos5l_decap_8_5634 \$2 \$1 sg13cmos5l_decap_8
* cell instance sg13cmos5l_decap_8_5635 r0 *1 0,0
Xsg13cmos5l_decap_8_5635 \$2 \$1 sg13cmos5l_decap_8
* cell instance sg13cmos5l_decap_8_5636 r0 *1 0,0
Xsg13cmos5l_decap_8_5636 \$2 \$1 sg13cmos5l_decap_8
* cell instance sg13cmos5l_decap_8_5637 r0 *1 0,0
Xsg13cmos5l_decap_8_5637 \$2 \$1 sg13cmos5l_decap_8
* cell instance sg13cmos5l_decap_8_5638 r0 *1 0,0
Xsg13cmos5l_decap_8_5638 \$2 \$1 sg13cmos5l_decap_8
* cell instance sg13cmos5l_decap_8_5639 r0 *1 0,0
Xsg13cmos5l_decap_8_5639 \$2 \$1 sg13cmos5l_decap_8
* cell instance sg13cmos5l_decap_8_5640 r0 *1 0,0
Xsg13cmos5l_decap_8_5640 \$2 \$1 sg13cmos5l_decap_8
* cell instance sg13cmos5l_decap_8_5641 r0 *1 0,0
Xsg13cmos5l_decap_8_5641 \$2 \$1 sg13cmos5l_decap_8
* cell instance sg13cmos5l_decap_8_5642 r0 *1 0,0
Xsg13cmos5l_decap_8_5642 \$2 \$1 sg13cmos5l_decap_8
* cell instance sg13cmos5l_decap_8_5643 r0 *1 0,0
Xsg13cmos5l_decap_8_5643 \$2 \$1 sg13cmos5l_decap_8
* cell instance sg13cmos5l_decap_8_5644 r0 *1 0,0
Xsg13cmos5l_decap_8_5644 \$2 \$1 sg13cmos5l_decap_8
* cell instance sg13cmos5l_decap_8_5645 r0 *1 0,0
Xsg13cmos5l_decap_8_5645 \$2 \$1 sg13cmos5l_decap_8
* cell instance sg13cmos5l_decap_8_5646 r0 *1 0,0
Xsg13cmos5l_decap_8_5646 \$2 \$1 sg13cmos5l_decap_8
* cell instance sg13cmos5l_decap_8_5647 r0 *1 0,0
Xsg13cmos5l_decap_8_5647 \$2 \$1 sg13cmos5l_decap_8
* cell instance sg13cmos5l_decap_8_5648 r0 *1 0,0
Xsg13cmos5l_decap_8_5648 \$2 \$1 sg13cmos5l_decap_8
* cell instance sg13cmos5l_decap_8_5649 r0 *1 0,0
Xsg13cmos5l_decap_8_5649 \$2 \$1 sg13cmos5l_decap_8
* cell instance sg13cmos5l_decap_8_5650 r0 *1 0,0
Xsg13cmos5l_decap_8_5650 \$2 \$1 sg13cmos5l_decap_8
* cell instance sg13cmos5l_decap_8_5651 r0 *1 0,0
Xsg13cmos5l_decap_8_5651 \$2 \$1 sg13cmos5l_decap_8
* cell instance sg13cmos5l_decap_8_5652 r0 *1 0,0
Xsg13cmos5l_decap_8_5652 \$2 \$1 sg13cmos5l_decap_8
* cell instance sg13cmos5l_decap_8_5653 r0 *1 0,0
Xsg13cmos5l_decap_8_5653 \$2 \$1 sg13cmos5l_decap_8
* cell instance sg13cmos5l_decap_8_5654 r0 *1 0,0
Xsg13cmos5l_decap_8_5654 \$2 \$1 sg13cmos5l_decap_8
* cell instance sg13cmos5l_decap_8_5655 r0 *1 0,0
Xsg13cmos5l_decap_8_5655 \$2 \$1 sg13cmos5l_decap_8
* cell instance sg13cmos5l_decap_8_5656 r0 *1 0,0
Xsg13cmos5l_decap_8_5656 \$2 \$1 sg13cmos5l_decap_8
* cell instance sg13cmos5l_decap_8_5657 r0 *1 0,0
Xsg13cmos5l_decap_8_5657 \$2 \$1 sg13cmos5l_decap_8
* cell instance sg13cmos5l_decap_8_5658 r0 *1 0,0
Xsg13cmos5l_decap_8_5658 \$2 \$1 sg13cmos5l_decap_8
* cell instance sg13cmos5l_decap_8_5659 r0 *1 0,0
Xsg13cmos5l_decap_8_5659 \$2 \$1 sg13cmos5l_decap_8
* cell instance sg13cmos5l_decap_8_5660 r0 *1 0,0
Xsg13cmos5l_decap_8_5660 \$2 \$1 sg13cmos5l_decap_8
* cell instance sg13cmos5l_decap_8_5661 r0 *1 0,0
Xsg13cmos5l_decap_8_5661 \$2 \$1 sg13cmos5l_decap_8
* cell instance sg13cmos5l_decap_8_5662 r0 *1 0,0
Xsg13cmos5l_decap_8_5662 \$2 \$1 sg13cmos5l_decap_8
* cell instance sg13cmos5l_decap_8_5663 r0 *1 0,0
Xsg13cmos5l_decap_8_5663 \$2 \$1 sg13cmos5l_decap_8
* cell instance sg13cmos5l_decap_8_5664 r0 *1 0,0
Xsg13cmos5l_decap_8_5664 \$2 \$1 sg13cmos5l_decap_8
* cell instance sg13cmos5l_decap_8_5665 r0 *1 0,0
Xsg13cmos5l_decap_8_5665 \$2 \$1 sg13cmos5l_decap_8
* cell instance sg13cmos5l_decap_8_5666 r0 *1 0,0
Xsg13cmos5l_decap_8_5666 \$2 \$1 sg13cmos5l_decap_8
* cell instance sg13cmos5l_decap_8_5667 r0 *1 0,0
Xsg13cmos5l_decap_8_5667 \$2 \$1 sg13cmos5l_decap_8
* cell instance sg13cmos5l_decap_8_5668 r0 *1 0,0
Xsg13cmos5l_decap_8_5668 \$2 \$1 sg13cmos5l_decap_8
* cell instance sg13cmos5l_decap_8_5669 r0 *1 0,0
Xsg13cmos5l_decap_8_5669 \$2 \$1 sg13cmos5l_decap_8
* cell instance sg13cmos5l_decap_8_5670 r0 *1 0,0
Xsg13cmos5l_decap_8_5670 \$2 \$1 sg13cmos5l_decap_8
* cell instance sg13cmos5l_decap_8_5671 r0 *1 0,0
Xsg13cmos5l_decap_8_5671 \$2 \$1 sg13cmos5l_decap_8
* cell instance sg13cmos5l_decap_8_5672 r0 *1 0,0
Xsg13cmos5l_decap_8_5672 \$2 \$1 sg13cmos5l_decap_8
* cell instance sg13cmos5l_decap_8_5673 r0 *1 0,0
Xsg13cmos5l_decap_8_5673 \$2 \$1 sg13cmos5l_decap_8
* cell instance sg13cmos5l_decap_8_5674 r0 *1 0,0
Xsg13cmos5l_decap_8_5674 \$2 \$1 sg13cmos5l_decap_8
* cell instance sg13cmos5l_decap_8_5675 r0 *1 0,0
Xsg13cmos5l_decap_8_5675 \$2 \$1 sg13cmos5l_decap_8
* cell instance sg13cmos5l_decap_8_5676 r0 *1 0,0
Xsg13cmos5l_decap_8_5676 \$2 \$1 sg13cmos5l_decap_8
* cell instance sg13cmos5l_decap_8_5677 r0 *1 0,0
Xsg13cmos5l_decap_8_5677 \$2 \$1 sg13cmos5l_decap_8
* cell instance sg13cmos5l_decap_8_5678 r0 *1 0,0
Xsg13cmos5l_decap_8_5678 \$2 \$1 sg13cmos5l_decap_8
* cell instance sg13cmos5l_decap_8_5679 r0 *1 0,0
Xsg13cmos5l_decap_8_5679 \$2 \$1 sg13cmos5l_decap_8
* cell instance sg13cmos5l_decap_8_5680 r0 *1 0,0
Xsg13cmos5l_decap_8_5680 \$2 \$1 sg13cmos5l_decap_8
* cell instance sg13cmos5l_decap_8_5681 r0 *1 0,0
Xsg13cmos5l_decap_8_5681 \$2 \$1 sg13cmos5l_decap_8
* cell instance sg13cmos5l_decap_8_5682 r0 *1 0,0
Xsg13cmos5l_decap_8_5682 \$2 \$1 sg13cmos5l_decap_8
* cell instance sg13cmos5l_decap_8_5683 r0 *1 0,0
Xsg13cmos5l_decap_8_5683 \$2 \$1 sg13cmos5l_decap_8
* cell instance sg13cmos5l_decap_8_5684 r0 *1 0,0
Xsg13cmos5l_decap_8_5684 \$2 \$1 sg13cmos5l_decap_8
* cell instance sg13cmos5l_decap_8_5685 r0 *1 0,0
Xsg13cmos5l_decap_8_5685 \$2 \$1 sg13cmos5l_decap_8
* cell instance sg13cmos5l_decap_8_5686 r0 *1 0,0
Xsg13cmos5l_decap_8_5686 \$2 \$1 sg13cmos5l_decap_8
* cell instance sg13cmos5l_decap_8_5687 r0 *1 0,0
Xsg13cmos5l_decap_8_5687 \$2 \$1 sg13cmos5l_decap_8
* cell instance sg13cmos5l_decap_8_5688 r0 *1 0,0
Xsg13cmos5l_decap_8_5688 \$2 \$1 sg13cmos5l_decap_8
* cell instance sg13cmos5l_decap_8_5689 r0 *1 0,0
Xsg13cmos5l_decap_8_5689 \$2 \$1 sg13cmos5l_decap_8
* cell instance sg13cmos5l_decap_8_5690 r0 *1 0,0
Xsg13cmos5l_decap_8_5690 \$2 \$1 sg13cmos5l_decap_8
* cell instance sg13cmos5l_decap_8_5691 r0 *1 0,0
Xsg13cmos5l_decap_8_5691 \$2 \$1 sg13cmos5l_decap_8
* cell instance sg13cmos5l_decap_8_5692 r0 *1 0,0
Xsg13cmos5l_decap_8_5692 \$2 \$1 sg13cmos5l_decap_8
* cell instance sg13cmos5l_decap_8_5693 r0 *1 0,0
Xsg13cmos5l_decap_8_5693 \$2 \$1 sg13cmos5l_decap_8
* cell instance sg13cmos5l_decap_8_5694 r0 *1 0,0
Xsg13cmos5l_decap_8_5694 \$2 \$1 sg13cmos5l_decap_8
* cell instance sg13cmos5l_decap_8_5695 r0 *1 0,0
Xsg13cmos5l_decap_8_5695 \$2 \$1 sg13cmos5l_decap_8
* cell instance sg13cmos5l_decap_8_5696 r0 *1 0,0
Xsg13cmos5l_decap_8_5696 \$2 \$1 sg13cmos5l_decap_8
* cell instance sg13cmos5l_decap_8_5697 r0 *1 0,0
Xsg13cmos5l_decap_8_5697 \$2 \$1 sg13cmos5l_decap_8
* cell instance sg13cmos5l_decap_8_5698 r0 *1 0,0
Xsg13cmos5l_decap_8_5698 \$2 \$1 sg13cmos5l_decap_8
* cell instance sg13cmos5l_decap_8_5699 r0 *1 0,0
Xsg13cmos5l_decap_8_5699 \$2 \$1 sg13cmos5l_decap_8
* cell instance sg13cmos5l_decap_8_5700 r0 *1 0,0
Xsg13cmos5l_decap_8_5700 \$2 \$1 sg13cmos5l_decap_8
* cell instance sg13cmos5l_decap_8_5701 r0 *1 0,0
Xsg13cmos5l_decap_8_5701 \$2 \$1 sg13cmos5l_decap_8
* cell instance sg13cmos5l_decap_8_5702 r0 *1 0,0
Xsg13cmos5l_decap_8_5702 \$2 \$1 sg13cmos5l_decap_8
* cell instance sg13cmos5l_decap_8_5703 r0 *1 0,0
Xsg13cmos5l_decap_8_5703 \$2 \$1 sg13cmos5l_decap_8
* cell instance sg13cmos5l_decap_8_5704 r0 *1 0,0
Xsg13cmos5l_decap_8_5704 \$2 \$1 sg13cmos5l_decap_8
* cell instance sg13cmos5l_decap_8_5705 r0 *1 0,0
Xsg13cmos5l_decap_8_5705 \$2 \$1 sg13cmos5l_decap_8
* cell instance sg13cmos5l_decap_8_5706 r0 *1 0,0
Xsg13cmos5l_decap_8_5706 \$2 \$1 sg13cmos5l_decap_8
* cell instance sg13cmos5l_decap_8_5707 r0 *1 0,0
Xsg13cmos5l_decap_8_5707 \$2 \$1 sg13cmos5l_decap_8
* cell instance sg13cmos5l_decap_8_5708 r0 *1 0,0
Xsg13cmos5l_decap_8_5708 \$2 \$1 sg13cmos5l_decap_8
* cell instance sg13cmos5l_decap_8_5709 r0 *1 0,0
Xsg13cmos5l_decap_8_5709 \$2 \$1 sg13cmos5l_decap_8
* cell instance sg13cmos5l_decap_8_5710 r0 *1 0,0
Xsg13cmos5l_decap_8_5710 \$2 \$1 sg13cmos5l_decap_8
* cell instance sg13cmos5l_decap_8_5711 r0 *1 0,0
Xsg13cmos5l_decap_8_5711 \$2 \$1 sg13cmos5l_decap_8
* cell instance sg13cmos5l_decap_8_5712 r0 *1 0,0
Xsg13cmos5l_decap_8_5712 \$2 \$1 sg13cmos5l_decap_8
* cell instance sg13cmos5l_decap_8_5713 r0 *1 0,0
Xsg13cmos5l_decap_8_5713 \$2 \$1 sg13cmos5l_decap_8
* cell instance sg13cmos5l_decap_8_5714 r0 *1 0,0
Xsg13cmos5l_decap_8_5714 \$2 \$1 sg13cmos5l_decap_8
* cell instance sg13cmos5l_decap_8_5715 r0 *1 0,0
Xsg13cmos5l_decap_8_5715 \$2 \$1 sg13cmos5l_decap_8
* cell instance sg13cmos5l_decap_8_5716 r0 *1 0,0
Xsg13cmos5l_decap_8_5716 \$2 \$1 sg13cmos5l_decap_8
* cell instance sg13cmos5l_decap_8_5717 r0 *1 0,0
Xsg13cmos5l_decap_8_5717 \$2 \$1 sg13cmos5l_decap_8
* cell instance sg13cmos5l_decap_8_5718 r0 *1 0,0
Xsg13cmos5l_decap_8_5718 \$2 \$1 sg13cmos5l_decap_8
* cell instance sg13cmos5l_decap_8_5719 r0 *1 0,0
Xsg13cmos5l_decap_8_5719 \$2 \$1 sg13cmos5l_decap_8
* cell instance sg13cmos5l_decap_8_5720 r0 *1 0,0
Xsg13cmos5l_decap_8_5720 \$2 \$1 sg13cmos5l_decap_8
* cell instance sg13cmos5l_decap_8_5721 r0 *1 0,0
Xsg13cmos5l_decap_8_5721 \$2 \$1 sg13cmos5l_decap_8
* cell instance sg13cmos5l_decap_8_5722 r0 *1 0,0
Xsg13cmos5l_decap_8_5722 \$2 \$1 sg13cmos5l_decap_8
* cell instance sg13cmos5l_decap_8_5723 r0 *1 0,0
Xsg13cmos5l_decap_8_5723 \$2 \$1 sg13cmos5l_decap_8
* cell instance sg13cmos5l_decap_8_5724 r0 *1 0,0
Xsg13cmos5l_decap_8_5724 \$2 \$1 sg13cmos5l_decap_8
* cell instance sg13cmos5l_decap_8_5725 r0 *1 0,0
Xsg13cmos5l_decap_8_5725 \$2 \$1 sg13cmos5l_decap_8
* cell instance sg13cmos5l_decap_8_5726 r0 *1 0,0
Xsg13cmos5l_decap_8_5726 \$2 \$1 sg13cmos5l_decap_8
* cell instance sg13cmos5l_decap_8_5727 r0 *1 0,0
Xsg13cmos5l_decap_8_5727 \$2 \$1 sg13cmos5l_decap_8
* cell instance sg13cmos5l_decap_8_5728 r0 *1 0,0
Xsg13cmos5l_decap_8_5728 \$2 \$1 sg13cmos5l_decap_8
* cell instance sg13cmos5l_decap_8_5729 r0 *1 0,0
Xsg13cmos5l_decap_8_5729 \$2 \$1 sg13cmos5l_decap_8
* cell instance sg13cmos5l_decap_8_5730 r0 *1 0,0
Xsg13cmos5l_decap_8_5730 \$2 \$1 sg13cmos5l_decap_8
* cell instance sg13cmos5l_decap_8_5731 r0 *1 0,0
Xsg13cmos5l_decap_8_5731 \$2 \$1 sg13cmos5l_decap_8
* cell instance sg13cmos5l_decap_8_5732 r0 *1 0,0
Xsg13cmos5l_decap_8_5732 \$2 \$1 sg13cmos5l_decap_8
* cell instance sg13cmos5l_decap_8_5733 r0 *1 0,0
Xsg13cmos5l_decap_8_5733 \$2 \$1 sg13cmos5l_decap_8
* cell instance sg13cmos5l_decap_8_5734 r0 *1 0,0
Xsg13cmos5l_decap_8_5734 \$2 \$1 sg13cmos5l_decap_8
* cell instance sg13cmos5l_decap_8_5735 r0 *1 0,0
Xsg13cmos5l_decap_8_5735 \$2 \$1 sg13cmos5l_decap_8
* cell instance sg13cmos5l_decap_8_5736 r0 *1 0,0
Xsg13cmos5l_decap_8_5736 \$2 \$1 sg13cmos5l_decap_8
* cell instance sg13cmos5l_decap_8_5737 r0 *1 0,0
Xsg13cmos5l_decap_8_5737 \$2 \$1 sg13cmos5l_decap_8
* cell instance sg13cmos5l_decap_8_5738 r0 *1 0,0
Xsg13cmos5l_decap_8_5738 \$2 \$1 sg13cmos5l_decap_8
* cell instance sg13cmos5l_decap_8_5739 r0 *1 0,0
Xsg13cmos5l_decap_8_5739 \$2 \$1 sg13cmos5l_decap_8
* cell instance sg13cmos5l_decap_8_5740 r0 *1 0,0
Xsg13cmos5l_decap_8_5740 \$2 \$1 sg13cmos5l_decap_8
* cell instance sg13cmos5l_decap_8_5741 r0 *1 0,0
Xsg13cmos5l_decap_8_5741 \$2 \$1 sg13cmos5l_decap_8
* cell instance sg13cmos5l_decap_8_5742 r0 *1 0,0
Xsg13cmos5l_decap_8_5742 \$2 \$1 sg13cmos5l_decap_8
* cell instance sg13cmos5l_decap_8_5743 r0 *1 0,0
Xsg13cmos5l_decap_8_5743 \$2 \$1 sg13cmos5l_decap_8
* cell instance sg13cmos5l_decap_8_5744 r0 *1 0,0
Xsg13cmos5l_decap_8_5744 \$2 \$1 sg13cmos5l_decap_8
* cell instance sg13cmos5l_decap_8_5745 r0 *1 0,0
Xsg13cmos5l_decap_8_5745 \$2 \$1 sg13cmos5l_decap_8
* cell instance sg13cmos5l_dfrbpq_1_0 r0 *1 0,0
Xsg13cmos5l_dfrbpq_1_0 \$6581 \$11239 \$10206 \$11237 \$2 \$1
+ sg13cmos5l_dfrbpq_1
* cell instance sg13cmos5l_dfrbpq_1_1 r0 *1 0,0
Xsg13cmos5l_dfrbpq_1_1 \$1860 \$3487 \$3490 \$2073 \$2 \$1 sg13cmos5l_dfrbpq_1
* cell instance sg13cmos5l_dfrbpq_1_2 r0 *1 0,0
Xsg13cmos5l_dfrbpq_1_2 \$2210 \$4320 \$4147 \$4233 \$2 \$1 sg13cmos5l_dfrbpq_1
* cell instance sg13cmos5l_dfrbpq_1_3 r0 *1 0,0
Xsg13cmos5l_dfrbpq_1_3 \$4616 \$5931 \$5356 \$4233 \$2 \$1 sg13cmos5l_dfrbpq_1
* cell instance sg13cmos5l_dfrbpq_1_4 r0 *1 0,0
Xsg13cmos5l_dfrbpq_1_4 \$7271 \$6827 \$5357 \$4233 \$2 \$1 sg13cmos5l_dfrbpq_1
* cell instance sg13cmos5l_dfrbpq_1_5 r0 *1 0,0
Xsg13cmos5l_dfrbpq_1_5 \$7271 \$7702 \$7622 \$4233 \$2 \$1 sg13cmos5l_dfrbpq_1
* cell instance sg13cmos5l_dfrbpq_1_6 r0 *1 0,0
Xsg13cmos5l_dfrbpq_1_6 \$1316 \$2072 \$1925 \$2073 \$2 \$1 sg13cmos5l_dfrbpq_1
* cell instance sg13cmos5l_dfrbpq_1_7 r0 *1 0,0
Xsg13cmos5l_dfrbpq_1_7 \$1316 \$2450 \$2422 \$2073 \$2 \$1 sg13cmos5l_dfrbpq_1
* cell instance sg13cmos5l_dfrbpq_1_8 r0 *1 0,0
Xsg13cmos5l_dfrbpq_1_8 \$1860 \$3058 \$3064 \$2073 \$2 \$1 sg13cmos5l_dfrbpq_1
* cell instance sg13cmos5l_dfrbpq_1_9 r0 *1 0,0
Xsg13cmos5l_dfrbpq_1_9 \$2210 \$3741 \$3822 \$1305 \$2 \$1 sg13cmos5l_dfrbpq_1
* cell instance sg13cmos5l_dfrbpq_1_10 r0 *1 0,0
Xsg13cmos5l_dfrbpq_1_10 \$2210 \$4067 \$3825 \$2073 \$2 \$1 sg13cmos5l_dfrbpq_1
* cell instance sg13cmos5l_dfrbpq_1_11 r0 *1 0,0
Xsg13cmos5l_dfrbpq_1_11 \$2210 \$4758 \$4087 \$4233 \$2 \$1 sg13cmos5l_dfrbpq_1
* cell instance sg13cmos5l_dfrbpq_1_12 r0 *1 0,0
Xsg13cmos5l_dfrbpq_1_12 \$1860 \$1874 \$1857 \$77 \$2 \$1 sg13cmos5l_dfrbpq_1
* cell instance sg13cmos5l_dfrbpq_1_13 r0 *1 0,0
Xsg13cmos5l_dfrbpq_1_13 \$7861 \$10480 \$10207 \$11237 \$2 \$1
+ sg13cmos5l_dfrbpq_1
* cell instance sg13cmos5l_dfrbpq_1_14 r0 *1 0,0
Xsg13cmos5l_dfrbpq_1_14 \$4616 \$6566 \$5358 \$4233 \$2 \$1 sg13cmos5l_dfrbpq_1
* cell instance sg13cmos5l_dfrbpq_1_15 r0 *1 0,0
Xsg13cmos5l_dfrbpq_1_15 \$7271 \$8279 \$7704 \$4233 \$2 \$1 sg13cmos5l_dfrbpq_1
* cell instance sg13cmos5l_dfrbpq_1_16 r0 *1 0,0
Xsg13cmos5l_dfrbpq_1_16 \$1860 \$2876 \$3056 \$2073 \$2 \$1 sg13cmos5l_dfrbpq_1
* cell instance sg13cmos5l_dfrbpq_1_17 r0 *1 0,0
Xsg13cmos5l_dfrbpq_1_17 \$6581 \$10633 \$10208 \$11237 \$2 \$1
+ sg13cmos5l_dfrbpq_1
* cell instance sg13cmos5l_dfrbpq_1_18 r0 *1 0,0
Xsg13cmos5l_dfrbpq_1_18 \$1860 \$1858 \$1812 \$37 \$2 \$1 sg13cmos5l_dfrbpq_1
* cell instance sg13cmos5l_dfrbpq_1_19 r0 *1 0,0
Xsg13cmos5l_dfrbpq_1_19 \$7271 \$8712 \$8572 \$4233 \$2 \$1 sg13cmos5l_dfrbpq_1
* cell instance sg13cmos5l_dfrbpq_1_20 r0 *1 0,0
Xsg13cmos5l_dfrbpq_1_20 \$1860 \$1792 \$1813 \$37 \$2 \$1 sg13cmos5l_dfrbpq_1
* cell instance sg13cmos5l_dfrbpq_1_21 r0 *1 0,0
Xsg13cmos5l_dfrbpq_1_21 \$1316 \$2709 \$2719 \$2073 \$2 \$1 sg13cmos5l_dfrbpq_1
* cell instance sg13cmos5l_dfrbpq_1_22 r0 *1 0,0
Xsg13cmos5l_dfrbpq_1_22 \$7271 \$9285 \$9136 \$9320 \$2 \$1 sg13cmos5l_dfrbpq_1
* cell instance sg13cmos5l_dfrbpq_1_23 r0 *1 0,0
Xsg13cmos5l_dfrbpq_1_23 \$7271 \$10109 \$11074 \$11237 \$2 \$1
+ sg13cmos5l_dfrbpq_1
* cell instance sg13cmos5l_dfrbpq_1_24 r0 *1 0,0
Xsg13cmos5l_dfrbpq_1_24 \$6581 \$13721 \$13733 \$12712 \$2 \$1
+ sg13cmos5l_dfrbpq_1
* cell instance sg13cmos5l_dfrbpq_1_25 r0 *1 0,0
Xsg13cmos5l_dfrbpq_1_25 \$551 \$1073 \$847 \$77 \$2 \$1 sg13cmos5l_dfrbpq_1
* cell instance sg13cmos5l_dfrbpq_1_26 r0 *1 0,0
Xsg13cmos5l_dfrbpq_1_26 \$6581 \$13774 \$13839 \$12712 \$2 \$1
+ sg13cmos5l_dfrbpq_1
* cell instance sg13cmos5l_dfrbpq_1_27 r0 *1 0,0
Xsg13cmos5l_dfrbpq_1_27 \$551 \$379 \$556 \$77 \$2 \$1 sg13cmos5l_dfrbpq_1
* cell instance sg13cmos5l_dfrbpq_1_28 r0 *1 0,0
Xsg13cmos5l_dfrbpq_1_28 \$92 \$73 \$86 \$77 \$2 \$1 sg13cmos5l_dfrbpq_1
* cell instance sg13cmos5l_dfrbpq_1_29 r0 *1 0,0
Xsg13cmos5l_dfrbpq_1_29 \$1316 \$1890 \$1900 \$77 \$2 \$1 sg13cmos5l_dfrbpq_1
* cell instance sg13cmos5l_dfrbpq_1_30 r0 *1 0,0
Xsg13cmos5l_dfrbpq_1_30 \$92 \$207 \$219 \$77 \$2 \$1 sg13cmos5l_dfrbpq_1
* cell instance sg13cmos5l_dfrbpq_1_31 r0 *1 0,0
Xsg13cmos5l_dfrbpq_1_31 \$1316 \$1308 \$857 \$77 \$2 \$1 sg13cmos5l_dfrbpq_1
* cell instance sg13cmos5l_dfrbpq_1_32 r0 *1 0,0
Xsg13cmos5l_dfrbpq_1_32 \$2210 \$2209 \$2081 \$2073 \$2 \$1 sg13cmos5l_dfrbpq_1
* cell instance sg13cmos5l_dfrbpq_1_33 r0 *1 0,0
Xsg13cmos5l_dfrbpq_1_33 \$7861 \$12494 \$12499 \$12712 \$2 \$1
+ sg13cmos5l_dfrbpq_1
* cell instance sg13cmos5l_dfrbpq_1_34 r0 *1 0,0
Xsg13cmos5l_dfrbpq_1_34 \$6581 \$9758 \$9619 \$11237 \$2 \$1 sg13cmos5l_dfrbpq_1
* cell instance sg13cmos5l_dfrbpq_1_35 r0 *1 0,0
Xsg13cmos5l_dfrbpq_1_35 \$7861 \$12076 \$13020 \$12712 \$2 \$1
+ sg13cmos5l_dfrbpq_1
* cell instance sg13cmos5l_dfrbpq_1_36 r0 *1 0,0
Xsg13cmos5l_dfrbpq_1_36 \$7861 \$13586 \$13696 \$12712 \$2 \$1
+ sg13cmos5l_dfrbpq_1
* cell instance sg13cmos5l_dfrbpq_1_37 r0 *1 0,0
Xsg13cmos5l_dfrbpq_1_37 \$6581 \$11081 \$11079 \$11237 \$2 \$1
+ sg13cmos5l_dfrbpq_1
* cell instance sg13cmos5l_dfrbpq_1_38 r0 *1 0,0
Xsg13cmos5l_dfrbpq_1_38 \$7271 \$10209 \$10795 \$11237 \$2 \$1
+ sg13cmos5l_dfrbpq_1
* cell instance sg13cmos5l_dfrbpq_1_39 r0 *1 0,0
Xsg13cmos5l_dfrbpq_1_39 \$1316 \$1820 \$1840 \$37 \$2 \$1 sg13cmos5l_dfrbpq_1
* cell instance sg13cmos5l_dfrbpq_1_40 r0 *1 0,0
Xsg13cmos5l_dfrbpq_1_40 \$1316 \$1861 \$1939 \$77 \$2 \$1 sg13cmos5l_dfrbpq_1
* cell instance sg13cmos5l_dfrbpq_1_41 r0 *1 0,0
Xsg13cmos5l_dfrbpq_1_41 \$7861 \$10114 \$9620 \$11237 \$2 \$1
+ sg13cmos5l_dfrbpq_1
* cell instance sg13cmos5l_dfrbpq_1_42 r0 *1 0,0
Xsg13cmos5l_dfrbpq_1_42 \$7861 \$13786 \$13817 \$12712 \$2 \$1
+ sg13cmos5l_dfrbpq_1
* cell instance sg13cmos5l_dfrbpq_1_43 r0 *1 0,0
Xsg13cmos5l_dfrbpq_1_43 \$92 \$223 \$234 \$37 \$2 \$1 sg13cmos5l_dfrbpq_1
* cell instance sg13cmos5l_dfrbpq_1_44 r0 *1 0,0
Xsg13cmos5l_dfrbpq_1_44 \$551 \$1093 \$1333 \$37 \$2 \$1 sg13cmos5l_dfrbpq_1
* cell instance sg13cmos5l_dfrbpq_1_45 r0 *1 0,0
Xsg13cmos5l_dfrbpq_1_45 \$7119 \$13598 \$13251 \$11238 \$2 \$1
+ sg13cmos5l_dfrbpq_1
* cell instance sg13cmos5l_dfrbpq_1_46 r0 *1 0,0
Xsg13cmos5l_dfrbpq_1_46 \$7119 \$13700 \$13712 \$12148 \$2 \$1
+ sg13cmos5l_dfrbpq_1
* cell instance sg13cmos5l_dfrbpq_1_47 r0 *1 0,0
Xsg13cmos5l_dfrbpq_1_47 \$7119 \$13801 \$13818 \$11238 \$2 \$1
+ sg13cmos5l_dfrbpq_1
* cell instance sg13cmos5l_dfrbpq_1_48 r0 *1 0,0
Xsg13cmos5l_dfrbpq_1_48 \$92 \$34 \$32 \$37 \$2 \$1 sg13cmos5l_dfrbpq_1
* cell instance sg13cmos5l_dfrbpq_1_49 r0 *1 0,0
Xsg13cmos5l_dfrbpq_1_49 \$4616 \$12501 \$12506 \$11238 \$2 \$1
+ sg13cmos5l_dfrbpq_1
* cell instance sg13cmos5l_dfrbpq_1_50 r0 *1 0,0
Xsg13cmos5l_dfrbpq_1_50 \$7119 \$13753 \$13613 \$11238 \$2 \$1
+ sg13cmos5l_dfrbpq_1
* cell instance sg13cmos5l_dfrbpq_1_51 r0 *1 0,0
Xsg13cmos5l_dfrbpq_1_51 \$551 \$1096 \$591 \$1305 \$2 \$1 sg13cmos5l_dfrbpq_1
* cell instance sg13cmos5l_dfrbpq_1_52 r0 *1 0,0
Xsg13cmos5l_dfrbpq_1_52 \$92 \$95 \$237 \$37 \$2 \$1 sg13cmos5l_dfrbpq_1
* cell instance sg13cmos5l_dfrbpq_1_53 r0 *1 0,0
Xsg13cmos5l_dfrbpq_1_53 \$4616 \$11248 \$13253 \$11238 \$2 \$1
+ sg13cmos5l_dfrbpq_1
* cell instance sg13cmos5l_dfrbpq_1_54 r0 *1 0,0
Xsg13cmos5l_dfrbpq_1_54 \$4616 \$11577 \$10757 \$11238 \$2 \$1
+ sg13cmos5l_dfrbpq_1
* cell instance sg13cmos5l_dfrbpq_1_55 r0 *1 0,0
Xsg13cmos5l_dfrbpq_1_55 \$4616 \$12261 \$12006 \$11238 \$2 \$1
+ sg13cmos5l_dfrbpq_1
* cell instance sg13cmos5l_dfrbpq_1_56 r0 *1 0,0
Xsg13cmos5l_dfrbpq_1_56 \$2210 \$3746 \$2085 \$1305 \$2 \$1 sg13cmos5l_dfrbpq_1
* cell instance sg13cmos5l_dfrbpq_1_57 r0 *1 0,0
Xsg13cmos5l_dfrbpq_1_57 \$7119 \$13612 \$13764 \$11238 \$2 \$1
+ sg13cmos5l_dfrbpq_1
* cell instance sg13cmos5l_dfrbpq_1_58 r0 *1 0,0
Xsg13cmos5l_dfrbpq_1_58 \$7119 \$13869 \$13881 \$9320 \$2 \$1
+ sg13cmos5l_dfrbpq_1
* cell instance sg13cmos5l_dfrbpq_1_59 r0 *1 0,0
Xsg13cmos5l_dfrbpq_1_59 \$551 \$47 \$59 \$50 \$2 \$1 sg13cmos5l_dfrbpq_1
* cell instance sg13cmos5l_dfrbpq_1_60 r0 *1 0,0
Xsg13cmos5l_dfrbpq_1_60 \$92 \$107 \$112 \$50 \$2 \$1 sg13cmos5l_dfrbpq_1
* cell instance sg13cmos5l_dfrbpq_1_61 r0 *1 0,0
Xsg13cmos5l_dfrbpq_1_61 \$551 \$1115 \$1548 \$50 \$2 \$1 sg13cmos5l_dfrbpq_1
* cell instance sg13cmos5l_dfrbpq_1_62 r0 *1 0,0
Xsg13cmos5l_dfrbpq_1_62 \$759 \$876 \$537 \$50 \$2 \$1 sg13cmos5l_dfrbpq_1
* cell instance sg13cmos5l_dfrbpq_1_63 r0 *1 0,0
Xsg13cmos5l_dfrbpq_1_63 \$92 \$120 \$266 \$50 \$2 \$1 sg13cmos5l_dfrbpq_1
* cell instance sg13cmos5l_dfrbpq_1_64 r0 *1 0,0
Xsg13cmos5l_dfrbpq_1_64 \$759 \$1358 \$1370 \$50 \$2 \$1 sg13cmos5l_dfrbpq_1
* cell instance sg13cmos5l_dfrbpq_1_65 r0 *1 0,0
Xsg13cmos5l_dfrbpq_1_65 \$277 \$269 \$268 \$272 \$2 \$1 sg13cmos5l_dfrbpq_1
* cell instance sg13cmos5l_dfrbpq_1_66 r0 *1 0,0
Xsg13cmos5l_dfrbpq_1_66 \$759 \$888 \$1139 \$50 \$2 \$1 sg13cmos5l_dfrbpq_1
* cell instance sg13cmos5l_dfrbpq_1_67 r0 *1 0,0
Xsg13cmos5l_dfrbpq_1_67 \$277 \$285 \$135 \$272 \$2 \$1 sg13cmos5l_dfrbpq_1
* cell instance sg13cmos5l_dfrbpq_1_68 r0 *1 0,0
Xsg13cmos5l_dfrbpq_1_68 \$759 \$1376 \$1156 \$50 \$2 \$1 sg13cmos5l_dfrbpq_1
* cell instance sg13cmos5l_dfrbpq_1_69 r0 *1 0,0
Xsg13cmos5l_dfrbpq_1_69 \$277 \$463 \$474 \$272 \$2 \$1 sg13cmos5l_dfrbpq_1
* cell instance sg13cmos5l_dfrbpq_1_70 r0 *1 0,0
Xsg13cmos5l_dfrbpq_1_70 \$277 \$901 \$1064 \$272 \$2 \$1 sg13cmos5l_dfrbpq_1
* cell instance sg13cmos5l_dfrbpq_1_71 r0 *1 0,0
Xsg13cmos5l_dfrbpq_1_71 \$277 \$620 \$687 \$272 \$2 \$1 sg13cmos5l_dfrbpq_1
* cell instance sg13cmos5l_dfrbpq_1_72 r0 *1 0,0
Xsg13cmos5l_dfrbpq_1_72 \$277 \$301 \$145 \$272 \$2 \$1 sg13cmos5l_dfrbpq_1
* cell instance sg13cmos5l_dfrbpq_1_73 r0 *1 0,0
Xsg13cmos5l_dfrbpq_1_73 \$759 \$1159 \$1632 \$315 \$2 \$1 sg13cmos5l_dfrbpq_1
* cell instance sg13cmos5l_dfrbpq_1_74 r0 *1 0,0
Xsg13cmos5l_dfrbpq_1_74 \$759 \$475 \$544 \$315 \$2 \$1 sg13cmos5l_dfrbpq_1
* cell instance sg13cmos5l_dfrbpq_1_75 r0 *1 0,0
Xsg13cmos5l_dfrbpq_1_75 \$320 \$917 \$928 \$315 \$2 \$1 sg13cmos5l_dfrbpq_1
* cell instance sg13cmos5l_dfrbpq_1_76 r0 *1 0,0
Xsg13cmos5l_dfrbpq_1_76 \$320 \$769 \$1185 \$315 \$2 \$1 sg13cmos5l_dfrbpq_1
* cell instance sg13cmos5l_dfrbpq_1_77 r0 *1 0,0
Xsg13cmos5l_dfrbpq_1_77 \$320 \$312 \$325 \$315 \$2 \$1 sg13cmos5l_dfrbpq_1
* cell instance sg13cmos5l_dfrbpq_1_78 r0 *1 0,0
Xsg13cmos5l_dfrbpq_1_78 \$320 \$486 \$498 \$315 \$2 \$1 sg13cmos5l_dfrbpq_1
* cell instance sg13cmos5l_dfrbpq_1_79 r0 *1 0,0
Xsg13cmos5l_dfrbpq_1_79 \$320 \$1186 \$934 \$315 \$2 \$1 sg13cmos5l_dfrbpq_1
* cell instance sg13cmos5l_dfrbpq_1_80 r0 *1 0,0
Xsg13cmos5l_dfrbpq_1_80 \$326 \$158 \$338 \$315 \$2 \$1 sg13cmos5l_dfrbpq_1
* cell instance sg13cmos5l_dfrbpq_1_81 r0 *1 0,0
Xsg13cmos5l_dfrbpq_1_81 \$320 \$159 \$172 \$163 \$2 \$1 sg13cmos5l_dfrbpq_1
* cell instance sg13cmos5l_dfrbpq_1_82 r0 *1 0,0
Xsg13cmos5l_dfrbpq_1_82 \$326 \$19 \$173 \$163 \$2 \$1 sg13cmos5l_dfrbpq_1
* cell instance sg13cmos5l_dfrbpq_1_83 r0 *1 0,0
Xsg13cmos5l_dfrbpq_1_83 \$326 \$660 \$965 \$163 \$2 \$1 sg13cmos5l_dfrbpq_1
* cell instance sg13cmos5l_dfrbpq_1_84 r0 *1 0,0
Xsg13cmos5l_dfrbpq_1_84 \$1216 \$797 \$972 \$163 \$2 \$1 sg13cmos5l_dfrbpq_1
* cell instance sg13cmos5l_dfrbpq_1_85 r0 *1 0,0
Xsg13cmos5l_dfrbpq_1_85 \$326 \$182 \$359 \$163 \$2 \$1 sg13cmos5l_dfrbpq_1
* cell instance sg13cmos5l_dfrbpq_1_86 r0 *1 0,0
Xsg13cmos5l_dfrbpq_1_86 \$326 \$667 \$532 \$163 \$2 \$1 sg13cmos5l_dfrbpq_1
* cell instance sg13cmos5l_dfrbpq_1_87 r0 *1 0,0
Xsg13cmos5l_dfrbpq_1_87 \$326 \$187 \$195 \$163 \$2 \$1 sg13cmos5l_dfrbpq_1
* cell instance sg13cmos5l_dfrbpq_1_88 r0 *1 0,0
Xsg13cmos5l_dfrbpq_1_88 \$1216 \$1224 \$977 \$163 \$2 \$1 sg13cmos5l_dfrbpq_1
* cell instance sg13cmos5l_dfrbpq_1_89 r0 *1 0,0
Xsg13cmos5l_dfrbpq_1_89 \$819 \$689 \$676 \$1242 \$2 \$1 sg13cmos5l_dfrbpq_1
* cell instance sg13cmos5l_dfrbpq_1_90 r0 *1 0,0
Xsg13cmos5l_dfrbpq_1_90 \$819 \$981 \$1068 \$1242 \$2 \$1 sg13cmos5l_dfrbpq_1
* cell instance sg13cmos5l_dfrbpq_1_91 r0 *1 0,0
Xsg13cmos5l_dfrbpq_1_91 \$819 \$1238 \$1251 \$1242 \$2 \$1 sg13cmos5l_dfrbpq_1
* cell instance sg13cmos5l_dfrbpq_1_92 r0 *1 0,0
Xsg13cmos5l_dfrbpq_1_92 \$819 \$992 \$1003 \$1242 \$2 \$1 sg13cmos5l_dfrbpq_1
* cell instance sg13cmos5l_dfrbpq_1_93 r0 *1 0,0
Xsg13cmos5l_dfrbpq_1_93 \$1216 \$1488 \$1264 \$1242 \$2 \$1 sg13cmos5l_dfrbpq_1
* cell instance sg13cmos5l_dfrbpq_1_94 r0 *1 0,0
Xsg13cmos5l_dfrbpq_1_94 \$819 \$1012 \$1023 \$1242 \$2 \$1 sg13cmos5l_dfrbpq_1
* cell instance sg13cmos5l_dfrbpq_1_95 r0 *1 0,0
Xsg13cmos5l_dfrbpq_1_95 \$1216 \$1268 \$1280 \$1242 \$2 \$1 sg13cmos5l_dfrbpq_1
* cell instance sg13cmos5l_dfrbpq_1_96 r0 *1 0,0
Xsg13cmos5l_dfrbpq_1_96 \$1216 \$1035 \$1292 \$1242 \$2 \$1 sg13cmos5l_dfrbpq_1
* cell instance sg13cmos5l_dfrbpq_1_97 r0 *1 0,0
Xsg13cmos5l_dfrbpq_1_97 \$819 \$1043 \$1055 \$773 \$2 \$1 sg13cmos5l_dfrbpq_1
* cell instance sg13cmos5l_dfrbpq_1_98 r0 *1 0,0
Xsg13cmos5l_dfrbpq_1_98 \$1216 \$1518 \$1530 \$773 \$2 \$1 sg13cmos5l_dfrbpq_1
* cell instance sg13cmos5l_dlygate4sd3_1_0 r0 *1 0,0
Xsg13cmos5l_dlygate4sd3_1_0 \$1925 \$2 \$1 \$2205 sg13cmos5l_dlygate4sd3_1
* cell instance sg13cmos5l_dlygate4sd3_1_1 r0 *1 0,0
Xsg13cmos5l_dlygate4sd3_1_1 \$3056 \$2 \$1 \$2939 sg13cmos5l_dlygate4sd3_1
* cell instance sg13cmos5l_dlygate4sd3_1_2 r0 *1 0,0
Xsg13cmos5l_dlygate4sd3_1_2 \$4147 \$2 \$1 \$4757 sg13cmos5l_dlygate4sd3_1
* cell instance sg13cmos5l_dlygate4sd3_1_3 r0 *1 0,0
Xsg13cmos5l_dlygate4sd3_1_3 \$7622 \$2 \$1 \$9013 sg13cmos5l_dlygate4sd3_1
* cell instance sg13cmos5l_dlygate4sd3_1_4 r0 *1 0,0
Xsg13cmos5l_dlygate4sd3_1_4 \$1857 \$2 \$1 \$1789 sg13cmos5l_dlygate4sd3_1
* cell instance sg13cmos5l_dlygate4sd3_1_5 r0 *1 0,0
Xsg13cmos5l_dlygate4sd3_1_5 \$10206 \$2 \$1 \$12257 sg13cmos5l_dlygate4sd3_1
* cell instance sg13cmos5l_dlygate4sd3_1_6 r0 *1 0,0
Xsg13cmos5l_dlygate4sd3_1_6 \$10207 \$2 \$1 \$10632 sg13cmos5l_dlygate4sd3_1
* cell instance sg13cmos5l_dlygate4sd3_1_7 r0 *1 0,0
Xsg13cmos5l_dlygate4sd3_1_7 \$3822 \$2 \$1 \$3821 sg13cmos5l_dlygate4sd3_1
* cell instance sg13cmos5l_dlygate4sd3_1_8 r0 *1 0,0
Xsg13cmos5l_dlygate4sd3_1_8 \$10208 \$2 \$1 \$10204 sg13cmos5l_dlygate4sd3_1
* cell instance sg13cmos5l_dlygate4sd3_1_9 r0 *1 0,0
Xsg13cmos5l_dlygate4sd3_1_9 \$3064 \$2 \$1 \$3268 sg13cmos5l_dlygate4sd3_1
* cell instance sg13cmos5l_dlygate4sd3_1_10 r0 *1 0,0
Xsg13cmos5l_dlygate4sd3_1_10 \$3825 \$2 \$1 \$4086 sg13cmos5l_dlygate4sd3_1
* cell instance sg13cmos5l_dlygate4sd3_1_11 r0 *1 0,0
Xsg13cmos5l_dlygate4sd3_1_11 \$5356 \$2 \$1 \$5796 sg13cmos5l_dlygate4sd3_1
* cell instance sg13cmos5l_dlygate4sd3_1_12 r0 *1 0,0
Xsg13cmos5l_dlygate4sd3_1_12 \$7704 \$2 \$1 \$7857 sg13cmos5l_dlygate4sd3_1
* cell instance sg13cmos5l_dlygate4sd3_1_13 r0 *1 0,0
Xsg13cmos5l_dlygate4sd3_1_13 \$1812 \$2 \$1 \$2207 sg13cmos5l_dlygate4sd3_1
* cell instance sg13cmos5l_dlygate4sd3_1_14 r0 *1 0,0
Xsg13cmos5l_dlygate4sd3_1_14 \$3490 \$2 \$1 \$3734 sg13cmos5l_dlygate4sd3_1
* cell instance sg13cmos5l_dlygate4sd3_1_15 r0 *1 0,0
Xsg13cmos5l_dlygate4sd3_1_15 \$4087 \$2 \$1 \$4924 sg13cmos5l_dlygate4sd3_1
* cell instance sg13cmos5l_dlygate4sd3_1_16 r0 *1 0,0
Xsg13cmos5l_dlygate4sd3_1_16 \$5357 \$2 \$1 \$6675 sg13cmos5l_dlygate4sd3_1
* cell instance sg13cmos5l_dlygate4sd3_1_17 r0 *1 0,0
Xsg13cmos5l_dlygate4sd3_1_17 \$11074 \$2 \$1 \$10205 sg13cmos5l_dlygate4sd3_1
* cell instance sg13cmos5l_dlygate4sd3_1_18 r0 *1 0,0
Xsg13cmos5l_dlygate4sd3_1_18 \$2719 \$2 \$1 \$2750 sg13cmos5l_dlygate4sd3_1
* cell instance sg13cmos5l_dlygate4sd3_1_19 r0 *1 0,0
Xsg13cmos5l_dlygate4sd3_1_19 \$9136 \$2 \$1 \$9615 sg13cmos5l_dlygate4sd3_1
* cell instance sg13cmos5l_dlygate4sd3_1_20 r0 *1 0,0
Xsg13cmos5l_dlygate4sd3_1_20 \$1813 \$2 \$1 \$1867 sg13cmos5l_dlygate4sd3_1
* cell instance sg13cmos5l_dlygate4sd3_1_21 r0 *1 0,0
Xsg13cmos5l_dlygate4sd3_1_21 \$5358 \$2 \$1 \$6672 sg13cmos5l_dlygate4sd3_1
* cell instance sg13cmos5l_dlygate4sd3_1_22 r0 *1 0,0
Xsg13cmos5l_dlygate4sd3_1_22 \$2422 \$2 \$1 \$2722 sg13cmos5l_dlygate4sd3_1
* cell instance sg13cmos5l_dlygate4sd3_1_23 r0 *1 0,0
Xsg13cmos5l_dlygate4sd3_1_23 \$8572 \$2 \$1 \$9180 sg13cmos5l_dlygate4sd3_1
* cell instance sg13cmos5l_dlygate4sd3_1_24 r0 *1 0,0
Xsg13cmos5l_dlygate4sd3_1_24 \$376 \$2 \$1 \$73 sg13cmos5l_dlygate4sd3_1
* cell instance sg13cmos5l_dlygate4sd3_1_25 r0 *1 0,0
Xsg13cmos5l_dlygate4sd3_1_25 \$11079 \$2 \$1 \$11244 sg13cmos5l_dlygate4sd3_1
* cell instance sg13cmos5l_dlygate4sd3_1_26 r0 *1 0,0
Xsg13cmos5l_dlygate4sd3_1_26 \$847 \$2 \$1 \$845 sg13cmos5l_dlygate4sd3_1
* cell instance sg13cmos5l_dlygate4sd3_1_27 r0 *1 0,0
Xsg13cmos5l_dlygate4sd3_1_27 \$203 \$2 \$1 \$207 sg13cmos5l_dlygate4sd3_1
* cell instance sg13cmos5l_dlygate4sd3_1_28 r0 *1 0,0
Xsg13cmos5l_dlygate4sd3_1_28 \$1552 \$2 \$1 \$1308 sg13cmos5l_dlygate4sd3_1
* cell instance sg13cmos5l_dlygate4sd3_1_29 r0 *1 0,0
Xsg13cmos5l_dlygate4sd3_1_29 \$691 \$2 \$1 \$377 sg13cmos5l_dlygate4sd3_1
* cell instance sg13cmos5l_dlygate4sd3_1_30 r0 *1 0,0
Xsg13cmos5l_dlygate4sd3_1_30 \$26 \$2 \$1 \$31 sg13cmos5l_dlygate4sd3_1
* cell instance sg13cmos5l_dlygate4sd3_1_31 r0 *1 0,0
Xsg13cmos5l_dlygate4sd3_1_31 \$1900 \$2 \$1 \$2079 sg13cmos5l_dlygate4sd3_1
* cell instance sg13cmos5l_dlygate4sd3_1_32 r0 *1 0,0
Xsg13cmos5l_dlygate4sd3_1_32 \$13839 \$2 \$1 \$13837 sg13cmos5l_dlygate4sd3_1
* cell instance sg13cmos5l_dlygate4sd3_1_33 r0 *1 0,0
Xsg13cmos5l_dlygate4sd3_1_33 \$13733 \$2 \$1 \$13737 sg13cmos5l_dlygate4sd3_1
* cell instance sg13cmos5l_dlygate4sd3_1_34 r0 *1 0,0
Xsg13cmos5l_dlygate4sd3_1_34 \$86 \$2 \$1 \$692 sg13cmos5l_dlygate4sd3_1
* cell instance sg13cmos5l_dlygate4sd3_1_35 r0 *1 0,0
Xsg13cmos5l_dlygate4sd3_1_35 \$852 \$2 \$1 \$1073 sg13cmos5l_dlygate4sd3_1
* cell instance sg13cmos5l_dlygate4sd3_1_36 r0 *1 0,0
Xsg13cmos5l_dlygate4sd3_1_36 \$556 \$2 \$1 \$387 sg13cmos5l_dlygate4sd3_1
* cell instance sg13cmos5l_dlygate4sd3_1_37 r0 *1 0,0
Xsg13cmos5l_dlygate4sd3_1_37 \$2081 \$2 \$1 \$2456 sg13cmos5l_dlygate4sd3_1
* cell instance sg13cmos5l_dlygate4sd3_1_38 r0 *1 0,0
Xsg13cmos5l_dlygate4sd3_1_38 \$10795 \$2 \$1 \$11245 sg13cmos5l_dlygate4sd3_1
* cell instance sg13cmos5l_dlygate4sd3_1_39 r0 *1 0,0
Xsg13cmos5l_dlygate4sd3_1_39 \$857 \$2 \$1 \$700 sg13cmos5l_dlygate4sd3_1
* cell instance sg13cmos5l_dlygate4sd3_1_40 r0 *1 0,0
Xsg13cmos5l_dlygate4sd3_1_40 \$1840 \$2 \$1 \$1819 sg13cmos5l_dlygate4sd3_1
* cell instance sg13cmos5l_dlygate4sd3_1_41 r0 *1 0,0
Xsg13cmos5l_dlygate4sd3_1_41 \$13696 \$2 \$1 \$13691 sg13cmos5l_dlygate4sd3_1
* cell instance sg13cmos5l_dlygate4sd3_1_42 r0 *1 0,0
Xsg13cmos5l_dlygate4sd3_1_42 \$13746 \$2 \$1 \$13786 sg13cmos5l_dlygate4sd3_1
* cell instance sg13cmos5l_dlygate4sd3_1_43 r0 *1 0,0
Xsg13cmos5l_dlygate4sd3_1_43 \$219 \$2 \$1 \$87 sg13cmos5l_dlygate4sd3_1
* cell instance sg13cmos5l_dlygate4sd3_1_44 r0 *1 0,0
Xsg13cmos5l_dlygate4sd3_1_44 \$12499 \$2 \$1 \$12593 sg13cmos5l_dlygate4sd3_1
* cell instance sg13cmos5l_dlygate4sd3_1_45 r0 *1 0,0
Xsg13cmos5l_dlygate4sd3_1_45 \$13020 \$2 \$1 \$12259 sg13cmos5l_dlygate4sd3_1
* cell instance sg13cmos5l_dlygate4sd3_1_46 r0 *1 0,0
Xsg13cmos5l_dlygate4sd3_1_46 \$13817 \$2 \$1 \$13745 sg13cmos5l_dlygate4sd3_1
* cell instance sg13cmos5l_dlygate4sd3_1_47 r0 *1 0,0
Xsg13cmos5l_dlygate4sd3_1_47 \$1939 \$2 \$1 \$2080 sg13cmos5l_dlygate4sd3_1
* cell instance sg13cmos5l_dlygate4sd3_1_48 r0 *1 0,0
Xsg13cmos5l_dlygate4sd3_1_48 \$9619 \$2 \$1 \$9617 sg13cmos5l_dlygate4sd3_1
* cell instance sg13cmos5l_dlygate4sd3_1_49 r0 *1 0,0
Xsg13cmos5l_dlygate4sd3_1_49 \$9620 \$2 \$1 \$11095 sg13cmos5l_dlygate4sd3_1
* cell instance sg13cmos5l_dlygate4sd3_1_50 r0 *1 0,0
Xsg13cmos5l_dlygate4sd3_1_50 \$393 \$2 \$1 \$223 sg13cmos5l_dlygate4sd3_1
* cell instance sg13cmos5l_dlygate4sd3_1_51 r0 *1 0,0
Xsg13cmos5l_dlygate4sd3_1_51 \$13818 \$2 \$1 \$13800 sg13cmos5l_dlygate4sd3_1
* cell instance sg13cmos5l_dlygate4sd3_1_52 r0 *1 0,0
Xsg13cmos5l_dlygate4sd3_1_52 \$562 \$2 \$1 \$394 sg13cmos5l_dlygate4sd3_1
* cell instance sg13cmos5l_dlygate4sd3_1_53 r0 *1 0,0
Xsg13cmos5l_dlygate4sd3_1_53 \$32 \$2 \$1 \$89 sg13cmos5l_dlygate4sd3_1
* cell instance sg13cmos5l_dlygate4sd3_1_54 r0 *1 0,0
Xsg13cmos5l_dlygate4sd3_1_54 \$13251 \$2 \$1 \$13027 sg13cmos5l_dlygate4sd3_1
* cell instance sg13cmos5l_dlygate4sd3_1_55 r0 *1 0,0
Xsg13cmos5l_dlygate4sd3_1_55 \$234 \$2 \$1 \$399 sg13cmos5l_dlygate4sd3_1
* cell instance sg13cmos5l_dlygate4sd3_1_56 r0 *1 0,0
Xsg13cmos5l_dlygate4sd3_1_56 \$1333 \$2 \$1 \$1843 sg13cmos5l_dlygate4sd3_1
* cell instance sg13cmos5l_dlygate4sd3_1_57 r0 *1 0,0
Xsg13cmos5l_dlygate4sd3_1_57 \$13608 \$2 \$1 \$13612 sg13cmos5l_dlygate4sd3_1
* cell instance sg13cmos5l_dlygate4sd3_1_58 r0 *1 0,0
Xsg13cmos5l_dlygate4sd3_1_58 \$10757 \$2 \$1 \$10501 sg13cmos5l_dlygate4sd3_1
* cell instance sg13cmos5l_dlygate4sd3_1_59 r0 *1 0,0
Xsg13cmos5l_dlygate4sd3_1_59 \$13253 \$2 \$1 \$12260 sg13cmos5l_dlygate4sd3_1
* cell instance sg13cmos5l_dlygate4sd3_1_60 r0 *1 0,0
Xsg13cmos5l_dlygate4sd3_1_60 \$237 \$2 \$1 \$408 sg13cmos5l_dlygate4sd3_1
* cell instance sg13cmos5l_dlygate4sd3_1_61 r0 *1 0,0
Xsg13cmos5l_dlygate4sd3_1_61 \$240 \$2 \$1 \$34 sg13cmos5l_dlygate4sd3_1
* cell instance sg13cmos5l_dlygate4sd3_1_62 r0 *1 0,0
Xsg13cmos5l_dlygate4sd3_1_62 \$13613 \$2 \$1 \$13617 sg13cmos5l_dlygate4sd3_1
* cell instance sg13cmos5l_dlygate4sd3_1_63 r0 *1 0,0
Xsg13cmos5l_dlygate4sd3_1_63 \$591 \$2 \$1 \$1569 sg13cmos5l_dlygate4sd3_1
* cell instance sg13cmos5l_dlygate4sd3_1_64 r0 *1 0,0
Xsg13cmos5l_dlygate4sd3_1_64 \$12006 \$2 \$1 \$13252 sg13cmos5l_dlygate4sd3_1
* cell instance sg13cmos5l_dlygate4sd3_1_65 r0 *1 0,0
Xsg13cmos5l_dlygate4sd3_1_65 \$12506 \$2 \$1 \$12603 sg13cmos5l_dlygate4sd3_1
* cell instance sg13cmos5l_dlygate4sd3_1_66 r0 *1 0,0
Xsg13cmos5l_dlygate4sd3_1_66 \$2085 \$2 \$1 \$3497 sg13cmos5l_dlygate4sd3_1
* cell instance sg13cmos5l_dlygate4sd3_1_67 r0 *1 0,0
Xsg13cmos5l_dlygate4sd3_1_67 \$13712 \$2 \$1 \$13719 sg13cmos5l_dlygate4sd3_1
* cell instance sg13cmos5l_dlygate4sd3_1_68 r0 *1 0,0
Xsg13cmos5l_dlygate4sd3_1_68 \$13764 \$2 \$1 \$13715 sg13cmos5l_dlygate4sd3_1
* cell instance sg13cmos5l_dlygate4sd3_1_69 r0 *1 0,0
Xsg13cmos5l_dlygate4sd3_1_69 \$59 \$2 \$1 \$247 sg13cmos5l_dlygate4sd3_1
* cell instance sg13cmos5l_dlygate4sd3_1_70 r0 *1 0,0
Xsg13cmos5l_dlygate4sd3_1_70 \$711 \$2 \$1 \$583 sg13cmos5l_dlygate4sd3_1
* cell instance sg13cmos5l_dlygate4sd3_1_71 r0 *1 0,0
Xsg13cmos5l_dlygate4sd3_1_71 \$245 \$2 \$1 \$47 sg13cmos5l_dlygate4sd3_1
* cell instance sg13cmos5l_dlygate4sd3_1_72 r0 *1 0,0
Xsg13cmos5l_dlygate4sd3_1_72 \$13881 \$2 \$1 \$13868 sg13cmos5l_dlygate4sd3_1
* cell instance sg13cmos5l_dlygate4sd3_1_73 r0 *1 0,0
Xsg13cmos5l_dlygate4sd3_1_73 \$112 \$2 \$1 \$256 sg13cmos5l_dlygate4sd3_1
* cell instance sg13cmos5l_dlygate4sd3_1_74 r0 *1 0,0
Xsg13cmos5l_dlygate4sd3_1_74 \$423 \$2 \$1 \$107 sg13cmos5l_dlygate4sd3_1
* cell instance sg13cmos5l_dlygate4sd3_1_75 r0 *1 0,0
Xsg13cmos5l_dlygate4sd3_1_75 \$1589 \$2 \$1 \$1118 sg13cmos5l_dlygate4sd3_1
* cell instance sg13cmos5l_dlygate4sd3_1_76 r0 *1 0,0
Xsg13cmos5l_dlygate4sd3_1_76 \$1548 \$2 \$1 \$1589 sg13cmos5l_dlygate4sd3_1
* cell instance sg13cmos5l_dlygate4sd3_1_77 r0 *1 0,0
Xsg13cmos5l_dlygate4sd3_1_77 \$1118 \$2 \$1 \$1061 sg13cmos5l_dlygate4sd3_1
* cell instance sg13cmos5l_dlygate4sd3_1_78 r0 *1 0,0
Xsg13cmos5l_dlygate4sd3_1_78 \$721 \$2 \$1 \$720 sg13cmos5l_dlygate4sd3_1
* cell instance sg13cmos5l_dlygate4sd3_1_79 r0 *1 0,0
Xsg13cmos5l_dlygate4sd3_1_79 \$268 \$2 \$1 \$265 sg13cmos5l_dlygate4sd3_1
* cell instance sg13cmos5l_dlygate4sd3_1_80 r0 *1 0,0
Xsg13cmos5l_dlygate4sd3_1_80 \$435 \$2 \$1 \$120 sg13cmos5l_dlygate4sd3_1
* cell instance sg13cmos5l_dlygate4sd3_1_81 r0 *1 0,0
Xsg13cmos5l_dlygate4sd3_1_81 \$537 \$2 \$1 \$717 sg13cmos5l_dlygate4sd3_1
* cell instance sg13cmos5l_dlygate4sd3_1_82 r0 *1 0,0
Xsg13cmos5l_dlygate4sd3_1_82 \$1602 \$2 \$1 \$1597 sg13cmos5l_dlygate4sd3_1
* cell instance sg13cmos5l_dlygate4sd3_1_83 r0 *1 0,0
Xsg13cmos5l_dlygate4sd3_1_83 \$1597 \$2 \$1 \$887 sg13cmos5l_dlygate4sd3_1
* cell instance sg13cmos5l_dlygate4sd3_1_84 r0 *1 0,0
Xsg13cmos5l_dlygate4sd3_1_84 \$441 \$2 \$1 \$269 sg13cmos5l_dlygate4sd3_1
* cell instance sg13cmos5l_dlygate4sd3_1_85 r0 *1 0,0
Xsg13cmos5l_dlygate4sd3_1_85 \$1370 \$2 \$1 \$1602 sg13cmos5l_dlygate4sd3_1
* cell instance sg13cmos5l_dlygate4sd3_1_86 r0 *1 0,0
Xsg13cmos5l_dlygate4sd3_1_86 \$1139 \$2 \$1 \$1143 sg13cmos5l_dlygate4sd3_1
* cell instance sg13cmos5l_dlygate4sd3_1_87 r0 *1 0,0
Xsg13cmos5l_dlygate4sd3_1_87 \$1143 \$2 \$1 \$1612 sg13cmos5l_dlygate4sd3_1
* cell instance sg13cmos5l_dlygate4sd3_1_88 r0 *1 0,0
Xsg13cmos5l_dlygate4sd3_1_88 \$1612 \$2 \$1 \$1616 sg13cmos5l_dlygate4sd3_1
* cell instance sg13cmos5l_dlygate4sd3_1_89 r0 *1 0,0
Xsg13cmos5l_dlygate4sd3_1_89 \$135 \$2 \$1 \$134 sg13cmos5l_dlygate4sd3_1
* cell instance sg13cmos5l_dlygate4sd3_1_90 r0 *1 0,0
Xsg13cmos5l_dlygate4sd3_1_90 \$282 \$2 \$1 \$285 sg13cmos5l_dlygate4sd3_1
* cell instance sg13cmos5l_dlygate4sd3_1_91 r0 *1 0,0
Xsg13cmos5l_dlygate4sd3_1_91 \$1375 \$2 \$1 \$1550 sg13cmos5l_dlygate4sd3_1
* cell instance sg13cmos5l_dlygate4sd3_1_92 r0 *1 0,0
Xsg13cmos5l_dlygate4sd3_1_92 \$1388 \$2 \$1 \$1375 sg13cmos5l_dlygate4sd3_1
* cell instance sg13cmos5l_dlygate4sd3_1_93 r0 *1 0,0
Xsg13cmos5l_dlygate4sd3_1_93 \$140 \$2 \$1 \$463 sg13cmos5l_dlygate4sd3_1
* cell instance sg13cmos5l_dlygate4sd3_1_94 r0 *1 0,0
Xsg13cmos5l_dlygate4sd3_1_94 \$474 \$2 \$1 \$455 sg13cmos5l_dlygate4sd3_1
* cell instance sg13cmos5l_dlygate4sd3_1_95 r0 *1 0,0
Xsg13cmos5l_dlygate4sd3_1_95 \$1156 \$2 \$1 \$1388 sg13cmos5l_dlygate4sd3_1
* cell instance sg13cmos5l_dlygate4sd3_1_96 r0 *1 0,0
Xsg13cmos5l_dlygate4sd3_1_96 \$1385 \$2 \$1 \$1631 sg13cmos5l_dlygate4sd3_1
* cell instance sg13cmos5l_dlygate4sd3_1_97 r0 *1 0,0
Xsg13cmos5l_dlygate4sd3_1_97 \$610 \$2 \$1 \$620 sg13cmos5l_dlygate4sd3_1
* cell instance sg13cmos5l_dlygate4sd3_1_98 r0 *1 0,0
Xsg13cmos5l_dlygate4sd3_1_98 \$687 \$2 \$1 \$142 sg13cmos5l_dlygate4sd3_1
* cell instance sg13cmos5l_dlygate4sd3_1_99 r0 *1 0,0
Xsg13cmos5l_dlygate4sd3_1_99 \$1064 \$2 \$1 \$1392 sg13cmos5l_dlygate4sd3_1
* cell instance sg13cmos5l_dlygate4sd3_1_100 r0 *1 0,0
Xsg13cmos5l_dlygate4sd3_1_100 \$1632 \$2 \$1 \$1636 sg13cmos5l_dlygate4sd3_1
* cell instance sg13cmos5l_dlygate4sd3_1_101 r0 *1 0,0
Xsg13cmos5l_dlygate4sd3_1_101 \$1636 \$2 \$1 \$1395 sg13cmos5l_dlygate4sd3_1
* cell instance sg13cmos5l_dlygate4sd3_1_102 r0 *1 0,0
Xsg13cmos5l_dlygate4sd3_1_102 \$145 \$2 \$1 \$143 sg13cmos5l_dlygate4sd3_1
* cell instance sg13cmos5l_dlygate4sd3_1_103 r0 *1 0,0
Xsg13cmos5l_dlygate4sd3_1_103 \$1395 \$2 \$1 \$914 sg13cmos5l_dlygate4sd3_1
* cell instance sg13cmos5l_dlygate4sd3_1_104 r0 *1 0,0
Xsg13cmos5l_dlygate4sd3_1_104 \$544 \$2 \$1 \$301 sg13cmos5l_dlygate4sd3_1
* cell instance sg13cmos5l_dlygate4sd3_1_105 r0 *1 0,0
Xsg13cmos5l_dlygate4sd3_1_105 \$1392 \$2 \$1 \$1385 sg13cmos5l_dlygate4sd3_1
* cell instance sg13cmos5l_dlygate4sd3_1_106 r0 *1 0,0
Xsg13cmos5l_dlygate4sd3_1_106 \$1400 \$2 \$1 \$1655 sg13cmos5l_dlygate4sd3_1
* cell instance sg13cmos5l_dlygate4sd3_1_107 r0 *1 0,0
Xsg13cmos5l_dlygate4sd3_1_107 \$1415 \$2 \$1 \$1400 sg13cmos5l_dlygate4sd3_1
* cell instance sg13cmos5l_dlygate4sd3_1_108 r0 *1 0,0
Xsg13cmos5l_dlygate4sd3_1_108 \$928 \$2 \$1 \$1415 sg13cmos5l_dlygate4sd3_1
* cell instance sg13cmos5l_dlygate4sd3_1_109 r0 *1 0,0
Xsg13cmos5l_dlygate4sd3_1_109 \$1185 \$2 \$1 \$931 sg13cmos5l_dlygate4sd3_1
* cell instance sg13cmos5l_dlygate4sd3_1_110 r0 *1 0,0
Xsg13cmos5l_dlygate4sd3_1_110 \$151 \$2 \$1 \$637 sg13cmos5l_dlygate4sd3_1
* cell instance sg13cmos5l_dlygate4sd3_1_111 r0 *1 0,0
Xsg13cmos5l_dlygate4sd3_1_111 \$777 \$2 \$1 \$1663 sg13cmos5l_dlygate4sd3_1
* cell instance sg13cmos5l_dlygate4sd3_1_112 r0 *1 0,0
Xsg13cmos5l_dlygate4sd3_1_112 \$498 \$2 \$1 \$646 sg13cmos5l_dlygate4sd3_1
* cell instance sg13cmos5l_dlygate4sd3_1_113 r0 *1 0,0
Xsg13cmos5l_dlygate4sd3_1_113 \$642 \$2 \$1 \$1422 sg13cmos5l_dlygate4sd3_1
* cell instance sg13cmos5l_dlygate4sd3_1_114 r0 *1 0,0
Xsg13cmos5l_dlygate4sd3_1_114 \$500 \$2 \$1 \$157 sg13cmos5l_dlygate4sd3_1
* cell instance sg13cmos5l_dlygate4sd3_1_115 r0 *1 0,0
Xsg13cmos5l_dlygate4sd3_1_115 \$646 \$2 \$1 \$149 sg13cmos5l_dlygate4sd3_1
* cell instance sg13cmos5l_dlygate4sd3_1_116 r0 *1 0,0
Xsg13cmos5l_dlygate4sd3_1_116 \$325 \$2 \$1 \$151 sg13cmos5l_dlygate4sd3_1
* cell instance sg13cmos5l_dlygate4sd3_1_117 r0 *1 0,0
Xsg13cmos5l_dlygate4sd3_1_117 \$934 \$2 \$1 \$1198 sg13cmos5l_dlygate4sd3_1
* cell instance sg13cmos5l_dlygate4sd3_1_118 r0 *1 0,0
Xsg13cmos5l_dlygate4sd3_1_118 \$1426 \$2 \$1 \$1430 sg13cmos5l_dlygate4sd3_1
* cell instance sg13cmos5l_dlygate4sd3_1_119 r0 *1 0,0
Xsg13cmos5l_dlygate4sd3_1_119 \$1198 \$2 \$1 \$1405 sg13cmos5l_dlygate4sd3_1
* cell instance sg13cmos5l_dlygate4sd3_1_120 r0 *1 0,0
Xsg13cmos5l_dlygate4sd3_1_120 \$510 \$2 \$1 \$1434 sg13cmos5l_dlygate4sd3_1
* cell instance sg13cmos5l_dlygate4sd3_1_121 r0 *1 0,0
Xsg13cmos5l_dlygate4sd3_1_121 \$341 \$2 \$1 \$21 sg13cmos5l_dlygate4sd3_1
* cell instance sg13cmos5l_dlygate4sd3_1_122 r0 *1 0,0
Xsg13cmos5l_dlygate4sd3_1_122 \$338 \$2 \$1 \$500 sg13cmos5l_dlygate4sd3_1
* cell instance sg13cmos5l_dlygate4sd3_1_123 r0 *1 0,0
Xsg13cmos5l_dlygate4sd3_1_123 \$172 \$2 \$1 \$341 sg13cmos5l_dlygate4sd3_1
* cell instance sg13cmos5l_dlygate4sd3_1_124 r0 *1 0,0
Xsg13cmos5l_dlygate4sd3_1_124 \$653 \$2 \$1 \$1438 sg13cmos5l_dlygate4sd3_1
* cell instance sg13cmos5l_dlygate4sd3_1_125 r0 *1 0,0
Xsg13cmos5l_dlygate4sd3_1_125 \$173 \$2 \$1 \$177 sg13cmos5l_dlygate4sd3_1
* cell instance sg13cmos5l_dlygate4sd3_1_126 r0 *1 0,0
Xsg13cmos5l_dlygate4sd3_1_126 \$1204 \$2 \$1 \$1208 sg13cmos5l_dlygate4sd3_1
* cell instance sg13cmos5l_dlygate4sd3_1_127 r0 *1 0,0
Xsg13cmos5l_dlygate4sd3_1_127 \$177 \$2 \$1 \$22 sg13cmos5l_dlygate4sd3_1
* cell instance sg13cmos5l_dlygate4sd3_1_128 r0 *1 0,0
Xsg13cmos5l_dlygate4sd3_1_128 \$656 \$2 \$1 \$1443 sg13cmos5l_dlygate4sd3_1
* cell instance sg13cmos5l_dlygate4sd3_1_129 r0 *1 0,0
Xsg13cmos5l_dlygate4sd3_1_129 \$790 \$2 \$1 \$1675 sg13cmos5l_dlygate4sd3_1
* cell instance sg13cmos5l_dlygate4sd3_1_130 r0 *1 0,0
Xsg13cmos5l_dlygate4sd3_1_130 \$514 \$2 \$1 \$1447 sg13cmos5l_dlygate4sd3_1
* cell instance sg13cmos5l_dlygate4sd3_1_131 r0 *1 0,0
Xsg13cmos5l_dlygate4sd3_1_131 \$965 \$2 \$1 \$662 sg13cmos5l_dlygate4sd3_1
* cell instance sg13cmos5l_dlygate4sd3_1_132 r0 *1 0,0
Xsg13cmos5l_dlygate4sd3_1_132 \$799 \$2 \$1 \$1668 sg13cmos5l_dlygate4sd3_1
* cell instance sg13cmos5l_dlygate4sd3_1_133 r0 *1 0,0
Xsg13cmos5l_dlygate4sd3_1_133 \$518 \$2 \$1 \$513 sg13cmos5l_dlygate4sd3_1
* cell instance sg13cmos5l_dlygate4sd3_1_134 r0 *1 0,0
Xsg13cmos5l_dlygate4sd3_1_134 \$801 \$2 \$1 \$517 sg13cmos5l_dlygate4sd3_1
* cell instance sg13cmos5l_dlygate4sd3_1_135 r0 *1 0,0
Xsg13cmos5l_dlygate4sd3_1_135 \$804 \$2 \$1 \$515 sg13cmos5l_dlygate4sd3_1
* cell instance sg13cmos5l_dlygate4sd3_1_136 r0 *1 0,0
Xsg13cmos5l_dlygate4sd3_1_136 \$363 \$2 \$1 \$348 sg13cmos5l_dlygate4sd3_1
* cell instance sg13cmos5l_dlygate4sd3_1_137 r0 *1 0,0
Xsg13cmos5l_dlygate4sd3_1_137 \$972 \$2 \$1 \$664 sg13cmos5l_dlygate4sd3_1
* cell instance sg13cmos5l_dlygate4sd3_1_138 r0 *1 0,0
Xsg13cmos5l_dlygate4sd3_1_138 \$359 \$2 \$1 \$518 sg13cmos5l_dlygate4sd3_1
* cell instance sg13cmos5l_dlygate4sd3_1_139 r0 *1 0,0
Xsg13cmos5l_dlygate4sd3_1_139 \$532 \$2 \$1 \$804 sg13cmos5l_dlygate4sd3_1
* cell instance sg13cmos5l_dlygate4sd3_1_140 r0 *1 0,0
Xsg13cmos5l_dlygate4sd3_1_140 \$977 \$2 \$1 \$808 sg13cmos5l_dlygate4sd3_1
* cell instance sg13cmos5l_dlygate4sd3_1_141 r0 *1 0,0
Xsg13cmos5l_dlygate4sd3_1_141 \$195 \$2 \$1 \$363 sg13cmos5l_dlygate4sd3_1
* cell instance sg13cmos5l_dlygate4sd3_1_142 r0 *1 0,0
Xsg13cmos5l_dlygate4sd3_1_142 \$676 \$2 \$1 \$674 sg13cmos5l_dlygate4sd3_1
* cell instance sg13cmos5l_dlygate4sd3_1_143 r0 *1 0,0
Xsg13cmos5l_dlygate4sd3_1_143 \$1068 \$2 \$1 \$807 sg13cmos5l_dlygate4sd3_1
* cell instance sg13cmos5l_dlygate4sd3_1_144 r0 *1 0,0
Xsg13cmos5l_dlygate4sd3_1_144 \$534 \$2 \$1 \$689 sg13cmos5l_dlygate4sd3_1
* cell instance sg13cmos5l_dlygate4sd3_1_145 r0 *1 0,0
Xsg13cmos5l_dlygate4sd3_1_145 \$1463 \$2 \$1 \$981 sg13cmos5l_dlygate4sd3_1
* cell instance sg13cmos5l_dlygate4sd3_1_146 r0 *1 0,0
Xsg13cmos5l_dlygate4sd3_1_146 \$1473 \$2 \$1 \$1721 sg13cmos5l_dlygate4sd3_1
* cell instance sg13cmos5l_dlygate4sd3_1_147 r0 *1 0,0
Xsg13cmos5l_dlygate4sd3_1_147 \$1723 \$2 \$1 \$1473 sg13cmos5l_dlygate4sd3_1
* cell instance sg13cmos5l_dlygate4sd3_1_148 r0 *1 0,0
Xsg13cmos5l_dlygate4sd3_1_148 \$1251 \$2 \$1 \$1723 sg13cmos5l_dlygate4sd3_1
* cell instance sg13cmos5l_dlygate4sd3_1_149 r0 *1 0,0
Xsg13cmos5l_dlygate4sd3_1_149 \$1730 \$2 \$1 \$1484 sg13cmos5l_dlygate4sd3_1
* cell instance sg13cmos5l_dlygate4sd3_1_150 r0 *1 0,0
Xsg13cmos5l_dlygate4sd3_1_150 \$1003 \$2 \$1 \$1730 sg13cmos5l_dlygate4sd3_1
* cell instance sg13cmos5l_dlygate4sd3_1_151 r0 *1 0,0
Xsg13cmos5l_dlygate4sd3_1_151 \$1484 \$2 \$1 \$1736 sg13cmos5l_dlygate4sd3_1
* cell instance sg13cmos5l_dlygate4sd3_1_152 r0 *1 0,0
Xsg13cmos5l_dlygate4sd3_1_152 \$1740 \$2 \$1 \$1487 sg13cmos5l_dlygate4sd3_1
* cell instance sg13cmos5l_dlygate4sd3_1_153 r0 *1 0,0
Xsg13cmos5l_dlygate4sd3_1_153 \$1264 \$2 \$1 \$1740 sg13cmos5l_dlygate4sd3_1
* cell instance sg13cmos5l_dlygate4sd3_1_154 r0 *1 0,0
Xsg13cmos5l_dlygate4sd3_1_154 \$1487 \$2 \$1 \$1750 sg13cmos5l_dlygate4sd3_1
* cell instance sg13cmos5l_dlygate4sd3_1_155 r0 *1 0,0
Xsg13cmos5l_dlygate4sd3_1_155 \$1023 \$2 \$1 \$1507 sg13cmos5l_dlygate4sd3_1
* cell instance sg13cmos5l_dlygate4sd3_1_156 r0 *1 0,0
Xsg13cmos5l_dlygate4sd3_1_156 \$1507 \$2 \$1 \$1497 sg13cmos5l_dlygate4sd3_1
* cell instance sg13cmos5l_dlygate4sd3_1_157 r0 *1 0,0
Xsg13cmos5l_dlygate4sd3_1_157 \$1512 \$2 \$1 \$1503 sg13cmos5l_dlygate4sd3_1
* cell instance sg13cmos5l_dlygate4sd3_1_158 r0 *1 0,0
Xsg13cmos5l_dlygate4sd3_1_158 \$1497 \$2 \$1 \$1755 sg13cmos5l_dlygate4sd3_1
* cell instance sg13cmos5l_dlygate4sd3_1_159 r0 *1 0,0
Xsg13cmos5l_dlygate4sd3_1_159 \$1280 \$2 \$1 \$1512 sg13cmos5l_dlygate4sd3_1
* cell instance sg13cmos5l_dlygate4sd3_1_160 r0 *1 0,0
Xsg13cmos5l_dlygate4sd3_1_160 \$1503 \$2 \$1 \$1766 sg13cmos5l_dlygate4sd3_1
* cell instance sg13cmos5l_dlygate4sd3_1_161 r0 *1 0,0
Xsg13cmos5l_dlygate4sd3_1_161 \$1294 \$2 \$1 \$1034 sg13cmos5l_dlygate4sd3_1
* cell instance sg13cmos5l_dlygate4sd3_1_162 r0 *1 0,0
Xsg13cmos5l_dlygate4sd3_1_162 \$1292 \$2 \$1 \$1294 sg13cmos5l_dlygate4sd3_1
* cell instance sg13cmos5l_dlygate4sd3_1_163 r0 *1 0,0
Xsg13cmos5l_dlygate4sd3_1_163 \$1055 \$2 \$1 \$1300 sg13cmos5l_dlygate4sd3_1
* cell instance sg13cmos5l_dlygate4sd3_1_164 r0 *1 0,0
Xsg13cmos5l_dlygate4sd3_1_164 \$1034 \$2 \$1 \$1534 sg13cmos5l_dlygate4sd3_1
* cell instance sg13cmos5l_dlygate4sd3_1_165 r0 *1 0,0
Xsg13cmos5l_dlygate4sd3_1_165 \$1300 \$2 \$1 \$1521 sg13cmos5l_dlygate4sd3_1
* cell instance sg13cmos5l_dlygate4sd3_1_166 r0 *1 0,0
Xsg13cmos5l_dlygate4sd3_1_166 \$1521 \$2 \$1 \$1538 sg13cmos5l_dlygate4sd3_1
* cell instance sg13cmos5l_dlygate4sd3_1_167 r0 *1 0,0
Xsg13cmos5l_dlygate4sd3_1_167 \$1530 \$2 \$1 \$1776 sg13cmos5l_dlygate4sd3_1
* cell instance sg13cmos5l_dlygate4sd3_1_168 r0 *1 0,0
Xsg13cmos5l_dlygate4sd3_1_168 \$1776 \$2 \$1 \$1780 sg13cmos5l_dlygate4sd3_1
* cell instance sg13cmos5l_dlygate4sd3_1_169 r0 *1 0,0
Xsg13cmos5l_dlygate4sd3_1_169 \$1780 \$2 \$1 \$1784 sg13cmos5l_dlygate4sd3_1
* cell instance sg13cmos5l_fill_1_0 r0 *1 0,0
Xsg13cmos5l_fill_1_0 \$2 \$1 sg13cmos5l_fill_1
* cell instance sg13cmos5l_fill_1_1 r0 *1 0,0
Xsg13cmos5l_fill_1_1 \$2 \$1 sg13cmos5l_fill_1
* cell instance sg13cmos5l_fill_1_2 r0 *1 0,0
Xsg13cmos5l_fill_1_2 \$2 \$1 sg13cmos5l_fill_1
* cell instance sg13cmos5l_fill_1_3 r0 *1 0,0
Xsg13cmos5l_fill_1_3 \$2 \$1 sg13cmos5l_fill_1
* cell instance sg13cmos5l_fill_1_4 r0 *1 0,0
Xsg13cmos5l_fill_1_4 \$2 \$1 sg13cmos5l_fill_1
* cell instance sg13cmos5l_fill_1_5 r0 *1 0,0
Xsg13cmos5l_fill_1_5 \$2 \$1 sg13cmos5l_fill_1
* cell instance sg13cmos5l_fill_1_6 r0 *1 0,0
Xsg13cmos5l_fill_1_6 \$2 \$1 sg13cmos5l_fill_1
* cell instance sg13cmos5l_fill_1_7 r0 *1 0,0
Xsg13cmos5l_fill_1_7 \$2 \$1 sg13cmos5l_fill_1
* cell instance sg13cmos5l_fill_1_8 r0 *1 0,0
Xsg13cmos5l_fill_1_8 \$2 \$1 sg13cmos5l_fill_1
* cell instance sg13cmos5l_fill_1_9 r0 *1 0,0
Xsg13cmos5l_fill_1_9 \$2 \$1 sg13cmos5l_fill_1
* cell instance sg13cmos5l_fill_1_10 r0 *1 0,0
Xsg13cmos5l_fill_1_10 \$2 \$1 sg13cmos5l_fill_1
* cell instance sg13cmos5l_fill_1_11 r0 *1 0,0
Xsg13cmos5l_fill_1_11 \$2 \$1 sg13cmos5l_fill_1
* cell instance sg13cmos5l_fill_1_12 r0 *1 0,0
Xsg13cmos5l_fill_1_12 \$2 \$1 sg13cmos5l_fill_1
* cell instance sg13cmos5l_fill_1_13 r0 *1 0,0
Xsg13cmos5l_fill_1_13 \$2 \$1 sg13cmos5l_fill_1
* cell instance sg13cmos5l_fill_1_14 r0 *1 0,0
Xsg13cmos5l_fill_1_14 \$2 \$1 sg13cmos5l_fill_1
* cell instance sg13cmos5l_fill_1_15 r0 *1 0,0
Xsg13cmos5l_fill_1_15 \$2 \$1 sg13cmos5l_fill_1
* cell instance sg13cmos5l_fill_1_16 r0 *1 0,0
Xsg13cmos5l_fill_1_16 \$2 \$1 sg13cmos5l_fill_1
* cell instance sg13cmos5l_fill_1_17 r0 *1 0,0
Xsg13cmos5l_fill_1_17 \$2 \$1 sg13cmos5l_fill_1
* cell instance sg13cmos5l_fill_1_18 r0 *1 0,0
Xsg13cmos5l_fill_1_18 \$2 \$1 sg13cmos5l_fill_1
* cell instance sg13cmos5l_fill_1_19 r0 *1 0,0
Xsg13cmos5l_fill_1_19 \$2 \$1 sg13cmos5l_fill_1
* cell instance sg13cmos5l_fill_1_20 r0 *1 0,0
Xsg13cmos5l_fill_1_20 \$2 \$1 sg13cmos5l_fill_1
* cell instance sg13cmos5l_fill_1_21 r0 *1 0,0
Xsg13cmos5l_fill_1_21 \$2 \$1 sg13cmos5l_fill_1
* cell instance sg13cmos5l_fill_1_22 r0 *1 0,0
Xsg13cmos5l_fill_1_22 \$2 \$1 sg13cmos5l_fill_1
* cell instance sg13cmos5l_fill_1_23 r0 *1 0,0
Xsg13cmos5l_fill_1_23 \$2 \$1 sg13cmos5l_fill_1
* cell instance sg13cmos5l_fill_1_24 r0 *1 0,0
Xsg13cmos5l_fill_1_24 \$2 \$1 sg13cmos5l_fill_1
* cell instance sg13cmos5l_fill_1_25 r0 *1 0,0
Xsg13cmos5l_fill_1_25 \$2 \$1 sg13cmos5l_fill_1
* cell instance sg13cmos5l_fill_1_26 r0 *1 0,0
Xsg13cmos5l_fill_1_26 \$2 \$1 sg13cmos5l_fill_1
* cell instance sg13cmos5l_fill_1_27 r0 *1 0,0
Xsg13cmos5l_fill_1_27 \$2 \$1 sg13cmos5l_fill_1
* cell instance sg13cmos5l_fill_1_28 r0 *1 0,0
Xsg13cmos5l_fill_1_28 \$2 \$1 sg13cmos5l_fill_1
* cell instance sg13cmos5l_fill_1_29 r0 *1 0,0
Xsg13cmos5l_fill_1_29 \$2 \$1 sg13cmos5l_fill_1
* cell instance sg13cmos5l_fill_1_30 r0 *1 0,0
Xsg13cmos5l_fill_1_30 \$2 \$1 sg13cmos5l_fill_1
* cell instance sg13cmos5l_fill_1_31 r0 *1 0,0
Xsg13cmos5l_fill_1_31 \$2 \$1 sg13cmos5l_fill_1
* cell instance sg13cmos5l_fill_1_32 r0 *1 0,0
Xsg13cmos5l_fill_1_32 \$2 \$1 sg13cmos5l_fill_1
* cell instance sg13cmos5l_fill_1_33 r0 *1 0,0
Xsg13cmos5l_fill_1_33 \$2 \$1 sg13cmos5l_fill_1
* cell instance sg13cmos5l_fill_1_34 r0 *1 0,0
Xsg13cmos5l_fill_1_34 \$2 \$1 sg13cmos5l_fill_1
* cell instance sg13cmos5l_fill_1_35 r0 *1 0,0
Xsg13cmos5l_fill_1_35 \$2 \$1 sg13cmos5l_fill_1
* cell instance sg13cmos5l_fill_1_36 r0 *1 0,0
Xsg13cmos5l_fill_1_36 \$2 \$1 sg13cmos5l_fill_1
* cell instance sg13cmos5l_fill_1_37 r0 *1 0,0
Xsg13cmos5l_fill_1_37 \$2 \$1 sg13cmos5l_fill_1
* cell instance sg13cmos5l_fill_1_38 r0 *1 0,0
Xsg13cmos5l_fill_1_38 \$2 \$1 sg13cmos5l_fill_1
* cell instance sg13cmos5l_fill_1_39 r0 *1 0,0
Xsg13cmos5l_fill_1_39 \$2 \$1 sg13cmos5l_fill_1
* cell instance sg13cmos5l_fill_1_40 r0 *1 0,0
Xsg13cmos5l_fill_1_40 \$2 \$1 sg13cmos5l_fill_1
* cell instance sg13cmos5l_fill_1_41 r0 *1 0,0
Xsg13cmos5l_fill_1_41 \$2 \$1 sg13cmos5l_fill_1
* cell instance sg13cmos5l_fill_1_42 r0 *1 0,0
Xsg13cmos5l_fill_1_42 \$2 \$1 sg13cmos5l_fill_1
* cell instance sg13cmos5l_fill_1_43 r0 *1 0,0
Xsg13cmos5l_fill_1_43 \$2 \$1 sg13cmos5l_fill_1
* cell instance sg13cmos5l_fill_1_44 r0 *1 0,0
Xsg13cmos5l_fill_1_44 \$2 \$1 sg13cmos5l_fill_1
* cell instance sg13cmos5l_fill_1_45 r0 *1 0,0
Xsg13cmos5l_fill_1_45 \$2 \$1 sg13cmos5l_fill_1
* cell instance sg13cmos5l_fill_1_46 r0 *1 0,0
Xsg13cmos5l_fill_1_46 \$2 \$1 sg13cmos5l_fill_1
* cell instance sg13cmos5l_fill_1_47 r0 *1 0,0
Xsg13cmos5l_fill_1_47 \$2 \$1 sg13cmos5l_fill_1
* cell instance sg13cmos5l_fill_1_48 r0 *1 0,0
Xsg13cmos5l_fill_1_48 \$2 \$1 sg13cmos5l_fill_1
* cell instance sg13cmos5l_fill_1_49 r0 *1 0,0
Xsg13cmos5l_fill_1_49 \$2 \$1 sg13cmos5l_fill_1
* cell instance sg13cmos5l_fill_1_50 r0 *1 0,0
Xsg13cmos5l_fill_1_50 \$2 \$1 sg13cmos5l_fill_1
* cell instance sg13cmos5l_fill_1_51 r0 *1 0,0
Xsg13cmos5l_fill_1_51 \$2 \$1 sg13cmos5l_fill_1
* cell instance sg13cmos5l_fill_1_52 r0 *1 0,0
Xsg13cmos5l_fill_1_52 \$2 \$1 sg13cmos5l_fill_1
* cell instance sg13cmos5l_fill_1_53 r0 *1 0,0
Xsg13cmos5l_fill_1_53 \$2 \$1 sg13cmos5l_fill_1
* cell instance sg13cmos5l_fill_1_54 r0 *1 0,0
Xsg13cmos5l_fill_1_54 \$2 \$1 sg13cmos5l_fill_1
* cell instance sg13cmos5l_fill_1_55 r0 *1 0,0
Xsg13cmos5l_fill_1_55 \$2 \$1 sg13cmos5l_fill_1
* cell instance sg13cmos5l_fill_1_56 r0 *1 0,0
Xsg13cmos5l_fill_1_56 \$2 \$1 sg13cmos5l_fill_1
* cell instance sg13cmos5l_fill_1_57 r0 *1 0,0
Xsg13cmos5l_fill_1_57 \$2 \$1 sg13cmos5l_fill_1
* cell instance sg13cmos5l_fill_1_58 r0 *1 0,0
Xsg13cmos5l_fill_1_58 \$2 \$1 sg13cmos5l_fill_1
* cell instance sg13cmos5l_fill_1_59 r0 *1 0,0
Xsg13cmos5l_fill_1_59 \$2 \$1 sg13cmos5l_fill_1
* cell instance sg13cmos5l_fill_1_60 r0 *1 0,0
Xsg13cmos5l_fill_1_60 \$2 \$1 sg13cmos5l_fill_1
* cell instance sg13cmos5l_fill_1_61 r0 *1 0,0
Xsg13cmos5l_fill_1_61 \$2 \$1 sg13cmos5l_fill_1
* cell instance sg13cmos5l_fill_1_62 r0 *1 0,0
Xsg13cmos5l_fill_1_62 \$2 \$1 sg13cmos5l_fill_1
* cell instance sg13cmos5l_fill_1_63 r0 *1 0,0
Xsg13cmos5l_fill_1_63 \$2 \$1 sg13cmos5l_fill_1
* cell instance sg13cmos5l_fill_1_64 r0 *1 0,0
Xsg13cmos5l_fill_1_64 \$2 \$1 sg13cmos5l_fill_1
* cell instance sg13cmos5l_fill_1_65 r0 *1 0,0
Xsg13cmos5l_fill_1_65 \$2 \$1 sg13cmos5l_fill_1
* cell instance sg13cmos5l_fill_1_66 r0 *1 0,0
Xsg13cmos5l_fill_1_66 \$2 \$1 sg13cmos5l_fill_1
* cell instance sg13cmos5l_fill_1_67 r0 *1 0,0
Xsg13cmos5l_fill_1_67 \$2 \$1 sg13cmos5l_fill_1
* cell instance sg13cmos5l_fill_1_68 r0 *1 0,0
Xsg13cmos5l_fill_1_68 \$2 \$1 sg13cmos5l_fill_1
* cell instance sg13cmos5l_fill_1_69 r0 *1 0,0
Xsg13cmos5l_fill_1_69 \$2 \$1 sg13cmos5l_fill_1
* cell instance sg13cmos5l_fill_1_70 r0 *1 0,0
Xsg13cmos5l_fill_1_70 \$2 \$1 sg13cmos5l_fill_1
* cell instance sg13cmos5l_fill_1_71 r0 *1 0,0
Xsg13cmos5l_fill_1_71 \$2 \$1 sg13cmos5l_fill_1
* cell instance sg13cmos5l_fill_1_72 r0 *1 0,0
Xsg13cmos5l_fill_1_72 \$2 \$1 sg13cmos5l_fill_1
* cell instance sg13cmos5l_fill_1_73 r0 *1 0,0
Xsg13cmos5l_fill_1_73 \$2 \$1 sg13cmos5l_fill_1
* cell instance sg13cmos5l_fill_1_74 r0 *1 0,0
Xsg13cmos5l_fill_1_74 \$2 \$1 sg13cmos5l_fill_1
* cell instance sg13cmos5l_fill_1_75 r0 *1 0,0
Xsg13cmos5l_fill_1_75 \$2 \$1 sg13cmos5l_fill_1
* cell instance sg13cmos5l_fill_1_76 r0 *1 0,0
Xsg13cmos5l_fill_1_76 \$2 \$1 sg13cmos5l_fill_1
* cell instance sg13cmos5l_fill_1_77 r0 *1 0,0
Xsg13cmos5l_fill_1_77 \$2 \$1 sg13cmos5l_fill_1
* cell instance sg13cmos5l_fill_1_78 r0 *1 0,0
Xsg13cmos5l_fill_1_78 \$2 \$1 sg13cmos5l_fill_1
* cell instance sg13cmos5l_fill_1_79 r0 *1 0,0
Xsg13cmos5l_fill_1_79 \$2 \$1 sg13cmos5l_fill_1
* cell instance sg13cmos5l_fill_1_80 r0 *1 0,0
Xsg13cmos5l_fill_1_80 \$2 \$1 sg13cmos5l_fill_1
* cell instance sg13cmos5l_fill_1_81 r0 *1 0,0
Xsg13cmos5l_fill_1_81 \$2 \$1 sg13cmos5l_fill_1
* cell instance sg13cmos5l_fill_1_82 r0 *1 0,0
Xsg13cmos5l_fill_1_82 \$2 \$1 sg13cmos5l_fill_1
* cell instance sg13cmos5l_fill_1_83 r0 *1 0,0
Xsg13cmos5l_fill_1_83 \$2 \$1 sg13cmos5l_fill_1
* cell instance sg13cmos5l_fill_1_84 r0 *1 0,0
Xsg13cmos5l_fill_1_84 \$2 \$1 sg13cmos5l_fill_1
* cell instance sg13cmos5l_fill_1_85 r0 *1 0,0
Xsg13cmos5l_fill_1_85 \$2 \$1 sg13cmos5l_fill_1
* cell instance sg13cmos5l_fill_1_86 r0 *1 0,0
Xsg13cmos5l_fill_1_86 \$2 \$1 sg13cmos5l_fill_1
* cell instance sg13cmos5l_fill_1_87 r0 *1 0,0
Xsg13cmos5l_fill_1_87 \$2 \$1 sg13cmos5l_fill_1
* cell instance sg13cmos5l_fill_1_88 r0 *1 0,0
Xsg13cmos5l_fill_1_88 \$2 \$1 sg13cmos5l_fill_1
* cell instance sg13cmos5l_fill_1_89 r0 *1 0,0
Xsg13cmos5l_fill_1_89 \$2 \$1 sg13cmos5l_fill_1
* cell instance sg13cmos5l_fill_1_90 r0 *1 0,0
Xsg13cmos5l_fill_1_90 \$2 \$1 sg13cmos5l_fill_1
* cell instance sg13cmos5l_fill_1_91 r0 *1 0,0
Xsg13cmos5l_fill_1_91 \$2 \$1 sg13cmos5l_fill_1
* cell instance sg13cmos5l_fill_1_92 r0 *1 0,0
Xsg13cmos5l_fill_1_92 \$2 \$1 sg13cmos5l_fill_1
* cell instance sg13cmos5l_fill_1_93 r0 *1 0,0
Xsg13cmos5l_fill_1_93 \$2 \$1 sg13cmos5l_fill_1
* cell instance sg13cmos5l_fill_1_94 r0 *1 0,0
Xsg13cmos5l_fill_1_94 \$2 \$1 sg13cmos5l_fill_1
* cell instance sg13cmos5l_fill_1_95 r0 *1 0,0
Xsg13cmos5l_fill_1_95 \$2 \$1 sg13cmos5l_fill_1
* cell instance sg13cmos5l_fill_1_96 r0 *1 0,0
Xsg13cmos5l_fill_1_96 \$2 \$1 sg13cmos5l_fill_1
* cell instance sg13cmos5l_fill_1_97 r0 *1 0,0
Xsg13cmos5l_fill_1_97 \$2 \$1 sg13cmos5l_fill_1
* cell instance sg13cmos5l_fill_1_98 r0 *1 0,0
Xsg13cmos5l_fill_1_98 \$2 \$1 sg13cmos5l_fill_1
* cell instance sg13cmos5l_fill_1_99 r0 *1 0,0
Xsg13cmos5l_fill_1_99 \$2 \$1 sg13cmos5l_fill_1
* cell instance sg13cmos5l_fill_1_100 r0 *1 0,0
Xsg13cmos5l_fill_1_100 \$2 \$1 sg13cmos5l_fill_1
* cell instance sg13cmos5l_fill_1_101 r0 *1 0,0
Xsg13cmos5l_fill_1_101 \$2 \$1 sg13cmos5l_fill_1
* cell instance sg13cmos5l_fill_1_102 r0 *1 0,0
Xsg13cmos5l_fill_1_102 \$2 \$1 sg13cmos5l_fill_1
* cell instance sg13cmos5l_fill_1_103 r0 *1 0,0
Xsg13cmos5l_fill_1_103 \$2 \$1 sg13cmos5l_fill_1
* cell instance sg13cmos5l_fill_1_104 r0 *1 0,0
Xsg13cmos5l_fill_1_104 \$2 \$1 sg13cmos5l_fill_1
* cell instance sg13cmos5l_fill_1_105 r0 *1 0,0
Xsg13cmos5l_fill_1_105 \$2 \$1 sg13cmos5l_fill_1
* cell instance sg13cmos5l_fill_1_106 r0 *1 0,0
Xsg13cmos5l_fill_1_106 \$2 \$1 sg13cmos5l_fill_1
* cell instance sg13cmos5l_fill_1_107 r0 *1 0,0
Xsg13cmos5l_fill_1_107 \$2 \$1 sg13cmos5l_fill_1
* cell instance sg13cmos5l_fill_1_108 r0 *1 0,0
Xsg13cmos5l_fill_1_108 \$2 \$1 sg13cmos5l_fill_1
* cell instance sg13cmos5l_fill_1_109 r0 *1 0,0
Xsg13cmos5l_fill_1_109 \$2 \$1 sg13cmos5l_fill_1
* cell instance sg13cmos5l_fill_1_110 r0 *1 0,0
Xsg13cmos5l_fill_1_110 \$2 \$1 sg13cmos5l_fill_1
* cell instance sg13cmos5l_fill_1_111 r0 *1 0,0
Xsg13cmos5l_fill_1_111 \$2 \$1 sg13cmos5l_fill_1
* cell instance sg13cmos5l_fill_1_112 r0 *1 0,0
Xsg13cmos5l_fill_1_112 \$2 \$1 sg13cmos5l_fill_1
* cell instance sg13cmos5l_fill_1_113 r0 *1 0,0
Xsg13cmos5l_fill_1_113 \$2 \$1 sg13cmos5l_fill_1
* cell instance sg13cmos5l_fill_1_114 r0 *1 0,0
Xsg13cmos5l_fill_1_114 \$2 \$1 sg13cmos5l_fill_1
* cell instance sg13cmos5l_fill_1_115 r0 *1 0,0
Xsg13cmos5l_fill_1_115 \$2 \$1 sg13cmos5l_fill_1
* cell instance sg13cmos5l_fill_1_116 r0 *1 0,0
Xsg13cmos5l_fill_1_116 \$2 \$1 sg13cmos5l_fill_1
* cell instance sg13cmos5l_fill_1_117 r0 *1 0,0
Xsg13cmos5l_fill_1_117 \$2 \$1 sg13cmos5l_fill_1
* cell instance sg13cmos5l_fill_1_118 r0 *1 0,0
Xsg13cmos5l_fill_1_118 \$2 \$1 sg13cmos5l_fill_1
* cell instance sg13cmos5l_fill_1_119 r0 *1 0,0
Xsg13cmos5l_fill_1_119 \$2 \$1 sg13cmos5l_fill_1
* cell instance sg13cmos5l_fill_1_120 r0 *1 0,0
Xsg13cmos5l_fill_1_120 \$2 \$1 sg13cmos5l_fill_1
* cell instance sg13cmos5l_fill_1_121 r0 *1 0,0
Xsg13cmos5l_fill_1_121 \$2 \$1 sg13cmos5l_fill_1
* cell instance sg13cmos5l_fill_1_122 r0 *1 0,0
Xsg13cmos5l_fill_1_122 \$2 \$1 sg13cmos5l_fill_1
* cell instance sg13cmos5l_fill_1_123 r0 *1 0,0
Xsg13cmos5l_fill_1_123 \$2 \$1 sg13cmos5l_fill_1
* cell instance sg13cmos5l_fill_1_124 r0 *1 0,0
Xsg13cmos5l_fill_1_124 \$2 \$1 sg13cmos5l_fill_1
* cell instance sg13cmos5l_fill_1_125 r0 *1 0,0
Xsg13cmos5l_fill_1_125 \$2 \$1 sg13cmos5l_fill_1
* cell instance sg13cmos5l_fill_1_126 r0 *1 0,0
Xsg13cmos5l_fill_1_126 \$2 \$1 sg13cmos5l_fill_1
* cell instance sg13cmos5l_fill_1_127 r0 *1 0,0
Xsg13cmos5l_fill_1_127 \$2 \$1 sg13cmos5l_fill_1
* cell instance sg13cmos5l_fill_1_128 r0 *1 0,0
Xsg13cmos5l_fill_1_128 \$2 \$1 sg13cmos5l_fill_1
* cell instance sg13cmos5l_fill_1_129 r0 *1 0,0
Xsg13cmos5l_fill_1_129 \$2 \$1 sg13cmos5l_fill_1
* cell instance sg13cmos5l_fill_1_130 r0 *1 0,0
Xsg13cmos5l_fill_1_130 \$2 \$1 sg13cmos5l_fill_1
* cell instance sg13cmos5l_fill_1_131 r0 *1 0,0
Xsg13cmos5l_fill_1_131 \$2 \$1 sg13cmos5l_fill_1
* cell instance sg13cmos5l_fill_1_132 r0 *1 0,0
Xsg13cmos5l_fill_1_132 \$2 \$1 sg13cmos5l_fill_1
* cell instance sg13cmos5l_fill_1_133 r0 *1 0,0
Xsg13cmos5l_fill_1_133 \$2 \$1 sg13cmos5l_fill_1
* cell instance sg13cmos5l_fill_1_134 r0 *1 0,0
Xsg13cmos5l_fill_1_134 \$2 \$1 sg13cmos5l_fill_1
* cell instance sg13cmos5l_fill_1_135 r0 *1 0,0
Xsg13cmos5l_fill_1_135 \$2 \$1 sg13cmos5l_fill_1
* cell instance sg13cmos5l_fill_1_136 r0 *1 0,0
Xsg13cmos5l_fill_1_136 \$2 \$1 sg13cmos5l_fill_1
* cell instance sg13cmos5l_fill_1_137 r0 *1 0,0
Xsg13cmos5l_fill_1_137 \$2 \$1 sg13cmos5l_fill_1
* cell instance sg13cmos5l_fill_1_138 r0 *1 0,0
Xsg13cmos5l_fill_1_138 \$2 \$1 sg13cmos5l_fill_1
* cell instance sg13cmos5l_fill_1_139 r0 *1 0,0
Xsg13cmos5l_fill_1_139 \$2 \$1 sg13cmos5l_fill_1
* cell instance sg13cmos5l_fill_1_140 r0 *1 0,0
Xsg13cmos5l_fill_1_140 \$2 \$1 sg13cmos5l_fill_1
* cell instance sg13cmos5l_fill_1_141 r0 *1 0,0
Xsg13cmos5l_fill_1_141 \$2 \$1 sg13cmos5l_fill_1
* cell instance sg13cmos5l_fill_1_142 r0 *1 0,0
Xsg13cmos5l_fill_1_142 \$2 \$1 sg13cmos5l_fill_1
* cell instance sg13cmos5l_fill_1_143 r0 *1 0,0
Xsg13cmos5l_fill_1_143 \$2 \$1 sg13cmos5l_fill_1
* cell instance sg13cmos5l_fill_1_144 r0 *1 0,0
Xsg13cmos5l_fill_1_144 \$2 \$1 sg13cmos5l_fill_1
* cell instance sg13cmos5l_fill_1_145 r0 *1 0,0
Xsg13cmos5l_fill_1_145 \$2 \$1 sg13cmos5l_fill_1
* cell instance sg13cmos5l_fill_1_146 r0 *1 0,0
Xsg13cmos5l_fill_1_146 \$2 \$1 sg13cmos5l_fill_1
* cell instance sg13cmos5l_fill_1_147 r0 *1 0,0
Xsg13cmos5l_fill_1_147 \$2 \$1 sg13cmos5l_fill_1
* cell instance sg13cmos5l_fill_1_148 r0 *1 0,0
Xsg13cmos5l_fill_1_148 \$2 \$1 sg13cmos5l_fill_1
* cell instance sg13cmos5l_fill_1_149 r0 *1 0,0
Xsg13cmos5l_fill_1_149 \$2 \$1 sg13cmos5l_fill_1
* cell instance sg13cmos5l_fill_1_150 r0 *1 0,0
Xsg13cmos5l_fill_1_150 \$2 \$1 sg13cmos5l_fill_1
* cell instance sg13cmos5l_fill_1_151 r0 *1 0,0
Xsg13cmos5l_fill_1_151 \$2 \$1 sg13cmos5l_fill_1
* cell instance sg13cmos5l_fill_1_152 r0 *1 0,0
Xsg13cmos5l_fill_1_152 \$2 \$1 sg13cmos5l_fill_1
* cell instance sg13cmos5l_fill_1_153 r0 *1 0,0
Xsg13cmos5l_fill_1_153 \$2 \$1 sg13cmos5l_fill_1
* cell instance sg13cmos5l_fill_1_154 r0 *1 0,0
Xsg13cmos5l_fill_1_154 \$2 \$1 sg13cmos5l_fill_1
* cell instance sg13cmos5l_fill_1_155 r0 *1 0,0
Xsg13cmos5l_fill_1_155 \$2 \$1 sg13cmos5l_fill_1
* cell instance sg13cmos5l_fill_1_156 r0 *1 0,0
Xsg13cmos5l_fill_1_156 \$2 \$1 sg13cmos5l_fill_1
* cell instance sg13cmos5l_fill_1_157 r0 *1 0,0
Xsg13cmos5l_fill_1_157 \$2 \$1 sg13cmos5l_fill_1
* cell instance sg13cmos5l_fill_1_158 r0 *1 0,0
Xsg13cmos5l_fill_1_158 \$2 \$1 sg13cmos5l_fill_1
* cell instance sg13cmos5l_fill_1_159 r0 *1 0,0
Xsg13cmos5l_fill_1_159 \$2 \$1 sg13cmos5l_fill_1
* cell instance sg13cmos5l_fill_1_160 r0 *1 0,0
Xsg13cmos5l_fill_1_160 \$2 \$1 sg13cmos5l_fill_1
* cell instance sg13cmos5l_fill_1_161 r0 *1 0,0
Xsg13cmos5l_fill_1_161 \$2 \$1 sg13cmos5l_fill_1
* cell instance sg13cmos5l_fill_1_162 r0 *1 0,0
Xsg13cmos5l_fill_1_162 \$2 \$1 sg13cmos5l_fill_1
* cell instance sg13cmos5l_fill_1_163 r0 *1 0,0
Xsg13cmos5l_fill_1_163 \$2 \$1 sg13cmos5l_fill_1
* cell instance sg13cmos5l_fill_1_164 r0 *1 0,0
Xsg13cmos5l_fill_1_164 \$2 \$1 sg13cmos5l_fill_1
* cell instance sg13cmos5l_fill_1_165 r0 *1 0,0
Xsg13cmos5l_fill_1_165 \$2 \$1 sg13cmos5l_fill_1
* cell instance sg13cmos5l_fill_1_166 r0 *1 0,0
Xsg13cmos5l_fill_1_166 \$2 \$1 sg13cmos5l_fill_1
* cell instance sg13cmos5l_fill_1_167 r0 *1 0,0
Xsg13cmos5l_fill_1_167 \$2 \$1 sg13cmos5l_fill_1
* cell instance sg13cmos5l_fill_1_168 r0 *1 0,0
Xsg13cmos5l_fill_1_168 \$2 \$1 sg13cmos5l_fill_1
* cell instance sg13cmos5l_fill_1_169 r0 *1 0,0
Xsg13cmos5l_fill_1_169 \$2 \$1 sg13cmos5l_fill_1
* cell instance sg13cmos5l_fill_1_170 r0 *1 0,0
Xsg13cmos5l_fill_1_170 \$2 \$1 sg13cmos5l_fill_1
* cell instance sg13cmos5l_fill_1_171 r0 *1 0,0
Xsg13cmos5l_fill_1_171 \$2 \$1 sg13cmos5l_fill_1
* cell instance sg13cmos5l_fill_1_172 r0 *1 0,0
Xsg13cmos5l_fill_1_172 \$2 \$1 sg13cmos5l_fill_1
* cell instance sg13cmos5l_fill_1_173 r0 *1 0,0
Xsg13cmos5l_fill_1_173 \$2 \$1 sg13cmos5l_fill_1
* cell instance sg13cmos5l_fill_1_174 r0 *1 0,0
Xsg13cmos5l_fill_1_174 \$2 \$1 sg13cmos5l_fill_1
* cell instance sg13cmos5l_fill_1_175 r0 *1 0,0
Xsg13cmos5l_fill_1_175 \$2 \$1 sg13cmos5l_fill_1
* cell instance sg13cmos5l_fill_1_176 r0 *1 0,0
Xsg13cmos5l_fill_1_176 \$2 \$1 sg13cmos5l_fill_1
* cell instance sg13cmos5l_fill_1_177 r0 *1 0,0
Xsg13cmos5l_fill_1_177 \$2 \$1 sg13cmos5l_fill_1
* cell instance sg13cmos5l_fill_1_178 r0 *1 0,0
Xsg13cmos5l_fill_1_178 \$2 \$1 sg13cmos5l_fill_1
* cell instance sg13cmos5l_fill_1_179 r0 *1 0,0
Xsg13cmos5l_fill_1_179 \$2 \$1 sg13cmos5l_fill_1
* cell instance sg13cmos5l_fill_1_180 r0 *1 0,0
Xsg13cmos5l_fill_1_180 \$2 \$1 sg13cmos5l_fill_1
* cell instance sg13cmos5l_fill_1_181 r0 *1 0,0
Xsg13cmos5l_fill_1_181 \$2 \$1 sg13cmos5l_fill_1
* cell instance sg13cmos5l_fill_1_182 r0 *1 0,0
Xsg13cmos5l_fill_1_182 \$2 \$1 sg13cmos5l_fill_1
* cell instance sg13cmos5l_fill_1_183 r0 *1 0,0
Xsg13cmos5l_fill_1_183 \$2 \$1 sg13cmos5l_fill_1
* cell instance sg13cmos5l_fill_1_184 r0 *1 0,0
Xsg13cmos5l_fill_1_184 \$2 \$1 sg13cmos5l_fill_1
* cell instance sg13cmos5l_fill_1_185 r0 *1 0,0
Xsg13cmos5l_fill_1_185 \$2 \$1 sg13cmos5l_fill_1
* cell instance sg13cmos5l_fill_1_186 r0 *1 0,0
Xsg13cmos5l_fill_1_186 \$2 \$1 sg13cmos5l_fill_1
* cell instance sg13cmos5l_fill_1_187 r0 *1 0,0
Xsg13cmos5l_fill_1_187 \$2 \$1 sg13cmos5l_fill_1
* cell instance sg13cmos5l_fill_1_188 r0 *1 0,0
Xsg13cmos5l_fill_1_188 \$2 \$1 sg13cmos5l_fill_1
* cell instance sg13cmos5l_fill_1_189 r0 *1 0,0
Xsg13cmos5l_fill_1_189 \$2 \$1 sg13cmos5l_fill_1
* cell instance sg13cmos5l_fill_1_190 r0 *1 0,0
Xsg13cmos5l_fill_1_190 \$2 \$1 sg13cmos5l_fill_1
* cell instance sg13cmos5l_fill_1_191 r0 *1 0,0
Xsg13cmos5l_fill_1_191 \$2 \$1 sg13cmos5l_fill_1
* cell instance sg13cmos5l_fill_1_192 r0 *1 0,0
Xsg13cmos5l_fill_1_192 \$2 \$1 sg13cmos5l_fill_1
* cell instance sg13cmos5l_fill_1_193 r0 *1 0,0
Xsg13cmos5l_fill_1_193 \$2 \$1 sg13cmos5l_fill_1
* cell instance sg13cmos5l_fill_1_194 r0 *1 0,0
Xsg13cmos5l_fill_1_194 \$2 \$1 sg13cmos5l_fill_1
* cell instance sg13cmos5l_fill_1_195 r0 *1 0,0
Xsg13cmos5l_fill_1_195 \$2 \$1 sg13cmos5l_fill_1
* cell instance sg13cmos5l_fill_1_196 r0 *1 0,0
Xsg13cmos5l_fill_1_196 \$2 \$1 sg13cmos5l_fill_1
* cell instance sg13cmos5l_fill_1_197 r0 *1 0,0
Xsg13cmos5l_fill_1_197 \$2 \$1 sg13cmos5l_fill_1
* cell instance sg13cmos5l_fill_1_198 r0 *1 0,0
Xsg13cmos5l_fill_1_198 \$2 \$1 sg13cmos5l_fill_1
* cell instance sg13cmos5l_fill_1_199 r0 *1 0,0
Xsg13cmos5l_fill_1_199 \$2 \$1 sg13cmos5l_fill_1
* cell instance sg13cmos5l_fill_1_200 r0 *1 0,0
Xsg13cmos5l_fill_1_200 \$2 \$1 sg13cmos5l_fill_1
* cell instance sg13cmos5l_fill_1_201 r0 *1 0,0
Xsg13cmos5l_fill_1_201 \$2 \$1 sg13cmos5l_fill_1
* cell instance sg13cmos5l_fill_1_202 r0 *1 0,0
Xsg13cmos5l_fill_1_202 \$2 \$1 sg13cmos5l_fill_1
* cell instance sg13cmos5l_fill_1_203 r0 *1 0,0
Xsg13cmos5l_fill_1_203 \$2 \$1 sg13cmos5l_fill_1
* cell instance sg13cmos5l_fill_1_204 r0 *1 0,0
Xsg13cmos5l_fill_1_204 \$2 \$1 sg13cmos5l_fill_1
* cell instance sg13cmos5l_fill_1_205 r0 *1 0,0
Xsg13cmos5l_fill_1_205 \$2 \$1 sg13cmos5l_fill_1
* cell instance sg13cmos5l_fill_1_206 r0 *1 0,0
Xsg13cmos5l_fill_1_206 \$2 \$1 sg13cmos5l_fill_1
* cell instance sg13cmos5l_fill_1_207 r0 *1 0,0
Xsg13cmos5l_fill_1_207 \$2 \$1 sg13cmos5l_fill_1
* cell instance sg13cmos5l_fill_1_208 r0 *1 0,0
Xsg13cmos5l_fill_1_208 \$2 \$1 sg13cmos5l_fill_1
* cell instance sg13cmos5l_fill_1_209 r0 *1 0,0
Xsg13cmos5l_fill_1_209 \$2 \$1 sg13cmos5l_fill_1
* cell instance sg13cmos5l_fill_1_210 r0 *1 0,0
Xsg13cmos5l_fill_1_210 \$2 \$1 sg13cmos5l_fill_1
* cell instance sg13cmos5l_fill_1_211 r0 *1 0,0
Xsg13cmos5l_fill_1_211 \$2 \$1 sg13cmos5l_fill_1
* cell instance sg13cmos5l_fill_1_212 r0 *1 0,0
Xsg13cmos5l_fill_1_212 \$2 \$1 sg13cmos5l_fill_1
* cell instance sg13cmos5l_fill_1_213 r0 *1 0,0
Xsg13cmos5l_fill_1_213 \$2 \$1 sg13cmos5l_fill_1
* cell instance sg13cmos5l_fill_1_214 r0 *1 0,0
Xsg13cmos5l_fill_1_214 \$2 \$1 sg13cmos5l_fill_1
* cell instance sg13cmos5l_fill_1_215 r0 *1 0,0
Xsg13cmos5l_fill_1_215 \$2 \$1 sg13cmos5l_fill_1
* cell instance sg13cmos5l_fill_1_216 r0 *1 0,0
Xsg13cmos5l_fill_1_216 \$2 \$1 sg13cmos5l_fill_1
* cell instance sg13cmos5l_fill_1_217 r0 *1 0,0
Xsg13cmos5l_fill_1_217 \$2 \$1 sg13cmos5l_fill_1
* cell instance sg13cmos5l_fill_1_218 r0 *1 0,0
Xsg13cmos5l_fill_1_218 \$2 \$1 sg13cmos5l_fill_1
* cell instance sg13cmos5l_fill_1_219 r0 *1 0,0
Xsg13cmos5l_fill_1_219 \$2 \$1 sg13cmos5l_fill_1
* cell instance sg13cmos5l_fill_1_220 r0 *1 0,0
Xsg13cmos5l_fill_1_220 \$2 \$1 sg13cmos5l_fill_1
* cell instance sg13cmos5l_fill_2_0 r0 *1 0,0
Xsg13cmos5l_fill_2_0 \$2 \$1 sg13cmos5l_fill_2
* cell instance sg13cmos5l_fill_2_1 r0 *1 0,0
Xsg13cmos5l_fill_2_1 \$2 \$1 sg13cmos5l_fill_2
* cell instance sg13cmos5l_fill_2_2 r0 *1 0,0
Xsg13cmos5l_fill_2_2 \$2 \$1 sg13cmos5l_fill_2
* cell instance sg13cmos5l_fill_2_3 r0 *1 0,0
Xsg13cmos5l_fill_2_3 \$2 \$1 sg13cmos5l_fill_2
* cell instance sg13cmos5l_fill_2_4 r0 *1 0,0
Xsg13cmos5l_fill_2_4 \$2 \$1 sg13cmos5l_fill_2
* cell instance sg13cmos5l_fill_2_5 r0 *1 0,0
Xsg13cmos5l_fill_2_5 \$2 \$1 sg13cmos5l_fill_2
* cell instance sg13cmos5l_fill_2_6 r0 *1 0,0
Xsg13cmos5l_fill_2_6 \$2 \$1 sg13cmos5l_fill_2
* cell instance sg13cmos5l_fill_2_7 r0 *1 0,0
Xsg13cmos5l_fill_2_7 \$2 \$1 sg13cmos5l_fill_2
* cell instance sg13cmos5l_fill_2_8 r0 *1 0,0
Xsg13cmos5l_fill_2_8 \$2 \$1 sg13cmos5l_fill_2
* cell instance sg13cmos5l_fill_2_9 r0 *1 0,0
Xsg13cmos5l_fill_2_9 \$2 \$1 sg13cmos5l_fill_2
* cell instance sg13cmos5l_fill_2_10 r0 *1 0,0
Xsg13cmos5l_fill_2_10 \$2 \$1 sg13cmos5l_fill_2
* cell instance sg13cmos5l_fill_2_11 r0 *1 0,0
Xsg13cmos5l_fill_2_11 \$2 \$1 sg13cmos5l_fill_2
* cell instance sg13cmos5l_fill_2_12 r0 *1 0,0
Xsg13cmos5l_fill_2_12 \$2 \$1 sg13cmos5l_fill_2
* cell instance sg13cmos5l_fill_2_13 r0 *1 0,0
Xsg13cmos5l_fill_2_13 \$2 \$1 sg13cmos5l_fill_2
* cell instance sg13cmos5l_fill_2_14 r0 *1 0,0
Xsg13cmos5l_fill_2_14 \$2 \$1 sg13cmos5l_fill_2
* cell instance sg13cmos5l_fill_2_15 r0 *1 0,0
Xsg13cmos5l_fill_2_15 \$2 \$1 sg13cmos5l_fill_2
* cell instance sg13cmos5l_fill_2_16 r0 *1 0,0
Xsg13cmos5l_fill_2_16 \$2 \$1 sg13cmos5l_fill_2
* cell instance sg13cmos5l_fill_2_17 r0 *1 0,0
Xsg13cmos5l_fill_2_17 \$2 \$1 sg13cmos5l_fill_2
* cell instance sg13cmos5l_fill_2_18 r0 *1 0,0
Xsg13cmos5l_fill_2_18 \$2 \$1 sg13cmos5l_fill_2
* cell instance sg13cmos5l_fill_2_19 r0 *1 0,0
Xsg13cmos5l_fill_2_19 \$2 \$1 sg13cmos5l_fill_2
* cell instance sg13cmos5l_fill_2_20 r0 *1 0,0
Xsg13cmos5l_fill_2_20 \$2 \$1 sg13cmos5l_fill_2
* cell instance sg13cmos5l_fill_2_21 r0 *1 0,0
Xsg13cmos5l_fill_2_21 \$2 \$1 sg13cmos5l_fill_2
* cell instance sg13cmos5l_fill_2_22 r0 *1 0,0
Xsg13cmos5l_fill_2_22 \$2 \$1 sg13cmos5l_fill_2
* cell instance sg13cmos5l_fill_2_23 r0 *1 0,0
Xsg13cmos5l_fill_2_23 \$2 \$1 sg13cmos5l_fill_2
* cell instance sg13cmos5l_fill_2_24 r0 *1 0,0
Xsg13cmos5l_fill_2_24 \$2 \$1 sg13cmos5l_fill_2
* cell instance sg13cmos5l_fill_2_25 r0 *1 0,0
Xsg13cmos5l_fill_2_25 \$2 \$1 sg13cmos5l_fill_2
* cell instance sg13cmos5l_fill_2_26 r0 *1 0,0
Xsg13cmos5l_fill_2_26 \$2 \$1 sg13cmos5l_fill_2
* cell instance sg13cmos5l_fill_2_27 r0 *1 0,0
Xsg13cmos5l_fill_2_27 \$2 \$1 sg13cmos5l_fill_2
* cell instance sg13cmos5l_fill_2_28 r0 *1 0,0
Xsg13cmos5l_fill_2_28 \$2 \$1 sg13cmos5l_fill_2
* cell instance sg13cmos5l_fill_2_29 r0 *1 0,0
Xsg13cmos5l_fill_2_29 \$2 \$1 sg13cmos5l_fill_2
* cell instance sg13cmos5l_fill_2_30 r0 *1 0,0
Xsg13cmos5l_fill_2_30 \$2 \$1 sg13cmos5l_fill_2
* cell instance sg13cmos5l_fill_2_31 r0 *1 0,0
Xsg13cmos5l_fill_2_31 \$2 \$1 sg13cmos5l_fill_2
* cell instance sg13cmos5l_fill_2_32 r0 *1 0,0
Xsg13cmos5l_fill_2_32 \$2 \$1 sg13cmos5l_fill_2
* cell instance sg13cmos5l_fill_2_33 r0 *1 0,0
Xsg13cmos5l_fill_2_33 \$2 \$1 sg13cmos5l_fill_2
* cell instance sg13cmos5l_fill_2_34 r0 *1 0,0
Xsg13cmos5l_fill_2_34 \$2 \$1 sg13cmos5l_fill_2
* cell instance sg13cmos5l_fill_2_35 r0 *1 0,0
Xsg13cmos5l_fill_2_35 \$2 \$1 sg13cmos5l_fill_2
* cell instance sg13cmos5l_fill_2_36 r0 *1 0,0
Xsg13cmos5l_fill_2_36 \$2 \$1 sg13cmos5l_fill_2
* cell instance sg13cmos5l_fill_2_37 r0 *1 0,0
Xsg13cmos5l_fill_2_37 \$2 \$1 sg13cmos5l_fill_2
* cell instance sg13cmos5l_fill_2_38 r0 *1 0,0
Xsg13cmos5l_fill_2_38 \$2 \$1 sg13cmos5l_fill_2
* cell instance sg13cmos5l_fill_2_39 r0 *1 0,0
Xsg13cmos5l_fill_2_39 \$2 \$1 sg13cmos5l_fill_2
* cell instance sg13cmos5l_fill_2_40 r0 *1 0,0
Xsg13cmos5l_fill_2_40 \$2 \$1 sg13cmos5l_fill_2
* cell instance sg13cmos5l_fill_2_41 r0 *1 0,0
Xsg13cmos5l_fill_2_41 \$2 \$1 sg13cmos5l_fill_2
* cell instance sg13cmos5l_fill_2_42 r0 *1 0,0
Xsg13cmos5l_fill_2_42 \$2 \$1 sg13cmos5l_fill_2
* cell instance sg13cmos5l_fill_2_43 r0 *1 0,0
Xsg13cmos5l_fill_2_43 \$2 \$1 sg13cmos5l_fill_2
* cell instance sg13cmos5l_fill_2_44 r0 *1 0,0
Xsg13cmos5l_fill_2_44 \$2 \$1 sg13cmos5l_fill_2
* cell instance sg13cmos5l_fill_2_45 r0 *1 0,0
Xsg13cmos5l_fill_2_45 \$2 \$1 sg13cmos5l_fill_2
* cell instance sg13cmos5l_fill_2_46 r0 *1 0,0
Xsg13cmos5l_fill_2_46 \$2 \$1 sg13cmos5l_fill_2
* cell instance sg13cmos5l_fill_2_47 r0 *1 0,0
Xsg13cmos5l_fill_2_47 \$2 \$1 sg13cmos5l_fill_2
* cell instance sg13cmos5l_fill_2_48 r0 *1 0,0
Xsg13cmos5l_fill_2_48 \$2 \$1 sg13cmos5l_fill_2
* cell instance sg13cmos5l_fill_2_49 r0 *1 0,0
Xsg13cmos5l_fill_2_49 \$2 \$1 sg13cmos5l_fill_2
* cell instance sg13cmos5l_fill_2_50 r0 *1 0,0
Xsg13cmos5l_fill_2_50 \$2 \$1 sg13cmos5l_fill_2
* cell instance sg13cmos5l_fill_2_51 r0 *1 0,0
Xsg13cmos5l_fill_2_51 \$2 \$1 sg13cmos5l_fill_2
* cell instance sg13cmos5l_fill_2_52 r0 *1 0,0
Xsg13cmos5l_fill_2_52 \$2 \$1 sg13cmos5l_fill_2
* cell instance sg13cmos5l_fill_2_53 r0 *1 0,0
Xsg13cmos5l_fill_2_53 \$2 \$1 sg13cmos5l_fill_2
* cell instance sg13cmos5l_fill_2_54 r0 *1 0,0
Xsg13cmos5l_fill_2_54 \$2 \$1 sg13cmos5l_fill_2
* cell instance sg13cmos5l_fill_2_55 r0 *1 0,0
Xsg13cmos5l_fill_2_55 \$2 \$1 sg13cmos5l_fill_2
* cell instance sg13cmos5l_fill_2_56 r0 *1 0,0
Xsg13cmos5l_fill_2_56 \$2 \$1 sg13cmos5l_fill_2
* cell instance sg13cmos5l_fill_2_57 r0 *1 0,0
Xsg13cmos5l_fill_2_57 \$2 \$1 sg13cmos5l_fill_2
* cell instance sg13cmos5l_fill_2_58 r0 *1 0,0
Xsg13cmos5l_fill_2_58 \$2 \$1 sg13cmos5l_fill_2
* cell instance sg13cmos5l_fill_2_59 r0 *1 0,0
Xsg13cmos5l_fill_2_59 \$2 \$1 sg13cmos5l_fill_2
* cell instance sg13cmos5l_fill_2_60 r0 *1 0,0
Xsg13cmos5l_fill_2_60 \$2 \$1 sg13cmos5l_fill_2
* cell instance sg13cmos5l_fill_2_61 r0 *1 0,0
Xsg13cmos5l_fill_2_61 \$2 \$1 sg13cmos5l_fill_2
* cell instance sg13cmos5l_fill_2_62 r0 *1 0,0
Xsg13cmos5l_fill_2_62 \$2 \$1 sg13cmos5l_fill_2
* cell instance sg13cmos5l_fill_2_63 r0 *1 0,0
Xsg13cmos5l_fill_2_63 \$2 \$1 sg13cmos5l_fill_2
* cell instance sg13cmos5l_fill_2_64 r0 *1 0,0
Xsg13cmos5l_fill_2_64 \$2 \$1 sg13cmos5l_fill_2
* cell instance sg13cmos5l_fill_2_65 r0 *1 0,0
Xsg13cmos5l_fill_2_65 \$2 \$1 sg13cmos5l_fill_2
* cell instance sg13cmos5l_fill_2_66 r0 *1 0,0
Xsg13cmos5l_fill_2_66 \$2 \$1 sg13cmos5l_fill_2
* cell instance sg13cmos5l_fill_2_67 r0 *1 0,0
Xsg13cmos5l_fill_2_67 \$2 \$1 sg13cmos5l_fill_2
* cell instance sg13cmos5l_fill_2_68 r0 *1 0,0
Xsg13cmos5l_fill_2_68 \$2 \$1 sg13cmos5l_fill_2
* cell instance sg13cmos5l_fill_2_69 r0 *1 0,0
Xsg13cmos5l_fill_2_69 \$2 \$1 sg13cmos5l_fill_2
* cell instance sg13cmos5l_fill_2_70 r0 *1 0,0
Xsg13cmos5l_fill_2_70 \$2 \$1 sg13cmos5l_fill_2
* cell instance sg13cmos5l_fill_2_71 r0 *1 0,0
Xsg13cmos5l_fill_2_71 \$2 \$1 sg13cmos5l_fill_2
* cell instance sg13cmos5l_fill_2_72 r0 *1 0,0
Xsg13cmos5l_fill_2_72 \$2 \$1 sg13cmos5l_fill_2
* cell instance sg13cmos5l_fill_2_73 r0 *1 0,0
Xsg13cmos5l_fill_2_73 \$2 \$1 sg13cmos5l_fill_2
* cell instance sg13cmos5l_fill_2_74 r0 *1 0,0
Xsg13cmos5l_fill_2_74 \$2 \$1 sg13cmos5l_fill_2
* cell instance sg13cmos5l_fill_2_75 r0 *1 0,0
Xsg13cmos5l_fill_2_75 \$2 \$1 sg13cmos5l_fill_2
* cell instance sg13cmos5l_fill_2_76 r0 *1 0,0
Xsg13cmos5l_fill_2_76 \$2 \$1 sg13cmos5l_fill_2
* cell instance sg13cmos5l_fill_2_77 r0 *1 0,0
Xsg13cmos5l_fill_2_77 \$2 \$1 sg13cmos5l_fill_2
* cell instance sg13cmos5l_fill_2_78 r0 *1 0,0
Xsg13cmos5l_fill_2_78 \$2 \$1 sg13cmos5l_fill_2
* cell instance sg13cmos5l_fill_2_79 r0 *1 0,0
Xsg13cmos5l_fill_2_79 \$2 \$1 sg13cmos5l_fill_2
* cell instance sg13cmos5l_fill_2_80 r0 *1 0,0
Xsg13cmos5l_fill_2_80 \$2 \$1 sg13cmos5l_fill_2
* cell instance sg13cmos5l_fill_2_81 r0 *1 0,0
Xsg13cmos5l_fill_2_81 \$2 \$1 sg13cmos5l_fill_2
* cell instance sg13cmos5l_fill_2_82 r0 *1 0,0
Xsg13cmos5l_fill_2_82 \$2 \$1 sg13cmos5l_fill_2
* cell instance sg13cmos5l_fill_2_83 r0 *1 0,0
Xsg13cmos5l_fill_2_83 \$2 \$1 sg13cmos5l_fill_2
* cell instance sg13cmos5l_fill_2_84 r0 *1 0,0
Xsg13cmos5l_fill_2_84 \$2 \$1 sg13cmos5l_fill_2
* cell instance sg13cmos5l_fill_2_85 r0 *1 0,0
Xsg13cmos5l_fill_2_85 \$2 \$1 sg13cmos5l_fill_2
* cell instance sg13cmos5l_fill_2_86 r0 *1 0,0
Xsg13cmos5l_fill_2_86 \$2 \$1 sg13cmos5l_fill_2
* cell instance sg13cmos5l_fill_2_87 r0 *1 0,0
Xsg13cmos5l_fill_2_87 \$2 \$1 sg13cmos5l_fill_2
* cell instance sg13cmos5l_fill_2_88 r0 *1 0,0
Xsg13cmos5l_fill_2_88 \$2 \$1 sg13cmos5l_fill_2
* cell instance sg13cmos5l_fill_2_89 r0 *1 0,0
Xsg13cmos5l_fill_2_89 \$2 \$1 sg13cmos5l_fill_2
* cell instance sg13cmos5l_fill_2_90 r0 *1 0,0
Xsg13cmos5l_fill_2_90 \$2 \$1 sg13cmos5l_fill_2
* cell instance sg13cmos5l_fill_2_91 r0 *1 0,0
Xsg13cmos5l_fill_2_91 \$2 \$1 sg13cmos5l_fill_2
* cell instance sg13cmos5l_fill_2_92 r0 *1 0,0
Xsg13cmos5l_fill_2_92 \$2 \$1 sg13cmos5l_fill_2
* cell instance sg13cmos5l_fill_2_93 r0 *1 0,0
Xsg13cmos5l_fill_2_93 \$2 \$1 sg13cmos5l_fill_2
* cell instance sg13cmos5l_fill_2_94 r0 *1 0,0
Xsg13cmos5l_fill_2_94 \$2 \$1 sg13cmos5l_fill_2
* cell instance sg13cmos5l_fill_2_95 r0 *1 0,0
Xsg13cmos5l_fill_2_95 \$2 \$1 sg13cmos5l_fill_2
* cell instance sg13cmos5l_fill_2_96 r0 *1 0,0
Xsg13cmos5l_fill_2_96 \$2 \$1 sg13cmos5l_fill_2
* cell instance sg13cmos5l_fill_2_97 r0 *1 0,0
Xsg13cmos5l_fill_2_97 \$2 \$1 sg13cmos5l_fill_2
* cell instance sg13cmos5l_fill_2_98 r0 *1 0,0
Xsg13cmos5l_fill_2_98 \$2 \$1 sg13cmos5l_fill_2
* cell instance sg13cmos5l_fill_2_99 r0 *1 0,0
Xsg13cmos5l_fill_2_99 \$2 \$1 sg13cmos5l_fill_2
* cell instance sg13cmos5l_fill_2_100 r0 *1 0,0
Xsg13cmos5l_fill_2_100 \$2 \$1 sg13cmos5l_fill_2
* cell instance sg13cmos5l_fill_2_101 r0 *1 0,0
Xsg13cmos5l_fill_2_101 \$2 \$1 sg13cmos5l_fill_2
* cell instance sg13cmos5l_fill_2_102 r0 *1 0,0
Xsg13cmos5l_fill_2_102 \$2 \$1 sg13cmos5l_fill_2
* cell instance sg13cmos5l_fill_2_103 r0 *1 0,0
Xsg13cmos5l_fill_2_103 \$2 \$1 sg13cmos5l_fill_2
* cell instance sg13cmos5l_fill_2_104 r0 *1 0,0
Xsg13cmos5l_fill_2_104 \$2 \$1 sg13cmos5l_fill_2
* cell instance sg13cmos5l_fill_2_105 r0 *1 0,0
Xsg13cmos5l_fill_2_105 \$2 \$1 sg13cmos5l_fill_2
* cell instance sg13cmos5l_fill_2_106 r0 *1 0,0
Xsg13cmos5l_fill_2_106 \$2 \$1 sg13cmos5l_fill_2
* cell instance sg13cmos5l_fill_2_107 r0 *1 0,0
Xsg13cmos5l_fill_2_107 \$2 \$1 sg13cmos5l_fill_2
* cell instance sg13cmos5l_fill_2_108 r0 *1 0,0
Xsg13cmos5l_fill_2_108 \$2 \$1 sg13cmos5l_fill_2
* cell instance sg13cmos5l_fill_2_109 r0 *1 0,0
Xsg13cmos5l_fill_2_109 \$2 \$1 sg13cmos5l_fill_2
* cell instance sg13cmos5l_fill_2_110 r0 *1 0,0
Xsg13cmos5l_fill_2_110 \$2 \$1 sg13cmos5l_fill_2
* cell instance sg13cmos5l_fill_2_111 r0 *1 0,0
Xsg13cmos5l_fill_2_111 \$2 \$1 sg13cmos5l_fill_2
* cell instance sg13cmos5l_fill_2_112 r0 *1 0,0
Xsg13cmos5l_fill_2_112 \$2 \$1 sg13cmos5l_fill_2
* cell instance sg13cmos5l_fill_2_113 r0 *1 0,0
Xsg13cmos5l_fill_2_113 \$2 \$1 sg13cmos5l_fill_2
* cell instance sg13cmos5l_fill_2_114 r0 *1 0,0
Xsg13cmos5l_fill_2_114 \$2 \$1 sg13cmos5l_fill_2
* cell instance sg13cmos5l_fill_2_115 r0 *1 0,0
Xsg13cmos5l_fill_2_115 \$2 \$1 sg13cmos5l_fill_2
* cell instance sg13cmos5l_fill_2_116 r0 *1 0,0
Xsg13cmos5l_fill_2_116 \$2 \$1 sg13cmos5l_fill_2
* cell instance sg13cmos5l_fill_2_117 r0 *1 0,0
Xsg13cmos5l_fill_2_117 \$2 \$1 sg13cmos5l_fill_2
* cell instance sg13cmos5l_fill_2_118 r0 *1 0,0
Xsg13cmos5l_fill_2_118 \$2 \$1 sg13cmos5l_fill_2
* cell instance sg13cmos5l_fill_2_119 r0 *1 0,0
Xsg13cmos5l_fill_2_119 \$2 \$1 sg13cmos5l_fill_2
* cell instance sg13cmos5l_fill_2_120 r0 *1 0,0
Xsg13cmos5l_fill_2_120 \$2 \$1 sg13cmos5l_fill_2
* cell instance sg13cmos5l_fill_2_121 r0 *1 0,0
Xsg13cmos5l_fill_2_121 \$2 \$1 sg13cmos5l_fill_2
* cell instance sg13cmos5l_fill_2_122 r0 *1 0,0
Xsg13cmos5l_fill_2_122 \$2 \$1 sg13cmos5l_fill_2
* cell instance sg13cmos5l_fill_2_123 r0 *1 0,0
Xsg13cmos5l_fill_2_123 \$2 \$1 sg13cmos5l_fill_2
* cell instance sg13cmos5l_fill_2_124 r0 *1 0,0
Xsg13cmos5l_fill_2_124 \$2 \$1 sg13cmos5l_fill_2
* cell instance sg13cmos5l_fill_2_125 r0 *1 0,0
Xsg13cmos5l_fill_2_125 \$2 \$1 sg13cmos5l_fill_2
* cell instance sg13cmos5l_fill_2_126 r0 *1 0,0
Xsg13cmos5l_fill_2_126 \$2 \$1 sg13cmos5l_fill_2
* cell instance sg13cmos5l_fill_2_127 r0 *1 0,0
Xsg13cmos5l_fill_2_127 \$2 \$1 sg13cmos5l_fill_2
* cell instance sg13cmos5l_fill_2_128 r0 *1 0,0
Xsg13cmos5l_fill_2_128 \$2 \$1 sg13cmos5l_fill_2
* cell instance sg13cmos5l_fill_2_129 r0 *1 0,0
Xsg13cmos5l_fill_2_129 \$2 \$1 sg13cmos5l_fill_2
* cell instance sg13cmos5l_fill_2_130 r0 *1 0,0
Xsg13cmos5l_fill_2_130 \$2 \$1 sg13cmos5l_fill_2
* cell instance sg13cmos5l_fill_2_131 r0 *1 0,0
Xsg13cmos5l_fill_2_131 \$2 \$1 sg13cmos5l_fill_2
* cell instance sg13cmos5l_fill_2_132 r0 *1 0,0
Xsg13cmos5l_fill_2_132 \$2 \$1 sg13cmos5l_fill_2
* cell instance sg13cmos5l_fill_2_133 r0 *1 0,0
Xsg13cmos5l_fill_2_133 \$2 \$1 sg13cmos5l_fill_2
* cell instance sg13cmos5l_fill_2_134 r0 *1 0,0
Xsg13cmos5l_fill_2_134 \$2 \$1 sg13cmos5l_fill_2
* cell instance sg13cmos5l_fill_2_135 r0 *1 0,0
Xsg13cmos5l_fill_2_135 \$2 \$1 sg13cmos5l_fill_2
* cell instance sg13cmos5l_fill_2_136 r0 *1 0,0
Xsg13cmos5l_fill_2_136 \$2 \$1 sg13cmos5l_fill_2
* cell instance sg13cmos5l_fill_2_137 r0 *1 0,0
Xsg13cmos5l_fill_2_137 \$2 \$1 sg13cmos5l_fill_2
* cell instance sg13cmos5l_fill_2_138 r0 *1 0,0
Xsg13cmos5l_fill_2_138 \$2 \$1 sg13cmos5l_fill_2
* cell instance sg13cmos5l_fill_2_139 r0 *1 0,0
Xsg13cmos5l_fill_2_139 \$2 \$1 sg13cmos5l_fill_2
* cell instance sg13cmos5l_fill_2_140 r0 *1 0,0
Xsg13cmos5l_fill_2_140 \$2 \$1 sg13cmos5l_fill_2
* cell instance sg13cmos5l_fill_2_141 r0 *1 0,0
Xsg13cmos5l_fill_2_141 \$2 \$1 sg13cmos5l_fill_2
* cell instance sg13cmos5l_fill_2_142 r0 *1 0,0
Xsg13cmos5l_fill_2_142 \$2 \$1 sg13cmos5l_fill_2
* cell instance sg13cmos5l_fill_2_143 r0 *1 0,0
Xsg13cmos5l_fill_2_143 \$2 \$1 sg13cmos5l_fill_2
* cell instance sg13cmos5l_fill_2_144 r0 *1 0,0
Xsg13cmos5l_fill_2_144 \$2 \$1 sg13cmos5l_fill_2
* cell instance sg13cmos5l_fill_2_145 r0 *1 0,0
Xsg13cmos5l_fill_2_145 \$2 \$1 sg13cmos5l_fill_2
* cell instance sg13cmos5l_fill_2_146 r0 *1 0,0
Xsg13cmos5l_fill_2_146 \$2 \$1 sg13cmos5l_fill_2
* cell instance sg13cmos5l_fill_2_147 r0 *1 0,0
Xsg13cmos5l_fill_2_147 \$2 \$1 sg13cmos5l_fill_2
* cell instance sg13cmos5l_fill_2_148 r0 *1 0,0
Xsg13cmos5l_fill_2_148 \$2 \$1 sg13cmos5l_fill_2
* cell instance sg13cmos5l_fill_2_149 r0 *1 0,0
Xsg13cmos5l_fill_2_149 \$2 \$1 sg13cmos5l_fill_2
* cell instance sg13cmos5l_fill_2_150 r0 *1 0,0
Xsg13cmos5l_fill_2_150 \$2 \$1 sg13cmos5l_fill_2
* cell instance sg13cmos5l_fill_2_151 r0 *1 0,0
Xsg13cmos5l_fill_2_151 \$2 \$1 sg13cmos5l_fill_2
* cell instance sg13cmos5l_fill_2_152 r0 *1 0,0
Xsg13cmos5l_fill_2_152 \$2 \$1 sg13cmos5l_fill_2
* cell instance sg13cmos5l_fill_2_153 r0 *1 0,0
Xsg13cmos5l_fill_2_153 \$2 \$1 sg13cmos5l_fill_2
* cell instance sg13cmos5l_fill_2_154 r0 *1 0,0
Xsg13cmos5l_fill_2_154 \$2 \$1 sg13cmos5l_fill_2
* cell instance sg13cmos5l_fill_2_155 r0 *1 0,0
Xsg13cmos5l_fill_2_155 \$2 \$1 sg13cmos5l_fill_2
* cell instance sg13cmos5l_fill_2_156 r0 *1 0,0
Xsg13cmos5l_fill_2_156 \$2 \$1 sg13cmos5l_fill_2
* cell instance sg13cmos5l_fill_2_157 r0 *1 0,0
Xsg13cmos5l_fill_2_157 \$2 \$1 sg13cmos5l_fill_2
* cell instance sg13cmos5l_fill_2_158 r0 *1 0,0
Xsg13cmos5l_fill_2_158 \$2 \$1 sg13cmos5l_fill_2
* cell instance sg13cmos5l_fill_2_159 r0 *1 0,0
Xsg13cmos5l_fill_2_159 \$2 \$1 sg13cmos5l_fill_2
* cell instance sg13cmos5l_fill_2_160 r0 *1 0,0
Xsg13cmos5l_fill_2_160 \$2 \$1 sg13cmos5l_fill_2
* cell instance sg13cmos5l_fill_2_161 r0 *1 0,0
Xsg13cmos5l_fill_2_161 \$2 \$1 sg13cmos5l_fill_2
* cell instance sg13cmos5l_fill_2_162 r0 *1 0,0
Xsg13cmos5l_fill_2_162 \$2 \$1 sg13cmos5l_fill_2
* cell instance sg13cmos5l_fill_2_163 r0 *1 0,0
Xsg13cmos5l_fill_2_163 \$2 \$1 sg13cmos5l_fill_2
* cell instance sg13cmos5l_fill_2_164 r0 *1 0,0
Xsg13cmos5l_fill_2_164 \$2 \$1 sg13cmos5l_fill_2
* cell instance sg13cmos5l_fill_2_165 r0 *1 0,0
Xsg13cmos5l_fill_2_165 \$2 \$1 sg13cmos5l_fill_2
* cell instance sg13cmos5l_fill_2_166 r0 *1 0,0
Xsg13cmos5l_fill_2_166 \$2 \$1 sg13cmos5l_fill_2
* cell instance sg13cmos5l_fill_2_167 r0 *1 0,0
Xsg13cmos5l_fill_2_167 \$2 \$1 sg13cmos5l_fill_2
* cell instance sg13cmos5l_fill_2_168 r0 *1 0,0
Xsg13cmos5l_fill_2_168 \$2 \$1 sg13cmos5l_fill_2
* cell instance sg13cmos5l_fill_2_169 r0 *1 0,0
Xsg13cmos5l_fill_2_169 \$2 \$1 sg13cmos5l_fill_2
* cell instance sg13cmos5l_fill_2_170 r0 *1 0,0
Xsg13cmos5l_fill_2_170 \$2 \$1 sg13cmos5l_fill_2
* cell instance sg13cmos5l_fill_2_171 r0 *1 0,0
Xsg13cmos5l_fill_2_171 \$2 \$1 sg13cmos5l_fill_2
* cell instance sg13cmos5l_fill_2_172 r0 *1 0,0
Xsg13cmos5l_fill_2_172 \$2 \$1 sg13cmos5l_fill_2
* cell instance sg13cmos5l_fill_2_173 r0 *1 0,0
Xsg13cmos5l_fill_2_173 \$2 \$1 sg13cmos5l_fill_2
* cell instance sg13cmos5l_fill_2_174 r0 *1 0,0
Xsg13cmos5l_fill_2_174 \$2 \$1 sg13cmos5l_fill_2
* cell instance sg13cmos5l_fill_2_175 r0 *1 0,0
Xsg13cmos5l_fill_2_175 \$2 \$1 sg13cmos5l_fill_2
* cell instance sg13cmos5l_fill_2_176 r0 *1 0,0
Xsg13cmos5l_fill_2_176 \$2 \$1 sg13cmos5l_fill_2
* cell instance sg13cmos5l_fill_2_177 r0 *1 0,0
Xsg13cmos5l_fill_2_177 \$2 \$1 sg13cmos5l_fill_2
* cell instance sg13cmos5l_fill_2_178 r0 *1 0,0
Xsg13cmos5l_fill_2_178 \$2 \$1 sg13cmos5l_fill_2
* cell instance sg13cmos5l_fill_2_179 r0 *1 0,0
Xsg13cmos5l_fill_2_179 \$2 \$1 sg13cmos5l_fill_2
* cell instance sg13cmos5l_fill_2_180 r0 *1 0,0
Xsg13cmos5l_fill_2_180 \$2 \$1 sg13cmos5l_fill_2
* cell instance sg13cmos5l_fill_2_181 r0 *1 0,0
Xsg13cmos5l_fill_2_181 \$2 \$1 sg13cmos5l_fill_2
* cell instance sg13cmos5l_fill_2_182 r0 *1 0,0
Xsg13cmos5l_fill_2_182 \$2 \$1 sg13cmos5l_fill_2
* cell instance sg13cmos5l_fill_2_183 r0 *1 0,0
Xsg13cmos5l_fill_2_183 \$2 \$1 sg13cmos5l_fill_2
* cell instance sg13cmos5l_fill_2_184 r0 *1 0,0
Xsg13cmos5l_fill_2_184 \$2 \$1 sg13cmos5l_fill_2
* cell instance sg13cmos5l_fill_2_185 r0 *1 0,0
Xsg13cmos5l_fill_2_185 \$2 \$1 sg13cmos5l_fill_2
* cell instance sg13cmos5l_fill_2_186 r0 *1 0,0
Xsg13cmos5l_fill_2_186 \$2 \$1 sg13cmos5l_fill_2
* cell instance sg13cmos5l_fill_2_187 r0 *1 0,0
Xsg13cmos5l_fill_2_187 \$2 \$1 sg13cmos5l_fill_2
* cell instance sg13cmos5l_fill_2_188 r0 *1 0,0
Xsg13cmos5l_fill_2_188 \$2 \$1 sg13cmos5l_fill_2
* cell instance sg13cmos5l_fill_2_189 r0 *1 0,0
Xsg13cmos5l_fill_2_189 \$2 \$1 sg13cmos5l_fill_2
* cell instance sg13cmos5l_fill_2_190 r0 *1 0,0
Xsg13cmos5l_fill_2_190 \$2 \$1 sg13cmos5l_fill_2
* cell instance sg13cmos5l_fill_2_191 r0 *1 0,0
Xsg13cmos5l_fill_2_191 \$2 \$1 sg13cmos5l_fill_2
* cell instance sg13cmos5l_fill_2_192 r0 *1 0,0
Xsg13cmos5l_fill_2_192 \$2 \$1 sg13cmos5l_fill_2
* cell instance sg13cmos5l_fill_2_193 r0 *1 0,0
Xsg13cmos5l_fill_2_193 \$2 \$1 sg13cmos5l_fill_2
* cell instance sg13cmos5l_fill_2_194 r0 *1 0,0
Xsg13cmos5l_fill_2_194 \$2 \$1 sg13cmos5l_fill_2
* cell instance sg13cmos5l_fill_2_195 r0 *1 0,0
Xsg13cmos5l_fill_2_195 \$2 \$1 sg13cmos5l_fill_2
* cell instance sg13cmos5l_fill_2_196 r0 *1 0,0
Xsg13cmos5l_fill_2_196 \$2 \$1 sg13cmos5l_fill_2
* cell instance sg13cmos5l_fill_2_197 r0 *1 0,0
Xsg13cmos5l_fill_2_197 \$2 \$1 sg13cmos5l_fill_2
* cell instance sg13cmos5l_fill_2_198 r0 *1 0,0
Xsg13cmos5l_fill_2_198 \$2 \$1 sg13cmos5l_fill_2
* cell instance sg13cmos5l_fill_2_199 r0 *1 0,0
Xsg13cmos5l_fill_2_199 \$2 \$1 sg13cmos5l_fill_2
* cell instance sg13cmos5l_fill_2_200 r0 *1 0,0
Xsg13cmos5l_fill_2_200 \$2 \$1 sg13cmos5l_fill_2
* cell instance sg13cmos5l_fill_2_201 r0 *1 0,0
Xsg13cmos5l_fill_2_201 \$2 \$1 sg13cmos5l_fill_2
* cell instance sg13cmos5l_fill_2_202 r0 *1 0,0
Xsg13cmos5l_fill_2_202 \$2 \$1 sg13cmos5l_fill_2
* cell instance sg13cmos5l_fill_2_203 r0 *1 0,0
Xsg13cmos5l_fill_2_203 \$2 \$1 sg13cmos5l_fill_2
* cell instance sg13cmos5l_fill_2_204 r0 *1 0,0
Xsg13cmos5l_fill_2_204 \$2 \$1 sg13cmos5l_fill_2
* cell instance sg13cmos5l_fill_2_205 r0 *1 0,0
Xsg13cmos5l_fill_2_205 \$2 \$1 sg13cmos5l_fill_2
* cell instance sg13cmos5l_fill_2_206 r0 *1 0,0
Xsg13cmos5l_fill_2_206 \$2 \$1 sg13cmos5l_fill_2
* cell instance sg13cmos5l_fill_2_207 r0 *1 0,0
Xsg13cmos5l_fill_2_207 \$2 \$1 sg13cmos5l_fill_2
* cell instance sg13cmos5l_inv_1_0 r0 *1 0,0
Xsg13cmos5l_inv_1_0 \$4612 \$2 \$1 \$4613 sg13cmos5l_inv_1
* cell instance sg13cmos5l_inv_1_1 r0 *1 0,0
Xsg13cmos5l_inv_1_1 \$1860 \$2 \$1 \$3514 sg13cmos5l_inv_1
* cell instance sg13cmos5l_inv_1_2 r0 *1 0,0
Xsg13cmos5l_inv_1_2 \$845 \$2 \$1 \$846 sg13cmos5l_inv_1
* cell instance sg13cmos5l_inv_1_3 r0 *1 0,0
Xsg13cmos5l_inv_1_3 \$2208 \$2 \$1 \$2723 sg13cmos5l_inv_1
* cell instance sg13cmos5l_inv_1_4 r0 *1 0,0
Xsg13cmos5l_inv_1_4 \$2271 \$2 \$1 \$2426 sg13cmos5l_inv_1
* cell instance sg13cmos5l_inv_1_5 r0 *1 0,0
Xsg13cmos5l_inv_1_5 \$2210 \$2 \$1 \$4018 sg13cmos5l_inv_1
* cell instance sg13cmos5l_inv_1_6 r0 *1 0,0
Xsg13cmos5l_inv_1_6 \$5141 \$2 \$1 \$4236 sg13cmos5l_inv_1
* cell instance sg13cmos5l_inv_1_7 r0 *1 0,0
Xsg13cmos5l_inv_1_7 \$4081 \$2 \$1 \$7272 sg13cmos5l_inv_1
* cell instance sg13cmos5l_inv_1_8 r0 *1 0,0
Xsg13cmos5l_inv_1_8 \$4616 \$2 \$1 \$4614 sg13cmos5l_inv_1
* cell instance sg13cmos5l_inv_1_9 r0 *1 0,0
Xsg13cmos5l_inv_1_9 \$1562 \$2 \$1 \$1092 sg13cmos5l_inv_1
* cell instance sg13cmos5l_inv_1_10 r0 *1 0,0
Xsg13cmos5l_inv_1_10 \$1563 \$2 \$1 \$1544 sg13cmos5l_inv_1
* cell instance sg13cmos5l_inv_1_11 r0 *1 0,0
Xsg13cmos5l_inv_1_11 \$392 \$2 \$1 \$1863 sg13cmos5l_inv_1
* cell instance sg13cmos5l_inv_1_12 r0 *1 0,0
Xsg13cmos5l_inv_1_12 \$860 \$2 \$1 \$2274 sg13cmos5l_inv_1
* cell instance sg13cmos5l_inv_1_13 r0 *1 0,0
Xsg13cmos5l_inv_1_13 \$1864 \$2 \$1 \$1564 sg13cmos5l_inv_1
* cell instance sg13cmos5l_inv_1_14 r0 *1 0,0
Xsg13cmos5l_inv_1_14 \$6581 \$2 \$1 \$7630 sg13cmos5l_inv_1
* cell instance sg13cmos5l_inv_1_15 r0 *1 0,0
Xsg13cmos5l_inv_1_15 \$1844 \$2 \$1 \$1845 sg13cmos5l_inv_1
* cell instance sg13cmos5l_inv_1_16 r0 *1 0,0
Xsg13cmos5l_inv_1_16 \$1851 \$2 \$1 \$1565 sg13cmos5l_inv_1
* cell instance sg13cmos5l_inv_1_17 r0 *1 0,0
Xsg13cmos5l_inv_1_17 \$2082 \$2 \$1 \$10212 sg13cmos5l_inv_1
* cell instance sg13cmos5l_inv_1_18 r0 *1 0,0
Xsg13cmos5l_inv_1_18 \$89 \$2 \$1 \$404 sg13cmos5l_inv_1
* cell instance sg13cmos5l_inv_1_19 r0 *1 0,0
Xsg13cmos5l_inv_1_19 \$412 \$2 \$1 \$560 sg13cmos5l_inv_1
* cell instance sg13cmos5l_inv_1_20 r0 *1 0,0
Xsg13cmos5l_inv_1_20 \$3833 \$2 \$1 \$8789 sg13cmos5l_inv_1
* cell instance sg13cmos5l_inv_1_21 r0 *1 0,0
Xsg13cmos5l_inv_1_21 \$3497 \$2 \$1 \$3796 sg13cmos5l_inv_1
* cell instance sg13cmos5l_inv_1_22 r0 *1 0,0
Xsg13cmos5l_inv_1_22 \$408 \$2 \$1 \$574 sg13cmos5l_inv_1
* cell instance sg13cmos5l_inv_1_23 r0 *1 0,0
Xsg13cmos5l_inv_1_23 \$7861 \$2 \$1 \$8130 sg13cmos5l_inv_1
* cell instance sg13cmos5l_inv_1_24 r0 *1 0,0
Xsg13cmos5l_inv_1_24 \$1561 \$2 \$1 \$1854 sg13cmos5l_inv_1
* cell instance sg13cmos5l_inv_1_25 r0 *1 0,0
Xsg13cmos5l_inv_1_25 \$7119 \$2 \$1 \$7120 sg13cmos5l_inv_1
* cell instance sg13cmos5l_inv_1_26 r0 *1 0,0
Xsg13cmos5l_inv_1_26 \$1575 \$2 \$1 \$1341 sg13cmos5l_inv_1
* cell instance sg13cmos5l_inv_1_27 r0 *1 0,0
Xsg13cmos5l_inv_1_27 \$256 \$2 \$1 \$428 sg13cmos5l_inv_1
* cell instance sg13cmos5l_inv_1_28 r0 *1 0,0
Xsg13cmos5l_inv_1_28 \$266 \$2 \$1 \$264 sg13cmos5l_inv_1
* cell instance sg13cmos5l_inv_1_29 r0 *1 0,0
Xsg13cmos5l_inv_1_29 \$265 \$2 \$1 \$267 sg13cmos5l_inv_1
* cell instance sg13cmos5l_inv_1_30 r0 *1 0,0
Xsg13cmos5l_inv_1_30 \$134 \$2 \$1 \$582 sg13cmos5l_inv_1
* cell instance sg13cmos5l_inv_1_31 r0 *1 0,0
Xsg13cmos5l_inv_1_31 \$551 \$2 \$1 \$751 sg13cmos5l_inv_1
* cell instance sg13cmos5l_inv_1_32 r0 *1 0,0
Xsg13cmos5l_inv_1_32 \$759 \$2 \$1 \$899 sg13cmos5l_inv_1
* cell instance sg13cmos5l_inv_1_33 r0 *1 0,0
Xsg13cmos5l_inv_1_33 \$277 \$2 \$1 \$912 sg13cmos5l_inv_1
* cell instance sg13cmos5l_inv_1_34 r0 *1 0,0
Xsg13cmos5l_inv_1_34 \$320 \$2 \$1 \$771 sg13cmos5l_inv_1
* cell instance sg13cmos5l_inv_1_35 r0 *1 0,0
Xsg13cmos5l_inv_1_35 \$326 \$2 \$1 \$327 sg13cmos5l_inv_1
* cell instance sg13cmos5l_inv_1_36 r0 *1 0,0
Xsg13cmos5l_inv_1_36 \$1405 \$2 \$1 \$651 sg13cmos5l_inv_1
* cell instance sg13cmos5l_inv_1_37 r0 *1 0,0
Xsg13cmos5l_inv_1_37 \$179 \$2 \$1 \$180 sg13cmos5l_inv_1
* cell instance sg13cmos5l_inv_1_38 r0 *1 0,0
Xsg13cmos5l_inv_1_38 \$664 \$2 \$1 \$795 sg13cmos5l_inv_1
* cell instance sg13cmos5l_inv_1_39 r0 *1 0,0
Xsg13cmos5l_inv_1_39 \$674 \$2 \$1 \$675 sg13cmos5l_inv_1
* cell instance sg13cmos5l_inv_1_40 r0 *1 0,0
Xsg13cmos5l_inv_1_40 \$819 \$2 \$1 \$827 sg13cmos5l_inv_1
* cell instance sg13cmos5l_inv_1_41 r0 *1 0,0
Xsg13cmos5l_inv_1_41 \$1216 \$2 \$1 \$828 sg13cmos5l_inv_1
* cell instance sg13cmos5l_mux2_1_0 r0 *1 0,0
Xsg13cmos5l_mux2_1_0 \$3734 \$3740 \$2178 \$2 \$1 \$3487 sg13cmos5l_mux2_1
* cell instance sg13cmos5l_mux2_1_1 r0 *1 0,0
Xsg13cmos5l_mux2_1_1 \$4757 \$4756 \$2206 \$2 \$1 \$4320 sg13cmos5l_mux2_1
* cell instance sg13cmos5l_mux2_1_2 r0 *1 0,0
Xsg13cmos5l_mux2_1_2 \$1789 \$1888 \$1871 \$2 \$1 \$1874 sg13cmos5l_mux2_1
* cell instance sg13cmos5l_mux2_1_3 r0 *1 0,0
Xsg13cmos5l_mux2_1_3 \$6672 \$4756 \$1878 \$2 \$1 \$6566 sg13cmos5l_mux2_1
* cell instance sg13cmos5l_mux2_1_4 r0 *1 0,0
Xsg13cmos5l_mux2_1_4 \$2722 \$2749 \$1871 \$2 \$1 \$2450 sg13cmos5l_mux2_1
* cell instance sg13cmos5l_mux2_1_5 r0 *1 0,0
Xsg13cmos5l_mux2_1_5 \$2939 \$2749 \$2178 \$2 \$1 \$2876 sg13cmos5l_mux2_1
* cell instance sg13cmos5l_mux2_1_6 r0 *1 0,0
Xsg13cmos5l_mux2_1_6 \$10632 \$7632 \$2206 \$2 \$1 \$10480 sg13cmos5l_mux2_1
* cell instance sg13cmos5l_mux2_1_7 r0 *1 0,0
Xsg13cmos5l_mux2_1_7 \$7857 \$8711 \$2178 \$2 \$1 \$8279 sg13cmos5l_mux2_1
* cell instance sg13cmos5l_mux2_1_8 r0 *1 0,0
Xsg13cmos5l_mux2_1_8 \$2205 \$1888 \$2206 \$2 \$1 \$2072 sg13cmos5l_mux2_1
* cell instance sg13cmos5l_mux2_1_9 r0 *1 0,0
Xsg13cmos5l_mux2_1_9 \$5796 \$4756 \$1871 \$2 \$1 \$5931 sg13cmos5l_mux2_1
* cell instance sg13cmos5l_mux2_1_10 r0 *1 0,0
Xsg13cmos5l_mux2_1_10 \$10204 \$7632 \$2178 \$2 \$1 \$10633 sg13cmos5l_mux2_1
* cell instance sg13cmos5l_mux2_1_11 r0 *1 0,0
Xsg13cmos5l_mux2_1_11 \$12257 \$7632 \$1871 \$2 \$1 \$11239 sg13cmos5l_mux2_1
* cell instance sg13cmos5l_mux2_1_12 r0 *1 0,0
Xsg13cmos5l_mux2_1_12 \$2750 \$2749 \$1878 \$2 \$1 \$2709 sg13cmos5l_mux2_1
* cell instance sg13cmos5l_mux2_1_13 r0 *1 0,0
Xsg13cmos5l_mux2_1_13 \$4924 \$3740 \$1871 \$2 \$1 \$4758 sg13cmos5l_mux2_1
* cell instance sg13cmos5l_mux2_1_14 r0 *1 0,0
Xsg13cmos5l_mux2_1_14 \$9013 \$8711 \$1871 \$2 \$1 \$7702 sg13cmos5l_mux2_1
* cell instance sg13cmos5l_mux2_1_15 r0 *1 0,0
Xsg13cmos5l_mux2_1_15 \$3268 \$2749 \$2206 \$2 \$1 \$3058 sg13cmos5l_mux2_1
* cell instance sg13cmos5l_mux2_1_16 r0 *1 0,0
Xsg13cmos5l_mux2_1_16 \$4086 \$3740 \$2206 \$2 \$1 \$4067 sg13cmos5l_mux2_1
* cell instance sg13cmos5l_mux2_1_17 r0 *1 0,0
Xsg13cmos5l_mux2_1_17 \$9180 \$8711 \$2206 \$2 \$1 \$8712 sg13cmos5l_mux2_1
* cell instance sg13cmos5l_mux2_1_18 r0 *1 0,0
Xsg13cmos5l_mux2_1_18 \$3821 \$3740 \$1878 \$2 \$1 \$3741 sg13cmos5l_mux2_1
* cell instance sg13cmos5l_mux2_1_19 r0 *1 0,0
Xsg13cmos5l_mux2_1_19 \$2207 \$1888 \$2178 \$2 \$1 \$1858 sg13cmos5l_mux2_1
* cell instance sg13cmos5l_mux2_1_20 r0 *1 0,0
Xsg13cmos5l_mux2_1_20 \$10205 \$7632 \$1878 \$2 \$1 \$10109 sg13cmos5l_mux2_1
* cell instance sg13cmos5l_mux2_1_21 r0 *1 0,0
Xsg13cmos5l_mux2_1_21 \$9615 \$8711 \$1878 \$2 \$1 \$9285 sg13cmos5l_mux2_1
* cell instance sg13cmos5l_mux2_1_22 r0 *1 0,0
Xsg13cmos5l_mux2_1_22 \$1867 \$1888 \$1878 \$2 \$1 \$1792 sg13cmos5l_mux2_1
* cell instance sg13cmos5l_mux2_1_23 r0 *1 0,0
Xsg13cmos5l_mux2_1_23 \$6675 \$4756 \$2178 \$2 \$1 \$6827 sg13cmos5l_mux2_1
* cell instance sg13cmos5l_mux2_1_24 r0 *1 0,0
Xsg13cmos5l_mux2_1_24 \$4091 \$13737 \$12258 \$2 \$1 \$13721 sg13cmos5l_mux2_1
* cell instance sg13cmos5l_mux2_1_25 r0 *1 0,0
Xsg13cmos5l_mux2_1_25 \$11244 \$6653 \$1871 \$2 \$1 \$11081 sg13cmos5l_mux2_1
* cell instance sg13cmos5l_mux2_1_26 r0 *1 0,0
Xsg13cmos5l_mux2_1_26 \$2079 \$1934 \$1871 \$2 \$1 \$1890 sg13cmos5l_mux2_1
* cell instance sg13cmos5l_mux2_1_27 r0 *1 0,0
Xsg13cmos5l_mux2_1_27 \$5719 \$12593 \$12258 \$2 \$1 \$12494 sg13cmos5l_mux2_1
* cell instance sg13cmos5l_mux2_1_28 r0 *1 0,0
Xsg13cmos5l_mux2_1_28 \$11095 \$6653 \$1878 \$2 \$1 \$10114 sg13cmos5l_mux2_1
* cell instance sg13cmos5l_mux2_1_29 r0 *1 0,0
Xsg13cmos5l_mux2_1_29 \$3257 \$13837 \$12258 \$2 \$1 \$13774 sg13cmos5l_mux2_1
* cell instance sg13cmos5l_mux2_1_30 r0 *1 0,0
Xsg13cmos5l_mux2_1_30 \$1819 \$1934 \$1878 \$2 \$1 \$1820 sg13cmos5l_mux2_1
* cell instance sg13cmos5l_mux2_1_31 r0 *1 0,0
Xsg13cmos5l_mux2_1_31 \$11245 \$6653 \$2178 \$2 \$1 \$10209 sg13cmos5l_mux2_1
* cell instance sg13cmos5l_mux2_1_32 r0 *1 0,0
Xsg13cmos5l_mux2_1_32 \$2456 \$1934 \$2206 \$2 \$1 \$2209 sg13cmos5l_mux2_1
* cell instance sg13cmos5l_mux2_1_33 r0 *1 0,0
Xsg13cmos5l_mux2_1_33 \$2080 \$1934 \$2178 \$2 \$1 \$1861 sg13cmos5l_mux2_1
* cell instance sg13cmos5l_mux2_1_34 r0 *1 0,0
Xsg13cmos5l_mux2_1_34 \$9617 \$6653 \$2206 \$2 \$1 \$9758 sg13cmos5l_mux2_1
* cell instance sg13cmos5l_mux2_1_35 r0 *1 0,0
Xsg13cmos5l_mux2_1_35 \$9181 \$12259 \$12258 \$2 \$1 \$12076 sg13cmos5l_mux2_1
* cell instance sg13cmos5l_mux2_1_36 r0 *1 0,0
Xsg13cmos5l_mux2_1_36 \$388 \$387 \$374 \$2 \$1 \$379 sg13cmos5l_mux2_1
* cell instance sg13cmos5l_mux2_1_37 r0 *1 0,0
Xsg13cmos5l_mux2_1_37 \$4764 \$13691 \$12258 \$2 \$1 \$13586 sg13cmos5l_mux2_1
* cell instance sg13cmos5l_mux2_1_38 r0 *1 0,0
Xsg13cmos5l_mux2_1_38 \$700 \$1319 \$365 \$2 \$1 \$1552 sg13cmos5l_mux2_1
* cell instance sg13cmos5l_mux2_1_39 r0 *1 0,0
Xsg13cmos5l_mux2_1_39 \$9527 \$13745 \$12258 \$2 \$1 \$13746 sg13cmos5l_mux2_1
* cell instance sg13cmos5l_mux2_1_40 r0 *1 0,0
Xsg13cmos5l_mux2_1_40 \$4764 \$13027 \$10796 \$2 \$1 \$13598 sg13cmos5l_mux2_1
* cell instance sg13cmos5l_mux2_1_41 r0 *1 0,0
Xsg13cmos5l_mux2_1_41 \$3257 \$13800 \$10796 \$2 \$1 \$13801 sg13cmos5l_mux2_1
* cell instance sg13cmos5l_mux2_1_42 r0 *1 0,0
Xsg13cmos5l_mux2_1_42 \$5719 \$12603 \$10796 \$2 \$1 \$12501 sg13cmos5l_mux2_1
* cell instance sg13cmos5l_mux2_1_43 r0 *1 0,0
Xsg13cmos5l_mux2_1_43 \$2434 \$13719 \$12258 \$2 \$1 \$13700 sg13cmos5l_mux2_1
* cell instance sg13cmos5l_mux2_1_44 r0 *1 0,0
Xsg13cmos5l_mux2_1_44 \$2174 \$10501 \$10796 \$2 \$1 \$11577 sg13cmos5l_mux2_1
* cell instance sg13cmos5l_mux2_1_45 r0 *1 0,0
Xsg13cmos5l_mux2_1_45 \$2174 \$12260 \$12258 \$2 \$1 \$11248 sg13cmos5l_mux2_1
* cell instance sg13cmos5l_mux2_1_46 r0 *1 0,0
Xsg13cmos5l_mux2_1_46 \$2434 \$13617 \$10796 \$2 \$1 \$13753 sg13cmos5l_mux2_1
* cell instance sg13cmos5l_mux2_1_47 r0 *1 0,0
Xsg13cmos5l_mux2_1_47 \$9181 \$13252 \$10796 \$2 \$1 \$12261 sg13cmos5l_mux2_1
* cell instance sg13cmos5l_mux2_1_48 r0 *1 0,0
Xsg13cmos5l_mux2_1_48 \$824 \$1691 \$2085 \$2 \$1 \$1855 sg13cmos5l_mux2_1
* cell instance sg13cmos5l_mux2_1_49 r0 *1 0,0
Xsg13cmos5l_mux2_1_49 \$9527 \$13715 \$10796 \$2 \$1 \$13608 sg13cmos5l_mux2_1
* cell instance sg13cmos5l_mux2_1_50 r0 *1 0,0
Xsg13cmos5l_mux2_1_50 \$4091 \$13868 \$10796 \$2 \$1 \$13869 sg13cmos5l_mux2_1
* cell instance sg13cmos5l_mux2_1_51 r0 *1 0,0
Xsg13cmos5l_mux2_1_51 \$1119 \$1118 \$1367 \$2 \$1 \$1115 sg13cmos5l_mux2_1
* cell instance sg13cmos5l_mux2_1_52 r0 *1 0,0
Xsg13cmos5l_mux2_1_52 \$1118 \$1597 \$1367 \$2 \$1 \$1358 sg13cmos5l_mux2_1
* cell instance sg13cmos5l_mux2_1_53 r0 *1 0,0
Xsg13cmos5l_mux2_1_53 \$13888 \$929 \$13900 \$2 \$1 \$9624 sg13cmos5l_mux2_1
* cell instance sg13cmos5l_mux2_1_54 r0 *1 0,0
Xsg13cmos5l_mux2_1_54 \$13891 \$13905 \$13900 \$2 \$1 \$9623 sg13cmos5l_mux2_1
* cell instance sg13cmos5l_mux2_1_55 r0 *1 0,0
Xsg13cmos5l_mux2_1_55 \$13894 \$13908 \$13900 \$2 \$1 \$8716 sg13cmos5l_mux2_1
* cell instance sg13cmos5l_mux2_1_56 r0 *1 0,0
Xsg13cmos5l_mux2_1_56 \$1597 \$1612 \$1367 \$2 \$1 \$888 sg13cmos5l_mux2_1
* cell instance sg13cmos5l_mux2_1_57 r0 *1 0,0
Xsg13cmos5l_mux2_1_57 \$13819 \$13820 \$13900 \$2 \$1 \$9182 sg13cmos5l_mux2_1
* cell instance sg13cmos5l_mux2_1_58 r0 *1 0,0
Xsg13cmos5l_mux2_1_58 \$1612 \$1375 \$1367 \$2 \$1 \$1376 sg13cmos5l_mux2_1
* cell instance sg13cmos5l_mux2_1_59 r0 *1 0,0
Xsg13cmos5l_mux2_1_59 \$13899 \$13913 \$13900 \$2 \$1 \$9622 sg13cmos5l_mux2_1
* cell instance sg13cmos5l_mux2_1_60 r0 *1 0,0
Xsg13cmos5l_mux2_1_60 \$13815 \$13916 \$13900 \$2 \$1 \$4768 sg13cmos5l_mux2_1
* cell instance sg13cmos5l_mux2_1_61 r0 *1 0,0
Xsg13cmos5l_mux2_1_61 \$13919 \$1119 \$13900 \$2 \$1 \$3495 sg13cmos5l_mux2_1
* cell instance sg13cmos5l_mux2_1_62 r0 *1 0,0
Xsg13cmos5l_mux2_1_62 \$13923 \$13922 \$13900 \$2 \$1 \$9029 sg13cmos5l_mux2_1
* cell instance sg13cmos5l_mux2_1_63 r0 *1 0,0
Xsg13cmos5l_mux2_1_63 \$1375 \$1385 \$1367 \$2 \$1 \$901 sg13cmos5l_mux2_1
* cell instance sg13cmos5l_mux2_1_64 r0 *1 0,0
Xsg13cmos5l_mux2_1_64 \$1385 \$1395 \$1367 \$2 \$1 \$1159 sg13cmos5l_mux2_1
* cell instance sg13cmos5l_mux2_1_65 r0 *1 0,0
Xsg13cmos5l_mux2_1_65 \$1395 \$1400 \$1367 \$2 \$1 \$917 sg13cmos5l_mux2_1
* cell instance sg13cmos5l_mux2_1_66 r0 *1 0,0
Xsg13cmos5l_mux2_1_66 \$637 \$47 \$508 \$2 \$1 \$642 sg13cmos5l_mux2_1
* cell instance sg13cmos5l_mux2_1_67 r0 *1 0,0
Xsg13cmos5l_mux2_1_67 \$149 \$107 \$508 \$2 \$1 \$777 sg13cmos5l_mux2_1
* cell instance sg13cmos5l_mux2_1_68 r0 *1 0,0
Xsg13cmos5l_mux2_1_68 \$157 \$285 \$651 \$2 \$1 \$653 sg13cmos5l_mux2_1
* cell instance sg13cmos5l_mux2_1_69 r0 *1 0,0
Xsg13cmos5l_mux2_1_69 \$22 \$463 \$508 \$2 \$1 \$656 sg13cmos5l_mux2_1
* cell instance sg13cmos5l_mux2_1_70 r0 *1 0,0
Xsg13cmos5l_mux2_1_70 \$21 \$620 \$508 \$2 \$1 \$790 sg13cmos5l_mux2_1
* cell instance sg13cmos5l_mux2_1_71 r0 *1 0,0
Xsg13cmos5l_mux2_1_71 \$348 \$120 \$508 \$2 \$1 \$510 sg13cmos5l_mux2_1
* cell instance sg13cmos5l_mux2_1_72 r0 *1 0,0
Xsg13cmos5l_mux2_1_72 \$515 \$876 \$508 \$2 \$1 \$1204 sg13cmos5l_mux2_1
* cell instance sg13cmos5l_mux2_1_73 r0 *1 0,0
Xsg13cmos5l_mux2_1_73 \$513 \$269 \$508 \$2 \$1 \$514 sg13cmos5l_mux2_1
* cell instance sg13cmos5l_mux2_1_74 r0 *1 0,0
Xsg13cmos5l_mux2_1_74 \$1400 \$1473 \$1367 \$2 \$1 \$1238 sg13cmos5l_mux2_1
* cell instance sg13cmos5l_mux2_1_75 r0 *1 0,0
Xsg13cmos5l_mux2_1_75 \$1473 \$1484 \$1472 \$2 \$1 \$992 sg13cmos5l_mux2_1
* cell instance sg13cmos5l_mux2_1_76 r0 *1 0,0
Xsg13cmos5l_mux2_1_76 \$1484 \$1487 \$1472 \$2 \$1 \$1488 sg13cmos5l_mux2_1
* cell instance sg13cmos5l_mux2_1_77 r0 *1 0,0
Xsg13cmos5l_mux2_1_77 \$1487 \$1497 \$1472 \$2 \$1 \$1012 sg13cmos5l_mux2_1
* cell instance sg13cmos5l_mux2_1_78 r0 *1 0,0
Xsg13cmos5l_mux2_1_78 \$1497 \$1503 \$1472 \$2 \$1 \$1268 sg13cmos5l_mux2_1
* cell instance sg13cmos5l_mux2_1_79 r0 *1 0,0
Xsg13cmos5l_mux2_1_79 \$1503 \$1034 \$1472 \$2 \$1 \$1035 sg13cmos5l_mux2_1
* cell instance sg13cmos5l_mux2_1_80 r0 *1 0,0
Xsg13cmos5l_mux2_1_80 \$1034 \$1521 \$1472 \$2 \$1 \$1043 sg13cmos5l_mux2_1
* cell instance sg13cmos5l_mux2_1_81 r0 *1 0,0
Xsg13cmos5l_mux2_1_81 \$1521 \$1780 \$1472 \$2 \$1 \$1518 sg13cmos5l_mux2_1
* cell instance sg13cmos5l_mux4_1_0 r0 *1 0,0
Xsg13cmos5l_mux4_1_0 \$5356 \$4147 \$5357 \$5358 \$2208 \$2271 \$2 \$1 \$4091
+ sg13cmos5l_mux4_1
* cell instance sg13cmos5l_mux4_1_1 r0 *1 0,0
Xsg13cmos5l_mux4_1_1 \$5356 \$4147 \$5357 \$5358 \$2078 \$1912 \$2 \$1 \$4093
+ sg13cmos5l_mux4_1
* cell instance sg13cmos5l_mux4_1_2 r0 *1 0,0
Xsg13cmos5l_mux4_1_2 \$4087 \$3825 \$3490 \$3822 \$2078 \$2082 \$2 \$1 \$4081
+ sg13cmos5l_mux4_1
* cell instance sg13cmos5l_mux4_1_3 r0 *1 0,0
Xsg13cmos5l_mux4_1_3 \$1857 \$1925 \$1812 \$1813 \$2208 \$2271 \$2 \$1 \$2174
+ sg13cmos5l_mux4_1
* cell instance sg13cmos5l_mux4_1_4 r0 *1 0,0
Xsg13cmos5l_mux4_1_4 \$2422 \$3064 \$3056 \$2719 \$2208 \$2271 \$2 \$1 \$3257
+ sg13cmos5l_mux4_1
* cell instance sg13cmos5l_mux4_1_5 r0 *1 0,0
Xsg13cmos5l_mux4_1_5 \$10206 \$10207 \$10208 \$11074 \$2272 \$1448 \$2 \$1
+ \$9181 sg13cmos5l_mux4_1
* cell instance sg13cmos5l_mux4_1_6 r0 *1 0,0
Xsg13cmos5l_mux4_1_6 \$1857 \$1925 \$1812 \$1813 \$2078 \$2082 \$2 \$1 \$1931
+ sg13cmos5l_mux4_1
* cell instance sg13cmos5l_mux4_1_7 r0 *1 0,0
Xsg13cmos5l_mux4_1_7 \$2422 \$3064 \$3056 \$2719 \$2078 \$2082 \$2 \$1 \$3017
+ sg13cmos5l_mux4_1
* cell instance sg13cmos5l_mux4_1_8 r0 *1 0,0
Xsg13cmos5l_mux4_1_8 \$7622 \$8572 \$7704 \$9136 \$2272 \$1448 \$2 \$1 \$4764
+ sg13cmos5l_mux4_1
* cell instance sg13cmos5l_mux4_1_9 r0 *1 0,0
Xsg13cmos5l_mux4_1_9 \$10206 \$10207 \$10208 \$11074 \$2078 \$2082 \$2 \$1
+ \$9183 sg13cmos5l_mux4_1
* cell instance sg13cmos5l_mux4_1_10 r0 *1 0,0
Xsg13cmos5l_mux4_1_10 \$7622 \$8572 \$7704 \$9136 \$2078 \$1912 \$2 \$1 \$8282
+ sg13cmos5l_mux4_1
* cell instance sg13cmos5l_mux4_1_11 r0 *1 0,0
Xsg13cmos5l_mux4_1_11 \$1900 \$2081 \$1939 \$1840 \$2208 \$2271 \$2 \$1 \$2434
+ sg13cmos5l_mux4_1
* cell instance sg13cmos5l_mux4_1_12 r0 *1 0,0
Xsg13cmos5l_mux4_1_12 \$1900 \$2081 \$1939 \$1840 \$2078 \$2082 \$2 \$1 \$2138
+ sg13cmos5l_mux4_1
* cell instance sg13cmos5l_mux4_1_13 r0 *1 0,0
Xsg13cmos5l_mux4_1_13 \$11079 \$9619 \$10795 \$9620 \$2272 \$1448 \$2 \$1
+ \$9527 sg13cmos5l_mux4_1
* cell instance sg13cmos5l_mux4_1_14 r0 *1 0,0
Xsg13cmos5l_mux4_1_14 \$11079 \$9619 \$10795 \$9620 \$2078 \$2082 \$2 \$1
+ \$8718 sg13cmos5l_mux4_1
* cell instance sg13cmos5l_nand2_1_0 r0 *1 0,0
Xsg13cmos5l_nand2_1_0 \$6496 \$4076 \$2 \$1 \$6427 sg13cmos5l_nand2_1
* cell instance sg13cmos5l_nand2_1_1 r0 *1 0,0
Xsg13cmos5l_nand2_1_1 \$692 \$200 \$2 \$1 \$691 sg13cmos5l_nand2_1
* cell instance sg13cmos5l_nand2_1_2 r0 *1 0,0
Xsg13cmos5l_nand2_1_2 \$365 \$693 \$2 \$1 \$206 sg13cmos5l_nand2_1
* cell instance sg13cmos5l_nand2_1_3 r0 *1 0,0
Xsg13cmos5l_nand2_1_3 \$2174 \$1931 \$2 \$1 \$3018 sg13cmos5l_nand2_1
* cell instance sg13cmos5l_nand2_1_4 r0 *1 0,0
Xsg13cmos5l_nand2_1_4 \$87 \$206 \$2 \$1 \$26 sg13cmos5l_nand2_1
* cell instance sg13cmos5l_nand2_1_5 r0 *1 0,0
Xsg13cmos5l_nand2_1_5 \$6577 \$4076 \$2 \$1 \$6678 sg13cmos5l_nand2_1
* cell instance sg13cmos5l_nand2_1_6 r0 *1 0,0
Xsg13cmos5l_nand2_1_6 \$3491 \$3493 \$2 \$1 \$3736 sg13cmos5l_nand2_1
* cell instance sg13cmos5l_nand2_1_7 r0 *1 0,0
Xsg13cmos5l_nand2_1_7 \$560 \$1092 \$2 \$1 \$855 sg13cmos5l_nand2_1
* cell instance sg13cmos5l_nand2_1_8 r0 *1 0,0
Xsg13cmos5l_nand2_1_8 \$2434 \$2138 \$2 \$1 \$3205 sg13cmos5l_nand2_1
* cell instance sg13cmos5l_nand2_1_9 r0 *1 0,0
Xsg13cmos5l_nand2_1_9 \$4097 \$3269 \$2 \$1 \$4082 sg13cmos5l_nand2_1
* cell instance sg13cmos5l_nand2_1_10 r0 *1 0,0
Xsg13cmos5l_nand2_1_10 \$560 \$860 \$2 \$1 \$703 sg13cmos5l_nand2_1
* cell instance sg13cmos5l_nand2_1_11 r0 *1 0,0
Xsg13cmos5l_nand2_1_11 \$3205 \$3097 \$2 \$1 \$3206 sg13cmos5l_nand2_1
* cell instance sg13cmos5l_nand2_1_12 r0 *1 0,0
Xsg13cmos5l_nand2_1_12 \$9181 \$9183 \$2 \$1 \$3833 sg13cmos5l_nand2_1
* cell instance sg13cmos5l_nand2_1_13 r0 *1 0,0
Xsg13cmos5l_nand2_1_13 \$7274 \$3269 \$2 \$1 \$4166 sg13cmos5l_nand2_1
* cell instance sg13cmos5l_nand2_1_14 r0 *1 0,0
Xsg13cmos5l_nand2_1_14 \$9527 \$8718 \$2 \$1 \$7274 sg13cmos5l_nand2_1
* cell instance sg13cmos5l_nand2_1_15 r0 *1 0,0
Xsg13cmos5l_nand2_1_15 \$2078 \$2893 \$2 \$1 \$2435 sg13cmos5l_nand2_1
* cell instance sg13cmos5l_nand2_1_16 r0 *1 0,0
Xsg13cmos5l_nand2_1_16 \$1869 \$1911 \$2 \$1 \$1568 sg13cmos5l_nand2_1
* cell instance sg13cmos5l_nand2_1_17 r0 *1 0,0
Xsg13cmos5l_nand2_1_17 \$1691 \$824 \$2 \$1 \$1570 sg13cmos5l_nand2_1
* cell instance sg13cmos5l_nand2_1_18 r0 *1 0,0
Xsg13cmos5l_nand2_1_18 \$1573 \$1572 \$2 \$1 \$1342 sg13cmos5l_nand2_1
* cell instance sg13cmos5l_nand2_1_19 r0 *1 0,0
Xsg13cmos5l_nand2_1_19 \$412 \$403 \$2 \$1 \$260 sg13cmos5l_nand2_1
* cell instance sg13cmos5l_nand2_1_20 r0 *1 0,0
Xsg13cmos5l_nand2_1_20 \$707 \$250 \$2 \$1 \$577 sg13cmos5l_nand2_1
* cell instance sg13cmos5l_nand2_1_21 r0 *1 0,0
Xsg13cmos5l_nand2_1_21 \$1111 \$1108 \$2 \$1 \$867 sg13cmos5l_nand2_1
* cell instance sg13cmos5l_nand2_1_22 r0 *1 0,0
Xsg13cmos5l_nand2_1_22 \$260 \$867 \$2 \$1 \$587 sg13cmos5l_nand2_1
* cell instance sg13cmos5l_nand2_1_23 r0 *1 0,0
Xsg13cmos5l_nand2_1_23 \$256 \$255 \$2 \$1 \$249 sg13cmos5l_nand2_1
* cell instance sg13cmos5l_nand2_1_24 r0 *1 0,0
Xsg13cmos5l_nand2_1_24 \$260 \$261 \$2 \$1 \$716 sg13cmos5l_nand2_1
* cell instance sg13cmos5l_nand2_1_25 r0 *1 0,0
Xsg13cmos5l_nand2_1_25 \$455 \$728 \$2 \$1 \$132 sg13cmos5l_nand2_1
* cell instance sg13cmos5l_nand2_1_26 r0 *1 0,0
Xsg13cmos5l_nand2_1_26 \$134 \$728 \$2 \$1 \$133 sg13cmos5l_nand2_1
* cell instance sg13cmos5l_nand2_1_27 r0 *1 0,0
Xsg13cmos5l_nand2_1_27 \$301 \$143 \$2 \$1 \$139 sg13cmos5l_nand2_1
* cell instance sg13cmos5l_nand2_1_28 r0 *1 0,0
Xsg13cmos5l_nand2_1_28 \$1405 \$929 \$2 \$1 \$1411 sg13cmos5l_nand2_1
* cell instance sg13cmos5l_nand2_1_29 r0 *1 0,0
Xsg13cmos5l_nand2_1_29 \$149 \$150 \$2 \$1 \$638 sg13cmos5l_nand2_1
* cell instance sg13cmos5l_nand2_1_30 r0 *1 0,0
Xsg13cmos5l_nand2_1_30 \$149 \$637 \$2 \$1 \$499 sg13cmos5l_nand2_1
* cell instance sg13cmos5l_nand2_1_31 r0 *1 0,0
Xsg13cmos5l_nand2_1_31 \$664 \$779 \$2 \$1 \$800 sg13cmos5l_nand2_1
* cell instance sg13cmos5l_nand2b_1_0 r0 *1 0,0
Xsg13cmos5l_nand2b_1_0 \$2271 \$3825 \$2 \$1 \$3735 sg13cmos5l_nand2b_1
* cell instance sg13cmos5l_nand2b_1_1 r0 *1 0,0
Xsg13cmos5l_nand2b_1_1 \$2208 \$3490 \$2 \$1 \$3447 sg13cmos5l_nand2b_1
* cell instance sg13cmos5l_nand2b_1_2 r0 *1 0,0
Xsg13cmos5l_nand2b_1_2 \$6358 \$6427 \$2 \$1 \$6428 sg13cmos5l_nand2b_1
* cell instance sg13cmos5l_nand2b_1_3 r0 *1 0,0
Xsg13cmos5l_nand2b_1_3 \$8282 \$4764 \$2 \$1 \$6676 sg13cmos5l_nand2b_1
* cell instance sg13cmos5l_nand2b_1_4 r0 *1 0,0
Xsg13cmos5l_nand2b_1_4 \$3491 \$3517 \$2 \$1 \$4094 sg13cmos5l_nand2b_1
* cell instance sg13cmos5l_nand2b_1_5 r0 *1 0,0
Xsg13cmos5l_nand2b_1_5 \$3018 \$3269 \$2 \$1 \$3069 sg13cmos5l_nand2b_1
* cell instance sg13cmos5l_nand2b_1_6 r0 *1 0,0
Xsg13cmos5l_nand2b_1_6 \$3517 \$3020 \$2 \$1 \$4237 sg13cmos5l_nand2b_1
* cell instance sg13cmos5l_nand2b_1_7 r0 *1 0,0
Xsg13cmos5l_nand2b_1_7 \$857 \$398 \$2 \$1 \$854 sg13cmos5l_nand2b_1
* cell instance sg13cmos5l_nand2b_1_8 r0 *1 0,0
Xsg13cmos5l_nand2b_1_8 \$5793 \$7273 \$2 \$1 \$6496 sg13cmos5l_nand2b_1
* cell instance sg13cmos5l_nand2b_1_9 r0 *1 0,0
Xsg13cmos5l_nand2b_1_9 \$398 \$700 \$2 \$1 \$859 sg13cmos5l_nand2b_1
* cell instance sg13cmos5l_nand2b_1_10 r0 *1 0,0
Xsg13cmos5l_nand2b_1_10 \$2434 \$2138 \$2 \$1 \$3071 sg13cmos5l_nand2b_1
* cell instance sg13cmos5l_nand2b_1_11 r0 *1 0,0
Xsg13cmos5l_nand2b_1_11 \$5793 \$5140 \$2 \$1 \$5221 sg13cmos5l_nand2b_1
* cell instance sg13cmos5l_nand2b_1_12 r0 *1 0,0
Xsg13cmos5l_nand2b_1_12 \$398 \$705 \$2 \$1 \$567 sg13cmos5l_nand2b_1
* cell instance sg13cmos5l_nand2b_1_13 r0 *1 0,0
Xsg13cmos5l_nand2b_1_13 \$3205 \$3269 \$2 \$1 \$3263 sg13cmos5l_nand2b_1
* cell instance sg13cmos5l_nand2b_1_14 r0 *1 0,0
Xsg13cmos5l_nand2b_1_14 \$5361 \$4083 \$2 \$1 \$5144 sg13cmos5l_nand2b_1
* cell instance sg13cmos5l_nand2b_1_15 r0 *1 0,0
Xsg13cmos5l_nand2b_1_15 \$1691 \$824 \$2 \$1 \$1848 sg13cmos5l_nand2b_1
* cell instance sg13cmos5l_nand2b_1_16 r0 *1 0,0
Xsg13cmos5l_nand2b_1_16 \$824 \$1691 \$2 \$1 \$1910 sg13cmos5l_nand2b_1
* cell instance sg13cmos5l_nand2b_1_17 r0 *1 0,0
Xsg13cmos5l_nand2b_1_17 \$1869 \$1911 \$2 \$1 \$1909 sg13cmos5l_nand2b_1
* cell instance sg13cmos5l_nand2b_1_18 r0 *1 0,0
Xsg13cmos5l_nand2b_1_18 \$9183 \$9181 \$2 \$1 \$8278 sg13cmos5l_nand2b_1
* cell instance sg13cmos5l_nand2b_1_19 r0 *1 0,0
Xsg13cmos5l_nand2b_1_19 \$1911 \$1869 \$2 \$1 \$2458 sg13cmos5l_nand2b_1
* cell instance sg13cmos5l_nand2b_1_20 r0 *1 0,0
Xsg13cmos5l_nand2b_1_20 \$1572 \$1573 \$2 \$1 \$1110 sg13cmos5l_nand2b_1
* cell instance sg13cmos5l_nand2b_1_21 r0 *1 0,0
Xsg13cmos5l_nand2b_1_21 \$1336 \$1110 \$2 \$1 \$1111 sg13cmos5l_nand2b_1
* cell instance sg13cmos5l_nand2b_1_22 r0 *1 0,0
Xsg13cmos5l_nand2b_1_22 \$403 \$250 \$2 \$1 \$579 sg13cmos5l_nand2b_1
* cell instance sg13cmos5l_nand2b_1_23 r0 *1 0,0
Xsg13cmos5l_nand2b_1_23 \$690 \$863 \$2 \$1 \$417 sg13cmos5l_nand2b_1
* cell instance sg13cmos5l_nand2b_1_24 r0 *1 0,0
Xsg13cmos5l_nand2b_1_24 \$707 \$560 \$2 \$1 \$261 sg13cmos5l_nand2b_1
* cell instance sg13cmos5l_nand2b_1_25 r0 *1 0,0
Xsg13cmos5l_nand2b_1_25 \$580 \$709 \$2 \$1 \$684 sg13cmos5l_nand2b_1
* cell instance sg13cmos5l_nand2b_1_26 r0 *1 0,0
Xsg13cmos5l_nand2b_1_26 \$690 \$880 \$2 \$1 \$875 sg13cmos5l_nand2b_1
* cell instance sg13cmos5l_nand2b_1_27 r0 *1 0,0
Xsg13cmos5l_nand2b_1_27 \$637 \$638 \$2 \$1 \$312 sg13cmos5l_nand2b_1
* cell instance sg13cmos5l_nand2b_1_28 r0 *1 0,0
Xsg13cmos5l_nand2b_1_28 \$1668 \$1405 \$2 \$1 \$1426 sg13cmos5l_nand2b_1
* cell instance sg13cmos5l_nand3_1_0 r0 *1 0,0
Xsg13cmos5l_nand3_1_0 \$2271 \$2208 \$3822 \$2 \$1 \$3788 sg13cmos5l_nand3_1
* cell instance sg13cmos5l_nand3_1_1 r0 *1 0,0
Xsg13cmos5l_nand3_1_1 \$4613 \$3513 \$4081 \$2 \$1 \$5140 sg13cmos5l_nand3_1
* cell instance sg13cmos5l_nand3_1_2 r0 *1 0,0
Xsg13cmos5l_nand3_1_2 \$5359 \$6427 \$6676 \$2 \$1 \$6575 sg13cmos5l_nand3_1
* cell instance sg13cmos5l_nand3_1_3 r0 *1 0,0
Xsg13cmos5l_nand3_1_3 \$6678 \$6575 \$6677 \$2 \$1 \$4761 sg13cmos5l_nand3_1
* cell instance sg13cmos5l_nand3_1_4 r0 *1 0,0
Xsg13cmos5l_nand3_1_4 \$8577 \$8283 \$7627 \$2 \$1 \$5360 sg13cmos5l_nand3_1
* cell instance sg13cmos5l_nand3_1_5 r0 *1 0,0
Xsg13cmos5l_nand3_1_5 \$8717 \$8715 \$8144 \$2 \$1 \$6679 sg13cmos5l_nand3_1
* cell instance sg13cmos5l_nand3_1_6 r0 *1 0,0
Xsg13cmos5l_nand3_1_6 \$5137 \$5140 \$4766 \$2 \$1 \$5723 sg13cmos5l_nand3_1
* cell instance sg13cmos5l_nand3_1_7 r0 *1 0,0
Xsg13cmos5l_nand3_1_7 \$5141 \$2921 \$4765 \$2 \$1 \$4100 sg13cmos5l_nand3_1
* cell instance sg13cmos5l_nand3_1_8 r0 *1 0,0
Xsg13cmos5l_nand3_1_8 \$1545 \$2437 \$2435 \$2 \$1 \$2755 sg13cmos5l_nand3_1
* cell instance sg13cmos5l_nand3_1_9 r0 *1 0,0
Xsg13cmos5l_nand3_1_9 \$2082 \$2078 \$1908 \$2 \$1 \$12258 sg13cmos5l_nand3_1
* cell instance sg13cmos5l_nand3_1_10 r0 *1 0,0
Xsg13cmos5l_nand3_1_10 \$3833 \$3018 \$3205 \$2 \$1 \$3795 sg13cmos5l_nand3_1
* cell instance sg13cmos5l_nand3_1_11 r0 *1 0,0
Xsg13cmos5l_nand3_1_11 \$10212 \$2895 \$1908 \$2 \$1 \$10796 sg13cmos5l_nand3_1
* cell instance sg13cmos5l_nand3_1_12 r0 *1 0,0
Xsg13cmos5l_nand3_1_12 \$8857 \$9529 \$8578 \$2 \$1 \$6681 sg13cmos5l_nand3_1
* cell instance sg13cmos5l_nand3_1_13 r0 *1 0,0
Xsg13cmos5l_nand3_1_13 \$1691 \$824 \$1911 \$2 \$1 \$1575 sg13cmos5l_nand3_1
* cell instance sg13cmos5l_nand3_1_14 r0 *1 0,0
Xsg13cmos5l_nand3_1_14 \$9184 \$9032 \$8721 \$2 \$1 \$7276 sg13cmos5l_nand3_1
* cell instance sg13cmos5l_nand3_1_15 r0 *1 0,0
Xsg13cmos5l_nand3_1_15 \$261 \$257 \$249 \$2 \$1 \$253 sg13cmos5l_nand3_1
* cell instance sg13cmos5l_nand3_1_16 r0 *1 0,0
Xsg13cmos5l_nand3_1_16 \$260 \$261 \$262 \$2 \$1 \$263 sg13cmos5l_nand3_1
* cell instance sg13cmos5l_nand3_1_17 r0 *1 0,0
Xsg13cmos5l_nand3_1_17 \$717 \$880 \$728 \$2 \$1 \$721 sg13cmos5l_nand3_1
* cell instance sg13cmos5l_nand3_1_18 r0 *1 0,0
Xsg13cmos5l_nand3_1_18 \$605 \$452 \$458 \$2 \$1 \$612 sg13cmos5l_nand3_1
* cell instance sg13cmos5l_nand3_1_19 r0 *1 0,0
Xsg13cmos5l_nand3_1_19 \$455 \$142 \$448 \$2 \$1 \$458 sg13cmos5l_nand3_1
* cell instance sg13cmos5l_nand3_1_20 r0 *1 0,0
Xsg13cmos5l_nand3_1_20 \$934 \$1185 \$929 \$2 \$1 \$766 sg13cmos5l_nand3_1
* cell instance sg13cmos5l_nand3_1_21 r0 *1 0,0
Xsg13cmos5l_nand3_1_21 \$22 \$21 \$20 \$2 \$1 \$18 sg13cmos5l_nand3_1
* cell instance sg13cmos5l_nand3_1_22 r0 *1 0,0
Xsg13cmos5l_nand3_1_22 \$22 \$21 \$157 \$2 \$1 \$339 sg13cmos5l_nand3_1
* cell instance sg13cmos5l_nand3_1_23 r0 *1 0,0
Xsg13cmos5l_nand3_1_23 \$515 \$348 \$513 \$2 \$1 \$505 sg13cmos5l_nand3_1
* cell instance sg13cmos5l_nand3_1_24 r0 *1 0,0
Xsg13cmos5l_nand3_1_24 \$664 \$977 \$779 \$2 \$1 \$1461 sg13cmos5l_nand3_1
* cell instance sg13cmos5l_nand3_1_25 r0 *1 0,0
Xsg13cmos5l_nand3_1_25 \$808 \$807 \$674 \$2 \$1 \$798 sg13cmos5l_nand3_1
* cell instance sg13cmos5l_nand3b_1_0 r0 *1 0,0
Xsg13cmos5l_nand3b_1_0 \$3492 \$3736 \$3501 \$2 \$1 \$3519 sg13cmos5l_nand3b_1
* cell instance sg13cmos5l_nand3b_1_1 r0 *1 0,0
Xsg13cmos5l_nand3b_1_1 \$3737 \$3738 \$3206 \$2 \$1 \$3522 sg13cmos5l_nand3b_1
* cell instance sg13cmos5l_nand3b_1_2 r0 *1 0,0
Xsg13cmos5l_nand3b_1_2 \$4046 \$3068 \$3206 \$2 \$1 \$4026 sg13cmos5l_nand3b_1
* cell instance sg13cmos5l_nand4_1_0 r0 *1 0,0
Xsg13cmos5l_nand4_1_0 \$3499 \$3447 \$3788 \$3735 \$2 \$1 \$3513
+ sg13cmos5l_nand4_1
* cell instance sg13cmos5l_nand4_1_1 r0 *1 0,0
Xsg13cmos5l_nand4_1_1 \$4322 \$4428 \$4154 \$4237 \$2 \$1 \$3828
+ sg13cmos5l_nand4_1
* cell instance sg13cmos5l_nand4_1_2 r0 *1 0,0
Xsg13cmos5l_nand4_1_2 \$2886 \$2944 \$2728 \$3069 \$2 \$1 \$2891
+ sg13cmos5l_nand4_1
* cell instance sg13cmos5l_nand4_1_3 r0 *1 0,0
Xsg13cmos5l_nand4_1_3 \$408 \$404 \$561 \$88 \$2 \$1 \$403 sg13cmos5l_nand4_1
* cell instance sg13cmos5l_nand4_1_4 r0 *1 0,0
Xsg13cmos5l_nand4_1_4 \$4161 \$4324 \$4082 \$4323 \$2 \$1 \$4045
+ sg13cmos5l_nand4_1
* cell instance sg13cmos5l_nand4_1_5 r0 *1 0,0
Xsg13cmos5l_nand4_1_5 \$3275 \$3270 \$3074 \$3263 \$2 \$1 \$3075
+ sg13cmos5l_nand4_1
* cell instance sg13cmos5l_nand4_1_6 r0 *1 0,0
Xsg13cmos5l_nand4_1_6 \$664 \$808 \$807 \$779 \$2 \$1 \$806 sg13cmos5l_nand4_1
* cell instance sg13cmos5l_nor2_1_0 r0 *1 0,0
Xsg13cmos5l_nor2_1_0 \$3499 \$2755 \$2 \$1 \$1871 sg13cmos5l_nor2_1
* cell instance sg13cmos5l_nor2_1_1 r0 *1 0,0
Xsg13cmos5l_nor2_1_1 \$3492 \$3826 \$2 \$1 \$3789 sg13cmos5l_nor2_1
* cell instance sg13cmos5l_nor2_1_2 r0 *1 0,0
Xsg13cmos5l_nor2_1_2 \$3257 \$3017 \$2 \$1 \$5141 sg13cmos5l_nor2_1
* cell instance sg13cmos5l_nor2_1_3 r0 *1 0,0
Xsg13cmos5l_nor2_1_3 \$3491 \$3493 \$2 \$1 \$3492 sg13cmos5l_nor2_1
* cell instance sg13cmos5l_nor2_1_4 r0 *1 0,0
Xsg13cmos5l_nor2_1_4 \$5793 \$5362 \$2 \$1 \$5720 sg13cmos5l_nor2_1
* cell instance sg13cmos5l_nor2_1_5 r0 *1 0,0
Xsg13cmos5l_nor2_1_5 \$391 \$392 \$2 \$1 \$202 sg13cmos5l_nor2_1
* cell instance sg13cmos5l_nor2_1_6 r0 *1 0,0
Xsg13cmos5l_nor2_1_6 \$692 \$87 \$2 \$1 \$88 sg13cmos5l_nor2_1
* cell instance sg13cmos5l_nor2_1_7 r0 *1 0,0
Xsg13cmos5l_nor2_1_7 \$560 \$88 \$2 \$1 \$205 sg13cmos5l_nor2_1
* cell instance sg13cmos5l_nor2_1_8 r0 *1 0,0
Xsg13cmos5l_nor2_1_8 \$391 \$1561 \$2 \$1 \$375 sg13cmos5l_nor2_1
* cell instance sg13cmos5l_nor2_1_9 r0 *1 0,0
Xsg13cmos5l_nor2_1_9 \$399 \$396 \$2 \$1 \$562 sg13cmos5l_nor2_1
* cell instance sg13cmos5l_nor2_1_10 r0 *1 0,0
Xsg13cmos5l_nor2_1_10 \$89 \$365 \$2 \$1 \$90 sg13cmos5l_nor2_1
* cell instance sg13cmos5l_nor2_1_11 r0 *1 0,0
Xsg13cmos5l_nor2_1_11 \$1848 \$2458 \$2 \$1 \$2761 sg13cmos5l_nor2_1
* cell instance sg13cmos5l_nor2_1_12 r0 *1 0,0
Xsg13cmos5l_nor2_1_12 \$1570 \$2458 \$2 \$1 \$2729 sg13cmos5l_nor2_1
* cell instance sg13cmos5l_nor2_1_13 r0 *1 0,0
Xsg13cmos5l_nor2_1_13 \$1910 \$2458 \$2 \$1 \$2436 sg13cmos5l_nor2_1
* cell instance sg13cmos5l_nor2_1_14 r0 *1 0,0
Xsg13cmos5l_nor2_1_14 \$863 \$875 \$2 \$1 \$1545 sg13cmos5l_nor2_1
* cell instance sg13cmos5l_nor2_1_15 r0 *1 0,0
Xsg13cmos5l_nor2_1_15 \$412 \$1845 \$2 \$1 \$568 sg13cmos5l_nor2_1
* cell instance sg13cmos5l_nor2_1_16 r0 *1 0,0
Xsg13cmos5l_nor2_1_16 \$863 \$1565 \$2 \$1 \$572 sg13cmos5l_nor2_1
* cell instance sg13cmos5l_nor2_1_17 r0 *1 0,0
Xsg13cmos5l_nor2_1_17 \$5223 \$5224 \$2 \$1 \$6214 sg13cmos5l_nor2_1
* cell instance sg13cmos5l_nor2_1_18 r0 *1 0,0
Xsg13cmos5l_nor2_1_18 \$408 \$365 \$2 \$1 \$409 sg13cmos5l_nor2_1
* cell instance sg13cmos5l_nor2_1_19 r0 *1 0,0
Xsg13cmos5l_nor2_1_19 \$412 \$1564 \$2 \$1 \$410 sg13cmos5l_nor2_1
* cell instance sg13cmos5l_nor2_1_20 r0 *1 0,0
Xsg13cmos5l_nor2_1_20 \$1570 \$2459 \$2 \$1 \$2731 sg13cmos5l_nor2_1
* cell instance sg13cmos5l_nor2_1_21 r0 *1 0,0
Xsg13cmos5l_nor2_1_21 \$1909 \$1848 \$2 \$1 \$2416 sg13cmos5l_nor2_1
* cell instance sg13cmos5l_nor2_1_22 r0 *1 0,0
Xsg13cmos5l_nor2_1_22 \$1910 \$2459 \$2 \$1 \$3077 sg13cmos5l_nor2_1
* cell instance sg13cmos5l_nor2_1_23 r0 *1 0,0
Xsg13cmos5l_nor2_1_23 \$3501 \$3020 \$2 \$1 \$4723 sg13cmos5l_nor2_1
* cell instance sg13cmos5l_nor2_1_24 r0 *1 0,0
Xsg13cmos5l_nor2_1_24 \$1570 \$1568 \$2 \$1 \$1336 sg13cmos5l_nor2_1
* cell instance sg13cmos5l_nor2_1_25 r0 *1 0,0
Xsg13cmos5l_nor2_1_25 \$1691 \$1909 \$2 \$1 \$2763 sg13cmos5l_nor2_1
* cell instance sg13cmos5l_nor2_1_26 r0 *1 0,0
Xsg13cmos5l_nor2_1_26 \$1869 \$1575 \$2 \$1 \$1573 sg13cmos5l_nor2_1
* cell instance sg13cmos5l_nor2_1_27 r0 *1 0,0
Xsg13cmos5l_nor2_1_27 \$1568 \$1855 \$2 \$1 \$589 sg13cmos5l_nor2_1
* cell instance sg13cmos5l_nor2_1_28 r0 *1 0,0
Xsg13cmos5l_nor2_1_28 \$863 \$1854 \$2 \$1 \$576 sg13cmos5l_nor2_1
* cell instance sg13cmos5l_nor2_1_29 r0 *1 0,0
Xsg13cmos5l_nor2_1_29 \$412 \$690 \$2 \$1 \$868 sg13cmos5l_nor2_1
* cell instance sg13cmos5l_nor2_1_30 r0 *1 0,0
Xsg13cmos5l_nor2_1_30 \$690 \$139 \$2 \$1 \$706 sg13cmos5l_nor2_1
* cell instance sg13cmos5l_nor2_1_31 r0 *1 0,0
Xsg13cmos5l_nor2_1_31 \$717 \$716 \$2 \$1 \$718 sg13cmos5l_nor2_1
* cell instance sg13cmos5l_nor2_1_32 r0 *1 0,0
Xsg13cmos5l_nor2_1_32 \$2082 \$2895 \$2 \$1 \$13900 sg13cmos5l_nor2_1
* cell instance sg13cmos5l_nor2_1_33 r0 *1 0,0
Xsg13cmos5l_nor2_1_33 \$427 \$716 \$2 \$1 \$605 sg13cmos5l_nor2_1
* cell instance sg13cmos5l_nor2_1_34 r0 *1 0,0
Xsg13cmos5l_nor2_1_34 \$582 \$458 \$2 \$1 \$255 sg13cmos5l_nor2_1
* cell instance sg13cmos5l_nor2_1_35 r0 *1 0,0
Xsg13cmos5l_nor2_1_35 \$148 \$487 \$2 \$1 \$486 sg13cmos5l_nor2_1
* cell instance sg13cmos5l_nor2_1_36 r0 *1 0,0
Xsg13cmos5l_nor2_1_36 \$1405 \$929 \$2 \$1 \$1406 sg13cmos5l_nor2_1
* cell instance sg13cmos5l_nor2_1_37 r0 *1 0,0
Xsg13cmos5l_nor2_1_37 \$637 \$638 \$2 \$1 \$487 sg13cmos5l_nor2_1
* cell instance sg13cmos5l_nor2_1_38 r0 *1 0,0
Xsg13cmos5l_nor2_1_38 \$149 \$150 \$2 \$1 \$148 sg13cmos5l_nor2_1
* cell instance sg13cmos5l_nor2_1_39 r0 *1 0,0
Xsg13cmos5l_nor2_1_39 \$20 \$183 \$2 \$1 \$182 sg13cmos5l_nor2_1
* cell instance sg13cmos5l_nor2b_1_0 r0 *1 0,0
Xsg13cmos5l_nor2b_1_0 \$3017 \$3257 \$2 \$1 \$3790 sg13cmos5l_nor2b_1
* cell instance sg13cmos5l_nor2b_1_1 r0 *1 0,0
Xsg13cmos5l_nor2b_1_1 \$4093 \$4091 \$2 \$1 \$3826 sg13cmos5l_nor2b_1
* cell instance sg13cmos5l_nor2b_1_2 r0 *1 0,0
Xsg13cmos5l_nor2b_1_2 \$7106 \$3501 \$2 \$1 \$6677 sg13cmos5l_nor2b_1
* cell instance sg13cmos5l_nor2b_1_3 r0 *1 0,0
Xsg13cmos5l_nor2b_1_3 \$1931 \$2174 \$2 \$1 \$3274 sg13cmos5l_nor2b_1
* cell instance sg13cmos5l_nor2b_1_4 r0 *1 0,0
Xsg13cmos5l_nor2b_1_4 \$5140 \$3269 \$2 \$1 \$7775 sg13cmos5l_nor2b_1
* cell instance sg13cmos5l_nor2b_1_5 r0 *1 0,0
Xsg13cmos5l_nor2b_1_5 \$5793 \$7273 \$2 \$1 \$4766 sg13cmos5l_nor2b_1
* cell instance sg13cmos5l_nor2b_1_6 r0 *1 0,0
Xsg13cmos5l_nor2b_1_6 \$5362 \$5649 \$2 \$1 \$4098 sg13cmos5l_nor2b_1
* cell instance sg13cmos5l_nor2b_1_7 r0 *1 0,0
Xsg13cmos5l_nor2b_1_7 \$7274 \$2761 \$2 \$1 \$8720 sg13cmos5l_nor2b_1
* cell instance sg13cmos5l_nor2b_1_8 r0 *1 0,0
Xsg13cmos5l_nor2b_1_8 \$1911 \$1869 \$2 \$1 \$2275 sg13cmos5l_nor2b_1
* cell instance sg13cmos5l_nor2b_1_9 r0 *1 0,0
Xsg13cmos5l_nor2b_1_9 \$61 \$18 \$2 \$1 \$159 sg13cmos5l_nor2b_1
* cell instance sg13cmos5l_nor3_1_0 r0 *1 0,0
Xsg13cmos5l_nor3_1_0 \$2271 \$2208 \$4087 \$2 \$1 \$4612 sg13cmos5l_nor3_1
* cell instance sg13cmos5l_nor3_1_1 r0 *1 0,0
Xsg13cmos5l_nor3_1_1 \$2426 \$2208 \$2755 \$2 \$1 \$2178 sg13cmos5l_nor3_1
* cell instance sg13cmos5l_nor3_1_2 r0 *1 0,0
Xsg13cmos5l_nor3_1_2 \$2271 \$2723 \$2755 \$2 \$1 \$2206 sg13cmos5l_nor3_1
* cell instance sg13cmos5l_nor3_1_3 r0 *1 0,0
Xsg13cmos5l_nor3_1_3 \$2426 \$2723 \$2755 \$2 \$1 \$1878 sg13cmos5l_nor3_1
* cell instance sg13cmos5l_nor3_1_4 r0 *1 0,0
Xsg13cmos5l_nor3_1_4 \$5141 \$4158 \$6496 \$2 \$1 \$5362 sg13cmos5l_nor3_1
* cell instance sg13cmos5l_nor3_1_5 r0 *1 0,0
Xsg13cmos5l_nor3_1_5 \$237 \$32 \$399 \$2 \$1 \$398 sg13cmos5l_nor3_1
* cell instance sg13cmos5l_nor3_1_6 r0 *1 0,0
Xsg13cmos5l_nor3_1_6 \$5141 \$4158 \$5723 \$2 \$1 \$5223 sg13cmos5l_nor3_1
* cell instance sg13cmos5l_nor3_1_7 r0 *1 0,0
Xsg13cmos5l_nor3_1_7 \$3073 \$3522 \$4100 \$2 \$1 \$4099 sg13cmos5l_nor3_1
* cell instance sg13cmos5l_nor3_1_8 r0 *1 0,0
Xsg13cmos5l_nor3_1_8 \$2762 \$3501 \$3020 \$2 \$1 \$3262 sg13cmos5l_nor3_1
* cell instance sg13cmos5l_nor3_1_9 r0 *1 0,0
Xsg13cmos5l_nor3_1_9 \$1691 \$824 \$2458 \$2 \$1 \$2897 sg13cmos5l_nor3_1
* cell instance sg13cmos5l_nor3_1_10 r0 *1 0,0
Xsg13cmos5l_nor3_1_10 \$1863 \$1568 \$1848 \$2 \$1 \$1785 sg13cmos5l_nor3_1
* cell instance sg13cmos5l_nor3_1_11 r0 *1 0,0
Xsg13cmos5l_nor3_1_11 \$505 \$339 \$499 \$2 \$1 \$506 sg13cmos5l_nor3_1
* cell instance sg13cmos5l_nor4_1_0 r0 *1 0,0
Xsg13cmos5l_nor4_1_0 \$399 \$700 \$387 \$845 \$2 \$1 \$561 sg13cmos5l_nor4_1
* cell instance sg13cmos5l_nor4_1_1 r0 *1 0,0
Xsg13cmos5l_nor4_1_1 \$4766 \$5359 \$4026 \$4618 \$2 \$1 \$4617
+ sg13cmos5l_nor4_1
* cell instance sg13cmos5l_nor4_1_2 r0 *1 0,0
Xsg13cmos5l_nor4_1_2 \$7705 \$7706 \$5137 \$7273 \$2 \$1 \$4765
+ sg13cmos5l_nor4_1
* cell instance sg13cmos5l_nor4_1_3 r0 *1 0,0
Xsg13cmos5l_nor4_1_3 \$2275 \$3073 \$3522 \$4098 \$2 \$1 \$4083
+ sg13cmos5l_nor4_1
* cell instance sg13cmos5l_nor4_1_4 r0 *1 0,0
Xsg13cmos5l_nor4_1_4 \$392 \$1562 \$860 \$1561 \$2 \$1 \$1846 sg13cmos5l_nor4_1
* cell instance sg13cmos5l_nor4_1_5 r0 *1 0,0
Xsg13cmos5l_nor4_1_5 \$863 \$875 \$1909 \$1910 \$2 \$1 \$1908 sg13cmos5l_nor4_1
* cell instance sg13cmos5l_nor4_1_6 r0 *1 0,0
Xsg13cmos5l_nor4_1_6 \$2275 \$2762 \$2763 \$2760 \$2 \$1 \$2730
+ sg13cmos5l_nor4_1
* cell instance sg13cmos5l_nor4_1_7 r0 *1 0,0
Xsg13cmos5l_nor4_1_7 \$2082 \$1691 \$824 \$1909 \$2 \$1 \$2945 sg13cmos5l_nor4_1
* cell instance sg13cmos5l_nor4_1_8 r0 *1 0,0
Xsg13cmos5l_nor4_1_8 \$3451 \$4099 \$4617 \$4101 \$2 \$1 \$3926
+ sg13cmos5l_nor4_1
* cell instance sg13cmos5l_nor4_1_9 r0 *1 0,0
Xsg13cmos5l_nor4_1_9 \$5221 \$4157 \$3795 \$4166 \$2 \$1 \$4101
+ sg13cmos5l_nor4_1
* cell instance sg13cmos5l_nor4_1_10 r0 *1 0,0
Xsg13cmos5l_nor4_1_10 \$10212 \$1691 \$824 \$1909 \$2 \$1 \$2759
+ sg13cmos5l_nor4_1
* cell instance sg13cmos5l_nor4_1_11 r0 *1 0,0
Xsg13cmos5l_nor4_1_11 \$1864 \$1851 \$1563 \$1844 \$2 \$1 \$1852
+ sg13cmos5l_nor4_1
* cell instance sg13cmos5l_nor4_1_12 r0 *1 0,0
Xsg13cmos5l_nor4_1_12 \$662 \$505 \$339 \$179 \$2 \$1 \$150 sg13cmos5l_nor4_1
* cell instance sg13cmos5l_nor4_1_13 r0 *1 0,0
Xsg13cmos5l_nor4_1_13 \$662 \$795 \$1411 \$798 \$2 \$1 \$799 sg13cmos5l_nor4_1
* cell instance sg13cmos5l_nor4_1_14 r0 *1 0,0
Xsg13cmos5l_nor4_1_14 \$662 \$798 \$506 \$800 \$2 \$1 \$801 sg13cmos5l_nor4_1
* cell instance sg13cmos5l_o21ai_1_0 r0 *1 0,0
Xsg13cmos5l_o21ai_1_0 \$374 \$375 \$377 \$2 \$1 \$376 sg13cmos5l_o21ai_1
* cell instance sg13cmos5l_o21ai_1_1 r0 *1 0,0
Xsg13cmos5l_o21ai_1_1 \$200 \$202 \$31 \$2 \$1 \$203 sg13cmos5l_o21ai_1
* cell instance sg13cmos5l_o21ai_1_2 r0 *1 0,0
Xsg13cmos5l_o21ai_1_2 \$4094 \$3493 \$4019 \$2 \$1 \$4076 sg13cmos5l_o21ai_1
* cell instance sg13cmos5l_o21ai_1_3 r0 *1 0,0
Xsg13cmos5l_o21ai_1_3 \$2174 \$1931 \$2888 \$2 \$1 \$2886 sg13cmos5l_o21ai_1
* cell instance sg13cmos5l_o21ai_1_4 r0 *1 0,0
Xsg13cmos5l_o21ai_1_4 \$6496 \$4076 \$3501 \$2 \$1 \$6358 sg13cmos5l_o21ai_1
* cell instance sg13cmos5l_o21ai_1_5 r0 *1 0,0
Xsg13cmos5l_o21ai_1_5 \$854 \$693 \$855 \$2 \$1 \$851 sg13cmos5l_o21ai_1
* cell instance sg13cmos5l_o21ai_1_6 r0 *1 0,0
Xsg13cmos5l_o21ai_1_6 \$5141 \$4158 \$6496 \$2 \$1 \$5649 sg13cmos5l_o21ai_1
* cell instance sg13cmos5l_o21ai_1_7 r0 *1 0,0
Xsg13cmos5l_o21ai_1_7 \$391 \$1544 \$1088 \$2 \$1 \$1319 sg13cmos5l_o21ai_1
* cell instance sg13cmos5l_o21ai_1_8 r0 *1 0,0
Xsg13cmos5l_o21ai_1_8 \$845 \$854 \$391 \$2 \$1 \$693 sg13cmos5l_o21ai_1
* cell instance sg13cmos5l_o21ai_1_9 r0 *1 0,0
Xsg13cmos5l_o21ai_1_9 \$560 \$387 \$703 \$2 \$1 \$388 sg13cmos5l_o21ai_1
* cell instance sg13cmos5l_o21ai_1_10 r0 *1 0,0
Xsg13cmos5l_o21ai_1_10 \$3068 \$3205 \$3018 \$2 \$1 \$3520 sg13cmos5l_o21ai_1
* cell instance sg13cmos5l_o21ai_1_11 r0 *1 0,0
Xsg13cmos5l_o21ai_1_11 \$237 \$32 \$399 \$2 \$1 \$705 sg13cmos5l_o21ai_1
* cell instance sg13cmos5l_o21ai_1_12 r0 *1 0,0
Xsg13cmos5l_o21ai_1_12 \$1848 \$2459 \$2084 \$2 \$1 \$2437 sg13cmos5l_o21ai_1
* cell instance sg13cmos5l_o21ai_1_13 r0 *1 0,0
Xsg13cmos5l_o21ai_1_13 \$4046 \$7109 \$3501 \$2 \$1 \$7275 sg13cmos5l_o21ai_1
* cell instance sg13cmos5l_o21ai_1_14 r0 *1 0,0
Xsg13cmos5l_o21ai_1_14 \$2275 \$2762 \$1545 \$2 \$1 \$3451 sg13cmos5l_o21ai_1
* cell instance sg13cmos5l_o21ai_1_15 r0 *1 0,0
Xsg13cmos5l_o21ai_1_15 \$5223 \$5224 \$4046 \$2 \$1 \$5145 sg13cmos5l_o21ai_1
* cell instance sg13cmos5l_o21ai_1_16 r0 *1 0,0
Xsg13cmos5l_o21ai_1_16 \$4091 \$4093 \$2921 \$2 \$1 \$4323 sg13cmos5l_o21ai_1
* cell instance sg13cmos5l_o21ai_1_17 r0 *1 0,0
Xsg13cmos5l_o21ai_1_17 \$4046 \$7109 \$8278 \$2 \$1 \$8129 sg13cmos5l_o21ai_1
* cell instance sg13cmos5l_o21ai_1_18 r0 *1 0,0
Xsg13cmos5l_o21ai_1_18 \$5800 \$5725 \$2731 \$2 \$1 \$6215 sg13cmos5l_o21ai_1
* cell instance sg13cmos5l_o21ai_1_19 r0 *1 0,0
Xsg13cmos5l_o21ai_1_19 \$863 \$1110 \$260 \$2 \$1 \$865 sg13cmos5l_o21ai_1
* cell instance sg13cmos5l_o21ai_1_20 r0 *1 0,0
Xsg13cmos5l_o21ai_1_20 \$1341 \$589 \$1342 \$2 \$1 \$707 sg13cmos5l_o21ai_1
* cell instance sg13cmos5l_o21ai_1_21 r0 *1 0,0
Xsg13cmos5l_o21ai_1_21 \$707 \$1785 \$868 \$2 \$1 \$709 sg13cmos5l_o21ai_1
* cell instance sg13cmos5l_o21ai_1_22 r0 *1 0,0
Xsg13cmos5l_o21ai_1_22 \$875 \$872 \$720 \$2 \$1 \$876 sg13cmos5l_o21ai_1
* cell instance sg13cmos5l_or2_1_0 r0 *1 0,0
Xsg13cmos5l_or2_1_0 \$2271 \$2208 \$2 \$1 \$3499 sg13cmos5l_or2_1
* cell instance sg13cmos5l_or2_1_1 r0 *1 0,0
Xsg13cmos5l_or2_1_1 \$206 \$205 \$2 \$1 \$374 sg13cmos5l_or2_1
* cell instance sg13cmos5l_or2_1_2 r0 *1 0,0
Xsg13cmos5l_or2_1_2 \$4764 \$8282 \$2 \$1 \$7273 sg13cmos5l_or2_1
* cell instance sg13cmos5l_or2_1_3 r0 *1 0,0
Xsg13cmos5l_or2_1_3 \$4097 \$4235 \$2 \$1 \$4157 sg13cmos5l_or2_1
* cell instance sg13cmos5l_or2_1_4 r0 *1 0,0
Xsg13cmos5l_or2_1_4 \$2434 \$2138 \$2 \$1 \$3097 sg13cmos5l_or2_1
* cell instance sg13cmos5l_or2_1_5 r0 *1 0,0
Xsg13cmos5l_or2_1_5 \$9181 \$9183 \$2 \$1 \$7706 sg13cmos5l_or2_1
* cell instance sg13cmos5l_or2_1_6 r0 *1 0,0
Xsg13cmos5l_or2_1_6 \$9527 \$8718 \$2 \$1 \$7705 sg13cmos5l_or2_1
* cell instance sg13cmos5l_or2_1_7 r0 *1 0,0
Xsg13cmos5l_or2_1_7 \$1869 \$1911 \$2 \$1 \$2459 sg13cmos5l_or2_1
* cell instance sg13cmos5l_or2_1_8 r0 *1 0,0
Xsg13cmos5l_or2_1_8 \$3206 \$3262 \$2 \$1 \$3275 sg13cmos5l_or2_1
* cell instance sg13cmos5l_or2_1_9 r0 *1 0,0
Xsg13cmos5l_or2_1_9 \$690 \$587 \$2 \$1 \$728 sg13cmos5l_or2_1
* cell instance sg13cmos5l_or2_1_10 r0 *1 0,0
Xsg13cmos5l_or2_1_10 \$301 \$636 \$2 \$1 \$475 sg13cmos5l_or2_1
* cell instance sg13cmos5l_or2_1_11 r0 *1 0,0
Xsg13cmos5l_or2_1_11 \$675 \$806 \$2 \$1 \$179 sg13cmos5l_or2_1
* cell instance sg13cmos5l_or3_1_0 r0 *1 0,0
Xsg13cmos5l_or3_1_0 \$4767 \$4094 \$4723 \$2 \$1 \$4618 sg13cmos5l_or3_1
* cell instance sg13cmos5l_or3_1_1 r0 *1 0,0
Xsg13cmos5l_or3_1_1 \$716 \$602 \$448 \$2 \$1 \$373 sg13cmos5l_or3_1
* cell instance sg13cmos5l_or4_1_0 r0 *1 0,0
Xsg13cmos5l_or4_1_0 \$5800 \$5725 \$5799 \$5144 \$2 \$1 \$3925 sg13cmos5l_or4_1
* cell instance sg13cmos5l_tiehi_0 r0 *1 0,0
Xsg13cmos5l_tiehi_0 \$1582 \$2 \$1 sg13cmos5l_tiehi
* cell instance sg13cmos5l_tiehi_1 r0 *1 0,0
Xsg13cmos5l_tiehi_1 \$1356 \$2 \$1 sg13cmos5l_tiehi
* cell instance sg13cmos5l_tiehi_2 r0 *1 0,0
Xsg13cmos5l_tiehi_2 \$724 \$2 \$1 sg13cmos5l_tiehi
* cell instance sg13cmos5l_tiehi_3 r0 *1 0,0
Xsg13cmos5l_tiehi_3 \$748 \$2 \$1 sg13cmos5l_tiehi
* cell instance sg13cmos5l_tiehi_4 r0 *1 0,0
Xsg13cmos5l_tiehi_4 \$1623 \$2 \$1 sg13cmos5l_tiehi
* cell instance sg13cmos5l_tiehi_5 r0 *1 0,0
Xsg13cmos5l_tiehi_5 \$298 \$2 \$1 sg13cmos5l_tiehi
* cell instance sg13cmos5l_tiehi_6 r0 *1 0,0
Xsg13cmos5l_tiehi_6 \$1403 \$2 \$1 sg13cmos5l_tiehi
* cell instance sg13cmos5l_tiehi_7 r0 *1 0,0
Xsg13cmos5l_tiehi_7 \$1650 \$2 \$1 sg13cmos5l_tiehi
* cell instance sg13cmos5l_tiehi_8 r0 *1 0,0
Xsg13cmos5l_tiehi_8 \$769 \$2 \$1 sg13cmos5l_tiehi
* cell instance sg13cmos5l_tiehi_9 r0 *1 0,0
Xsg13cmos5l_tiehi_9 \$1700 \$2 \$1 sg13cmos5l_tiehi
* cell instance sg13cmos5l_tiehi_10 r0 *1 0,0
Xsg13cmos5l_tiehi_10 \$1704 \$2 \$1 sg13cmos5l_tiehi
* cell instance sg13cmos5l_tiehi_11 r0 *1 0,0
Xsg13cmos5l_tiehi_11 \$1480 \$2 \$1 sg13cmos5l_tiehi
* cell instance sg13cmos5l_tiehi_12 r0 *1 0,0
Xsg13cmos5l_tiehi_12 \$1492 \$2 \$1 sg13cmos5l_tiehi
* cell instance sg13cmos5l_tiehi_13 r0 *1 0,0
Xsg13cmos5l_tiehi_13 \$1496 \$2 \$1 sg13cmos5l_tiehi
* cell instance sg13cmos5l_tiehi_14 r0 *1 0,0
Xsg13cmos5l_tiehi_14 \$1026 \$2 \$1 sg13cmos5l_tiehi
* cell instance sg13cmos5l_tiehi_15 r0 *1 0,0
Xsg13cmos5l_tiehi_15 \$1038 \$2 \$1 sg13cmos5l_tiehi
* cell instance sg13cmos5l_tiehi_16 r0 *1 0,0
Xsg13cmos5l_tiehi_16 \$839 \$2 \$1 sg13cmos5l_tiehi
* cell instance sg13cmos5l_tiehi_17 r0 *1 0,0
Xsg13cmos5l_tiehi_17 \$1303 \$2 \$1 sg13cmos5l_tiehi
* cell instance sg13cmos5l_tielo_0 r0 *1 0,0
Xsg13cmos5l_tielo_0 \$13823 \$2 \$1 sg13cmos5l_tielo
* cell instance sg13cmos5l_tielo_1 r0 *1 0,0
Xsg13cmos5l_tielo_1 \$13827 \$2 \$1 sg13cmos5l_tielo
* cell instance sg13cmos5l_tielo_2 r0 *1 0,0
Xsg13cmos5l_tielo_2 \$13772 \$2 \$1 sg13cmos5l_tielo
* cell instance sg13cmos5l_tielo_3 r0 *1 0,0
Xsg13cmos5l_tielo_3 \$13831 \$2 \$1 sg13cmos5l_tielo
* cell instance sg13cmos5l_tielo_4 r0 *1 0,0
Xsg13cmos5l_tielo_4 \$13694 \$2 \$1 sg13cmos5l_tielo
* cell instance sg13cmos5l_tielo_5 r0 *1 0,0
Xsg13cmos5l_tielo_5 \$13844 \$2 \$1 sg13cmos5l_tielo
* cell instance sg13cmos5l_tielo_6 r0 *1 0,0
Xsg13cmos5l_tielo_6 \$13741 \$2 \$1 sg13cmos5l_tielo
* cell instance sg13cmos5l_tielo_7 r0 *1 0,0
Xsg13cmos5l_tielo_7 \$13749 \$2 \$1 sg13cmos5l_tielo
* cell instance sg13cmos5l_tielo_8 r0 *1 0,0
Xsg13cmos5l_tielo_8 \$1913 \$2 \$1 sg13cmos5l_tielo
* cell instance sg13cmos5l_tielo_9 r0 *1 0,0
Xsg13cmos5l_tielo_9 \$1578 \$2 \$1 sg13cmos5l_tielo
* cell instance sg13cmos5l_tielo_10 r0 *1 0,0
Xsg13cmos5l_tielo_10 \$1586 \$2 \$1 sg13cmos5l_tielo
* cell instance sg13cmos5l_tielo_11 r0 *1 0,0
Xsg13cmos5l_tielo_11 \$1122 \$2 \$1 sg13cmos5l_tielo
* cell instance sg13cmos5l_tielo_12 r0 *1 0,0
Xsg13cmos5l_tielo_12 \$1600 \$2 \$1 sg13cmos5l_tielo
* cell instance sg13cmos5l_tielo_13 r0 *1 0,0
Xsg13cmos5l_tielo_13 \$732 \$2 \$1 sg13cmos5l_tielo
* cell instance sg13cmos5l_tielo_14 r0 *1 0,0
Xsg13cmos5l_tielo_14 \$736 \$2 \$1 sg13cmos5l_tielo
* cell instance sg13cmos5l_tielo_15 r0 *1 0,0
Xsg13cmos5l_tielo_15 \$1137 \$2 \$1 sg13cmos5l_tielo
* cell instance sg13cmos5l_tielo_16 r0 *1 0,0
Xsg13cmos5l_tielo_16 \$740 \$2 \$1 sg13cmos5l_tielo
* cell instance sg13cmos5l_tielo_17 r0 *1 0,0
Xsg13cmos5l_tielo_17 \$744 \$2 \$1 sg13cmos5l_tielo
* cell instance sg13cmos5l_tielo_18 r0 *1 0,0
Xsg13cmos5l_tielo_18 \$1619 \$2 \$1 sg13cmos5l_tielo
* cell instance sg13cmos5l_tielo_19 r0 *1 0,0
Xsg13cmos5l_tielo_19 \$1379 \$2 \$1 sg13cmos5l_tielo
* cell instance sg13cmos5l_tielo_20 r0 *1 0,0
Xsg13cmos5l_tielo_20 \$764 \$2 \$1 sg13cmos5l_tielo
* cell instance sg13cmos5l_tielo_21 r0 *1 0,0
Xsg13cmos5l_tielo_21 \$1306 \$2 \$1 sg13cmos5l_tielo
* cell instance sg13cmos5l_tielo_22 r0 *1 0,0
Xsg13cmos5l_tielo_22 \$1646 \$2 \$1 sg13cmos5l_tielo
* cell instance sg13cmos5l_tielo_23 r0 *1 0,0
Xsg13cmos5l_tielo_23 \$1409 \$2 \$1 sg13cmos5l_tielo
* cell instance sg13cmos5l_tielo_24 r0 *1 0,0
Xsg13cmos5l_tielo_24 \$938 \$2 \$1 sg13cmos5l_tielo
* cell instance sg13cmos5l_tielo_25 r0 *1 0,0
Xsg13cmos5l_tielo_25 \$942 \$2 \$1 sg13cmos5l_tielo
* cell instance sg13cmos5l_tielo_26 r0 *1 0,0
Xsg13cmos5l_tielo_26 \$946 \$2 \$1 sg13cmos5l_tielo
* cell instance sg13cmos5l_tielo_27 r0 *1 0,0
Xsg13cmos5l_tielo_27 \$950 \$2 \$1 sg13cmos5l_tielo
* cell instance sg13cmos5l_tielo_28 r0 *1 0,0
Xsg13cmos5l_tielo_28 \$786 \$2 \$1 sg13cmos5l_tielo
* cell instance sg13cmos5l_tielo_29 r0 *1 0,0
Xsg13cmos5l_tielo_29 \$2203 \$2 \$1 sg13cmos5l_tielo
* cell instance sg13cmos5l_tielo_30 r0 *1 0,0
Xsg13cmos5l_tielo_30 \$1681 \$2 \$1 sg13cmos5l_tielo
* cell instance sg13cmos5l_tielo_31 r0 *1 0,0
Xsg13cmos5l_tielo_31 \$1441 \$2 \$1 sg13cmos5l_tielo
* cell instance sg13cmos5l_tielo_32 r0 *1 0,0
Xsg13cmos5l_tielo_32 \$1685 \$2 \$1 sg13cmos5l_tielo
* cell instance sg13cmos5l_tielo_33 r0 *1 0,0
Xsg13cmos5l_tielo_33 \$1689 \$2 \$1 sg13cmos5l_tielo
* cell instance sg13cmos5l_tielo_34 r0 *1 0,0
Xsg13cmos5l_tielo_34 \$1856 \$2 \$1 sg13cmos5l_tielo
* cell instance sg13cmos5l_tielo_35 r0 *1 0,0
Xsg13cmos5l_tielo_35 \$1456 \$2 \$1 sg13cmos5l_tielo
* cell instance sg13cmos5l_tielo_36 r0 *1 0,0
Xsg13cmos5l_tielo_36 \$1696 \$2 \$1 sg13cmos5l_tielo
* cell instance sg13cmos5l_tielo_37 r0 *1 0,0
Xsg13cmos5l_tielo_37 \$1708 \$2 \$1 sg13cmos5l_tielo
* cell instance sg13cmos5l_tielo_38 r0 *1 0,0
Xsg13cmos5l_tielo_38 \$1712 \$2 \$1 sg13cmos5l_tielo
* cell instance sg13cmos5l_tielo_39 r0 *1 0,0
Xsg13cmos5l_tielo_39 \$1716 \$2 \$1 sg13cmos5l_tielo
* cell instance sg13cmos5l_tielo_40 r0 *1 0,0
Xsg13cmos5l_tielo_40 \$1476 \$2 \$1 sg13cmos5l_tielo
* cell instance sg13cmos5l_tielo_41 r0 *1 0,0
Xsg13cmos5l_tielo_41 \$1006 \$2 \$1 sg13cmos5l_tielo
* cell instance sg13cmos5l_tielo_42 r0 *1 0,0
Xsg13cmos5l_tielo_42 \$1010 \$2 \$1 sg13cmos5l_tielo
* cell instance sg13cmos5l_tielo_43 r0 *1 0,0
Xsg13cmos5l_tielo_43 \$1307 \$2 \$1 sg13cmos5l_tielo
* cell instance sg13cmos5l_tielo_44 r0 *1 0,0
Xsg13cmos5l_tielo_44 \$1030 \$2 \$1 sg13cmos5l_tielo
* cell instance sg13cmos5l_tielo_45 r0 *1 0,0
Xsg13cmos5l_tielo_45 \$1510 \$2 \$1 sg13cmos5l_tielo
* cell instance sg13cmos5l_tielo_46 r0 *1 0,0
Xsg13cmos5l_tielo_46 \$831 \$2 \$1 sg13cmos5l_tielo
* cell instance sg13cmos5l_tielo_47 r0 *1 0,0
Xsg13cmos5l_tielo_47 \$1042 \$2 \$1 sg13cmos5l_tielo
* cell instance sg13cmos5l_tielo_48 r0 *1 0,0
Xsg13cmos5l_tielo_48 \$835 \$2 \$1 sg13cmos5l_tielo
* cell instance sg13cmos5l_tielo_49 r0 *1 0,0
Xsg13cmos5l_tielo_49 \$843 \$2 \$1 sg13cmos5l_tielo
* cell instance sg13cmos5l_tielo_50 r0 *1 0,0
Xsg13cmos5l_tielo_50 \$1058 \$2 \$1 sg13cmos5l_tielo
* cell instance sg13cmos5l_tielo_51 r0 *1 0,0
Xsg13cmos5l_tielo_51 \$1539 \$2 \$1 sg13cmos5l_tielo
* cell instance sg13cmos5l_tielo_52 r0 *1 0,0
Xsg13cmos5l_tielo_52 \$1915 \$2 \$1 sg13cmos5l_tielo
* cell instance sg13cmos5l_xnor2_1_0 r0 *1 0,0
Xsg13cmos5l_xnor2_1_0 \$3257 \$3017 \$2 \$1 \$3517 sg13cmos5l_xnor2_1
* cell instance sg13cmos5l_xnor2_1_1 r0 *1 0,0
Xsg13cmos5l_xnor2_1_1 \$3517 \$3789 \$2 \$1 \$3923 sg13cmos5l_xnor2_1
* cell instance sg13cmos5l_xnor2_1_2 r0 *1 0,0
Xsg13cmos5l_xnor2_1_2 \$2174 \$1931 \$2 \$1 \$3068 sg13cmos5l_xnor2_1
* cell instance sg13cmos5l_xnor2_1_3 r0 *1 0,0
Xsg13cmos5l_xnor2_1_3 \$5359 \$5720 \$2 \$1 \$5361 sg13cmos5l_xnor2_1
* cell instance sg13cmos5l_xnor2_1_4 r0 *1 0,0
Xsg13cmos5l_xnor2_1_4 \$3491 \$3520 \$2 \$1 \$3738 sg13cmos5l_xnor2_1
* cell instance sg13cmos5l_xnor2_1_5 r0 *1 0,0
Xsg13cmos5l_xnor2_1_5 \$237 \$89 \$2 \$1 \$239 sg13cmos5l_xnor2_1
* cell instance sg13cmos5l_xnor2_1_6 r0 *1 0,0
Xsg13cmos5l_xnor2_1_6 \$4046 \$6214 \$2 \$1 \$5799 sg13cmos5l_xnor2_1
* cell instance sg13cmos5l_xnor2_1_7 r0 *1 0,0
Xsg13cmos5l_xnor2_1_7 \$4767 \$8129 \$2 \$1 \$7277 sg13cmos5l_xnor2_1
* cell instance sg13cmos5l_xnor2_1_8 r0 *1 0,0
Xsg13cmos5l_xnor2_1_8 \$247 \$249 \$2 \$1 \$250 sg13cmos5l_xnor2_1
* cell instance sg13cmos5l_xnor2_1_9 r0 *1 0,0
Xsg13cmos5l_xnor2_1_9 \$134 \$458 \$2 \$1 \$456 sg13cmos5l_xnor2_1
* cell instance sg13cmos5l_xnor2_1_10 r0 *1 0,0
Xsg13cmos5l_xnor2_1_10 \$157 \$18 \$2 \$1 \$158 sg13cmos5l_xnor2_1
* cell instance sg13cmos5l_xnor2_1_11 r0 *1 0,0
Xsg13cmos5l_xnor2_1_11 \$795 \$779 \$2 \$1 \$797 sg13cmos5l_xnor2_1
* cell instance sg13cmos5l_xnor2_1_12 r0 *1 0,0
Xsg13cmos5l_xnor2_1_12 \$808 \$800 \$2 \$1 \$1224 sg13cmos5l_xnor2_1
* cell instance sg13cmos5l_xnor2_1_13 r0 *1 0,0
Xsg13cmos5l_xnor2_1_13 \$807 \$1461 \$2 \$1 \$1463 sg13cmos5l_xnor2_1
* cell instance sg13cmos5l_xnor2_1_14 r0 *1 0,0
Xsg13cmos5l_xnor2_1_14 \$674 \$806 \$2 \$1 \$534 sg13cmos5l_xnor2_1
* cell instance sg13cmos5l_xor2_1_0 r0 *1 0,0
Xsg13cmos5l_xor2_1_0 \$4091 \$4093 \$2 \$1 \$3491 sg13cmos5l_xor2_1
* cell instance sg13cmos5l_xor2_1_1 r0 *1 0,0
Xsg13cmos5l_xor2_1_1 \$3068 \$3071 \$2 \$1 \$3072 sg13cmos5l_xor2_1
* cell instance sg13cmos5l_xor2_1_2 r0 *1 0,0
Xsg13cmos5l_xor2_1_2 \$3517 \$3830 \$2 \$1 \$3737 sg13cmos5l_xor2_1
* cell instance sg13cmos5l_xor2_1_3 r0 *1 0,0
Xsg13cmos5l_xor2_1_3 \$3068 \$3205 \$2 \$1 \$3073 sg13cmos5l_xor2_1
* cell instance sg13cmos5l_xor2_1_4 r0 *1 0,0
Xsg13cmos5l_xor2_1_4 \$3491 \$3520 \$2 \$1 \$3832 sg13cmos5l_xor2_1
* cell instance sg13cmos5l_xor2_1_5 r0 *1 0,0
Xsg13cmos5l_xor2_1_5 \$537 \$266 \$2 \$1 \$262 sg13cmos5l_xor2_1
* cell instance sg13cmos5l_xor2_1_6 r0 *1 0,0
Xsg13cmos5l_xor2_1_6 \$455 \$448 \$2 \$1 \$607 sg13cmos5l_xor2_1
* cell instance sg13cmos5l_xor2_1_7 r0 *1 0,0
Xsg13cmos5l_xor2_1_7 \$22 \$20 \$2 \$1 \$19 sg13cmos5l_xor2_1
* cell instance sg13cmos5l_xor2_1_8 r0 *1 0,0
Xsg13cmos5l_xor2_1_8 \$515 \$517 \$2 \$1 \$667 sg13cmos5l_xor2_1
* cell instance sg13cmos5l_xor2_1_9 r0 *1 0,0
Xsg13cmos5l_xor2_1_9 \$348 \$181 \$2 \$1 \$187 sg13cmos5l_xor2_1
.ENDS tt_um_2amlogic_protocol_emulator

* cell sg13cmos5l_xor2_1
* pin A
* pin B
* pin VDD
* pin VSS
* pin X
.SUBCKT sg13cmos5l_xor2_1 A B VDD VSS X
.ENDS sg13cmos5l_xor2_1

* cell sg13cmos5l_xnor2_1
* pin A
* pin B
* pin VDD
* pin VSS
* pin Y
.SUBCKT sg13cmos5l_xnor2_1 A B VDD VSS Y
.ENDS sg13cmos5l_xnor2_1

* cell sg13cmos5l_tielo
* pin L_LO
* pin VDD
* pin VSS
.SUBCKT sg13cmos5l_tielo L_LO VDD VSS
.ENDS sg13cmos5l_tielo

* cell sg13cmos5l_tiehi
* pin L_HI
* pin VDD
* pin VSS
.SUBCKT sg13cmos5l_tiehi L_HI VDD VSS
.ENDS sg13cmos5l_tiehi

* cell sg13cmos5l_or4_1
* pin A
* pin B
* pin C
* pin D
* pin VDD
* pin VSS
* pin X
.SUBCKT sg13cmos5l_or4_1 A B C D VDD VSS X
.ENDS sg13cmos5l_or4_1

* cell sg13cmos5l_or3_1
* pin A
* pin B
* pin C
* pin VDD
* pin VSS
* pin X
.SUBCKT sg13cmos5l_or3_1 A B C VDD VSS X
.ENDS sg13cmos5l_or3_1

* cell sg13cmos5l_or2_1
* pin A
* pin B
* pin VDD
* pin VSS
* pin X
.SUBCKT sg13cmos5l_or2_1 A B VDD VSS X
.ENDS sg13cmos5l_or2_1

* cell sg13cmos5l_o21ai_1
* pin A1
* pin A2
* pin B1
* pin VDD
* pin VSS
* pin Y
.SUBCKT sg13cmos5l_o21ai_1 A1 A2 B1 VDD VSS Y
.ENDS sg13cmos5l_o21ai_1

* cell sg13cmos5l_nor4_1
* pin A
* pin B
* pin C
* pin D
* pin VDD
* pin VSS
* pin Y
.SUBCKT sg13cmos5l_nor4_1 A B C D VDD VSS Y
.ENDS sg13cmos5l_nor4_1

* cell sg13cmos5l_nor3_1
* pin A
* pin B
* pin C
* pin VDD
* pin VSS
* pin Y
.SUBCKT sg13cmos5l_nor3_1 A B C VDD VSS Y
.ENDS sg13cmos5l_nor3_1

* cell sg13cmos5l_nor2b_1
* pin A
* pin B_N
* pin VDD
* pin VSS
* pin Y
.SUBCKT sg13cmos5l_nor2b_1 A B_N VDD VSS Y
.ENDS sg13cmos5l_nor2b_1

* cell sg13cmos5l_nor2_1
* pin A
* pin B
* pin VDD
* pin VSS
* pin Y
.SUBCKT sg13cmos5l_nor2_1 A B VDD VSS Y
.ENDS sg13cmos5l_nor2_1

* cell sg13cmos5l_nand4_1
* pin A
* pin B
* pin C
* pin D
* pin VDD
* pin VSS
* pin Y
.SUBCKT sg13cmos5l_nand4_1 A B C D VDD VSS Y
.ENDS sg13cmos5l_nand4_1

* cell sg13cmos5l_nand3b_1
* pin A_N
* pin B
* pin C
* pin VDD
* pin VSS
* pin Y
.SUBCKT sg13cmos5l_nand3b_1 A_N B C VDD VSS Y
.ENDS sg13cmos5l_nand3b_1

* cell sg13cmos5l_nand3_1
* pin A
* pin B
* pin C
* pin VDD
* pin VSS
* pin Y
.SUBCKT sg13cmos5l_nand3_1 A B C VDD VSS Y
.ENDS sg13cmos5l_nand3_1

* cell sg13cmos5l_nand2b_1
* pin A_N
* pin B
* pin VDD
* pin VSS
* pin Y
.SUBCKT sg13cmos5l_nand2b_1 A_N B VDD VSS Y
.ENDS sg13cmos5l_nand2b_1

* cell sg13cmos5l_nand2_1
* pin A
* pin B
* pin VDD
* pin VSS
* pin Y
.SUBCKT sg13cmos5l_nand2_1 A B VDD VSS Y
.ENDS sg13cmos5l_nand2_1

* cell sg13cmos5l_mux4_1
* pin A0
* pin A1
* pin A2
* pin A3
* pin S0
* pin S1
* pin VDD
* pin VSS
* pin X
.SUBCKT sg13cmos5l_mux4_1 A0 A1 A2 A3 S0 S1 VDD VSS X
.ENDS sg13cmos5l_mux4_1

* cell sg13cmos5l_mux2_1
* pin A0
* pin A1
* pin S
* pin VDD
* pin VSS
* pin X
.SUBCKT sg13cmos5l_mux2_1 A0 A1 S VDD VSS X
.ENDS sg13cmos5l_mux2_1

* cell sg13cmos5l_inv_1
* pin A
* pin VDD
* pin VSS
* pin Y
.SUBCKT sg13cmos5l_inv_1 A VDD VSS Y
.ENDS sg13cmos5l_inv_1

* cell sg13cmos5l_fill_2
* pin VDD
* pin VSS
.SUBCKT sg13cmos5l_fill_2 VDD VSS
.ENDS sg13cmos5l_fill_2

* cell sg13cmos5l_fill_1
* pin VDD
* pin VSS
.SUBCKT sg13cmos5l_fill_1 VDD VSS
.ENDS sg13cmos5l_fill_1

* cell sg13cmos5l_dlygate4sd3_1
* pin A
* pin VDD
* pin VSS
* pin X
.SUBCKT sg13cmos5l_dlygate4sd3_1 A VDD VSS X
.ENDS sg13cmos5l_dlygate4sd3_1

* cell sg13cmos5l_dfrbpq_1
* pin CLK
* pin D
* pin Q
* pin RESET_B
* pin VDD
* pin VSS
.SUBCKT sg13cmos5l_dfrbpq_1 CLK D Q RESET_B VDD VSS
.ENDS sg13cmos5l_dfrbpq_1

* cell sg13cmos5l_decap_8
* pin VDD
* pin VSS
.SUBCKT sg13cmos5l_decap_8 VDD VSS
.ENDS sg13cmos5l_decap_8

* cell sg13cmos5l_decap_4
* pin VDD
* pin VSS
.SUBCKT sg13cmos5l_decap_4 VDD VSS
.ENDS sg13cmos5l_decap_4

* cell sg13cmos5l_buf_8
* pin A
* pin VDD
* pin VSS
* pin X
.SUBCKT sg13cmos5l_buf_8 A VDD VSS X
.ENDS sg13cmos5l_buf_8

* cell sg13cmos5l_buf_4
* pin A
* pin VDD
* pin VSS
* pin X
.SUBCKT sg13cmos5l_buf_4 A VDD VSS X
.ENDS sg13cmos5l_buf_4

* cell sg13cmos5l_buf_1
* pin A
* pin VDD
* pin VSS
* pin X
.SUBCKT sg13cmos5l_buf_1 A VDD VSS X
.ENDS sg13cmos5l_buf_1

* cell sg13cmos5l_antennanp
* pin A
* pin VDD
* pin VSS
.SUBCKT sg13cmos5l_antennanp A VDD VSS
.ENDS sg13cmos5l_antennanp

* cell sg13cmos5l_and3_1
* pin A
* pin B
* pin C
* pin VDD
* pin VSS
* pin X
.SUBCKT sg13cmos5l_and3_1 A B C VDD VSS X
.ENDS sg13cmos5l_and3_1

* cell sg13cmos5l_and2_1
* pin A
* pin B
* pin VDD
* pin VSS
* pin X
.SUBCKT sg13cmos5l_and2_1 A B VDD VSS X
.ENDS sg13cmos5l_and2_1

* cell sg13cmos5l_a22oi_1
* pin A1
* pin A2
* pin B1
* pin B2
* pin VDD
* pin VSS
* pin Y
.SUBCKT sg13cmos5l_a22oi_1 A1 A2 B1 B2 VDD VSS Y
.ENDS sg13cmos5l_a22oi_1

* cell sg13cmos5l_a221oi_1
* pin A1
* pin A2
* pin B1
* pin B2
* pin C1
* pin VDD
* pin VSS
* pin Y
.SUBCKT sg13cmos5l_a221oi_1 A1 A2 B1 B2 C1 VDD VSS Y
.ENDS sg13cmos5l_a221oi_1

* cell sg13cmos5l_a21oi_1
* pin A1
* pin A2
* pin B1
* pin VDD
* pin VSS
* pin Y
.SUBCKT sg13cmos5l_a21oi_1 A1 A2 B1 VDD VSS Y
.ENDS sg13cmos5l_a21oi_1

* cell sg13cmos5l_a21o_1
* pin A1
* pin A2
* pin B1
* pin VDD
* pin VSS
* pin X
.SUBCKT sg13cmos5l_a21o_1 A1 A2 B1 VDD VSS X
.ENDS sg13cmos5l_a21o_1

* cell RM_IHPSG13_1P_256x16_c2_bm_bist
* pin A_ADDR[0]
* pin A_ADDR[1]
* pin A_ADDR[2]
* pin A_ADDR[3]
* pin A_ADDR[4]
* pin A_ADDR[5]
* pin A_ADDR[6]
* pin A_ADDR[7]
* pin A_BIST_ADDR[0]
* pin A_BIST_ADDR[1]
* pin A_BIST_ADDR[2]
* pin A_BIST_ADDR[3]
* pin A_BIST_ADDR[4]
* pin A_BIST_ADDR[5]
* pin A_BIST_ADDR[6]
* pin A_BIST_ADDR[7]
* pin A_BIST_BM[0]
* pin A_BIST_BM[10]
* pin A_BIST_BM[11]
* pin A_BIST_BM[12]
* pin A_BIST_BM[13]
* pin A_BIST_BM[14]
* pin A_BIST_BM[15]
* pin A_BIST_BM[1]
* pin A_BIST_BM[2]
* pin A_BIST_BM[3]
* pin A_BIST_BM[4]
* pin A_BIST_BM[5]
* pin A_BIST_BM[6]
* pin A_BIST_BM[7]
* pin A_BIST_BM[8]
* pin A_BIST_BM[9]
* pin A_BIST_CLK
* pin A_BIST_DIN[0]
* pin A_BIST_DIN[10]
* pin A_BIST_DIN[11]
* pin A_BIST_DIN[12]
* pin A_BIST_DIN[13]
* pin A_BIST_DIN[14]
* pin A_BIST_DIN[15]
* pin A_BIST_DIN[1]
* pin A_BIST_DIN[2]
* pin A_BIST_DIN[3]
* pin A_BIST_DIN[4]
* pin A_BIST_DIN[5]
* pin A_BIST_DIN[6]
* pin A_BIST_DIN[7]
* pin A_BIST_DIN[8]
* pin A_BIST_DIN[9]
* pin A_BIST_EN
* pin A_BIST_MEN
* pin A_BIST_REN
* pin A_BIST_WEN
* pin A_BM[0]
* pin A_BM[10]
* pin A_BM[11]
* pin A_BM[12]
* pin A_BM[13]
* pin A_BM[14]
* pin A_BM[15]
* pin A_BM[1]
* pin A_BM[2]
* pin A_BM[3]
* pin A_BM[4]
* pin A_BM[5]
* pin A_BM[6]
* pin A_BM[7]
* pin A_BM[8]
* pin A_BM[9]
* pin A_CLK
* pin A_DIN[0]
* pin A_DIN[10]
* pin A_DIN[11]
* pin A_DIN[12]
* pin A_DIN[13]
* pin A_DIN[14]
* pin A_DIN[15]
* pin A_DIN[1]
* pin A_DIN[2]
* pin A_DIN[3]
* pin A_DIN[4]
* pin A_DIN[5]
* pin A_DIN[6]
* pin A_DIN[7]
* pin A_DIN[8]
* pin A_DIN[9]
* pin A_DLY
* pin A_DOUT[0]
* pin A_DOUT[10]
* pin A_DOUT[11]
* pin A_DOUT[12]
* pin A_DOUT[13]
* pin A_DOUT[14]
* pin A_DOUT[15]
* pin A_DOUT[1]
* pin A_DOUT[2]
* pin A_DOUT[3]
* pin A_DOUT[4]
* pin A_DOUT[5]
* pin A_DOUT[6]
* pin A_DOUT[7]
* pin A_DOUT[8]
* pin A_DOUT[9]
* pin A_MEN
* pin A_REN
* pin A_WEN
* pin VDD!
* pin VDDARRAY!
* pin VSS!
.SUBCKT RM_IHPSG13_1P_256x16_c2_bm_bist A_ADDR[0] A_ADDR[1] A_ADDR[2] A_ADDR[3]
+ A_ADDR[4] A_ADDR[5] A_ADDR[6] A_ADDR[7] A_BIST_ADDR[0] A_BIST_ADDR[1]
+ A_BIST_ADDR[2] A_BIST_ADDR[3] A_BIST_ADDR[4] A_BIST_ADDR[5] A_BIST_ADDR[6]
+ A_BIST_ADDR[7] A_BIST_BM[0] A_BIST_BM[10] A_BIST_BM[11] A_BIST_BM[12]
+ A_BIST_BM[13] A_BIST_BM[14] A_BIST_BM[15] A_BIST_BM[1] A_BIST_BM[2]
+ A_BIST_BM[3] A_BIST_BM[4] A_BIST_BM[5] A_BIST_BM[6] A_BIST_BM[7] A_BIST_BM[8]
+ A_BIST_BM[9] A_BIST_CLK A_BIST_DIN[0] A_BIST_DIN[10] A_BIST_DIN[11]
+ A_BIST_DIN[12] A_BIST_DIN[13] A_BIST_DIN[14] A_BIST_DIN[15] A_BIST_DIN[1]
+ A_BIST_DIN[2] A_BIST_DIN[3] A_BIST_DIN[4] A_BIST_DIN[5] A_BIST_DIN[6]
+ A_BIST_DIN[7] A_BIST_DIN[8] A_BIST_DIN[9] A_BIST_EN A_BIST_MEN A_BIST_REN
+ A_BIST_WEN A_BM[0] A_BM[10] A_BM[11] A_BM[12] A_BM[13] A_BM[14] A_BM[15]
+ A_BM[1] A_BM[2] A_BM[3] A_BM[4] A_BM[5] A_BM[6] A_BM[7] A_BM[8] A_BM[9] A_CLK
+ A_DIN[0] A_DIN[10] A_DIN[11] A_DIN[12] A_DIN[13] A_DIN[14] A_DIN[15] A_DIN[1]
+ A_DIN[2] A_DIN[3] A_DIN[4] A_DIN[5] A_DIN[6] A_DIN[7] A_DIN[8] A_DIN[9] A_DLY
+ A_DOUT[0] A_DOUT[10] A_DOUT[11] A_DOUT[12] A_DOUT[13] A_DOUT[14] A_DOUT[15]
+ A_DOUT[1] A_DOUT[2] A_DOUT[3] A_DOUT[4] A_DOUT[5] A_DOUT[6] A_DOUT[7]
+ A_DOUT[8] A_DOUT[9] A_MEN A_REN A_WEN VDD! VDDARRAY! VSS!
.ENDS RM_IHPSG13_1P_256x16_c2_bm_bist
