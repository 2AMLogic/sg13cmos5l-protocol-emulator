* extracted by klt extract --deck sg13cmos5l

* cell tt_um_2amlogic_protocol_emulator
* pin VGND
* pin VPWR
* pin clk
* pin rst_n
* pin ui_in[0]
* pin ui_in[1]
* pin ui_in[2]
* pin ui_in[3]
* pin ui_in[4]
* pin ui_in[5]
* pin ui_in[6]
* pin ui_in[7]
* pin uio_in[0]
* pin uio_in[1]
* pin uio_in[2]
* pin uio_in[3]
* pin uio_in[4]
* pin uio_in[5]
* pin uio_in[6]
* pin uio_in[7]
* pin uio_oe[0]
* pin uio_oe[1]
* pin uio_oe[2]
* pin uio_oe[3]
* pin uio_oe[4]
* pin uio_oe[5]
* pin uio_oe[6]
* pin uio_oe[7]
* pin uio_out[0]
* pin uio_out[1]
* pin uio_out[2]
* pin uio_out[3]
* pin uio_out[4]
* pin uio_out[5]
* pin uio_out[6]
* pin uio_out[7]
* pin uo_out[0]
* pin uo_out[1]
* pin uo_out[2]
* pin uo_out[3]
* pin uo_out[4]
* pin uo_out[5]
* pin uo_out[6]
* pin uo_out[7]
* pin ena
.SUBCKT tt_um_2amlogic_protocol_emulator VGND VPWR clk rst_n ui_in[0] ui_in[1]
+ ui_in[2] ui_in[3] ui_in[4] ui_in[5] ui_in[6] ui_in[7] uio_in[0] uio_in[1]
+ uio_in[2] uio_in[3] uio_in[4] uio_in[5] uio_in[6] uio_in[7] uio_oe[0]
+ uio_oe[1] uio_oe[2] uio_oe[3] uio_oe[4] uio_oe[5] uio_oe[6] uio_oe[7]
+ uio_out[0] uio_out[1] uio_out[2] uio_out[3] uio_out[4] uio_out[5] uio_out[6]
+ uio_out[7] uo_out[0] uo_out[1] uo_out[2] uo_out[3] uo_out[4] uo_out[5]
+ uo_out[6] uo_out[7] ena
* cell instance RM_IHPSG13_1P_256x16_c2_bm_bist_0 r0 *1 0,0
XRM_IHPSG13_1P_256x16_c2_bm_bist_0 \$1209 \$1436 \$1449 \$1445 \$1676 \$1440
+ \$1664 \$1424 \$1686 \$1857 \$1690 \$1682 \$1697 \$1458 \$938 \$942 \$1579
+ \$1006 \$1308 \$1030 \$1042 \$842 \$1541 \$1124 \$736 \$744 \$1601 \$1620
+ \$1307 \$1411 \$1709 \$1478 \$786 \$1912 \$1010 \$1512 \$830 \$834 \$1058
+ \$1914 \$1587 \$732 \$740 \$1138 \$1381 \$764 \$1647 \$1717 \$1713 \$2204
+ \$946 \$1443 \$950 \$1583 \$1494 \$1498 \$1026 \$1038 \$838 \$1304 \$724
+ \$1358 \$748 \$298 \$1624 \$1405 \$1651 \$1705 \$1482 \$1667 \$1120 \$1751
+ \$1758 \$1767 \$1537 \$1534 \$1785 \$1061 \$887 \$1617 \$1551 \$1632 \$914
+ \$1656 \$1722 \$1737 \$1701 \$1852 \$1452 \$1913 \$825 \$1694 \$1869 \$1910
+ \$1865 \$1846 \$1564 \$1563 \$392 \$1562 \$859 \$1911 \$2894 \$1432 \$652
+ \$1669 VPWR VPWR VGND RM_IHPSG13_1P_256x16_c2_bm_bist
* cell instance sg13cmos5l_a21o_1_0 r0 *1 0,0
Xsg13cmos5l_a21o_1_0 \$4614 \$3513 \$4081 VPWR VGND \$5137 sg13cmos5l_a21o_1
* cell instance sg13cmos5l_a21o_1_1 r0 *1 0,0
Xsg13cmos5l_a21o_1_1 \$391 \$87 \$206 VPWR VGND \$200 sg13cmos5l_a21o_1
* cell instance sg13cmos5l_a21o_1_2 r0 *1 0,0
Xsg13cmos5l_a21o_1_2 \$3018 \$3020 \$2921 VPWR VGND \$2886 sg13cmos5l_a21o_1
* cell instance sg13cmos5l_a21o_1_3 r0 *1 0,0
Xsg13cmos5l_a21o_1_3 \$853 \$858 \$560 VPWR VGND \$1089 sg13cmos5l_a21o_1
* cell instance sg13cmos5l_a21o_1_4 r0 *1 0,0
Xsg13cmos5l_a21o_1_4 \$391 \$875 \$365 VPWR VGND \$1094 sg13cmos5l_a21o_1
* cell instance sg13cmos5l_a21o_1_5 r0 *1 0,0
Xsg13cmos5l_a21o_1_5 \$4046 \$7109 \$7274 VPWR VGND \$7113 sg13cmos5l_a21o_1
* cell instance sg13cmos5l_a21o_1_6 r0 *1 0,0
Xsg13cmos5l_a21o_1_6 \$1337 \$1547 \$690 VPWR VGND \$1097 sg13cmos5l_a21o_1
* cell instance sg13cmos5l_a21o_1_7 r0 *1 0,0
Xsg13cmos5l_a21o_1_7 \$260 \$255 \$256 VPWR VGND \$257 sg13cmos5l_a21o_1
* cell instance sg13cmos5l_a21o_1_8 r0 *1 0,0
Xsg13cmos5l_a21o_1_8 \$455 \$448 \$142 VPWR VGND \$452 sg13cmos5l_a21o_1
* cell instance sg13cmos5l_a21o_1_9 r0 *1 0,0
Xsg13cmos5l_a21o_1_9 \$506 \$180 \$663 VPWR VGND \$661 sg13cmos5l_a21o_1
* cell instance sg13cmos5l_a21oi_1_0 r0 *1 0,0
Xsg13cmos5l_a21oi_1_0 \$5137 \$5140 \$6677 VPWR VGND \$7106 sg13cmos5l_a21oi_1
* cell instance sg13cmos5l_a21oi_1_1 r0 *1 0,0
Xsg13cmos5l_a21oi_1_1 \$3517 \$3825 \$3790 VPWR VGND \$4019 sg13cmos5l_a21oi_1
* cell instance sg13cmos5l_a21oi_1_2 r0 *1 0,0
Xsg13cmos5l_a21oi_1_2 \$5137 \$2921 \$7776 VPWR VGND \$7705 sg13cmos5l_a21oi_1
* cell instance sg13cmos5l_a21oi_1_3 r0 *1 0,0
Xsg13cmos5l_a21oi_1_3 \$1546 \$2084 \$2943 VPWR VGND \$2749 sg13cmos5l_a21oi_1
* cell instance sg13cmos5l_a21oi_1_4 r0 *1 0,0
Xsg13cmos5l_a21oi_1_4 \$5137 \$5140 \$4767 VPWR VGND \$6577 sg13cmos5l_a21oi_1
* cell instance sg13cmos5l_a21oi_1_5 r0 *1 0,0
Xsg13cmos5l_a21oi_1_5 \$3069 \$3072 \$3275 VPWR VGND \$3493 sg13cmos5l_a21oi_1
* cell instance sg13cmos5l_a21oi_1_6 r0 *1 0,0
Xsg13cmos5l_a21oi_1_6 \$3491 \$3520 \$4097 VPWR VGND \$3829 sg13cmos5l_a21oi_1
* cell instance sg13cmos5l_a21oi_1_7 r0 *1 0,0
Xsg13cmos5l_a21oi_1_7 \$396 \$397 \$393 VPWR VGND \$394 sg13cmos5l_a21oi_1
* cell instance sg13cmos5l_a21oi_1_8 r0 *1 0,0
Xsg13cmos5l_a21oi_1_8 \$1565 \$2084 \$1905 VPWR VGND \$1888 sg13cmos5l_a21oi_1
* cell instance sg13cmos5l_a21oi_1_9 r0 *1 0,0
Xsg13cmos5l_a21oi_1_9 \$3491 \$3520 \$4157 VPWR VGND \$4158 sg13cmos5l_a21oi_1
* cell instance sg13cmos5l_a21oi_1_10 r0 *1 0,0
Xsg13cmos5l_a21oi_1_10 \$1566 \$2084 \$2083 VPWR VGND \$1933 sg13cmos5l_a21oi_1
* cell instance sg13cmos5l_a21oi_1_11 r0 *1 0,0
Xsg13cmos5l_a21oi_1_11 \$412 \$567 \$568 VPWR VGND \$397 sg13cmos5l_a21oi_1
* cell instance sg13cmos5l_a21oi_1_12 r0 *1 0,0
Xsg13cmos5l_a21oi_1_12 \$3097 \$2921 \$3076 VPWR VGND \$2083 sg13cmos5l_a21oi_1
* cell instance sg13cmos5l_a21oi_1_13 r0 *1 0,0
Xsg13cmos5l_a21oi_1_13 \$3832 \$5145 \$4768 VPWR VGND \$5726 sg13cmos5l_a21oi_1
* cell instance sg13cmos5l_a21oi_1_14 r0 *1 0,0
Xsg13cmos5l_a21oi_1_14 \$365 \$571 \$409 VPWR VGND \$95 sg13cmos5l_a21oi_1
* cell instance sg13cmos5l_a21oi_1_15 r0 *1 0,0
Xsg13cmos5l_a21oi_1_15 \$7706 \$2436 \$8719 VPWR VGND \$8720 sg13cmos5l_a21oi_1
* cell instance sg13cmos5l_a21oi_1_16 r0 *1 0,0
Xsg13cmos5l_a21oi_1_16 \$412 \$239 \$410 VPWR VGND \$238 sg13cmos5l_a21oi_1
* cell instance sg13cmos5l_a21oi_1_17 r0 *1 0,0
Xsg13cmos5l_a21oi_1_17 \$412 \$574 \$572 VPWR VGND \$571 sg13cmos5l_a21oi_1
* cell instance sg13cmos5l_a21oi_1_18 r0 *1 0,0
Xsg13cmos5l_a21oi_1_18 \$2892 \$3495 \$2084 VPWR VGND \$3269 sg13cmos5l_a21oi_1
* cell instance sg13cmos5l_a21oi_1_19 r0 *1 0,0
Xsg13cmos5l_a21oi_1_19 \$365 \$238 \$90 VPWR VGND \$240 sg13cmos5l_a21oi_1
* cell instance sg13cmos5l_a21oi_1_20 r0 *1 0,0
Xsg13cmos5l_a21oi_1_20 \$2416 \$9624 \$2084 VPWR VGND \$9184 sg13cmos5l_a21oi_1
* cell instance sg13cmos5l_a21oi_1_21 r0 *1 0,0
Xsg13cmos5l_a21oi_1_21 \$1576 \$1569 \$863 VPWR VGND \$1109 sg13cmos5l_a21oi_1
* cell instance sg13cmos5l_a21oi_1_22 r0 *1 0,0
Xsg13cmos5l_a21oi_1_22 \$582 \$403 \$418 VPWR VGND \$580 sg13cmos5l_a21oi_1
* cell instance sg13cmos5l_a21oi_1_23 r0 *1 0,0
Xsg13cmos5l_a21oi_1_23 \$248 \$403 \$418 VPWR VGND \$417 sg13cmos5l_a21oi_1
* cell instance sg13cmos5l_a21oi_1_24 r0 *1 0,0
Xsg13cmos5l_a21oi_1_24 \$248 \$880 \$706 VPWR VGND \$711 sg13cmos5l_a21oi_1
* cell instance sg13cmos5l_a21oi_1_25 r0 *1 0,0
Xsg13cmos5l_a21oi_1_25 \$589 \$572 \$716 VPWR VGND \$872 sg13cmos5l_a21oi_1
* cell instance sg13cmos5l_a21oi_1_26 r0 *1 0,0
Xsg13cmos5l_a21oi_1_26 \$537 \$266 \$265 VPWR VGND \$602 sg13cmos5l_a21oi_1
* cell instance sg13cmos5l_a21oi_1_27 r0 *1 0,0
Xsg13cmos5l_a21oi_1_27 \$133 \$284 \$139 VPWR VGND \$282 sg13cmos5l_a21oi_1
* cell instance sg13cmos5l_a21oi_1_28 r0 *1 0,0
Xsg13cmos5l_a21oi_1_28 \$612 \$613 \$139 VPWR VGND \$610 sg13cmos5l_a21oi_1
* cell instance sg13cmos5l_a21oi_1_29 r0 *1 0,0
Xsg13cmos5l_a21oi_1_29 \$132 \$606 \$139 VPWR VGND \$140 sg13cmos5l_a21oi_1
* cell instance sg13cmos5l_a21oi_1_30 r0 *1 0,0
Xsg13cmos5l_a21oi_1_30 \$508 \$931 \$929 VPWR VGND \$637 sg13cmos5l_a21oi_1
* cell instance sg13cmos5l_a21oi_1_31 r0 *1 0,0
Xsg13cmos5l_a21oi_1_31 \$931 \$1413 \$1408 VPWR VGND \$1187 sg13cmos5l_a21oi_1
* cell instance sg13cmos5l_a21oi_1_32 r0 *1 0,0
Xsg13cmos5l_a21oi_1_32 \$22 \$20 \$21 VPWR VGND \$61 sg13cmos5l_a21oi_1
* cell instance sg13cmos5l_a21oi_1_33 r0 *1 0,0
Xsg13cmos5l_a21oi_1_33 \$348 \$181 \$513 VPWR VGND \$183 sg13cmos5l_a21oi_1
* cell instance sg13cmos5l_a221oi_1_0 r0 *1 0,0
Xsg13cmos5l_a221oi_1_0 \$5720 \$7271 \$6577 \$4076 \$7106 VPWR VGND \$7109
+ sg13cmos5l_a221oi_1
* cell instance sg13cmos5l_a221oi_1_1 r0 *1 0,0
Xsg13cmos5l_a221oi_1_1 \$2762 \$3737 \$3501 \$3925 \$3827 VPWR VGND \$2943
+ sg13cmos5l_a221oi_1
* cell instance sg13cmos5l_a221oi_1_2 r0 *1 0,0
Xsg13cmos5l_a221oi_1_2 \$2762 \$5361 \$3020 \$5359 \$5360 VPWR VGND \$4763
+ sg13cmos5l_a221oi_1
* cell instance sg13cmos5l_a221oi_1_3 r0 *1 0,0
Xsg13cmos5l_a221oi_1_3 \$4081 \$2760 \$2892 \$8716 \$4764 VPWR VGND \$8577
+ sg13cmos5l_a221oi_1
* cell instance sg13cmos5l_a221oi_1_4 r0 *1 0,0
Xsg13cmos5l_a221oi_1_4 \$2762 \$4098 \$3020 \$4767 \$6680 VPWR VGND \$6578
+ sg13cmos5l_a221oi_1
* cell instance sg13cmos5l_a221oi_1_5 r0 *1 0,0
Xsg13cmos5l_a221oi_1_5 \$2762 \$3074 \$3501 \$3073 \$2890 VPWR VGND \$1905
+ sg13cmos5l_a221oi_1
* cell instance sg13cmos5l_a221oi_1_6 r0 *1 0,0
Xsg13cmos5l_a221oi_1_6 \$3274 \$2759 \$9182 \$2892 \$4764 VPWR VGND \$9025
+ sg13cmos5l_a221oi_1
* cell instance sg13cmos5l_a221oi_1_7 r0 *1 0,0
Xsg13cmos5l_a221oi_1_7 \$2762 \$3831 \$3020 \$3491 \$4045 VPWR VGND \$3926
+ sg13cmos5l_a221oi_1
* cell instance sg13cmos5l_a221oi_1_8 r0 *1 0,0
Xsg13cmos5l_a221oi_1_8 \$4091 \$2759 \$9622 \$2892 \$4764 VPWR VGND \$4428
+ sg13cmos5l_a221oi_1
* cell instance sg13cmos5l_a221oi_1_9 r0 *1 0,0
Xsg13cmos5l_a221oi_1_9 \$2731 \$5800 \$3020 \$4046 \$6682 VPWR VGND \$6579
+ sg13cmos5l_a221oi_1
* cell instance sg13cmos5l_a221oi_1_10 r0 *1 0,0
Xsg13cmos5l_a221oi_1_10 \$4091 \$2945 \$9030 \$2892 \$4764 VPWR VGND \$2944
+ sg13cmos5l_a221oi_1
* cell instance sg13cmos5l_a221oi_1_11 r0 *1 0,0
Xsg13cmos5l_a221oi_1_11 \$4768 \$2729 \$7276 \$2896 \$7275 VPWR VGND \$6681
+ sg13cmos5l_a221oi_1
* cell instance sg13cmos5l_a221oi_1_12 r0 *1 0,0
Xsg13cmos5l_a221oi_1_12 \$4093 \$2760 \$2892 \$4769 \$4764 VPWR VGND \$4324
+ sg13cmos5l_a221oi_1
* cell instance sg13cmos5l_a221oi_1_13 r0 *1 0,0
Xsg13cmos5l_a221oi_1_13 \$9183 \$2760 \$2892 \$9623 \$2730 VPWR VGND \$9529
+ sg13cmos5l_a221oi_1
* cell instance sg13cmos5l_a221oi_1_14 r0 *1 0,0
Xsg13cmos5l_a221oi_1_14 \$579 \$417 \$576 \$585 \$583 VPWR VGND \$245
+ sg13cmos5l_a221oi_1
* cell instance sg13cmos5l_a221oi_1_15 r0 *1 0,0
Xsg13cmos5l_a221oi_1_15 \$256 \$587 \$577 \$589 \$690 VPWR VGND \$425
+ sg13cmos5l_a221oi_1
* cell instance sg13cmos5l_a221oi_1_16 r0 *1 0,0
Xsg13cmos5l_a221oi_1_16 \$427 \$428 \$253 \$425 \$139 VPWR VGND \$423
+ sg13cmos5l_a221oi_1
* cell instance sg13cmos5l_a221oi_1_17 r0 *1 0,0
Xsg13cmos5l_a221oi_1_17 \$427 \$264 \$262 \$437 \$139 VPWR VGND \$435
+ sg13cmos5l_a221oi_1
* cell instance sg13cmos5l_a221oi_1_18 r0 *1 0,0
Xsg13cmos5l_a221oi_1_18 \$266 \$587 \$410 \$589 \$690 VPWR VGND \$437
+ sg13cmos5l_a221oi_1
* cell instance sg13cmos5l_a221oi_1_19 r0 *1 0,0
Xsg13cmos5l_a221oi_1_19 \$265 \$587 \$568 \$589 \$427 VPWR VGND \$595
+ sg13cmos5l_a221oi_1
* cell instance sg13cmos5l_a221oi_1_20 r0 *1 0,0
Xsg13cmos5l_a221oi_1_20 \$427 \$267 \$373 \$595 \$139 VPWR VGND \$441
+ sg13cmos5l_a221oi_1
* cell instance sg13cmos5l_a22oi_1_0 r0 *1 0,0
Xsg13cmos5l_a22oi_1_0 \$1864 \$4764 \$4762 \$4763 VPWR VGND \$3740
+ sg13cmos5l_a22oi_1
* cell instance sg13cmos5l_a22oi_1_1 r0 *1 0,0
Xsg13cmos5l_a22oi_1_1 \$4236 \$2921 \$3268 \$4235 VPWR VGND \$4154
+ sg13cmos5l_a22oi_1
* cell instance sg13cmos5l_a22oi_1_2 r0 *1 0,0
Xsg13cmos5l_a22oi_1_2 \$845 \$206 \$850 \$365 VPWR VGND \$851 sg13cmos5l_a22oi_1
* cell instance sg13cmos5l_a22oi_1_3 r0 *1 0,0
Xsg13cmos5l_a22oi_1_3 \$3017 \$2760 \$2945 \$4765 VPWR VGND \$4322
+ sg13cmos5l_a22oi_1
* cell instance sg13cmos5l_a22oi_1_4 r0 *1 0,0
Xsg13cmos5l_a22oi_1_4 \$1093 \$4764 \$6427 \$6578 VPWR VGND \$8711
+ sg13cmos5l_a22oi_1
* cell instance sg13cmos5l_a22oi_1_5 r0 *1 0,0
Xsg13cmos5l_a22oi_1_5 \$8282 \$2760 \$2945 \$5720 VPWR VGND \$8715
+ sg13cmos5l_a22oi_1
* cell instance sg13cmos5l_a22oi_1_6 r0 *1 0,0
Xsg13cmos5l_a22oi_1_6 \$9181 \$2945 \$2759 \$4765 VPWR VGND \$8283
+ sg13cmos5l_a22oi_1
* cell instance sg13cmos5l_a22oi_1_7 r0 *1 0,0
Xsg13cmos5l_a22oi_1_7 \$7272 \$2921 \$3268 \$5794 VPWR VGND \$8144
+ sg13cmos5l_a22oi_1
* cell instance sg13cmos5l_a22oi_1_8 r0 *1 0,0
Xsg13cmos5l_a22oi_1_8 \$1930 \$2760 \$2759 \$2434 VPWR VGND \$2728
+ sg13cmos5l_a22oi_1
* cell instance sg13cmos5l_a22oi_1_9 r0 *1 0,0
Xsg13cmos5l_a22oi_1_9 \$861 \$2084 \$3519 \$3926 VPWR VGND \$4757
+ sg13cmos5l_a22oi_1
* cell instance sg13cmos5l_a22oi_1_10 r0 *1 0,0
Xsg13cmos5l_a22oi_1_10 \$3274 \$2945 \$2759 \$2174 VPWR VGND \$4161
+ sg13cmos5l_a22oi_1
* cell instance sg13cmos5l_a22oi_1_11 r0 *1 0,0
Xsg13cmos5l_a22oi_1_11 \$2274 \$4764 \$6428 \$6681 VPWR VGND \$6653
+ sg13cmos5l_a22oi_1
* cell instance sg13cmos5l_a22oi_1_12 r0 *1 0,0
Xsg13cmos5l_a22oi_1_12 \$9527 \$2945 \$2759 \$5720 VPWR VGND \$8856
+ sg13cmos5l_a22oi_1
* cell instance sg13cmos5l_a22oi_1_13 r0 *1 0,0
Xsg13cmos5l_a22oi_1_13 \$2138 \$2760 \$2945 \$2174 VPWR VGND \$3075
+ sg13cmos5l_a22oi_1
* cell instance sg13cmos5l_a22oi_1_14 r0 *1 0,0
Xsg13cmos5l_a22oi_1_14 \$7707 \$2921 \$3268 \$8788 VPWR VGND \$8578
+ sg13cmos5l_a22oi_1
* cell instance sg13cmos5l_a22oi_1_15 r0 *1 0,0
Xsg13cmos5l_a22oi_1_15 \$1855 \$2730 \$7113 \$6579 VPWR VGND \$7632
+ sg13cmos5l_a22oi_1
* cell instance sg13cmos5l_a22oi_1_16 r0 *1 0,0
Xsg13cmos5l_a22oi_1_16 \$3833 \$3451 \$3927 \$3928 VPWR VGND \$3746
+ sg13cmos5l_a22oi_1
* cell instance sg13cmos5l_a22oi_1_17 r0 *1 0,0
Xsg13cmos5l_a22oi_1_17 \$8717 \$3078 \$2759 \$9181 VPWR VGND \$9033
+ sg13cmos5l_a22oi_1
* cell instance sg13cmos5l_a22oi_1_18 r0 *1 0,0
Xsg13cmos5l_a22oi_1_18 \$859 \$589 \$1112 \$248 VPWR VGND \$869
+ sg13cmos5l_a22oi_1
* cell instance sg13cmos5l_a22oi_1_19 r0 *1 0,0
Xsg13cmos5l_a22oi_1_19 \$392 \$604 \$685 \$458 VPWR VGND \$284
+ sg13cmos5l_a22oi_1
* cell instance sg13cmos5l_a22oi_1_20 r0 *1 0,0
Xsg13cmos5l_a22oi_1_20 \$605 \$607 \$604 \$1564 VPWR VGND \$606
+ sg13cmos5l_a22oi_1
* cell instance sg13cmos5l_a22oi_1_21 r0 *1 0,0
Xsg13cmos5l_a22oi_1_21 \$142 \$728 \$604 \$1563 VPWR VGND \$613
+ sg13cmos5l_a22oi_1
* cell instance sg13cmos5l_and2_1_0 r0 *1 0,0
Xsg13cmos5l_and2_1_0 \$4614 \$3513 VPWR VGND \$5720 sg13cmos5l_and2_1
* cell instance sg13cmos5l_and2_1_1 r0 *1 0,0
Xsg13cmos5l_and2_1_1 \$3274 \$3017 VPWR VGND \$4235 sg13cmos5l_and2_1
* cell instance sg13cmos5l_and2_1_2 r0 *1 0,0
Xsg13cmos5l_and2_1_2 \$4765 \$8282 VPWR VGND \$5794 sg13cmos5l_and2_1
* cell instance sg13cmos5l_and2_1_3 r0 *1 0,0
Xsg13cmos5l_and2_1_3 \$5137 \$5140 VPWR VGND \$5359 sg13cmos5l_and2_1
* cell instance sg13cmos5l_and2_1_4 r0 *1 0,0
Xsg13cmos5l_and2_1_4 \$4091 \$4093 VPWR VGND \$4097 sg13cmos5l_and2_1
* cell instance sg13cmos5l_and2_1_5 r0 *1 0,0
Xsg13cmos5l_and2_1_5 \$5137 \$5221 VPWR VGND \$5224 sg13cmos5l_and2_1
* cell instance sg13cmos5l_and2_1_6 r0 *1 0,0
Xsg13cmos5l_and2_1_6 \$7706 \$7273 VPWR VGND \$4768 sg13cmos5l_and2_1
* cell instance sg13cmos5l_and2_1_7 r0 *1 0,0
Xsg13cmos5l_and2_1_7 \$3832 \$7707 VPWR VGND \$4046 sg13cmos5l_and2_1
* cell instance sg13cmos5l_and2_1_8 r0 *1 0,0
Xsg13cmos5l_and2_1_8 \$1847 \$1853 VPWR VGND \$1573 sg13cmos5l_and2_1
* cell instance sg13cmos5l_and2_1_9 r0 *1 0,0
Xsg13cmos5l_and2_1_9 \$706 \$865 VPWR VGND \$396 sg13cmos5l_and2_1
* cell instance sg13cmos5l_and2_1_10 r0 *1 0,0
Xsg13cmos5l_and2_1_10 \$868 \$869 VPWR VGND \$585 sg13cmos5l_and2_1
* cell instance sg13cmos5l_and2_1_11 r0 *1 0,0
Xsg13cmos5l_and2_1_11 \$589 \$868 VPWR VGND \$604 sg13cmos5l_and2_1
* cell instance sg13cmos5l_and2_1_12 r0 *1 0,0
Xsg13cmos5l_and2_1_12 \$299 \$143 VPWR VGND \$880 sg13cmos5l_and2_1
* cell instance sg13cmos5l_and2_1_13 r0 *1 0,0
Xsg13cmos5l_and2_1_13 \$515 \$517 VPWR VGND \$181 sg13cmos5l_and2_1
* cell instance sg13cmos5l_and3_1_0 r0 *1 0,0
Xsg13cmos5l_and3_1_0 \$4768 \$3832 \$5145 VPWR VGND \$5801 sg13cmos5l_and3_1
* cell instance sg13cmos5l_and3_1_1 r0 *1 0,0
Xsg13cmos5l_and3_1_1 \$537 \$266 \$265 VPWR VGND \$448 sg13cmos5l_and3_1
* cell instance sg13cmos5l_and3_1_2 r0 *1 0,0
Xsg13cmos5l_and3_1_2 \$1407 \$931 \$929 VPWR VGND \$779 sg13cmos5l_and3_1
* cell instance sg13cmos5l_and3_1_3 r0 *1 0,0
Xsg13cmos5l_and3_1_3 \$348 \$513 \$181 VPWR VGND \$20 sg13cmos5l_and3_1
* cell instance sg13cmos5l_antennanp_0 r0 *1 0,0
Xsg13cmos5l_antennanp_0 \$933 VPWR VGND sg13cmos5l_antennanp
* cell instance sg13cmos5l_buf_1_0 r0 *1 0,0
Xsg13cmos5l_buf_1_0 \$9320 VPWR VGND \$4233 sg13cmos5l_buf_1
* cell instance sg13cmos5l_buf_1_1 r0 *1 0,0
Xsg13cmos5l_buf_1_1 \$1306 VPWR VGND \$2073 sg13cmos5l_buf_1
* cell instance sg13cmos5l_buf_1_2 r0 *1 0,0
Xsg13cmos5l_buf_1_2 \$2272 VPWR VGND \$2208 sg13cmos5l_buf_1
* cell instance sg13cmos5l_buf_1_3 r0 *1 0,0
Xsg13cmos5l_buf_1_3 \$12148 VPWR VGND \$11237 sg13cmos5l_buf_1
* cell instance sg13cmos5l_buf_1_4 r0 *1 0,0
Xsg13cmos5l_buf_1_4 \$12148 VPWR VGND \$12712 sg13cmos5l_buf_1
* cell instance sg13cmos5l_buf_1_5 r0 *1 0,0
Xsg13cmos5l_buf_1_5 \$1306 VPWR VGND \$36 sg13cmos5l_buf_1
* cell instance sg13cmos5l_buf_1_6 r0 *1 0,0
Xsg13cmos5l_buf_1_6 \$1450 VPWR VGND \$2271 sg13cmos5l_buf_1
* cell instance sg13cmos5l_buf_1_7 r0 *1 0,0
Xsg13cmos5l_buf_1_7 \$36 VPWR VGND \$77 sg13cmos5l_buf_1
* cell instance sg13cmos5l_buf_1_8 r0 *1 0,0
Xsg13cmos5l_buf_1_8 \$2416 VPWR VGND \$2892 sg13cmos5l_buf_1
* cell instance sg13cmos5l_buf_1_9 r0 *1 0,0
Xsg13cmos5l_buf_1_9 \$2894 VPWR VGND \$2078 sg13cmos5l_buf_1
* cell instance sg13cmos5l_buf_1_10 r0 *1 0,0
Xsg13cmos5l_buf_1_10 \$1911 VPWR VGND \$2082 sg13cmos5l_buf_1
* cell instance sg13cmos5l_buf_1_11 r0 *1 0,0
Xsg13cmos5l_buf_1_11 \$1845 VPWR VGND \$391 sg13cmos5l_buf_1
* cell instance sg13cmos5l_buf_1_12 r0 *1 0,0
Xsg13cmos5l_buf_1_12 \$2761 VPWR VGND \$3268 sg13cmos5l_buf_1
* cell instance sg13cmos5l_buf_1_13 r0 *1 0,0
Xsg13cmos5l_buf_1_13 \$2729 VPWR VGND \$3020 sg13cmos5l_buf_1
* cell instance sg13cmos5l_buf_1_14 r0 *1 0,0
Xsg13cmos5l_buf_1_14 \$2896 VPWR VGND \$3501 sg13cmos5l_buf_1
* cell instance sg13cmos5l_buf_1_15 r0 *1 0,0
Xsg13cmos5l_buf_1_15 \$863 VPWR VGND \$412 sg13cmos5l_buf_1
* cell instance sg13cmos5l_buf_1_16 r0 *1 0,0
Xsg13cmos5l_buf_1_16 \$2730 VPWR VGND \$2084 sg13cmos5l_buf_1
* cell instance sg13cmos5l_buf_1_17 r0 *1 0,0
Xsg13cmos5l_buf_1_17 \$391 VPWR VGND \$863 sg13cmos5l_buf_1
* cell instance sg13cmos5l_buf_1_18 r0 *1 0,0
Xsg13cmos5l_buf_1_18 \$3078 VPWR VGND \$2760 sg13cmos5l_buf_1
* cell instance sg13cmos5l_buf_1_19 r0 *1 0,0
Xsg13cmos5l_buf_1_19 \$2084 VPWR VGND \$4764 sg13cmos5l_buf_1
* cell instance sg13cmos5l_buf_1_20 r0 *1 0,0
Xsg13cmos5l_buf_1_20 \$1570 VPWR VGND \$690 sg13cmos5l_buf_1
* cell instance sg13cmos5l_buf_1_21 r0 *1 0,0
Xsg13cmos5l_buf_1_21 \$2436 VPWR VGND \$2921 sg13cmos5l_buf_1
* cell instance sg13cmos5l_buf_1_22 r0 *1 0,0
Xsg13cmos5l_buf_1_22 \$396 VPWR VGND \$365 sg13cmos5l_buf_1
* cell instance sg13cmos5l_buf_1_23 r0 *1 0,0
Xsg13cmos5l_buf_1_23 \$536 VPWR VGND \$1306 sg13cmos5l_buf_1
* cell instance sg13cmos5l_buf_1_24 r0 *1 0,0
Xsg13cmos5l_buf_1_24 \$2731 VPWR VGND \$2762 sg13cmos5l_buf_1
* cell instance sg13cmos5l_buf_1_25 r0 *1 0,0
Xsg13cmos5l_buf_1_25 \$536 VPWR VGND \$9320 sg13cmos5l_buf_1
* cell instance sg13cmos5l_buf_1_26 r0 *1 0,0
Xsg13cmos5l_buf_1_26 \$12148 VPWR VGND \$11238 sg13cmos5l_buf_1
* cell instance sg13cmos5l_buf_1_27 r0 *1 0,0
Xsg13cmos5l_buf_1_27 \$933 VPWR VGND \$536 sg13cmos5l_buf_1
* cell instance sg13cmos5l_buf_1_28 r0 *1 0,0
Xsg13cmos5l_buf_1_28 \$591 VPWR VGND \$427 sg13cmos5l_buf_1
* cell instance sg13cmos5l_buf_1_29 r0 *1 0,0
Xsg13cmos5l_buf_1_29 \$9320 VPWR VGND \$12148 sg13cmos5l_buf_1
* cell instance sg13cmos5l_buf_1_30 r0 *1 0,0
Xsg13cmos5l_buf_1_30 uio_in[7] VPWR VGND \$13888 sg13cmos5l_buf_1
* cell instance sg13cmos5l_buf_1_31 r0 *1 0,0
Xsg13cmos5l_buf_1_31 uio_in[6] VPWR VGND \$13891 sg13cmos5l_buf_1
* cell instance sg13cmos5l_buf_1_32 r0 *1 0,0
Xsg13cmos5l_buf_1_32 uio_in[5] VPWR VGND \$13894 sg13cmos5l_buf_1
* cell instance sg13cmos5l_buf_1_33 r0 *1 0,0
Xsg13cmos5l_buf_1_33 uio_in[4] VPWR VGND \$13818 sg13cmos5l_buf_1
* cell instance sg13cmos5l_buf_1_34 r0 *1 0,0
Xsg13cmos5l_buf_1_34 uio_in[3] VPWR VGND \$13899 sg13cmos5l_buf_1
* cell instance sg13cmos5l_buf_1_35 r0 *1 0,0
Xsg13cmos5l_buf_1_35 \$536 VPWR VGND \$50 sg13cmos5l_buf_1
* cell instance sg13cmos5l_buf_1_36 r0 *1 0,0
Xsg13cmos5l_buf_1_36 \$536 VPWR VGND \$272 sg13cmos5l_buf_1
* cell instance sg13cmos5l_buf_1_37 r0 *1 0,0
Xsg13cmos5l_buf_1_37 ui_in[7] VPWR VGND \$929 sg13cmos5l_buf_1
* cell instance sg13cmos5l_buf_1_38 r0 *1 0,0
Xsg13cmos5l_buf_1_38 uio_in[0] VPWR VGND \$13919 sg13cmos5l_buf_1
* cell instance sg13cmos5l_buf_1_39 r0 *1 0,0
Xsg13cmos5l_buf_1_39 ui_in[6] VPWR VGND \$13905 sg13cmos5l_buf_1
* cell instance sg13cmos5l_buf_1_40 r0 *1 0,0
Xsg13cmos5l_buf_1_40 uio_in[1] VPWR VGND \$13923 sg13cmos5l_buf_1
* cell instance sg13cmos5l_buf_1_41 r0 *1 0,0
Xsg13cmos5l_buf_1_41 ui_in[5] VPWR VGND \$13908 sg13cmos5l_buf_1
* cell instance sg13cmos5l_buf_1_42 r0 *1 0,0
Xsg13cmos5l_buf_1_42 uio_in[2] VPWR VGND \$13816 sg13cmos5l_buf_1
* cell instance sg13cmos5l_buf_1_43 r0 *1 0,0
Xsg13cmos5l_buf_1_43 ui_in[4] VPWR VGND \$13819 sg13cmos5l_buf_1
* cell instance sg13cmos5l_buf_1_44 r0 *1 0,0
Xsg13cmos5l_buf_1_44 \$766 VPWR VGND \$1369 sg13cmos5l_buf_1
* cell instance sg13cmos5l_buf_1_45 r0 *1 0,0
Xsg13cmos5l_buf_1_45 ui_in[3] VPWR VGND \$13913 sg13cmos5l_buf_1
* cell instance sg13cmos5l_buf_1_46 r0 *1 0,0
Xsg13cmos5l_buf_1_46 ui_in[2] VPWR VGND \$13916 sg13cmos5l_buf_1
* cell instance sg13cmos5l_buf_1_47 r0 *1 0,0
Xsg13cmos5l_buf_1_47 \$773 VPWR VGND \$315 sg13cmos5l_buf_1
* cell instance sg13cmos5l_buf_1_48 r0 *1 0,0
Xsg13cmos5l_buf_1_48 ui_in[1] VPWR VGND \$13922 sg13cmos5l_buf_1
* cell instance sg13cmos5l_buf_1_49 r0 *1 0,0
Xsg13cmos5l_buf_1_49 ui_in[0] VPWR VGND \$1120 sg13cmos5l_buf_1
* cell instance sg13cmos5l_buf_1_50 r0 *1 0,0
Xsg13cmos5l_buf_1_50 \$933 VPWR VGND \$773 sg13cmos5l_buf_1
* cell instance sg13cmos5l_buf_1_51 r0 *1 0,0
Xsg13cmos5l_buf_1_51 rst_n VPWR VGND \$933 sg13cmos5l_buf_1
* cell instance sg13cmos5l_buf_1_52 r0 *1 0,0
Xsg13cmos5l_buf_1_52 \$773 VPWR VGND \$163 sg13cmos5l_buf_1
* cell instance sg13cmos5l_buf_1_53 r0 *1 0,0
Xsg13cmos5l_buf_1_53 \$652 VPWR VGND \$508 sg13cmos5l_buf_1
* cell instance sg13cmos5l_buf_1_54 r0 *1 0,0
Xsg13cmos5l_buf_1_54 \$773 VPWR VGND \$1243 sg13cmos5l_buf_1
* cell instance sg13cmos5l_buf_1_55 r0 *1 0,0
Xsg13cmos5l_buf_1_55 \$766 VPWR VGND \$1474 sg13cmos5l_buf_1
* cell instance sg13cmos5l_buf_4_0 r0 *1 0,0
Xsg13cmos5l_buf_4_0 \$1913 VPWR VGND \$2272 sg13cmos5l_buf_4
* cell instance sg13cmos5l_buf_4_1 r0 *1 0,0
Xsg13cmos5l_buf_4_1 \$1452 VPWR VGND \$1450 sg13cmos5l_buf_4
* cell instance sg13cmos5l_buf_4_2 r0 *1 0,0
Xsg13cmos5l_buf_4_2 \$1694 VPWR VGND \$1692 sg13cmos5l_buf_4
* cell instance sg13cmos5l_buf_4_3 r0 *1 0,0
Xsg13cmos5l_buf_4_3 \$825 VPWR VGND \$823 sg13cmos5l_buf_4
* cell instance sg13cmos5l_buf_8_0 r0 *1 0,0
Xsg13cmos5l_buf_8_0 \$701 VPWR VGND \$1861 sg13cmos5l_buf_8
* cell instance sg13cmos5l_buf_8_1 r0 *1 0,0
Xsg13cmos5l_buf_8_1 \$701 VPWR VGND \$2210 sg13cmos5l_buf_8
* cell instance sg13cmos5l_buf_8_2 r0 *1 0,0
Xsg13cmos5l_buf_8_2 \$701 VPWR VGND \$1317 sg13cmos5l_buf_8
* cell instance sg13cmos5l_buf_8_3 r0 *1 0,0
Xsg13cmos5l_buf_8_3 \$701 VPWR VGND \$4617 sg13cmos5l_buf_8
* cell instance sg13cmos5l_buf_8_4 r0 *1 0,0
Xsg13cmos5l_buf_8_4 \$701 VPWR VGND \$7270 sg13cmos5l_buf_8
* cell instance sg13cmos5l_buf_8_5 r0 *1 0,0
Xsg13cmos5l_buf_8_5 \$701 VPWR VGND \$6581 sg13cmos5l_buf_8
* cell instance sg13cmos5l_buf_8_6 r0 *1 0,0
Xsg13cmos5l_buf_8_6 \$701 VPWR VGND \$7119 sg13cmos5l_buf_8
* cell instance sg13cmos5l_buf_8_7 r0 *1 0,0
Xsg13cmos5l_buf_8_7 \$701 VPWR VGND \$7861 sg13cmos5l_buf_8
* cell instance sg13cmos5l_buf_8_8 r0 *1 0,0
Xsg13cmos5l_buf_8_8 \$701 VPWR VGND \$92 sg13cmos5l_buf_8
* cell instance sg13cmos5l_buf_8_9 r0 *1 0,0
Xsg13cmos5l_buf_8_9 \$701 VPWR VGND \$551 sg13cmos5l_buf_8
* cell instance sg13cmos5l_buf_8_10 r0 *1 0,0
Xsg13cmos5l_buf_8_10 \$701 VPWR VGND \$759 sg13cmos5l_buf_8
* cell instance sg13cmos5l_buf_8_11 r0 *1 0,0
Xsg13cmos5l_buf_8_11 \$701 VPWR VGND \$277 sg13cmos5l_buf_8
* cell instance sg13cmos5l_buf_8_12 r0 *1 0,0
Xsg13cmos5l_buf_8_12 \$1399 VPWR VGND \$701 sg13cmos5l_buf_8
* cell instance sg13cmos5l_buf_8_13 r0 *1 0,0
Xsg13cmos5l_buf_8_13 clk VPWR VGND \$1399 sg13cmos5l_buf_8
* cell instance sg13cmos5l_buf_8_14 r0 *1 0,0
Xsg13cmos5l_buf_8_14 \$701 VPWR VGND \$320 sg13cmos5l_buf_8
* cell instance sg13cmos5l_buf_8_15 r0 *1 0,0
Xsg13cmos5l_buf_8_15 \$1666 VPWR VGND \$1667 sg13cmos5l_buf_8
* cell instance sg13cmos5l_buf_8_16 r0 *1 0,0
Xsg13cmos5l_buf_8_16 clk VPWR VGND \$13943 sg13cmos5l_buf_8
* cell instance sg13cmos5l_buf_8_17 r0 *1 0,0
Xsg13cmos5l_buf_8_17 \$701 VPWR VGND \$326 sg13cmos5l_buf_8
* cell instance sg13cmos5l_buf_8_18 r0 *1 0,0
Xsg13cmos5l_buf_8_18 \$13943 VPWR VGND \$13945 sg13cmos5l_buf_8
* cell instance sg13cmos5l_buf_8_19 r0 *1 0,0
Xsg13cmos5l_buf_8_19 \$13945 VPWR VGND \$1671 sg13cmos5l_buf_8
* cell instance sg13cmos5l_buf_8_20 r0 *1 0,0
Xsg13cmos5l_buf_8_20 \$1671 VPWR VGND \$1666 sg13cmos5l_buf_8
* cell instance sg13cmos5l_buf_8_21 r0 *1 0,0
Xsg13cmos5l_buf_8_21 \$701 VPWR VGND \$1217 sg13cmos5l_buf_8
* cell instance sg13cmos5l_buf_8_22 r0 *1 0,0
Xsg13cmos5l_buf_8_22 \$701 VPWR VGND \$988 sg13cmos5l_buf_8
* cell instance sg13cmos5l_decap_4_0 r0 *1 0,0
Xsg13cmos5l_decap_4_0 VPWR VGND sg13cmos5l_decap_4
* cell instance sg13cmos5l_decap_4_1 r0 *1 0,0
Xsg13cmos5l_decap_4_1 VPWR VGND sg13cmos5l_decap_4
* cell instance sg13cmos5l_decap_4_2 r0 *1 0,0
Xsg13cmos5l_decap_4_2 VPWR VGND sg13cmos5l_decap_4
* cell instance sg13cmos5l_decap_4_3 r0 *1 0,0
Xsg13cmos5l_decap_4_3 VPWR VGND sg13cmos5l_decap_4
* cell instance sg13cmos5l_decap_4_4 r0 *1 0,0
Xsg13cmos5l_decap_4_4 VPWR VGND sg13cmos5l_decap_4
* cell instance sg13cmos5l_decap_4_5 r0 *1 0,0
Xsg13cmos5l_decap_4_5 VPWR VGND sg13cmos5l_decap_4
* cell instance sg13cmos5l_decap_4_6 r0 *1 0,0
Xsg13cmos5l_decap_4_6 VPWR VGND sg13cmos5l_decap_4
* cell instance sg13cmos5l_decap_4_7 r0 *1 0,0
Xsg13cmos5l_decap_4_7 VPWR VGND sg13cmos5l_decap_4
* cell instance sg13cmos5l_decap_4_8 r0 *1 0,0
Xsg13cmos5l_decap_4_8 VPWR VGND sg13cmos5l_decap_4
* cell instance sg13cmos5l_decap_4_9 r0 *1 0,0
Xsg13cmos5l_decap_4_9 VPWR VGND sg13cmos5l_decap_4
* cell instance sg13cmos5l_decap_4_10 r0 *1 0,0
Xsg13cmos5l_decap_4_10 VPWR VGND sg13cmos5l_decap_4
* cell instance sg13cmos5l_decap_4_11 r0 *1 0,0
Xsg13cmos5l_decap_4_11 VPWR VGND sg13cmos5l_decap_4
* cell instance sg13cmos5l_decap_4_12 r0 *1 0,0
Xsg13cmos5l_decap_4_12 VPWR VGND sg13cmos5l_decap_4
* cell instance sg13cmos5l_decap_4_13 r0 *1 0,0
Xsg13cmos5l_decap_4_13 VPWR VGND sg13cmos5l_decap_4
* cell instance sg13cmos5l_decap_4_14 r0 *1 0,0
Xsg13cmos5l_decap_4_14 VPWR VGND sg13cmos5l_decap_4
* cell instance sg13cmos5l_decap_4_15 r0 *1 0,0
Xsg13cmos5l_decap_4_15 VPWR VGND sg13cmos5l_decap_4
* cell instance sg13cmos5l_decap_4_16 r0 *1 0,0
Xsg13cmos5l_decap_4_16 VPWR VGND sg13cmos5l_decap_4
* cell instance sg13cmos5l_decap_4_17 r0 *1 0,0
Xsg13cmos5l_decap_4_17 VPWR VGND sg13cmos5l_decap_4
* cell instance sg13cmos5l_decap_4_18 r0 *1 0,0
Xsg13cmos5l_decap_4_18 VPWR VGND sg13cmos5l_decap_4
* cell instance sg13cmos5l_decap_4_19 r0 *1 0,0
Xsg13cmos5l_decap_4_19 VPWR VGND sg13cmos5l_decap_4
* cell instance sg13cmos5l_decap_4_20 r0 *1 0,0
Xsg13cmos5l_decap_4_20 VPWR VGND sg13cmos5l_decap_4
* cell instance sg13cmos5l_decap_4_21 r0 *1 0,0
Xsg13cmos5l_decap_4_21 VPWR VGND sg13cmos5l_decap_4
* cell instance sg13cmos5l_decap_4_22 r0 *1 0,0
Xsg13cmos5l_decap_4_22 VPWR VGND sg13cmos5l_decap_4
* cell instance sg13cmos5l_decap_4_23 r0 *1 0,0
Xsg13cmos5l_decap_4_23 VPWR VGND sg13cmos5l_decap_4
* cell instance sg13cmos5l_decap_4_24 r0 *1 0,0
Xsg13cmos5l_decap_4_24 VPWR VGND sg13cmos5l_decap_4
* cell instance sg13cmos5l_decap_4_25 r0 *1 0,0
Xsg13cmos5l_decap_4_25 VPWR VGND sg13cmos5l_decap_4
* cell instance sg13cmos5l_decap_4_26 r0 *1 0,0
Xsg13cmos5l_decap_4_26 VPWR VGND sg13cmos5l_decap_4
* cell instance sg13cmos5l_decap_4_27 r0 *1 0,0
Xsg13cmos5l_decap_4_27 VPWR VGND sg13cmos5l_decap_4
* cell instance sg13cmos5l_decap_4_28 r0 *1 0,0
Xsg13cmos5l_decap_4_28 VPWR VGND sg13cmos5l_decap_4
* cell instance sg13cmos5l_decap_4_29 r0 *1 0,0
Xsg13cmos5l_decap_4_29 VPWR VGND sg13cmos5l_decap_4
* cell instance sg13cmos5l_decap_4_30 r0 *1 0,0
Xsg13cmos5l_decap_4_30 VPWR VGND sg13cmos5l_decap_4
* cell instance sg13cmos5l_decap_4_31 r0 *1 0,0
Xsg13cmos5l_decap_4_31 VPWR VGND sg13cmos5l_decap_4
* cell instance sg13cmos5l_decap_4_32 r0 *1 0,0
Xsg13cmos5l_decap_4_32 VPWR VGND sg13cmos5l_decap_4
* cell instance sg13cmos5l_decap_4_33 r0 *1 0,0
Xsg13cmos5l_decap_4_33 VPWR VGND sg13cmos5l_decap_4
* cell instance sg13cmos5l_decap_4_34 r0 *1 0,0
Xsg13cmos5l_decap_4_34 VPWR VGND sg13cmos5l_decap_4
* cell instance sg13cmos5l_decap_4_35 r0 *1 0,0
Xsg13cmos5l_decap_4_35 VPWR VGND sg13cmos5l_decap_4
* cell instance sg13cmos5l_decap_4_36 r0 *1 0,0
Xsg13cmos5l_decap_4_36 VPWR VGND sg13cmos5l_decap_4
* cell instance sg13cmos5l_decap_4_37 r0 *1 0,0
Xsg13cmos5l_decap_4_37 VPWR VGND sg13cmos5l_decap_4
* cell instance sg13cmos5l_decap_4_38 r0 *1 0,0
Xsg13cmos5l_decap_4_38 VPWR VGND sg13cmos5l_decap_4
* cell instance sg13cmos5l_decap_4_39 r0 *1 0,0
Xsg13cmos5l_decap_4_39 VPWR VGND sg13cmos5l_decap_4
* cell instance sg13cmos5l_decap_4_40 r0 *1 0,0
Xsg13cmos5l_decap_4_40 VPWR VGND sg13cmos5l_decap_4
* cell instance sg13cmos5l_decap_4_41 r0 *1 0,0
Xsg13cmos5l_decap_4_41 VPWR VGND sg13cmos5l_decap_4
* cell instance sg13cmos5l_decap_4_42 r0 *1 0,0
Xsg13cmos5l_decap_4_42 VPWR VGND sg13cmos5l_decap_4
* cell instance sg13cmos5l_decap_4_43 r0 *1 0,0
Xsg13cmos5l_decap_4_43 VPWR VGND sg13cmos5l_decap_4
* cell instance sg13cmos5l_decap_4_44 r0 *1 0,0
Xsg13cmos5l_decap_4_44 VPWR VGND sg13cmos5l_decap_4
* cell instance sg13cmos5l_decap_4_45 r0 *1 0,0
Xsg13cmos5l_decap_4_45 VPWR VGND sg13cmos5l_decap_4
* cell instance sg13cmos5l_decap_4_46 r0 *1 0,0
Xsg13cmos5l_decap_4_46 VPWR VGND sg13cmos5l_decap_4
* cell instance sg13cmos5l_decap_4_47 r0 *1 0,0
Xsg13cmos5l_decap_4_47 VPWR VGND sg13cmos5l_decap_4
* cell instance sg13cmos5l_decap_4_48 r0 *1 0,0
Xsg13cmos5l_decap_4_48 VPWR VGND sg13cmos5l_decap_4
* cell instance sg13cmos5l_decap_4_49 r0 *1 0,0
Xsg13cmos5l_decap_4_49 VPWR VGND sg13cmos5l_decap_4
* cell instance sg13cmos5l_decap_4_50 r0 *1 0,0
Xsg13cmos5l_decap_4_50 VPWR VGND sg13cmos5l_decap_4
* cell instance sg13cmos5l_decap_4_51 r0 *1 0,0
Xsg13cmos5l_decap_4_51 VPWR VGND sg13cmos5l_decap_4
* cell instance sg13cmos5l_decap_4_52 r0 *1 0,0
Xsg13cmos5l_decap_4_52 VPWR VGND sg13cmos5l_decap_4
* cell instance sg13cmos5l_decap_4_53 r0 *1 0,0
Xsg13cmos5l_decap_4_53 VPWR VGND sg13cmos5l_decap_4
* cell instance sg13cmos5l_decap_4_54 r0 *1 0,0
Xsg13cmos5l_decap_4_54 VPWR VGND sg13cmos5l_decap_4
* cell instance sg13cmos5l_decap_4_55 r0 *1 0,0
Xsg13cmos5l_decap_4_55 VPWR VGND sg13cmos5l_decap_4
* cell instance sg13cmos5l_decap_4_56 r0 *1 0,0
Xsg13cmos5l_decap_4_56 VPWR VGND sg13cmos5l_decap_4
* cell instance sg13cmos5l_decap_4_57 r0 *1 0,0
Xsg13cmos5l_decap_4_57 VPWR VGND sg13cmos5l_decap_4
* cell instance sg13cmos5l_decap_4_58 r0 *1 0,0
Xsg13cmos5l_decap_4_58 VPWR VGND sg13cmos5l_decap_4
* cell instance sg13cmos5l_decap_4_59 r0 *1 0,0
Xsg13cmos5l_decap_4_59 VPWR VGND sg13cmos5l_decap_4
* cell instance sg13cmos5l_decap_4_60 r0 *1 0,0
Xsg13cmos5l_decap_4_60 VPWR VGND sg13cmos5l_decap_4
* cell instance sg13cmos5l_decap_4_61 r0 *1 0,0
Xsg13cmos5l_decap_4_61 VPWR VGND sg13cmos5l_decap_4
* cell instance sg13cmos5l_decap_4_62 r0 *1 0,0
Xsg13cmos5l_decap_4_62 VPWR VGND sg13cmos5l_decap_4
* cell instance sg13cmos5l_decap_4_63 r0 *1 0,0
Xsg13cmos5l_decap_4_63 VPWR VGND sg13cmos5l_decap_4
* cell instance sg13cmos5l_decap_4_64 r0 *1 0,0
Xsg13cmos5l_decap_4_64 VPWR VGND sg13cmos5l_decap_4
* cell instance sg13cmos5l_decap_4_65 r0 *1 0,0
Xsg13cmos5l_decap_4_65 VPWR VGND sg13cmos5l_decap_4
* cell instance sg13cmos5l_decap_4_66 r0 *1 0,0
Xsg13cmos5l_decap_4_66 VPWR VGND sg13cmos5l_decap_4
* cell instance sg13cmos5l_decap_4_67 r0 *1 0,0
Xsg13cmos5l_decap_4_67 VPWR VGND sg13cmos5l_decap_4
* cell instance sg13cmos5l_decap_4_68 r0 *1 0,0
Xsg13cmos5l_decap_4_68 VPWR VGND sg13cmos5l_decap_4
* cell instance sg13cmos5l_decap_4_69 r0 *1 0,0
Xsg13cmos5l_decap_4_69 VPWR VGND sg13cmos5l_decap_4
* cell instance sg13cmos5l_decap_4_70 r0 *1 0,0
Xsg13cmos5l_decap_4_70 VPWR VGND sg13cmos5l_decap_4
* cell instance sg13cmos5l_decap_4_71 r0 *1 0,0
Xsg13cmos5l_decap_4_71 VPWR VGND sg13cmos5l_decap_4
* cell instance sg13cmos5l_decap_4_72 r0 *1 0,0
Xsg13cmos5l_decap_4_72 VPWR VGND sg13cmos5l_decap_4
* cell instance sg13cmos5l_decap_4_73 r0 *1 0,0
Xsg13cmos5l_decap_4_73 VPWR VGND sg13cmos5l_decap_4
* cell instance sg13cmos5l_decap_4_74 r0 *1 0,0
Xsg13cmos5l_decap_4_74 VPWR VGND sg13cmos5l_decap_4
* cell instance sg13cmos5l_decap_4_75 r0 *1 0,0
Xsg13cmos5l_decap_4_75 VPWR VGND sg13cmos5l_decap_4
* cell instance sg13cmos5l_decap_4_76 r0 *1 0,0
Xsg13cmos5l_decap_4_76 VPWR VGND sg13cmos5l_decap_4
* cell instance sg13cmos5l_decap_4_77 r0 *1 0,0
Xsg13cmos5l_decap_4_77 VPWR VGND sg13cmos5l_decap_4
* cell instance sg13cmos5l_decap_4_78 r0 *1 0,0
Xsg13cmos5l_decap_4_78 VPWR VGND sg13cmos5l_decap_4
* cell instance sg13cmos5l_decap_4_79 r0 *1 0,0
Xsg13cmos5l_decap_4_79 VPWR VGND sg13cmos5l_decap_4
* cell instance sg13cmos5l_decap_4_80 r0 *1 0,0
Xsg13cmos5l_decap_4_80 VPWR VGND sg13cmos5l_decap_4
* cell instance sg13cmos5l_decap_4_81 r0 *1 0,0
Xsg13cmos5l_decap_4_81 VPWR VGND sg13cmos5l_decap_4
* cell instance sg13cmos5l_decap_4_82 r0 *1 0,0
Xsg13cmos5l_decap_4_82 VPWR VGND sg13cmos5l_decap_4
* cell instance sg13cmos5l_decap_4_83 r0 *1 0,0
Xsg13cmos5l_decap_4_83 VPWR VGND sg13cmos5l_decap_4
* cell instance sg13cmos5l_decap_4_84 r0 *1 0,0
Xsg13cmos5l_decap_4_84 VPWR VGND sg13cmos5l_decap_4
* cell instance sg13cmos5l_decap_4_85 r0 *1 0,0
Xsg13cmos5l_decap_4_85 VPWR VGND sg13cmos5l_decap_4
* cell instance sg13cmos5l_decap_4_86 r0 *1 0,0
Xsg13cmos5l_decap_4_86 VPWR VGND sg13cmos5l_decap_4
* cell instance sg13cmos5l_decap_4_87 r0 *1 0,0
Xsg13cmos5l_decap_4_87 VPWR VGND sg13cmos5l_decap_4
* cell instance sg13cmos5l_decap_4_88 r0 *1 0,0
Xsg13cmos5l_decap_4_88 VPWR VGND sg13cmos5l_decap_4
* cell instance sg13cmos5l_decap_4_89 r0 *1 0,0
Xsg13cmos5l_decap_4_89 VPWR VGND sg13cmos5l_decap_4
* cell instance sg13cmos5l_decap_4_90 r0 *1 0,0
Xsg13cmos5l_decap_4_90 VPWR VGND sg13cmos5l_decap_4
* cell instance sg13cmos5l_decap_4_91 r0 *1 0,0
Xsg13cmos5l_decap_4_91 VPWR VGND sg13cmos5l_decap_4
* cell instance sg13cmos5l_decap_4_92 r0 *1 0,0
Xsg13cmos5l_decap_4_92 VPWR VGND sg13cmos5l_decap_4
* cell instance sg13cmos5l_decap_4_93 r0 *1 0,0
Xsg13cmos5l_decap_4_93 VPWR VGND sg13cmos5l_decap_4
* cell instance sg13cmos5l_decap_4_94 r0 *1 0,0
Xsg13cmos5l_decap_4_94 VPWR VGND sg13cmos5l_decap_4
* cell instance sg13cmos5l_decap_4_95 r0 *1 0,0
Xsg13cmos5l_decap_4_95 VPWR VGND sg13cmos5l_decap_4
* cell instance sg13cmos5l_decap_4_96 r0 *1 0,0
Xsg13cmos5l_decap_4_96 VPWR VGND sg13cmos5l_decap_4
* cell instance sg13cmos5l_decap_4_97 r0 *1 0,0
Xsg13cmos5l_decap_4_97 VPWR VGND sg13cmos5l_decap_4
* cell instance sg13cmos5l_decap_4_98 r0 *1 0,0
Xsg13cmos5l_decap_4_98 VPWR VGND sg13cmos5l_decap_4
* cell instance sg13cmos5l_decap_4_99 r0 *1 0,0
Xsg13cmos5l_decap_4_99 VPWR VGND sg13cmos5l_decap_4
* cell instance sg13cmos5l_decap_4_100 r0 *1 0,0
Xsg13cmos5l_decap_4_100 VPWR VGND sg13cmos5l_decap_4
* cell instance sg13cmos5l_decap_4_101 r0 *1 0,0
Xsg13cmos5l_decap_4_101 VPWR VGND sg13cmos5l_decap_4
* cell instance sg13cmos5l_decap_4_102 r0 *1 0,0
Xsg13cmos5l_decap_4_102 VPWR VGND sg13cmos5l_decap_4
* cell instance sg13cmos5l_decap_4_103 r0 *1 0,0
Xsg13cmos5l_decap_4_103 VPWR VGND sg13cmos5l_decap_4
* cell instance sg13cmos5l_decap_4_104 r0 *1 0,0
Xsg13cmos5l_decap_4_104 VPWR VGND sg13cmos5l_decap_4
* cell instance sg13cmos5l_decap_4_105 r0 *1 0,0
Xsg13cmos5l_decap_4_105 VPWR VGND sg13cmos5l_decap_4
* cell instance sg13cmos5l_decap_4_106 r0 *1 0,0
Xsg13cmos5l_decap_4_106 VPWR VGND sg13cmos5l_decap_4
* cell instance sg13cmos5l_decap_8_0 r0 *1 0,0
Xsg13cmos5l_decap_8_0 VPWR VGND sg13cmos5l_decap_8
* cell instance sg13cmos5l_decap_8_1 r0 *1 0,0
Xsg13cmos5l_decap_8_1 VPWR VGND sg13cmos5l_decap_8
* cell instance sg13cmos5l_decap_8_2 r0 *1 0,0
Xsg13cmos5l_decap_8_2 VPWR VGND sg13cmos5l_decap_8
* cell instance sg13cmos5l_decap_8_3 r0 *1 0,0
Xsg13cmos5l_decap_8_3 VPWR VGND sg13cmos5l_decap_8
* cell instance sg13cmos5l_decap_8_4 r0 *1 0,0
Xsg13cmos5l_decap_8_4 VPWR VGND sg13cmos5l_decap_8
* cell instance sg13cmos5l_decap_8_5 r0 *1 0,0
Xsg13cmos5l_decap_8_5 VPWR VGND sg13cmos5l_decap_8
* cell instance sg13cmos5l_decap_8_6 r0 *1 0,0
Xsg13cmos5l_decap_8_6 VPWR VGND sg13cmos5l_decap_8
* cell instance sg13cmos5l_decap_8_7 r0 *1 0,0
Xsg13cmos5l_decap_8_7 VPWR VGND sg13cmos5l_decap_8
* cell instance sg13cmos5l_decap_8_8 r0 *1 0,0
Xsg13cmos5l_decap_8_8 VPWR VGND sg13cmos5l_decap_8
* cell instance sg13cmos5l_decap_8_9 r0 *1 0,0
Xsg13cmos5l_decap_8_9 VPWR VGND sg13cmos5l_decap_8
* cell instance sg13cmos5l_decap_8_10 r0 *1 0,0
Xsg13cmos5l_decap_8_10 VPWR VGND sg13cmos5l_decap_8
* cell instance sg13cmos5l_decap_8_11 r0 *1 0,0
Xsg13cmos5l_decap_8_11 VPWR VGND sg13cmos5l_decap_8
* cell instance sg13cmos5l_decap_8_12 r0 *1 0,0
Xsg13cmos5l_decap_8_12 VPWR VGND sg13cmos5l_decap_8
* cell instance sg13cmos5l_decap_8_13 r0 *1 0,0
Xsg13cmos5l_decap_8_13 VPWR VGND sg13cmos5l_decap_8
* cell instance sg13cmos5l_decap_8_14 r0 *1 0,0
Xsg13cmos5l_decap_8_14 VPWR VGND sg13cmos5l_decap_8
* cell instance sg13cmos5l_decap_8_15 r0 *1 0,0
Xsg13cmos5l_decap_8_15 VPWR VGND sg13cmos5l_decap_8
* cell instance sg13cmos5l_decap_8_16 r0 *1 0,0
Xsg13cmos5l_decap_8_16 VPWR VGND sg13cmos5l_decap_8
* cell instance sg13cmos5l_decap_8_17 r0 *1 0,0
Xsg13cmos5l_decap_8_17 VPWR VGND sg13cmos5l_decap_8
* cell instance sg13cmos5l_decap_8_18 r0 *1 0,0
Xsg13cmos5l_decap_8_18 VPWR VGND sg13cmos5l_decap_8
* cell instance sg13cmos5l_decap_8_19 r0 *1 0,0
Xsg13cmos5l_decap_8_19 VPWR VGND sg13cmos5l_decap_8
* cell instance sg13cmos5l_decap_8_20 r0 *1 0,0
Xsg13cmos5l_decap_8_20 VPWR VGND sg13cmos5l_decap_8
* cell instance sg13cmos5l_decap_8_21 r0 *1 0,0
Xsg13cmos5l_decap_8_21 VPWR VGND sg13cmos5l_decap_8
* cell instance sg13cmos5l_decap_8_22 r0 *1 0,0
Xsg13cmos5l_decap_8_22 VPWR VGND sg13cmos5l_decap_8
* cell instance sg13cmos5l_decap_8_23 r0 *1 0,0
Xsg13cmos5l_decap_8_23 VPWR VGND sg13cmos5l_decap_8
* cell instance sg13cmos5l_decap_8_24 r0 *1 0,0
Xsg13cmos5l_decap_8_24 VPWR VGND sg13cmos5l_decap_8
* cell instance sg13cmos5l_decap_8_25 r0 *1 0,0
Xsg13cmos5l_decap_8_25 VPWR VGND sg13cmos5l_decap_8
* cell instance sg13cmos5l_decap_8_26 r0 *1 0,0
Xsg13cmos5l_decap_8_26 VPWR VGND sg13cmos5l_decap_8
* cell instance sg13cmos5l_decap_8_27 r0 *1 0,0
Xsg13cmos5l_decap_8_27 VPWR VGND sg13cmos5l_decap_8
* cell instance sg13cmos5l_decap_8_28 r0 *1 0,0
Xsg13cmos5l_decap_8_28 VPWR VGND sg13cmos5l_decap_8
* cell instance sg13cmos5l_decap_8_29 r0 *1 0,0
Xsg13cmos5l_decap_8_29 VPWR VGND sg13cmos5l_decap_8
* cell instance sg13cmos5l_decap_8_30 r0 *1 0,0
Xsg13cmos5l_decap_8_30 VPWR VGND sg13cmos5l_decap_8
* cell instance sg13cmos5l_decap_8_31 r0 *1 0,0
Xsg13cmos5l_decap_8_31 VPWR VGND sg13cmos5l_decap_8
* cell instance sg13cmos5l_decap_8_32 r0 *1 0,0
Xsg13cmos5l_decap_8_32 VPWR VGND sg13cmos5l_decap_8
* cell instance sg13cmos5l_decap_8_33 r0 *1 0,0
Xsg13cmos5l_decap_8_33 VPWR VGND sg13cmos5l_decap_8
* cell instance sg13cmos5l_decap_8_34 r0 *1 0,0
Xsg13cmos5l_decap_8_34 VPWR VGND sg13cmos5l_decap_8
* cell instance sg13cmos5l_decap_8_35 r0 *1 0,0
Xsg13cmos5l_decap_8_35 VPWR VGND sg13cmos5l_decap_8
* cell instance sg13cmos5l_decap_8_36 r0 *1 0,0
Xsg13cmos5l_decap_8_36 VPWR VGND sg13cmos5l_decap_8
* cell instance sg13cmos5l_decap_8_37 r0 *1 0,0
Xsg13cmos5l_decap_8_37 VPWR VGND sg13cmos5l_decap_8
* cell instance sg13cmos5l_decap_8_38 r0 *1 0,0
Xsg13cmos5l_decap_8_38 VPWR VGND sg13cmos5l_decap_8
* cell instance sg13cmos5l_decap_8_39 r0 *1 0,0
Xsg13cmos5l_decap_8_39 VPWR VGND sg13cmos5l_decap_8
* cell instance sg13cmos5l_decap_8_40 r0 *1 0,0
Xsg13cmos5l_decap_8_40 VPWR VGND sg13cmos5l_decap_8
* cell instance sg13cmos5l_decap_8_41 r0 *1 0,0
Xsg13cmos5l_decap_8_41 VPWR VGND sg13cmos5l_decap_8
* cell instance sg13cmos5l_decap_8_42 r0 *1 0,0
Xsg13cmos5l_decap_8_42 VPWR VGND sg13cmos5l_decap_8
* cell instance sg13cmos5l_decap_8_43 r0 *1 0,0
Xsg13cmos5l_decap_8_43 VPWR VGND sg13cmos5l_decap_8
* cell instance sg13cmos5l_decap_8_44 r0 *1 0,0
Xsg13cmos5l_decap_8_44 VPWR VGND sg13cmos5l_decap_8
* cell instance sg13cmos5l_decap_8_45 r0 *1 0,0
Xsg13cmos5l_decap_8_45 VPWR VGND sg13cmos5l_decap_8
* cell instance sg13cmos5l_decap_8_46 r0 *1 0,0
Xsg13cmos5l_decap_8_46 VPWR VGND sg13cmos5l_decap_8
* cell instance sg13cmos5l_decap_8_47 r0 *1 0,0
Xsg13cmos5l_decap_8_47 VPWR VGND sg13cmos5l_decap_8
* cell instance sg13cmos5l_decap_8_48 r0 *1 0,0
Xsg13cmos5l_decap_8_48 VPWR VGND sg13cmos5l_decap_8
* cell instance sg13cmos5l_decap_8_49 r0 *1 0,0
Xsg13cmos5l_decap_8_49 VPWR VGND sg13cmos5l_decap_8
* cell instance sg13cmos5l_decap_8_50 r0 *1 0,0
Xsg13cmos5l_decap_8_50 VPWR VGND sg13cmos5l_decap_8
* cell instance sg13cmos5l_decap_8_51 r0 *1 0,0
Xsg13cmos5l_decap_8_51 VPWR VGND sg13cmos5l_decap_8
* cell instance sg13cmos5l_decap_8_52 r0 *1 0,0
Xsg13cmos5l_decap_8_52 VPWR VGND sg13cmos5l_decap_8
* cell instance sg13cmos5l_decap_8_53 r0 *1 0,0
Xsg13cmos5l_decap_8_53 VPWR VGND sg13cmos5l_decap_8
* cell instance sg13cmos5l_decap_8_54 r0 *1 0,0
Xsg13cmos5l_decap_8_54 VPWR VGND sg13cmos5l_decap_8
* cell instance sg13cmos5l_decap_8_55 r0 *1 0,0
Xsg13cmos5l_decap_8_55 VPWR VGND sg13cmos5l_decap_8
* cell instance sg13cmos5l_decap_8_56 r0 *1 0,0
Xsg13cmos5l_decap_8_56 VPWR VGND sg13cmos5l_decap_8
* cell instance sg13cmos5l_decap_8_57 r0 *1 0,0
Xsg13cmos5l_decap_8_57 VPWR VGND sg13cmos5l_decap_8
* cell instance sg13cmos5l_decap_8_58 r0 *1 0,0
Xsg13cmos5l_decap_8_58 VPWR VGND sg13cmos5l_decap_8
* cell instance sg13cmos5l_decap_8_59 r0 *1 0,0
Xsg13cmos5l_decap_8_59 VPWR VGND sg13cmos5l_decap_8
* cell instance sg13cmos5l_decap_8_60 r0 *1 0,0
Xsg13cmos5l_decap_8_60 VPWR VGND sg13cmos5l_decap_8
* cell instance sg13cmos5l_decap_8_61 r0 *1 0,0
Xsg13cmos5l_decap_8_61 VPWR VGND sg13cmos5l_decap_8
* cell instance sg13cmos5l_decap_8_62 r0 *1 0,0
Xsg13cmos5l_decap_8_62 VPWR VGND sg13cmos5l_decap_8
* cell instance sg13cmos5l_decap_8_63 r0 *1 0,0
Xsg13cmos5l_decap_8_63 VPWR VGND sg13cmos5l_decap_8
* cell instance sg13cmos5l_decap_8_64 r0 *1 0,0
Xsg13cmos5l_decap_8_64 VPWR VGND sg13cmos5l_decap_8
* cell instance sg13cmos5l_decap_8_65 r0 *1 0,0
Xsg13cmos5l_decap_8_65 VPWR VGND sg13cmos5l_decap_8
* cell instance sg13cmos5l_decap_8_66 r0 *1 0,0
Xsg13cmos5l_decap_8_66 VPWR VGND sg13cmos5l_decap_8
* cell instance sg13cmos5l_decap_8_67 r0 *1 0,0
Xsg13cmos5l_decap_8_67 VPWR VGND sg13cmos5l_decap_8
* cell instance sg13cmos5l_decap_8_68 r0 *1 0,0
Xsg13cmos5l_decap_8_68 VPWR VGND sg13cmos5l_decap_8
* cell instance sg13cmos5l_decap_8_69 r0 *1 0,0
Xsg13cmos5l_decap_8_69 VPWR VGND sg13cmos5l_decap_8
* cell instance sg13cmos5l_decap_8_70 r0 *1 0,0
Xsg13cmos5l_decap_8_70 VPWR VGND sg13cmos5l_decap_8
* cell instance sg13cmos5l_decap_8_71 r0 *1 0,0
Xsg13cmos5l_decap_8_71 VPWR VGND sg13cmos5l_decap_8
* cell instance sg13cmos5l_decap_8_72 r0 *1 0,0
Xsg13cmos5l_decap_8_72 VPWR VGND sg13cmos5l_decap_8
* cell instance sg13cmos5l_decap_8_73 r0 *1 0,0
Xsg13cmos5l_decap_8_73 VPWR VGND sg13cmos5l_decap_8
* cell instance sg13cmos5l_decap_8_74 r0 *1 0,0
Xsg13cmos5l_decap_8_74 VPWR VGND sg13cmos5l_decap_8
* cell instance sg13cmos5l_decap_8_75 r0 *1 0,0
Xsg13cmos5l_decap_8_75 VPWR VGND sg13cmos5l_decap_8
* cell instance sg13cmos5l_decap_8_76 r0 *1 0,0
Xsg13cmos5l_decap_8_76 VPWR VGND sg13cmos5l_decap_8
* cell instance sg13cmos5l_decap_8_77 r0 *1 0,0
Xsg13cmos5l_decap_8_77 VPWR VGND sg13cmos5l_decap_8
* cell instance sg13cmos5l_decap_8_78 r0 *1 0,0
Xsg13cmos5l_decap_8_78 VPWR VGND sg13cmos5l_decap_8
* cell instance sg13cmos5l_decap_8_79 r0 *1 0,0
Xsg13cmos5l_decap_8_79 VPWR VGND sg13cmos5l_decap_8
* cell instance sg13cmos5l_decap_8_80 r0 *1 0,0
Xsg13cmos5l_decap_8_80 VPWR VGND sg13cmos5l_decap_8
* cell instance sg13cmos5l_decap_8_81 r0 *1 0,0
Xsg13cmos5l_decap_8_81 VPWR VGND sg13cmos5l_decap_8
* cell instance sg13cmos5l_decap_8_82 r0 *1 0,0
Xsg13cmos5l_decap_8_82 VPWR VGND sg13cmos5l_decap_8
* cell instance sg13cmos5l_decap_8_83 r0 *1 0,0
Xsg13cmos5l_decap_8_83 VPWR VGND sg13cmos5l_decap_8
* cell instance sg13cmos5l_decap_8_84 r0 *1 0,0
Xsg13cmos5l_decap_8_84 VPWR VGND sg13cmos5l_decap_8
* cell instance sg13cmos5l_decap_8_85 r0 *1 0,0
Xsg13cmos5l_decap_8_85 VPWR VGND sg13cmos5l_decap_8
* cell instance sg13cmos5l_decap_8_86 r0 *1 0,0
Xsg13cmos5l_decap_8_86 VPWR VGND sg13cmos5l_decap_8
* cell instance sg13cmos5l_decap_8_87 r0 *1 0,0
Xsg13cmos5l_decap_8_87 VPWR VGND sg13cmos5l_decap_8
* cell instance sg13cmos5l_decap_8_88 r0 *1 0,0
Xsg13cmos5l_decap_8_88 VPWR VGND sg13cmos5l_decap_8
* cell instance sg13cmos5l_decap_8_89 r0 *1 0,0
Xsg13cmos5l_decap_8_89 VPWR VGND sg13cmos5l_decap_8
* cell instance sg13cmos5l_decap_8_90 r0 *1 0,0
Xsg13cmos5l_decap_8_90 VPWR VGND sg13cmos5l_decap_8
* cell instance sg13cmos5l_decap_8_91 r0 *1 0,0
Xsg13cmos5l_decap_8_91 VPWR VGND sg13cmos5l_decap_8
* cell instance sg13cmos5l_decap_8_92 r0 *1 0,0
Xsg13cmos5l_decap_8_92 VPWR VGND sg13cmos5l_decap_8
* cell instance sg13cmos5l_decap_8_93 r0 *1 0,0
Xsg13cmos5l_decap_8_93 VPWR VGND sg13cmos5l_decap_8
* cell instance sg13cmos5l_decap_8_94 r0 *1 0,0
Xsg13cmos5l_decap_8_94 VPWR VGND sg13cmos5l_decap_8
* cell instance sg13cmos5l_decap_8_95 r0 *1 0,0
Xsg13cmos5l_decap_8_95 VPWR VGND sg13cmos5l_decap_8
* cell instance sg13cmos5l_decap_8_96 r0 *1 0,0
Xsg13cmos5l_decap_8_96 VPWR VGND sg13cmos5l_decap_8
* cell instance sg13cmos5l_decap_8_97 r0 *1 0,0
Xsg13cmos5l_decap_8_97 VPWR VGND sg13cmos5l_decap_8
* cell instance sg13cmos5l_decap_8_98 r0 *1 0,0
Xsg13cmos5l_decap_8_98 VPWR VGND sg13cmos5l_decap_8
* cell instance sg13cmos5l_decap_8_99 r0 *1 0,0
Xsg13cmos5l_decap_8_99 VPWR VGND sg13cmos5l_decap_8
* cell instance sg13cmos5l_decap_8_100 r0 *1 0,0
Xsg13cmos5l_decap_8_100 VPWR VGND sg13cmos5l_decap_8
* cell instance sg13cmos5l_decap_8_101 r0 *1 0,0
Xsg13cmos5l_decap_8_101 VPWR VGND sg13cmos5l_decap_8
* cell instance sg13cmos5l_decap_8_102 r0 *1 0,0
Xsg13cmos5l_decap_8_102 VPWR VGND sg13cmos5l_decap_8
* cell instance sg13cmos5l_decap_8_103 r0 *1 0,0
Xsg13cmos5l_decap_8_103 VPWR VGND sg13cmos5l_decap_8
* cell instance sg13cmos5l_decap_8_104 r0 *1 0,0
Xsg13cmos5l_decap_8_104 VPWR VGND sg13cmos5l_decap_8
* cell instance sg13cmos5l_decap_8_105 r0 *1 0,0
Xsg13cmos5l_decap_8_105 VPWR VGND sg13cmos5l_decap_8
* cell instance sg13cmos5l_decap_8_106 r0 *1 0,0
Xsg13cmos5l_decap_8_106 VPWR VGND sg13cmos5l_decap_8
* cell instance sg13cmos5l_decap_8_107 r0 *1 0,0
Xsg13cmos5l_decap_8_107 VPWR VGND sg13cmos5l_decap_8
* cell instance sg13cmos5l_decap_8_108 r0 *1 0,0
Xsg13cmos5l_decap_8_108 VPWR VGND sg13cmos5l_decap_8
* cell instance sg13cmos5l_decap_8_109 r0 *1 0,0
Xsg13cmos5l_decap_8_109 VPWR VGND sg13cmos5l_decap_8
* cell instance sg13cmos5l_decap_8_110 r0 *1 0,0
Xsg13cmos5l_decap_8_110 VPWR VGND sg13cmos5l_decap_8
* cell instance sg13cmos5l_decap_8_111 r0 *1 0,0
Xsg13cmos5l_decap_8_111 VPWR VGND sg13cmos5l_decap_8
* cell instance sg13cmos5l_decap_8_112 r0 *1 0,0
Xsg13cmos5l_decap_8_112 VPWR VGND sg13cmos5l_decap_8
* cell instance sg13cmos5l_decap_8_113 r0 *1 0,0
Xsg13cmos5l_decap_8_113 VPWR VGND sg13cmos5l_decap_8
* cell instance sg13cmos5l_decap_8_114 r0 *1 0,0
Xsg13cmos5l_decap_8_114 VPWR VGND sg13cmos5l_decap_8
* cell instance sg13cmos5l_decap_8_115 r0 *1 0,0
Xsg13cmos5l_decap_8_115 VPWR VGND sg13cmos5l_decap_8
* cell instance sg13cmos5l_decap_8_116 r0 *1 0,0
Xsg13cmos5l_decap_8_116 VPWR VGND sg13cmos5l_decap_8
* cell instance sg13cmos5l_decap_8_117 r0 *1 0,0
Xsg13cmos5l_decap_8_117 VPWR VGND sg13cmos5l_decap_8
* cell instance sg13cmos5l_decap_8_118 r0 *1 0,0
Xsg13cmos5l_decap_8_118 VPWR VGND sg13cmos5l_decap_8
* cell instance sg13cmos5l_decap_8_119 r0 *1 0,0
Xsg13cmos5l_decap_8_119 VPWR VGND sg13cmos5l_decap_8
* cell instance sg13cmos5l_decap_8_120 r0 *1 0,0
Xsg13cmos5l_decap_8_120 VPWR VGND sg13cmos5l_decap_8
* cell instance sg13cmos5l_decap_8_121 r0 *1 0,0
Xsg13cmos5l_decap_8_121 VPWR VGND sg13cmos5l_decap_8
* cell instance sg13cmos5l_decap_8_122 r0 *1 0,0
Xsg13cmos5l_decap_8_122 VPWR VGND sg13cmos5l_decap_8
* cell instance sg13cmos5l_decap_8_123 r0 *1 0,0
Xsg13cmos5l_decap_8_123 VPWR VGND sg13cmos5l_decap_8
* cell instance sg13cmos5l_decap_8_124 r0 *1 0,0
Xsg13cmos5l_decap_8_124 VPWR VGND sg13cmos5l_decap_8
* cell instance sg13cmos5l_decap_8_125 r0 *1 0,0
Xsg13cmos5l_decap_8_125 VPWR VGND sg13cmos5l_decap_8
* cell instance sg13cmos5l_decap_8_126 r0 *1 0,0
Xsg13cmos5l_decap_8_126 VPWR VGND sg13cmos5l_decap_8
* cell instance sg13cmos5l_decap_8_127 r0 *1 0,0
Xsg13cmos5l_decap_8_127 VPWR VGND sg13cmos5l_decap_8
* cell instance sg13cmos5l_decap_8_128 r0 *1 0,0
Xsg13cmos5l_decap_8_128 VPWR VGND sg13cmos5l_decap_8
* cell instance sg13cmos5l_decap_8_129 r0 *1 0,0
Xsg13cmos5l_decap_8_129 VPWR VGND sg13cmos5l_decap_8
* cell instance sg13cmos5l_decap_8_130 r0 *1 0,0
Xsg13cmos5l_decap_8_130 VPWR VGND sg13cmos5l_decap_8
* cell instance sg13cmos5l_decap_8_131 r0 *1 0,0
Xsg13cmos5l_decap_8_131 VPWR VGND sg13cmos5l_decap_8
* cell instance sg13cmos5l_decap_8_132 r0 *1 0,0
Xsg13cmos5l_decap_8_132 VPWR VGND sg13cmos5l_decap_8
* cell instance sg13cmos5l_decap_8_133 r0 *1 0,0
Xsg13cmos5l_decap_8_133 VPWR VGND sg13cmos5l_decap_8
* cell instance sg13cmos5l_decap_8_134 r0 *1 0,0
Xsg13cmos5l_decap_8_134 VPWR VGND sg13cmos5l_decap_8
* cell instance sg13cmos5l_decap_8_135 r0 *1 0,0
Xsg13cmos5l_decap_8_135 VPWR VGND sg13cmos5l_decap_8
* cell instance sg13cmos5l_decap_8_136 r0 *1 0,0
Xsg13cmos5l_decap_8_136 VPWR VGND sg13cmos5l_decap_8
* cell instance sg13cmos5l_decap_8_137 r0 *1 0,0
Xsg13cmos5l_decap_8_137 VPWR VGND sg13cmos5l_decap_8
* cell instance sg13cmos5l_decap_8_138 r0 *1 0,0
Xsg13cmos5l_decap_8_138 VPWR VGND sg13cmos5l_decap_8
* cell instance sg13cmos5l_decap_8_139 r0 *1 0,0
Xsg13cmos5l_decap_8_139 VPWR VGND sg13cmos5l_decap_8
* cell instance sg13cmos5l_decap_8_140 r0 *1 0,0
Xsg13cmos5l_decap_8_140 VPWR VGND sg13cmos5l_decap_8
* cell instance sg13cmos5l_decap_8_141 r0 *1 0,0
Xsg13cmos5l_decap_8_141 VPWR VGND sg13cmos5l_decap_8
* cell instance sg13cmos5l_decap_8_142 r0 *1 0,0
Xsg13cmos5l_decap_8_142 VPWR VGND sg13cmos5l_decap_8
* cell instance sg13cmos5l_decap_8_143 r0 *1 0,0
Xsg13cmos5l_decap_8_143 VPWR VGND sg13cmos5l_decap_8
* cell instance sg13cmos5l_decap_8_144 r0 *1 0,0
Xsg13cmos5l_decap_8_144 VPWR VGND sg13cmos5l_decap_8
* cell instance sg13cmos5l_decap_8_145 r0 *1 0,0
Xsg13cmos5l_decap_8_145 VPWR VGND sg13cmos5l_decap_8
* cell instance sg13cmos5l_decap_8_146 r0 *1 0,0
Xsg13cmos5l_decap_8_146 VPWR VGND sg13cmos5l_decap_8
* cell instance sg13cmos5l_decap_8_147 r0 *1 0,0
Xsg13cmos5l_decap_8_147 VPWR VGND sg13cmos5l_decap_8
* cell instance sg13cmos5l_decap_8_148 r0 *1 0,0
Xsg13cmos5l_decap_8_148 VPWR VGND sg13cmos5l_decap_8
* cell instance sg13cmos5l_decap_8_149 r0 *1 0,0
Xsg13cmos5l_decap_8_149 VPWR VGND sg13cmos5l_decap_8
* cell instance sg13cmos5l_decap_8_150 r0 *1 0,0
Xsg13cmos5l_decap_8_150 VPWR VGND sg13cmos5l_decap_8
* cell instance sg13cmos5l_decap_8_151 r0 *1 0,0
Xsg13cmos5l_decap_8_151 VPWR VGND sg13cmos5l_decap_8
* cell instance sg13cmos5l_decap_8_152 r0 *1 0,0
Xsg13cmos5l_decap_8_152 VPWR VGND sg13cmos5l_decap_8
* cell instance sg13cmos5l_decap_8_153 r0 *1 0,0
Xsg13cmos5l_decap_8_153 VPWR VGND sg13cmos5l_decap_8
* cell instance sg13cmos5l_decap_8_154 r0 *1 0,0
Xsg13cmos5l_decap_8_154 VPWR VGND sg13cmos5l_decap_8
* cell instance sg13cmos5l_decap_8_155 r0 *1 0,0
Xsg13cmos5l_decap_8_155 VPWR VGND sg13cmos5l_decap_8
* cell instance sg13cmos5l_decap_8_156 r0 *1 0,0
Xsg13cmos5l_decap_8_156 VPWR VGND sg13cmos5l_decap_8
* cell instance sg13cmos5l_decap_8_157 r0 *1 0,0
Xsg13cmos5l_decap_8_157 VPWR VGND sg13cmos5l_decap_8
* cell instance sg13cmos5l_decap_8_158 r0 *1 0,0
Xsg13cmos5l_decap_8_158 VPWR VGND sg13cmos5l_decap_8
* cell instance sg13cmos5l_decap_8_159 r0 *1 0,0
Xsg13cmos5l_decap_8_159 VPWR VGND sg13cmos5l_decap_8
* cell instance sg13cmos5l_decap_8_160 r0 *1 0,0
Xsg13cmos5l_decap_8_160 VPWR VGND sg13cmos5l_decap_8
* cell instance sg13cmos5l_decap_8_161 r0 *1 0,0
Xsg13cmos5l_decap_8_161 VPWR VGND sg13cmos5l_decap_8
* cell instance sg13cmos5l_decap_8_162 r0 *1 0,0
Xsg13cmos5l_decap_8_162 VPWR VGND sg13cmos5l_decap_8
* cell instance sg13cmos5l_decap_8_163 r0 *1 0,0
Xsg13cmos5l_decap_8_163 VPWR VGND sg13cmos5l_decap_8
* cell instance sg13cmos5l_decap_8_164 r0 *1 0,0
Xsg13cmos5l_decap_8_164 VPWR VGND sg13cmos5l_decap_8
* cell instance sg13cmos5l_decap_8_165 r0 *1 0,0
Xsg13cmos5l_decap_8_165 VPWR VGND sg13cmos5l_decap_8
* cell instance sg13cmos5l_decap_8_166 r0 *1 0,0
Xsg13cmos5l_decap_8_166 VPWR VGND sg13cmos5l_decap_8
* cell instance sg13cmos5l_decap_8_167 r0 *1 0,0
Xsg13cmos5l_decap_8_167 VPWR VGND sg13cmos5l_decap_8
* cell instance sg13cmos5l_decap_8_168 r0 *1 0,0
Xsg13cmos5l_decap_8_168 VPWR VGND sg13cmos5l_decap_8
* cell instance sg13cmos5l_decap_8_169 r0 *1 0,0
Xsg13cmos5l_decap_8_169 VPWR VGND sg13cmos5l_decap_8
* cell instance sg13cmos5l_decap_8_170 r0 *1 0,0
Xsg13cmos5l_decap_8_170 VPWR VGND sg13cmos5l_decap_8
* cell instance sg13cmos5l_decap_8_171 r0 *1 0,0
Xsg13cmos5l_decap_8_171 VPWR VGND sg13cmos5l_decap_8
* cell instance sg13cmos5l_decap_8_172 r0 *1 0,0
Xsg13cmos5l_decap_8_172 VPWR VGND sg13cmos5l_decap_8
* cell instance sg13cmos5l_decap_8_173 r0 *1 0,0
Xsg13cmos5l_decap_8_173 VPWR VGND sg13cmos5l_decap_8
* cell instance sg13cmos5l_decap_8_174 r0 *1 0,0
Xsg13cmos5l_decap_8_174 VPWR VGND sg13cmos5l_decap_8
* cell instance sg13cmos5l_decap_8_175 r0 *1 0,0
Xsg13cmos5l_decap_8_175 VPWR VGND sg13cmos5l_decap_8
* cell instance sg13cmos5l_decap_8_176 r0 *1 0,0
Xsg13cmos5l_decap_8_176 VPWR VGND sg13cmos5l_decap_8
* cell instance sg13cmos5l_decap_8_177 r0 *1 0,0
Xsg13cmos5l_decap_8_177 VPWR VGND sg13cmos5l_decap_8
* cell instance sg13cmos5l_decap_8_178 r0 *1 0,0
Xsg13cmos5l_decap_8_178 VPWR VGND sg13cmos5l_decap_8
* cell instance sg13cmos5l_decap_8_179 r0 *1 0,0
Xsg13cmos5l_decap_8_179 VPWR VGND sg13cmos5l_decap_8
* cell instance sg13cmos5l_decap_8_180 r0 *1 0,0
Xsg13cmos5l_decap_8_180 VPWR VGND sg13cmos5l_decap_8
* cell instance sg13cmos5l_decap_8_181 r0 *1 0,0
Xsg13cmos5l_decap_8_181 VPWR VGND sg13cmos5l_decap_8
* cell instance sg13cmos5l_decap_8_182 r0 *1 0,0
Xsg13cmos5l_decap_8_182 VPWR VGND sg13cmos5l_decap_8
* cell instance sg13cmos5l_decap_8_183 r0 *1 0,0
Xsg13cmos5l_decap_8_183 VPWR VGND sg13cmos5l_decap_8
* cell instance sg13cmos5l_decap_8_184 r0 *1 0,0
Xsg13cmos5l_decap_8_184 VPWR VGND sg13cmos5l_decap_8
* cell instance sg13cmos5l_decap_8_185 r0 *1 0,0
Xsg13cmos5l_decap_8_185 VPWR VGND sg13cmos5l_decap_8
* cell instance sg13cmos5l_decap_8_186 r0 *1 0,0
Xsg13cmos5l_decap_8_186 VPWR VGND sg13cmos5l_decap_8
* cell instance sg13cmos5l_decap_8_187 r0 *1 0,0
Xsg13cmos5l_decap_8_187 VPWR VGND sg13cmos5l_decap_8
* cell instance sg13cmos5l_decap_8_188 r0 *1 0,0
Xsg13cmos5l_decap_8_188 VPWR VGND sg13cmos5l_decap_8
* cell instance sg13cmos5l_decap_8_189 r0 *1 0,0
Xsg13cmos5l_decap_8_189 VPWR VGND sg13cmos5l_decap_8
* cell instance sg13cmos5l_decap_8_190 r0 *1 0,0
Xsg13cmos5l_decap_8_190 VPWR VGND sg13cmos5l_decap_8
* cell instance sg13cmos5l_decap_8_191 r0 *1 0,0
Xsg13cmos5l_decap_8_191 VPWR VGND sg13cmos5l_decap_8
* cell instance sg13cmos5l_decap_8_192 r0 *1 0,0
Xsg13cmos5l_decap_8_192 VPWR VGND sg13cmos5l_decap_8
* cell instance sg13cmos5l_decap_8_193 r0 *1 0,0
Xsg13cmos5l_decap_8_193 VPWR VGND sg13cmos5l_decap_8
* cell instance sg13cmos5l_decap_8_194 r0 *1 0,0
Xsg13cmos5l_decap_8_194 VPWR VGND sg13cmos5l_decap_8
* cell instance sg13cmos5l_decap_8_195 r0 *1 0,0
Xsg13cmos5l_decap_8_195 VPWR VGND sg13cmos5l_decap_8
* cell instance sg13cmos5l_decap_8_196 r0 *1 0,0
Xsg13cmos5l_decap_8_196 VPWR VGND sg13cmos5l_decap_8
* cell instance sg13cmos5l_decap_8_197 r0 *1 0,0
Xsg13cmos5l_decap_8_197 VPWR VGND sg13cmos5l_decap_8
* cell instance sg13cmos5l_decap_8_198 r0 *1 0,0
Xsg13cmos5l_decap_8_198 VPWR VGND sg13cmos5l_decap_8
* cell instance sg13cmos5l_decap_8_199 r0 *1 0,0
Xsg13cmos5l_decap_8_199 VPWR VGND sg13cmos5l_decap_8
* cell instance sg13cmos5l_decap_8_200 r0 *1 0,0
Xsg13cmos5l_decap_8_200 VPWR VGND sg13cmos5l_decap_8
* cell instance sg13cmos5l_decap_8_201 r0 *1 0,0
Xsg13cmos5l_decap_8_201 VPWR VGND sg13cmos5l_decap_8
* cell instance sg13cmos5l_decap_8_202 r0 *1 0,0
Xsg13cmos5l_decap_8_202 VPWR VGND sg13cmos5l_decap_8
* cell instance sg13cmos5l_decap_8_203 r0 *1 0,0
Xsg13cmos5l_decap_8_203 VPWR VGND sg13cmos5l_decap_8
* cell instance sg13cmos5l_decap_8_204 r0 *1 0,0
Xsg13cmos5l_decap_8_204 VPWR VGND sg13cmos5l_decap_8
* cell instance sg13cmos5l_decap_8_205 r0 *1 0,0
Xsg13cmos5l_decap_8_205 VPWR VGND sg13cmos5l_decap_8
* cell instance sg13cmos5l_decap_8_206 r0 *1 0,0
Xsg13cmos5l_decap_8_206 VPWR VGND sg13cmos5l_decap_8
* cell instance sg13cmos5l_decap_8_207 r0 *1 0,0
Xsg13cmos5l_decap_8_207 VPWR VGND sg13cmos5l_decap_8
* cell instance sg13cmos5l_decap_8_208 r0 *1 0,0
Xsg13cmos5l_decap_8_208 VPWR VGND sg13cmos5l_decap_8
* cell instance sg13cmos5l_decap_8_209 r0 *1 0,0
Xsg13cmos5l_decap_8_209 VPWR VGND sg13cmos5l_decap_8
* cell instance sg13cmos5l_decap_8_210 r0 *1 0,0
Xsg13cmos5l_decap_8_210 VPWR VGND sg13cmos5l_decap_8
* cell instance sg13cmos5l_decap_8_211 r0 *1 0,0
Xsg13cmos5l_decap_8_211 VPWR VGND sg13cmos5l_decap_8
* cell instance sg13cmos5l_decap_8_212 r0 *1 0,0
Xsg13cmos5l_decap_8_212 VPWR VGND sg13cmos5l_decap_8
* cell instance sg13cmos5l_decap_8_213 r0 *1 0,0
Xsg13cmos5l_decap_8_213 VPWR VGND sg13cmos5l_decap_8
* cell instance sg13cmos5l_decap_8_214 r0 *1 0,0
Xsg13cmos5l_decap_8_214 VPWR VGND sg13cmos5l_decap_8
* cell instance sg13cmos5l_decap_8_215 r0 *1 0,0
Xsg13cmos5l_decap_8_215 VPWR VGND sg13cmos5l_decap_8
* cell instance sg13cmos5l_decap_8_216 r0 *1 0,0
Xsg13cmos5l_decap_8_216 VPWR VGND sg13cmos5l_decap_8
* cell instance sg13cmos5l_decap_8_217 r0 *1 0,0
Xsg13cmos5l_decap_8_217 VPWR VGND sg13cmos5l_decap_8
* cell instance sg13cmos5l_decap_8_218 r0 *1 0,0
Xsg13cmos5l_decap_8_218 VPWR VGND sg13cmos5l_decap_8
* cell instance sg13cmos5l_decap_8_219 r0 *1 0,0
Xsg13cmos5l_decap_8_219 VPWR VGND sg13cmos5l_decap_8
* cell instance sg13cmos5l_decap_8_220 r0 *1 0,0
Xsg13cmos5l_decap_8_220 VPWR VGND sg13cmos5l_decap_8
* cell instance sg13cmos5l_decap_8_221 r0 *1 0,0
Xsg13cmos5l_decap_8_221 VPWR VGND sg13cmos5l_decap_8
* cell instance sg13cmos5l_decap_8_222 r0 *1 0,0
Xsg13cmos5l_decap_8_222 VPWR VGND sg13cmos5l_decap_8
* cell instance sg13cmos5l_decap_8_223 r0 *1 0,0
Xsg13cmos5l_decap_8_223 VPWR VGND sg13cmos5l_decap_8
* cell instance sg13cmos5l_decap_8_224 r0 *1 0,0
Xsg13cmos5l_decap_8_224 VPWR VGND sg13cmos5l_decap_8
* cell instance sg13cmos5l_decap_8_225 r0 *1 0,0
Xsg13cmos5l_decap_8_225 VPWR VGND sg13cmos5l_decap_8
* cell instance sg13cmos5l_decap_8_226 r0 *1 0,0
Xsg13cmos5l_decap_8_226 VPWR VGND sg13cmos5l_decap_8
* cell instance sg13cmos5l_decap_8_227 r0 *1 0,0
Xsg13cmos5l_decap_8_227 VPWR VGND sg13cmos5l_decap_8
* cell instance sg13cmos5l_decap_8_228 r0 *1 0,0
Xsg13cmos5l_decap_8_228 VPWR VGND sg13cmos5l_decap_8
* cell instance sg13cmos5l_decap_8_229 r0 *1 0,0
Xsg13cmos5l_decap_8_229 VPWR VGND sg13cmos5l_decap_8
* cell instance sg13cmos5l_decap_8_230 r0 *1 0,0
Xsg13cmos5l_decap_8_230 VPWR VGND sg13cmos5l_decap_8
* cell instance sg13cmos5l_decap_8_231 r0 *1 0,0
Xsg13cmos5l_decap_8_231 VPWR VGND sg13cmos5l_decap_8
* cell instance sg13cmos5l_decap_8_232 r0 *1 0,0
Xsg13cmos5l_decap_8_232 VPWR VGND sg13cmos5l_decap_8
* cell instance sg13cmos5l_decap_8_233 r0 *1 0,0
Xsg13cmos5l_decap_8_233 VPWR VGND sg13cmos5l_decap_8
* cell instance sg13cmos5l_decap_8_234 r0 *1 0,0
Xsg13cmos5l_decap_8_234 VPWR VGND sg13cmos5l_decap_8
* cell instance sg13cmos5l_decap_8_235 r0 *1 0,0
Xsg13cmos5l_decap_8_235 VPWR VGND sg13cmos5l_decap_8
* cell instance sg13cmos5l_decap_8_236 r0 *1 0,0
Xsg13cmos5l_decap_8_236 VPWR VGND sg13cmos5l_decap_8
* cell instance sg13cmos5l_decap_8_237 r0 *1 0,0
Xsg13cmos5l_decap_8_237 VPWR VGND sg13cmos5l_decap_8
* cell instance sg13cmos5l_decap_8_238 r0 *1 0,0
Xsg13cmos5l_decap_8_238 VPWR VGND sg13cmos5l_decap_8
* cell instance sg13cmos5l_decap_8_239 r0 *1 0,0
Xsg13cmos5l_decap_8_239 VPWR VGND sg13cmos5l_decap_8
* cell instance sg13cmos5l_decap_8_240 r0 *1 0,0
Xsg13cmos5l_decap_8_240 VPWR VGND sg13cmos5l_decap_8
* cell instance sg13cmos5l_decap_8_241 r0 *1 0,0
Xsg13cmos5l_decap_8_241 VPWR VGND sg13cmos5l_decap_8
* cell instance sg13cmos5l_decap_8_242 r0 *1 0,0
Xsg13cmos5l_decap_8_242 VPWR VGND sg13cmos5l_decap_8
* cell instance sg13cmos5l_decap_8_243 r0 *1 0,0
Xsg13cmos5l_decap_8_243 VPWR VGND sg13cmos5l_decap_8
* cell instance sg13cmos5l_decap_8_244 r0 *1 0,0
Xsg13cmos5l_decap_8_244 VPWR VGND sg13cmos5l_decap_8
* cell instance sg13cmos5l_decap_8_245 r0 *1 0,0
Xsg13cmos5l_decap_8_245 VPWR VGND sg13cmos5l_decap_8
* cell instance sg13cmos5l_decap_8_246 r0 *1 0,0
Xsg13cmos5l_decap_8_246 VPWR VGND sg13cmos5l_decap_8
* cell instance sg13cmos5l_decap_8_247 r0 *1 0,0
Xsg13cmos5l_decap_8_247 VPWR VGND sg13cmos5l_decap_8
* cell instance sg13cmos5l_decap_8_248 r0 *1 0,0
Xsg13cmos5l_decap_8_248 VPWR VGND sg13cmos5l_decap_8
* cell instance sg13cmos5l_decap_8_249 r0 *1 0,0
Xsg13cmos5l_decap_8_249 VPWR VGND sg13cmos5l_decap_8
* cell instance sg13cmos5l_decap_8_250 r0 *1 0,0
Xsg13cmos5l_decap_8_250 VPWR VGND sg13cmos5l_decap_8
* cell instance sg13cmos5l_decap_8_251 r0 *1 0,0
Xsg13cmos5l_decap_8_251 VPWR VGND sg13cmos5l_decap_8
* cell instance sg13cmos5l_decap_8_252 r0 *1 0,0
Xsg13cmos5l_decap_8_252 VPWR VGND sg13cmos5l_decap_8
* cell instance sg13cmos5l_decap_8_253 r0 *1 0,0
Xsg13cmos5l_decap_8_253 VPWR VGND sg13cmos5l_decap_8
* cell instance sg13cmos5l_decap_8_254 r0 *1 0,0
Xsg13cmos5l_decap_8_254 VPWR VGND sg13cmos5l_decap_8
* cell instance sg13cmos5l_decap_8_255 r0 *1 0,0
Xsg13cmos5l_decap_8_255 VPWR VGND sg13cmos5l_decap_8
* cell instance sg13cmos5l_decap_8_256 r0 *1 0,0
Xsg13cmos5l_decap_8_256 VPWR VGND sg13cmos5l_decap_8
* cell instance sg13cmos5l_decap_8_257 r0 *1 0,0
Xsg13cmos5l_decap_8_257 VPWR VGND sg13cmos5l_decap_8
* cell instance sg13cmos5l_decap_8_258 r0 *1 0,0
Xsg13cmos5l_decap_8_258 VPWR VGND sg13cmos5l_decap_8
* cell instance sg13cmos5l_decap_8_259 r0 *1 0,0
Xsg13cmos5l_decap_8_259 VPWR VGND sg13cmos5l_decap_8
* cell instance sg13cmos5l_decap_8_260 r0 *1 0,0
Xsg13cmos5l_decap_8_260 VPWR VGND sg13cmos5l_decap_8
* cell instance sg13cmos5l_decap_8_261 r0 *1 0,0
Xsg13cmos5l_decap_8_261 VPWR VGND sg13cmos5l_decap_8
* cell instance sg13cmos5l_decap_8_262 r0 *1 0,0
Xsg13cmos5l_decap_8_262 VPWR VGND sg13cmos5l_decap_8
* cell instance sg13cmos5l_decap_8_263 r0 *1 0,0
Xsg13cmos5l_decap_8_263 VPWR VGND sg13cmos5l_decap_8
* cell instance sg13cmos5l_decap_8_264 r0 *1 0,0
Xsg13cmos5l_decap_8_264 VPWR VGND sg13cmos5l_decap_8
* cell instance sg13cmos5l_decap_8_265 r0 *1 0,0
Xsg13cmos5l_decap_8_265 VPWR VGND sg13cmos5l_decap_8
* cell instance sg13cmos5l_decap_8_266 r0 *1 0,0
Xsg13cmos5l_decap_8_266 VPWR VGND sg13cmos5l_decap_8
* cell instance sg13cmos5l_decap_8_267 r0 *1 0,0
Xsg13cmos5l_decap_8_267 VPWR VGND sg13cmos5l_decap_8
* cell instance sg13cmos5l_decap_8_268 r0 *1 0,0
Xsg13cmos5l_decap_8_268 VPWR VGND sg13cmos5l_decap_8
* cell instance sg13cmos5l_decap_8_269 r0 *1 0,0
Xsg13cmos5l_decap_8_269 VPWR VGND sg13cmos5l_decap_8
* cell instance sg13cmos5l_decap_8_270 r0 *1 0,0
Xsg13cmos5l_decap_8_270 VPWR VGND sg13cmos5l_decap_8
* cell instance sg13cmos5l_decap_8_271 r0 *1 0,0
Xsg13cmos5l_decap_8_271 VPWR VGND sg13cmos5l_decap_8
* cell instance sg13cmos5l_decap_8_272 r0 *1 0,0
Xsg13cmos5l_decap_8_272 VPWR VGND sg13cmos5l_decap_8
* cell instance sg13cmos5l_decap_8_273 r0 *1 0,0
Xsg13cmos5l_decap_8_273 VPWR VGND sg13cmos5l_decap_8
* cell instance sg13cmos5l_decap_8_274 r0 *1 0,0
Xsg13cmos5l_decap_8_274 VPWR VGND sg13cmos5l_decap_8
* cell instance sg13cmos5l_decap_8_275 r0 *1 0,0
Xsg13cmos5l_decap_8_275 VPWR VGND sg13cmos5l_decap_8
* cell instance sg13cmos5l_decap_8_276 r0 *1 0,0
Xsg13cmos5l_decap_8_276 VPWR VGND sg13cmos5l_decap_8
* cell instance sg13cmos5l_decap_8_277 r0 *1 0,0
Xsg13cmos5l_decap_8_277 VPWR VGND sg13cmos5l_decap_8
* cell instance sg13cmos5l_decap_8_278 r0 *1 0,0
Xsg13cmos5l_decap_8_278 VPWR VGND sg13cmos5l_decap_8
* cell instance sg13cmos5l_decap_8_279 r0 *1 0,0
Xsg13cmos5l_decap_8_279 VPWR VGND sg13cmos5l_decap_8
* cell instance sg13cmos5l_decap_8_280 r0 *1 0,0
Xsg13cmos5l_decap_8_280 VPWR VGND sg13cmos5l_decap_8
* cell instance sg13cmos5l_decap_8_281 r0 *1 0,0
Xsg13cmos5l_decap_8_281 VPWR VGND sg13cmos5l_decap_8
* cell instance sg13cmos5l_decap_8_282 r0 *1 0,0
Xsg13cmos5l_decap_8_282 VPWR VGND sg13cmos5l_decap_8
* cell instance sg13cmos5l_decap_8_283 r0 *1 0,0
Xsg13cmos5l_decap_8_283 VPWR VGND sg13cmos5l_decap_8
* cell instance sg13cmos5l_decap_8_284 r0 *1 0,0
Xsg13cmos5l_decap_8_284 VPWR VGND sg13cmos5l_decap_8
* cell instance sg13cmos5l_decap_8_285 r0 *1 0,0
Xsg13cmos5l_decap_8_285 VPWR VGND sg13cmos5l_decap_8
* cell instance sg13cmos5l_decap_8_286 r0 *1 0,0
Xsg13cmos5l_decap_8_286 VPWR VGND sg13cmos5l_decap_8
* cell instance sg13cmos5l_decap_8_287 r0 *1 0,0
Xsg13cmos5l_decap_8_287 VPWR VGND sg13cmos5l_decap_8
* cell instance sg13cmos5l_decap_8_288 r0 *1 0,0
Xsg13cmos5l_decap_8_288 VPWR VGND sg13cmos5l_decap_8
* cell instance sg13cmos5l_decap_8_289 r0 *1 0,0
Xsg13cmos5l_decap_8_289 VPWR VGND sg13cmos5l_decap_8
* cell instance sg13cmos5l_decap_8_290 r0 *1 0,0
Xsg13cmos5l_decap_8_290 VPWR VGND sg13cmos5l_decap_8
* cell instance sg13cmos5l_decap_8_291 r0 *1 0,0
Xsg13cmos5l_decap_8_291 VPWR VGND sg13cmos5l_decap_8
* cell instance sg13cmos5l_decap_8_292 r0 *1 0,0
Xsg13cmos5l_decap_8_292 VPWR VGND sg13cmos5l_decap_8
* cell instance sg13cmos5l_decap_8_293 r0 *1 0,0
Xsg13cmos5l_decap_8_293 VPWR VGND sg13cmos5l_decap_8
* cell instance sg13cmos5l_decap_8_294 r0 *1 0,0
Xsg13cmos5l_decap_8_294 VPWR VGND sg13cmos5l_decap_8
* cell instance sg13cmos5l_decap_8_295 r0 *1 0,0
Xsg13cmos5l_decap_8_295 VPWR VGND sg13cmos5l_decap_8
* cell instance sg13cmos5l_decap_8_296 r0 *1 0,0
Xsg13cmos5l_decap_8_296 VPWR VGND sg13cmos5l_decap_8
* cell instance sg13cmos5l_decap_8_297 r0 *1 0,0
Xsg13cmos5l_decap_8_297 VPWR VGND sg13cmos5l_decap_8
* cell instance sg13cmos5l_decap_8_298 r0 *1 0,0
Xsg13cmos5l_decap_8_298 VPWR VGND sg13cmos5l_decap_8
* cell instance sg13cmos5l_decap_8_299 r0 *1 0,0
Xsg13cmos5l_decap_8_299 VPWR VGND sg13cmos5l_decap_8
* cell instance sg13cmos5l_decap_8_300 r0 *1 0,0
Xsg13cmos5l_decap_8_300 VPWR VGND sg13cmos5l_decap_8
* cell instance sg13cmos5l_decap_8_301 r0 *1 0,0
Xsg13cmos5l_decap_8_301 VPWR VGND sg13cmos5l_decap_8
* cell instance sg13cmos5l_decap_8_302 r0 *1 0,0
Xsg13cmos5l_decap_8_302 VPWR VGND sg13cmos5l_decap_8
* cell instance sg13cmos5l_decap_8_303 r0 *1 0,0
Xsg13cmos5l_decap_8_303 VPWR VGND sg13cmos5l_decap_8
* cell instance sg13cmos5l_decap_8_304 r0 *1 0,0
Xsg13cmos5l_decap_8_304 VPWR VGND sg13cmos5l_decap_8
* cell instance sg13cmos5l_decap_8_305 r0 *1 0,0
Xsg13cmos5l_decap_8_305 VPWR VGND sg13cmos5l_decap_8
* cell instance sg13cmos5l_decap_8_306 r0 *1 0,0
Xsg13cmos5l_decap_8_306 VPWR VGND sg13cmos5l_decap_8
* cell instance sg13cmos5l_decap_8_307 r0 *1 0,0
Xsg13cmos5l_decap_8_307 VPWR VGND sg13cmos5l_decap_8
* cell instance sg13cmos5l_decap_8_308 r0 *1 0,0
Xsg13cmos5l_decap_8_308 VPWR VGND sg13cmos5l_decap_8
* cell instance sg13cmos5l_decap_8_309 r0 *1 0,0
Xsg13cmos5l_decap_8_309 VPWR VGND sg13cmos5l_decap_8
* cell instance sg13cmos5l_decap_8_310 r0 *1 0,0
Xsg13cmos5l_decap_8_310 VPWR VGND sg13cmos5l_decap_8
* cell instance sg13cmos5l_decap_8_311 r0 *1 0,0
Xsg13cmos5l_decap_8_311 VPWR VGND sg13cmos5l_decap_8
* cell instance sg13cmos5l_decap_8_312 r0 *1 0,0
Xsg13cmos5l_decap_8_312 VPWR VGND sg13cmos5l_decap_8
* cell instance sg13cmos5l_decap_8_313 r0 *1 0,0
Xsg13cmos5l_decap_8_313 VPWR VGND sg13cmos5l_decap_8
* cell instance sg13cmos5l_decap_8_314 r0 *1 0,0
Xsg13cmos5l_decap_8_314 VPWR VGND sg13cmos5l_decap_8
* cell instance sg13cmos5l_decap_8_315 r0 *1 0,0
Xsg13cmos5l_decap_8_315 VPWR VGND sg13cmos5l_decap_8
* cell instance sg13cmos5l_decap_8_316 r0 *1 0,0
Xsg13cmos5l_decap_8_316 VPWR VGND sg13cmos5l_decap_8
* cell instance sg13cmos5l_decap_8_317 r0 *1 0,0
Xsg13cmos5l_decap_8_317 VPWR VGND sg13cmos5l_decap_8
* cell instance sg13cmos5l_decap_8_318 r0 *1 0,0
Xsg13cmos5l_decap_8_318 VPWR VGND sg13cmos5l_decap_8
* cell instance sg13cmos5l_decap_8_319 r0 *1 0,0
Xsg13cmos5l_decap_8_319 VPWR VGND sg13cmos5l_decap_8
* cell instance sg13cmos5l_decap_8_320 r0 *1 0,0
Xsg13cmos5l_decap_8_320 VPWR VGND sg13cmos5l_decap_8
* cell instance sg13cmos5l_decap_8_321 r0 *1 0,0
Xsg13cmos5l_decap_8_321 VPWR VGND sg13cmos5l_decap_8
* cell instance sg13cmos5l_decap_8_322 r0 *1 0,0
Xsg13cmos5l_decap_8_322 VPWR VGND sg13cmos5l_decap_8
* cell instance sg13cmos5l_decap_8_323 r0 *1 0,0
Xsg13cmos5l_decap_8_323 VPWR VGND sg13cmos5l_decap_8
* cell instance sg13cmos5l_decap_8_324 r0 *1 0,0
Xsg13cmos5l_decap_8_324 VPWR VGND sg13cmos5l_decap_8
* cell instance sg13cmos5l_decap_8_325 r0 *1 0,0
Xsg13cmos5l_decap_8_325 VPWR VGND sg13cmos5l_decap_8
* cell instance sg13cmos5l_decap_8_326 r0 *1 0,0
Xsg13cmos5l_decap_8_326 VPWR VGND sg13cmos5l_decap_8
* cell instance sg13cmos5l_decap_8_327 r0 *1 0,0
Xsg13cmos5l_decap_8_327 VPWR VGND sg13cmos5l_decap_8
* cell instance sg13cmos5l_decap_8_328 r0 *1 0,0
Xsg13cmos5l_decap_8_328 VPWR VGND sg13cmos5l_decap_8
* cell instance sg13cmos5l_decap_8_329 r0 *1 0,0
Xsg13cmos5l_decap_8_329 VPWR VGND sg13cmos5l_decap_8
* cell instance sg13cmos5l_decap_8_330 r0 *1 0,0
Xsg13cmos5l_decap_8_330 VPWR VGND sg13cmos5l_decap_8
* cell instance sg13cmos5l_decap_8_331 r0 *1 0,0
Xsg13cmos5l_decap_8_331 VPWR VGND sg13cmos5l_decap_8
* cell instance sg13cmos5l_decap_8_332 r0 *1 0,0
Xsg13cmos5l_decap_8_332 VPWR VGND sg13cmos5l_decap_8
* cell instance sg13cmos5l_decap_8_333 r0 *1 0,0
Xsg13cmos5l_decap_8_333 VPWR VGND sg13cmos5l_decap_8
* cell instance sg13cmos5l_decap_8_334 r0 *1 0,0
Xsg13cmos5l_decap_8_334 VPWR VGND sg13cmos5l_decap_8
* cell instance sg13cmos5l_decap_8_335 r0 *1 0,0
Xsg13cmos5l_decap_8_335 VPWR VGND sg13cmos5l_decap_8
* cell instance sg13cmos5l_decap_8_336 r0 *1 0,0
Xsg13cmos5l_decap_8_336 VPWR VGND sg13cmos5l_decap_8
* cell instance sg13cmos5l_decap_8_337 r0 *1 0,0
Xsg13cmos5l_decap_8_337 VPWR VGND sg13cmos5l_decap_8
* cell instance sg13cmos5l_decap_8_338 r0 *1 0,0
Xsg13cmos5l_decap_8_338 VPWR VGND sg13cmos5l_decap_8
* cell instance sg13cmos5l_decap_8_339 r0 *1 0,0
Xsg13cmos5l_decap_8_339 VPWR VGND sg13cmos5l_decap_8
* cell instance sg13cmos5l_decap_8_340 r0 *1 0,0
Xsg13cmos5l_decap_8_340 VPWR VGND sg13cmos5l_decap_8
* cell instance sg13cmos5l_decap_8_341 r0 *1 0,0
Xsg13cmos5l_decap_8_341 VPWR VGND sg13cmos5l_decap_8
* cell instance sg13cmos5l_decap_8_342 r0 *1 0,0
Xsg13cmos5l_decap_8_342 VPWR VGND sg13cmos5l_decap_8
* cell instance sg13cmos5l_decap_8_343 r0 *1 0,0
Xsg13cmos5l_decap_8_343 VPWR VGND sg13cmos5l_decap_8
* cell instance sg13cmos5l_decap_8_344 r0 *1 0,0
Xsg13cmos5l_decap_8_344 VPWR VGND sg13cmos5l_decap_8
* cell instance sg13cmos5l_decap_8_345 r0 *1 0,0
Xsg13cmos5l_decap_8_345 VPWR VGND sg13cmos5l_decap_8
* cell instance sg13cmos5l_decap_8_346 r0 *1 0,0
Xsg13cmos5l_decap_8_346 VPWR VGND sg13cmos5l_decap_8
* cell instance sg13cmos5l_decap_8_347 r0 *1 0,0
Xsg13cmos5l_decap_8_347 VPWR VGND sg13cmos5l_decap_8
* cell instance sg13cmos5l_decap_8_348 r0 *1 0,0
Xsg13cmos5l_decap_8_348 VPWR VGND sg13cmos5l_decap_8
* cell instance sg13cmos5l_decap_8_349 r0 *1 0,0
Xsg13cmos5l_decap_8_349 VPWR VGND sg13cmos5l_decap_8
* cell instance sg13cmos5l_decap_8_350 r0 *1 0,0
Xsg13cmos5l_decap_8_350 VPWR VGND sg13cmos5l_decap_8
* cell instance sg13cmos5l_decap_8_351 r0 *1 0,0
Xsg13cmos5l_decap_8_351 VPWR VGND sg13cmos5l_decap_8
* cell instance sg13cmos5l_decap_8_352 r0 *1 0,0
Xsg13cmos5l_decap_8_352 VPWR VGND sg13cmos5l_decap_8
* cell instance sg13cmos5l_decap_8_353 r0 *1 0,0
Xsg13cmos5l_decap_8_353 VPWR VGND sg13cmos5l_decap_8
* cell instance sg13cmos5l_decap_8_354 r0 *1 0,0
Xsg13cmos5l_decap_8_354 VPWR VGND sg13cmos5l_decap_8
* cell instance sg13cmos5l_decap_8_355 r0 *1 0,0
Xsg13cmos5l_decap_8_355 VPWR VGND sg13cmos5l_decap_8
* cell instance sg13cmos5l_decap_8_356 r0 *1 0,0
Xsg13cmos5l_decap_8_356 VPWR VGND sg13cmos5l_decap_8
* cell instance sg13cmos5l_decap_8_357 r0 *1 0,0
Xsg13cmos5l_decap_8_357 VPWR VGND sg13cmos5l_decap_8
* cell instance sg13cmos5l_decap_8_358 r0 *1 0,0
Xsg13cmos5l_decap_8_358 VPWR VGND sg13cmos5l_decap_8
* cell instance sg13cmos5l_decap_8_359 r0 *1 0,0
Xsg13cmos5l_decap_8_359 VPWR VGND sg13cmos5l_decap_8
* cell instance sg13cmos5l_decap_8_360 r0 *1 0,0
Xsg13cmos5l_decap_8_360 VPWR VGND sg13cmos5l_decap_8
* cell instance sg13cmos5l_decap_8_361 r0 *1 0,0
Xsg13cmos5l_decap_8_361 VPWR VGND sg13cmos5l_decap_8
* cell instance sg13cmos5l_decap_8_362 r0 *1 0,0
Xsg13cmos5l_decap_8_362 VPWR VGND sg13cmos5l_decap_8
* cell instance sg13cmos5l_decap_8_363 r0 *1 0,0
Xsg13cmos5l_decap_8_363 VPWR VGND sg13cmos5l_decap_8
* cell instance sg13cmos5l_decap_8_364 r0 *1 0,0
Xsg13cmos5l_decap_8_364 VPWR VGND sg13cmos5l_decap_8
* cell instance sg13cmos5l_decap_8_365 r0 *1 0,0
Xsg13cmos5l_decap_8_365 VPWR VGND sg13cmos5l_decap_8
* cell instance sg13cmos5l_decap_8_366 r0 *1 0,0
Xsg13cmos5l_decap_8_366 VPWR VGND sg13cmos5l_decap_8
* cell instance sg13cmos5l_decap_8_367 r0 *1 0,0
Xsg13cmos5l_decap_8_367 VPWR VGND sg13cmos5l_decap_8
* cell instance sg13cmos5l_decap_8_368 r0 *1 0,0
Xsg13cmos5l_decap_8_368 VPWR VGND sg13cmos5l_decap_8
* cell instance sg13cmos5l_decap_8_369 r0 *1 0,0
Xsg13cmos5l_decap_8_369 VPWR VGND sg13cmos5l_decap_8
* cell instance sg13cmos5l_decap_8_370 r0 *1 0,0
Xsg13cmos5l_decap_8_370 VPWR VGND sg13cmos5l_decap_8
* cell instance sg13cmos5l_decap_8_371 r0 *1 0,0
Xsg13cmos5l_decap_8_371 VPWR VGND sg13cmos5l_decap_8
* cell instance sg13cmos5l_decap_8_372 r0 *1 0,0
Xsg13cmos5l_decap_8_372 VPWR VGND sg13cmos5l_decap_8
* cell instance sg13cmos5l_decap_8_373 r0 *1 0,0
Xsg13cmos5l_decap_8_373 VPWR VGND sg13cmos5l_decap_8
* cell instance sg13cmos5l_decap_8_374 r0 *1 0,0
Xsg13cmos5l_decap_8_374 VPWR VGND sg13cmos5l_decap_8
* cell instance sg13cmos5l_decap_8_375 r0 *1 0,0
Xsg13cmos5l_decap_8_375 VPWR VGND sg13cmos5l_decap_8
* cell instance sg13cmos5l_decap_8_376 r0 *1 0,0
Xsg13cmos5l_decap_8_376 VPWR VGND sg13cmos5l_decap_8
* cell instance sg13cmos5l_decap_8_377 r0 *1 0,0
Xsg13cmos5l_decap_8_377 VPWR VGND sg13cmos5l_decap_8
* cell instance sg13cmos5l_decap_8_378 r0 *1 0,0
Xsg13cmos5l_decap_8_378 VPWR VGND sg13cmos5l_decap_8
* cell instance sg13cmos5l_decap_8_379 r0 *1 0,0
Xsg13cmos5l_decap_8_379 VPWR VGND sg13cmos5l_decap_8
* cell instance sg13cmos5l_decap_8_380 r0 *1 0,0
Xsg13cmos5l_decap_8_380 VPWR VGND sg13cmos5l_decap_8
* cell instance sg13cmos5l_decap_8_381 r0 *1 0,0
Xsg13cmos5l_decap_8_381 VPWR VGND sg13cmos5l_decap_8
* cell instance sg13cmos5l_decap_8_382 r0 *1 0,0
Xsg13cmos5l_decap_8_382 VPWR VGND sg13cmos5l_decap_8
* cell instance sg13cmos5l_decap_8_383 r0 *1 0,0
Xsg13cmos5l_decap_8_383 VPWR VGND sg13cmos5l_decap_8
* cell instance sg13cmos5l_decap_8_384 r0 *1 0,0
Xsg13cmos5l_decap_8_384 VPWR VGND sg13cmos5l_decap_8
* cell instance sg13cmos5l_decap_8_385 r0 *1 0,0
Xsg13cmos5l_decap_8_385 VPWR VGND sg13cmos5l_decap_8
* cell instance sg13cmos5l_decap_8_386 r0 *1 0,0
Xsg13cmos5l_decap_8_386 VPWR VGND sg13cmos5l_decap_8
* cell instance sg13cmos5l_decap_8_387 r0 *1 0,0
Xsg13cmos5l_decap_8_387 VPWR VGND sg13cmos5l_decap_8
* cell instance sg13cmos5l_decap_8_388 r0 *1 0,0
Xsg13cmos5l_decap_8_388 VPWR VGND sg13cmos5l_decap_8
* cell instance sg13cmos5l_decap_8_389 r0 *1 0,0
Xsg13cmos5l_decap_8_389 VPWR VGND sg13cmos5l_decap_8
* cell instance sg13cmos5l_decap_8_390 r0 *1 0,0
Xsg13cmos5l_decap_8_390 VPWR VGND sg13cmos5l_decap_8
* cell instance sg13cmos5l_decap_8_391 r0 *1 0,0
Xsg13cmos5l_decap_8_391 VPWR VGND sg13cmos5l_decap_8
* cell instance sg13cmos5l_decap_8_392 r0 *1 0,0
Xsg13cmos5l_decap_8_392 VPWR VGND sg13cmos5l_decap_8
* cell instance sg13cmos5l_decap_8_393 r0 *1 0,0
Xsg13cmos5l_decap_8_393 VPWR VGND sg13cmos5l_decap_8
* cell instance sg13cmos5l_decap_8_394 r0 *1 0,0
Xsg13cmos5l_decap_8_394 VPWR VGND sg13cmos5l_decap_8
* cell instance sg13cmos5l_decap_8_395 r0 *1 0,0
Xsg13cmos5l_decap_8_395 VPWR VGND sg13cmos5l_decap_8
* cell instance sg13cmos5l_decap_8_396 r0 *1 0,0
Xsg13cmos5l_decap_8_396 VPWR VGND sg13cmos5l_decap_8
* cell instance sg13cmos5l_decap_8_397 r0 *1 0,0
Xsg13cmos5l_decap_8_397 VPWR VGND sg13cmos5l_decap_8
* cell instance sg13cmos5l_decap_8_398 r0 *1 0,0
Xsg13cmos5l_decap_8_398 VPWR VGND sg13cmos5l_decap_8
* cell instance sg13cmos5l_decap_8_399 r0 *1 0,0
Xsg13cmos5l_decap_8_399 VPWR VGND sg13cmos5l_decap_8
* cell instance sg13cmos5l_decap_8_400 r0 *1 0,0
Xsg13cmos5l_decap_8_400 VPWR VGND sg13cmos5l_decap_8
* cell instance sg13cmos5l_decap_8_401 r0 *1 0,0
Xsg13cmos5l_decap_8_401 VPWR VGND sg13cmos5l_decap_8
* cell instance sg13cmos5l_decap_8_402 r0 *1 0,0
Xsg13cmos5l_decap_8_402 VPWR VGND sg13cmos5l_decap_8
* cell instance sg13cmos5l_decap_8_403 r0 *1 0,0
Xsg13cmos5l_decap_8_403 VPWR VGND sg13cmos5l_decap_8
* cell instance sg13cmos5l_decap_8_404 r0 *1 0,0
Xsg13cmos5l_decap_8_404 VPWR VGND sg13cmos5l_decap_8
* cell instance sg13cmos5l_decap_8_405 r0 *1 0,0
Xsg13cmos5l_decap_8_405 VPWR VGND sg13cmos5l_decap_8
* cell instance sg13cmos5l_decap_8_406 r0 *1 0,0
Xsg13cmos5l_decap_8_406 VPWR VGND sg13cmos5l_decap_8
* cell instance sg13cmos5l_decap_8_407 r0 *1 0,0
Xsg13cmos5l_decap_8_407 VPWR VGND sg13cmos5l_decap_8
* cell instance sg13cmos5l_decap_8_408 r0 *1 0,0
Xsg13cmos5l_decap_8_408 VPWR VGND sg13cmos5l_decap_8
* cell instance sg13cmos5l_decap_8_409 r0 *1 0,0
Xsg13cmos5l_decap_8_409 VPWR VGND sg13cmos5l_decap_8
* cell instance sg13cmos5l_decap_8_410 r0 *1 0,0
Xsg13cmos5l_decap_8_410 VPWR VGND sg13cmos5l_decap_8
* cell instance sg13cmos5l_decap_8_411 r0 *1 0,0
Xsg13cmos5l_decap_8_411 VPWR VGND sg13cmos5l_decap_8
* cell instance sg13cmos5l_decap_8_412 r0 *1 0,0
Xsg13cmos5l_decap_8_412 VPWR VGND sg13cmos5l_decap_8
* cell instance sg13cmos5l_decap_8_413 r0 *1 0,0
Xsg13cmos5l_decap_8_413 VPWR VGND sg13cmos5l_decap_8
* cell instance sg13cmos5l_decap_8_414 r0 *1 0,0
Xsg13cmos5l_decap_8_414 VPWR VGND sg13cmos5l_decap_8
* cell instance sg13cmos5l_decap_8_415 r0 *1 0,0
Xsg13cmos5l_decap_8_415 VPWR VGND sg13cmos5l_decap_8
* cell instance sg13cmos5l_decap_8_416 r0 *1 0,0
Xsg13cmos5l_decap_8_416 VPWR VGND sg13cmos5l_decap_8
* cell instance sg13cmos5l_decap_8_417 r0 *1 0,0
Xsg13cmos5l_decap_8_417 VPWR VGND sg13cmos5l_decap_8
* cell instance sg13cmos5l_decap_8_418 r0 *1 0,0
Xsg13cmos5l_decap_8_418 VPWR VGND sg13cmos5l_decap_8
* cell instance sg13cmos5l_decap_8_419 r0 *1 0,0
Xsg13cmos5l_decap_8_419 VPWR VGND sg13cmos5l_decap_8
* cell instance sg13cmos5l_decap_8_420 r0 *1 0,0
Xsg13cmos5l_decap_8_420 VPWR VGND sg13cmos5l_decap_8
* cell instance sg13cmos5l_decap_8_421 r0 *1 0,0
Xsg13cmos5l_decap_8_421 VPWR VGND sg13cmos5l_decap_8
* cell instance sg13cmos5l_decap_8_422 r0 *1 0,0
Xsg13cmos5l_decap_8_422 VPWR VGND sg13cmos5l_decap_8
* cell instance sg13cmos5l_decap_8_423 r0 *1 0,0
Xsg13cmos5l_decap_8_423 VPWR VGND sg13cmos5l_decap_8
* cell instance sg13cmos5l_decap_8_424 r0 *1 0,0
Xsg13cmos5l_decap_8_424 VPWR VGND sg13cmos5l_decap_8
* cell instance sg13cmos5l_decap_8_425 r0 *1 0,0
Xsg13cmos5l_decap_8_425 VPWR VGND sg13cmos5l_decap_8
* cell instance sg13cmos5l_decap_8_426 r0 *1 0,0
Xsg13cmos5l_decap_8_426 VPWR VGND sg13cmos5l_decap_8
* cell instance sg13cmos5l_decap_8_427 r0 *1 0,0
Xsg13cmos5l_decap_8_427 VPWR VGND sg13cmos5l_decap_8
* cell instance sg13cmos5l_decap_8_428 r0 *1 0,0
Xsg13cmos5l_decap_8_428 VPWR VGND sg13cmos5l_decap_8
* cell instance sg13cmos5l_decap_8_429 r0 *1 0,0
Xsg13cmos5l_decap_8_429 VPWR VGND sg13cmos5l_decap_8
* cell instance sg13cmos5l_decap_8_430 r0 *1 0,0
Xsg13cmos5l_decap_8_430 VPWR VGND sg13cmos5l_decap_8
* cell instance sg13cmos5l_decap_8_431 r0 *1 0,0
Xsg13cmos5l_decap_8_431 VPWR VGND sg13cmos5l_decap_8
* cell instance sg13cmos5l_decap_8_432 r0 *1 0,0
Xsg13cmos5l_decap_8_432 VPWR VGND sg13cmos5l_decap_8
* cell instance sg13cmos5l_decap_8_433 r0 *1 0,0
Xsg13cmos5l_decap_8_433 VPWR VGND sg13cmos5l_decap_8
* cell instance sg13cmos5l_decap_8_434 r0 *1 0,0
Xsg13cmos5l_decap_8_434 VPWR VGND sg13cmos5l_decap_8
* cell instance sg13cmos5l_decap_8_435 r0 *1 0,0
Xsg13cmos5l_decap_8_435 VPWR VGND sg13cmos5l_decap_8
* cell instance sg13cmos5l_decap_8_436 r0 *1 0,0
Xsg13cmos5l_decap_8_436 VPWR VGND sg13cmos5l_decap_8
* cell instance sg13cmos5l_decap_8_437 r0 *1 0,0
Xsg13cmos5l_decap_8_437 VPWR VGND sg13cmos5l_decap_8
* cell instance sg13cmos5l_decap_8_438 r0 *1 0,0
Xsg13cmos5l_decap_8_438 VPWR VGND sg13cmos5l_decap_8
* cell instance sg13cmos5l_decap_8_439 r0 *1 0,0
Xsg13cmos5l_decap_8_439 VPWR VGND sg13cmos5l_decap_8
* cell instance sg13cmos5l_decap_8_440 r0 *1 0,0
Xsg13cmos5l_decap_8_440 VPWR VGND sg13cmos5l_decap_8
* cell instance sg13cmos5l_decap_8_441 r0 *1 0,0
Xsg13cmos5l_decap_8_441 VPWR VGND sg13cmos5l_decap_8
* cell instance sg13cmos5l_decap_8_442 r0 *1 0,0
Xsg13cmos5l_decap_8_442 VPWR VGND sg13cmos5l_decap_8
* cell instance sg13cmos5l_decap_8_443 r0 *1 0,0
Xsg13cmos5l_decap_8_443 VPWR VGND sg13cmos5l_decap_8
* cell instance sg13cmos5l_decap_8_444 r0 *1 0,0
Xsg13cmos5l_decap_8_444 VPWR VGND sg13cmos5l_decap_8
* cell instance sg13cmos5l_decap_8_445 r0 *1 0,0
Xsg13cmos5l_decap_8_445 VPWR VGND sg13cmos5l_decap_8
* cell instance sg13cmos5l_decap_8_446 r0 *1 0,0
Xsg13cmos5l_decap_8_446 VPWR VGND sg13cmos5l_decap_8
* cell instance sg13cmos5l_decap_8_447 r0 *1 0,0
Xsg13cmos5l_decap_8_447 VPWR VGND sg13cmos5l_decap_8
* cell instance sg13cmos5l_decap_8_448 r0 *1 0,0
Xsg13cmos5l_decap_8_448 VPWR VGND sg13cmos5l_decap_8
* cell instance sg13cmos5l_decap_8_449 r0 *1 0,0
Xsg13cmos5l_decap_8_449 VPWR VGND sg13cmos5l_decap_8
* cell instance sg13cmos5l_decap_8_450 r0 *1 0,0
Xsg13cmos5l_decap_8_450 VPWR VGND sg13cmos5l_decap_8
* cell instance sg13cmos5l_decap_8_451 r0 *1 0,0
Xsg13cmos5l_decap_8_451 VPWR VGND sg13cmos5l_decap_8
* cell instance sg13cmos5l_decap_8_452 r0 *1 0,0
Xsg13cmos5l_decap_8_452 VPWR VGND sg13cmos5l_decap_8
* cell instance sg13cmos5l_decap_8_453 r0 *1 0,0
Xsg13cmos5l_decap_8_453 VPWR VGND sg13cmos5l_decap_8
* cell instance sg13cmos5l_decap_8_454 r0 *1 0,0
Xsg13cmos5l_decap_8_454 VPWR VGND sg13cmos5l_decap_8
* cell instance sg13cmos5l_decap_8_455 r0 *1 0,0
Xsg13cmos5l_decap_8_455 VPWR VGND sg13cmos5l_decap_8
* cell instance sg13cmos5l_decap_8_456 r0 *1 0,0
Xsg13cmos5l_decap_8_456 VPWR VGND sg13cmos5l_decap_8
* cell instance sg13cmos5l_decap_8_457 r0 *1 0,0
Xsg13cmos5l_decap_8_457 VPWR VGND sg13cmos5l_decap_8
* cell instance sg13cmos5l_decap_8_458 r0 *1 0,0
Xsg13cmos5l_decap_8_458 VPWR VGND sg13cmos5l_decap_8
* cell instance sg13cmos5l_decap_8_459 r0 *1 0,0
Xsg13cmos5l_decap_8_459 VPWR VGND sg13cmos5l_decap_8
* cell instance sg13cmos5l_decap_8_460 r0 *1 0,0
Xsg13cmos5l_decap_8_460 VPWR VGND sg13cmos5l_decap_8
* cell instance sg13cmos5l_decap_8_461 r0 *1 0,0
Xsg13cmos5l_decap_8_461 VPWR VGND sg13cmos5l_decap_8
* cell instance sg13cmos5l_decap_8_462 r0 *1 0,0
Xsg13cmos5l_decap_8_462 VPWR VGND sg13cmos5l_decap_8
* cell instance sg13cmos5l_decap_8_463 r0 *1 0,0
Xsg13cmos5l_decap_8_463 VPWR VGND sg13cmos5l_decap_8
* cell instance sg13cmos5l_decap_8_464 r0 *1 0,0
Xsg13cmos5l_decap_8_464 VPWR VGND sg13cmos5l_decap_8
* cell instance sg13cmos5l_decap_8_465 r0 *1 0,0
Xsg13cmos5l_decap_8_465 VPWR VGND sg13cmos5l_decap_8
* cell instance sg13cmos5l_decap_8_466 r0 *1 0,0
Xsg13cmos5l_decap_8_466 VPWR VGND sg13cmos5l_decap_8
* cell instance sg13cmos5l_decap_8_467 r0 *1 0,0
Xsg13cmos5l_decap_8_467 VPWR VGND sg13cmos5l_decap_8
* cell instance sg13cmos5l_decap_8_468 r0 *1 0,0
Xsg13cmos5l_decap_8_468 VPWR VGND sg13cmos5l_decap_8
* cell instance sg13cmos5l_decap_8_469 r0 *1 0,0
Xsg13cmos5l_decap_8_469 VPWR VGND sg13cmos5l_decap_8
* cell instance sg13cmos5l_decap_8_470 r0 *1 0,0
Xsg13cmos5l_decap_8_470 VPWR VGND sg13cmos5l_decap_8
* cell instance sg13cmos5l_decap_8_471 r0 *1 0,0
Xsg13cmos5l_decap_8_471 VPWR VGND sg13cmos5l_decap_8
* cell instance sg13cmos5l_decap_8_472 r0 *1 0,0
Xsg13cmos5l_decap_8_472 VPWR VGND sg13cmos5l_decap_8
* cell instance sg13cmos5l_decap_8_473 r0 *1 0,0
Xsg13cmos5l_decap_8_473 VPWR VGND sg13cmos5l_decap_8
* cell instance sg13cmos5l_decap_8_474 r0 *1 0,0
Xsg13cmos5l_decap_8_474 VPWR VGND sg13cmos5l_decap_8
* cell instance sg13cmos5l_decap_8_475 r0 *1 0,0
Xsg13cmos5l_decap_8_475 VPWR VGND sg13cmos5l_decap_8
* cell instance sg13cmos5l_decap_8_476 r0 *1 0,0
Xsg13cmos5l_decap_8_476 VPWR VGND sg13cmos5l_decap_8
* cell instance sg13cmos5l_decap_8_477 r0 *1 0,0
Xsg13cmos5l_decap_8_477 VPWR VGND sg13cmos5l_decap_8
* cell instance sg13cmos5l_decap_8_478 r0 *1 0,0
Xsg13cmos5l_decap_8_478 VPWR VGND sg13cmos5l_decap_8
* cell instance sg13cmos5l_decap_8_479 r0 *1 0,0
Xsg13cmos5l_decap_8_479 VPWR VGND sg13cmos5l_decap_8
* cell instance sg13cmos5l_decap_8_480 r0 *1 0,0
Xsg13cmos5l_decap_8_480 VPWR VGND sg13cmos5l_decap_8
* cell instance sg13cmos5l_decap_8_481 r0 *1 0,0
Xsg13cmos5l_decap_8_481 VPWR VGND sg13cmos5l_decap_8
* cell instance sg13cmos5l_decap_8_482 r0 *1 0,0
Xsg13cmos5l_decap_8_482 VPWR VGND sg13cmos5l_decap_8
* cell instance sg13cmos5l_decap_8_483 r0 *1 0,0
Xsg13cmos5l_decap_8_483 VPWR VGND sg13cmos5l_decap_8
* cell instance sg13cmos5l_decap_8_484 r0 *1 0,0
Xsg13cmos5l_decap_8_484 VPWR VGND sg13cmos5l_decap_8
* cell instance sg13cmos5l_decap_8_485 r0 *1 0,0
Xsg13cmos5l_decap_8_485 VPWR VGND sg13cmos5l_decap_8
* cell instance sg13cmos5l_decap_8_486 r0 *1 0,0
Xsg13cmos5l_decap_8_486 VPWR VGND sg13cmos5l_decap_8
* cell instance sg13cmos5l_decap_8_487 r0 *1 0,0
Xsg13cmos5l_decap_8_487 VPWR VGND sg13cmos5l_decap_8
* cell instance sg13cmos5l_decap_8_488 r0 *1 0,0
Xsg13cmos5l_decap_8_488 VPWR VGND sg13cmos5l_decap_8
* cell instance sg13cmos5l_decap_8_489 r0 *1 0,0
Xsg13cmos5l_decap_8_489 VPWR VGND sg13cmos5l_decap_8
* cell instance sg13cmos5l_decap_8_490 r0 *1 0,0
Xsg13cmos5l_decap_8_490 VPWR VGND sg13cmos5l_decap_8
* cell instance sg13cmos5l_decap_8_491 r0 *1 0,0
Xsg13cmos5l_decap_8_491 VPWR VGND sg13cmos5l_decap_8
* cell instance sg13cmos5l_decap_8_492 r0 *1 0,0
Xsg13cmos5l_decap_8_492 VPWR VGND sg13cmos5l_decap_8
* cell instance sg13cmos5l_decap_8_493 r0 *1 0,0
Xsg13cmos5l_decap_8_493 VPWR VGND sg13cmos5l_decap_8
* cell instance sg13cmos5l_decap_8_494 r0 *1 0,0
Xsg13cmos5l_decap_8_494 VPWR VGND sg13cmos5l_decap_8
* cell instance sg13cmos5l_decap_8_495 r0 *1 0,0
Xsg13cmos5l_decap_8_495 VPWR VGND sg13cmos5l_decap_8
* cell instance sg13cmos5l_decap_8_496 r0 *1 0,0
Xsg13cmos5l_decap_8_496 VPWR VGND sg13cmos5l_decap_8
* cell instance sg13cmos5l_decap_8_497 r0 *1 0,0
Xsg13cmos5l_decap_8_497 VPWR VGND sg13cmos5l_decap_8
* cell instance sg13cmos5l_decap_8_498 r0 *1 0,0
Xsg13cmos5l_decap_8_498 VPWR VGND sg13cmos5l_decap_8
* cell instance sg13cmos5l_decap_8_499 r0 *1 0,0
Xsg13cmos5l_decap_8_499 VPWR VGND sg13cmos5l_decap_8
* cell instance sg13cmos5l_decap_8_500 r0 *1 0,0
Xsg13cmos5l_decap_8_500 VPWR VGND sg13cmos5l_decap_8
* cell instance sg13cmos5l_decap_8_501 r0 *1 0,0
Xsg13cmos5l_decap_8_501 VPWR VGND sg13cmos5l_decap_8
* cell instance sg13cmos5l_decap_8_502 r0 *1 0,0
Xsg13cmos5l_decap_8_502 VPWR VGND sg13cmos5l_decap_8
* cell instance sg13cmos5l_decap_8_503 r0 *1 0,0
Xsg13cmos5l_decap_8_503 VPWR VGND sg13cmos5l_decap_8
* cell instance sg13cmos5l_decap_8_504 r0 *1 0,0
Xsg13cmos5l_decap_8_504 VPWR VGND sg13cmos5l_decap_8
* cell instance sg13cmos5l_decap_8_505 r0 *1 0,0
Xsg13cmos5l_decap_8_505 VPWR VGND sg13cmos5l_decap_8
* cell instance sg13cmos5l_decap_8_506 r0 *1 0,0
Xsg13cmos5l_decap_8_506 VPWR VGND sg13cmos5l_decap_8
* cell instance sg13cmos5l_decap_8_507 r0 *1 0,0
Xsg13cmos5l_decap_8_507 VPWR VGND sg13cmos5l_decap_8
* cell instance sg13cmos5l_decap_8_508 r0 *1 0,0
Xsg13cmos5l_decap_8_508 VPWR VGND sg13cmos5l_decap_8
* cell instance sg13cmos5l_decap_8_509 r0 *1 0,0
Xsg13cmos5l_decap_8_509 VPWR VGND sg13cmos5l_decap_8
* cell instance sg13cmos5l_decap_8_510 r0 *1 0,0
Xsg13cmos5l_decap_8_510 VPWR VGND sg13cmos5l_decap_8
* cell instance sg13cmos5l_decap_8_511 r0 *1 0,0
Xsg13cmos5l_decap_8_511 VPWR VGND sg13cmos5l_decap_8
* cell instance sg13cmos5l_decap_8_512 r0 *1 0,0
Xsg13cmos5l_decap_8_512 VPWR VGND sg13cmos5l_decap_8
* cell instance sg13cmos5l_decap_8_513 r0 *1 0,0
Xsg13cmos5l_decap_8_513 VPWR VGND sg13cmos5l_decap_8
* cell instance sg13cmos5l_decap_8_514 r0 *1 0,0
Xsg13cmos5l_decap_8_514 VPWR VGND sg13cmos5l_decap_8
* cell instance sg13cmos5l_decap_8_515 r0 *1 0,0
Xsg13cmos5l_decap_8_515 VPWR VGND sg13cmos5l_decap_8
* cell instance sg13cmos5l_decap_8_516 r0 *1 0,0
Xsg13cmos5l_decap_8_516 VPWR VGND sg13cmos5l_decap_8
* cell instance sg13cmos5l_decap_8_517 r0 *1 0,0
Xsg13cmos5l_decap_8_517 VPWR VGND sg13cmos5l_decap_8
* cell instance sg13cmos5l_decap_8_518 r0 *1 0,0
Xsg13cmos5l_decap_8_518 VPWR VGND sg13cmos5l_decap_8
* cell instance sg13cmos5l_decap_8_519 r0 *1 0,0
Xsg13cmos5l_decap_8_519 VPWR VGND sg13cmos5l_decap_8
* cell instance sg13cmos5l_decap_8_520 r0 *1 0,0
Xsg13cmos5l_decap_8_520 VPWR VGND sg13cmos5l_decap_8
* cell instance sg13cmos5l_decap_8_521 r0 *1 0,0
Xsg13cmos5l_decap_8_521 VPWR VGND sg13cmos5l_decap_8
* cell instance sg13cmos5l_decap_8_522 r0 *1 0,0
Xsg13cmos5l_decap_8_522 VPWR VGND sg13cmos5l_decap_8
* cell instance sg13cmos5l_decap_8_523 r0 *1 0,0
Xsg13cmos5l_decap_8_523 VPWR VGND sg13cmos5l_decap_8
* cell instance sg13cmos5l_decap_8_524 r0 *1 0,0
Xsg13cmos5l_decap_8_524 VPWR VGND sg13cmos5l_decap_8
* cell instance sg13cmos5l_decap_8_525 r0 *1 0,0
Xsg13cmos5l_decap_8_525 VPWR VGND sg13cmos5l_decap_8
* cell instance sg13cmos5l_decap_8_526 r0 *1 0,0
Xsg13cmos5l_decap_8_526 VPWR VGND sg13cmos5l_decap_8
* cell instance sg13cmos5l_decap_8_527 r0 *1 0,0
Xsg13cmos5l_decap_8_527 VPWR VGND sg13cmos5l_decap_8
* cell instance sg13cmos5l_decap_8_528 r0 *1 0,0
Xsg13cmos5l_decap_8_528 VPWR VGND sg13cmos5l_decap_8
* cell instance sg13cmos5l_decap_8_529 r0 *1 0,0
Xsg13cmos5l_decap_8_529 VPWR VGND sg13cmos5l_decap_8
* cell instance sg13cmos5l_decap_8_530 r0 *1 0,0
Xsg13cmos5l_decap_8_530 VPWR VGND sg13cmos5l_decap_8
* cell instance sg13cmos5l_decap_8_531 r0 *1 0,0
Xsg13cmos5l_decap_8_531 VPWR VGND sg13cmos5l_decap_8
* cell instance sg13cmos5l_decap_8_532 r0 *1 0,0
Xsg13cmos5l_decap_8_532 VPWR VGND sg13cmos5l_decap_8
* cell instance sg13cmos5l_decap_8_533 r0 *1 0,0
Xsg13cmos5l_decap_8_533 VPWR VGND sg13cmos5l_decap_8
* cell instance sg13cmos5l_decap_8_534 r0 *1 0,0
Xsg13cmos5l_decap_8_534 VPWR VGND sg13cmos5l_decap_8
* cell instance sg13cmos5l_decap_8_535 r0 *1 0,0
Xsg13cmos5l_decap_8_535 VPWR VGND sg13cmos5l_decap_8
* cell instance sg13cmos5l_decap_8_536 r0 *1 0,0
Xsg13cmos5l_decap_8_536 VPWR VGND sg13cmos5l_decap_8
* cell instance sg13cmos5l_decap_8_537 r0 *1 0,0
Xsg13cmos5l_decap_8_537 VPWR VGND sg13cmos5l_decap_8
* cell instance sg13cmos5l_decap_8_538 r0 *1 0,0
Xsg13cmos5l_decap_8_538 VPWR VGND sg13cmos5l_decap_8
* cell instance sg13cmos5l_decap_8_539 r0 *1 0,0
Xsg13cmos5l_decap_8_539 VPWR VGND sg13cmos5l_decap_8
* cell instance sg13cmos5l_decap_8_540 r0 *1 0,0
Xsg13cmos5l_decap_8_540 VPWR VGND sg13cmos5l_decap_8
* cell instance sg13cmos5l_decap_8_541 r0 *1 0,0
Xsg13cmos5l_decap_8_541 VPWR VGND sg13cmos5l_decap_8
* cell instance sg13cmos5l_decap_8_542 r0 *1 0,0
Xsg13cmos5l_decap_8_542 VPWR VGND sg13cmos5l_decap_8
* cell instance sg13cmos5l_decap_8_543 r0 *1 0,0
Xsg13cmos5l_decap_8_543 VPWR VGND sg13cmos5l_decap_8
* cell instance sg13cmos5l_decap_8_544 r0 *1 0,0
Xsg13cmos5l_decap_8_544 VPWR VGND sg13cmos5l_decap_8
* cell instance sg13cmos5l_decap_8_545 r0 *1 0,0
Xsg13cmos5l_decap_8_545 VPWR VGND sg13cmos5l_decap_8
* cell instance sg13cmos5l_decap_8_546 r0 *1 0,0
Xsg13cmos5l_decap_8_546 VPWR VGND sg13cmos5l_decap_8
* cell instance sg13cmos5l_decap_8_547 r0 *1 0,0
Xsg13cmos5l_decap_8_547 VPWR VGND sg13cmos5l_decap_8
* cell instance sg13cmos5l_decap_8_548 r0 *1 0,0
Xsg13cmos5l_decap_8_548 VPWR VGND sg13cmos5l_decap_8
* cell instance sg13cmos5l_decap_8_549 r0 *1 0,0
Xsg13cmos5l_decap_8_549 VPWR VGND sg13cmos5l_decap_8
* cell instance sg13cmos5l_decap_8_550 r0 *1 0,0
Xsg13cmos5l_decap_8_550 VPWR VGND sg13cmos5l_decap_8
* cell instance sg13cmos5l_decap_8_551 r0 *1 0,0
Xsg13cmos5l_decap_8_551 VPWR VGND sg13cmos5l_decap_8
* cell instance sg13cmos5l_decap_8_552 r0 *1 0,0
Xsg13cmos5l_decap_8_552 VPWR VGND sg13cmos5l_decap_8
* cell instance sg13cmos5l_decap_8_553 r0 *1 0,0
Xsg13cmos5l_decap_8_553 VPWR VGND sg13cmos5l_decap_8
* cell instance sg13cmos5l_decap_8_554 r0 *1 0,0
Xsg13cmos5l_decap_8_554 VPWR VGND sg13cmos5l_decap_8
* cell instance sg13cmos5l_decap_8_555 r0 *1 0,0
Xsg13cmos5l_decap_8_555 VPWR VGND sg13cmos5l_decap_8
* cell instance sg13cmos5l_decap_8_556 r0 *1 0,0
Xsg13cmos5l_decap_8_556 VPWR VGND sg13cmos5l_decap_8
* cell instance sg13cmos5l_decap_8_557 r0 *1 0,0
Xsg13cmos5l_decap_8_557 VPWR VGND sg13cmos5l_decap_8
* cell instance sg13cmos5l_decap_8_558 r0 *1 0,0
Xsg13cmos5l_decap_8_558 VPWR VGND sg13cmos5l_decap_8
* cell instance sg13cmos5l_decap_8_559 r0 *1 0,0
Xsg13cmos5l_decap_8_559 VPWR VGND sg13cmos5l_decap_8
* cell instance sg13cmos5l_decap_8_560 r0 *1 0,0
Xsg13cmos5l_decap_8_560 VPWR VGND sg13cmos5l_decap_8
* cell instance sg13cmos5l_decap_8_561 r0 *1 0,0
Xsg13cmos5l_decap_8_561 VPWR VGND sg13cmos5l_decap_8
* cell instance sg13cmos5l_decap_8_562 r0 *1 0,0
Xsg13cmos5l_decap_8_562 VPWR VGND sg13cmos5l_decap_8
* cell instance sg13cmos5l_decap_8_563 r0 *1 0,0
Xsg13cmos5l_decap_8_563 VPWR VGND sg13cmos5l_decap_8
* cell instance sg13cmos5l_decap_8_564 r0 *1 0,0
Xsg13cmos5l_decap_8_564 VPWR VGND sg13cmos5l_decap_8
* cell instance sg13cmos5l_decap_8_565 r0 *1 0,0
Xsg13cmos5l_decap_8_565 VPWR VGND sg13cmos5l_decap_8
* cell instance sg13cmos5l_decap_8_566 r0 *1 0,0
Xsg13cmos5l_decap_8_566 VPWR VGND sg13cmos5l_decap_8
* cell instance sg13cmos5l_decap_8_567 r0 *1 0,0
Xsg13cmos5l_decap_8_567 VPWR VGND sg13cmos5l_decap_8
* cell instance sg13cmos5l_decap_8_568 r0 *1 0,0
Xsg13cmos5l_decap_8_568 VPWR VGND sg13cmos5l_decap_8
* cell instance sg13cmos5l_decap_8_569 r0 *1 0,0
Xsg13cmos5l_decap_8_569 VPWR VGND sg13cmos5l_decap_8
* cell instance sg13cmos5l_decap_8_570 r0 *1 0,0
Xsg13cmos5l_decap_8_570 VPWR VGND sg13cmos5l_decap_8
* cell instance sg13cmos5l_decap_8_571 r0 *1 0,0
Xsg13cmos5l_decap_8_571 VPWR VGND sg13cmos5l_decap_8
* cell instance sg13cmos5l_decap_8_572 r0 *1 0,0
Xsg13cmos5l_decap_8_572 VPWR VGND sg13cmos5l_decap_8
* cell instance sg13cmos5l_decap_8_573 r0 *1 0,0
Xsg13cmos5l_decap_8_573 VPWR VGND sg13cmos5l_decap_8
* cell instance sg13cmos5l_decap_8_574 r0 *1 0,0
Xsg13cmos5l_decap_8_574 VPWR VGND sg13cmos5l_decap_8
* cell instance sg13cmos5l_decap_8_575 r0 *1 0,0
Xsg13cmos5l_decap_8_575 VPWR VGND sg13cmos5l_decap_8
* cell instance sg13cmos5l_decap_8_576 r0 *1 0,0
Xsg13cmos5l_decap_8_576 VPWR VGND sg13cmos5l_decap_8
* cell instance sg13cmos5l_decap_8_577 r0 *1 0,0
Xsg13cmos5l_decap_8_577 VPWR VGND sg13cmos5l_decap_8
* cell instance sg13cmos5l_decap_8_578 r0 *1 0,0
Xsg13cmos5l_decap_8_578 VPWR VGND sg13cmos5l_decap_8
* cell instance sg13cmos5l_decap_8_579 r0 *1 0,0
Xsg13cmos5l_decap_8_579 VPWR VGND sg13cmos5l_decap_8
* cell instance sg13cmos5l_decap_8_580 r0 *1 0,0
Xsg13cmos5l_decap_8_580 VPWR VGND sg13cmos5l_decap_8
* cell instance sg13cmos5l_decap_8_581 r0 *1 0,0
Xsg13cmos5l_decap_8_581 VPWR VGND sg13cmos5l_decap_8
* cell instance sg13cmos5l_decap_8_582 r0 *1 0,0
Xsg13cmos5l_decap_8_582 VPWR VGND sg13cmos5l_decap_8
* cell instance sg13cmos5l_decap_8_583 r0 *1 0,0
Xsg13cmos5l_decap_8_583 VPWR VGND sg13cmos5l_decap_8
* cell instance sg13cmos5l_decap_8_584 r0 *1 0,0
Xsg13cmos5l_decap_8_584 VPWR VGND sg13cmos5l_decap_8
* cell instance sg13cmos5l_decap_8_585 r0 *1 0,0
Xsg13cmos5l_decap_8_585 VPWR VGND sg13cmos5l_decap_8
* cell instance sg13cmos5l_decap_8_586 r0 *1 0,0
Xsg13cmos5l_decap_8_586 VPWR VGND sg13cmos5l_decap_8
* cell instance sg13cmos5l_decap_8_587 r0 *1 0,0
Xsg13cmos5l_decap_8_587 VPWR VGND sg13cmos5l_decap_8
* cell instance sg13cmos5l_decap_8_588 r0 *1 0,0
Xsg13cmos5l_decap_8_588 VPWR VGND sg13cmos5l_decap_8
* cell instance sg13cmos5l_decap_8_589 r0 *1 0,0
Xsg13cmos5l_decap_8_589 VPWR VGND sg13cmos5l_decap_8
* cell instance sg13cmos5l_decap_8_590 r0 *1 0,0
Xsg13cmos5l_decap_8_590 VPWR VGND sg13cmos5l_decap_8
* cell instance sg13cmos5l_decap_8_591 r0 *1 0,0
Xsg13cmos5l_decap_8_591 VPWR VGND sg13cmos5l_decap_8
* cell instance sg13cmos5l_decap_8_592 r0 *1 0,0
Xsg13cmos5l_decap_8_592 VPWR VGND sg13cmos5l_decap_8
* cell instance sg13cmos5l_decap_8_593 r0 *1 0,0
Xsg13cmos5l_decap_8_593 VPWR VGND sg13cmos5l_decap_8
* cell instance sg13cmos5l_decap_8_594 r0 *1 0,0
Xsg13cmos5l_decap_8_594 VPWR VGND sg13cmos5l_decap_8
* cell instance sg13cmos5l_decap_8_595 r0 *1 0,0
Xsg13cmos5l_decap_8_595 VPWR VGND sg13cmos5l_decap_8
* cell instance sg13cmos5l_decap_8_596 r0 *1 0,0
Xsg13cmos5l_decap_8_596 VPWR VGND sg13cmos5l_decap_8
* cell instance sg13cmos5l_decap_8_597 r0 *1 0,0
Xsg13cmos5l_decap_8_597 VPWR VGND sg13cmos5l_decap_8
* cell instance sg13cmos5l_decap_8_598 r0 *1 0,0
Xsg13cmos5l_decap_8_598 VPWR VGND sg13cmos5l_decap_8
* cell instance sg13cmos5l_decap_8_599 r0 *1 0,0
Xsg13cmos5l_decap_8_599 VPWR VGND sg13cmos5l_decap_8
* cell instance sg13cmos5l_decap_8_600 r0 *1 0,0
Xsg13cmos5l_decap_8_600 VPWR VGND sg13cmos5l_decap_8
* cell instance sg13cmos5l_decap_8_601 r0 *1 0,0
Xsg13cmos5l_decap_8_601 VPWR VGND sg13cmos5l_decap_8
* cell instance sg13cmos5l_decap_8_602 r0 *1 0,0
Xsg13cmos5l_decap_8_602 VPWR VGND sg13cmos5l_decap_8
* cell instance sg13cmos5l_decap_8_603 r0 *1 0,0
Xsg13cmos5l_decap_8_603 VPWR VGND sg13cmos5l_decap_8
* cell instance sg13cmos5l_decap_8_604 r0 *1 0,0
Xsg13cmos5l_decap_8_604 VPWR VGND sg13cmos5l_decap_8
* cell instance sg13cmos5l_decap_8_605 r0 *1 0,0
Xsg13cmos5l_decap_8_605 VPWR VGND sg13cmos5l_decap_8
* cell instance sg13cmos5l_decap_8_606 r0 *1 0,0
Xsg13cmos5l_decap_8_606 VPWR VGND sg13cmos5l_decap_8
* cell instance sg13cmos5l_decap_8_607 r0 *1 0,0
Xsg13cmos5l_decap_8_607 VPWR VGND sg13cmos5l_decap_8
* cell instance sg13cmos5l_decap_8_608 r0 *1 0,0
Xsg13cmos5l_decap_8_608 VPWR VGND sg13cmos5l_decap_8
* cell instance sg13cmos5l_decap_8_609 r0 *1 0,0
Xsg13cmos5l_decap_8_609 VPWR VGND sg13cmos5l_decap_8
* cell instance sg13cmos5l_decap_8_610 r0 *1 0,0
Xsg13cmos5l_decap_8_610 VPWR VGND sg13cmos5l_decap_8
* cell instance sg13cmos5l_decap_8_611 r0 *1 0,0
Xsg13cmos5l_decap_8_611 VPWR VGND sg13cmos5l_decap_8
* cell instance sg13cmos5l_decap_8_612 r0 *1 0,0
Xsg13cmos5l_decap_8_612 VPWR VGND sg13cmos5l_decap_8
* cell instance sg13cmos5l_decap_8_613 r0 *1 0,0
Xsg13cmos5l_decap_8_613 VPWR VGND sg13cmos5l_decap_8
* cell instance sg13cmos5l_decap_8_614 r0 *1 0,0
Xsg13cmos5l_decap_8_614 VPWR VGND sg13cmos5l_decap_8
* cell instance sg13cmos5l_decap_8_615 r0 *1 0,0
Xsg13cmos5l_decap_8_615 VPWR VGND sg13cmos5l_decap_8
* cell instance sg13cmos5l_decap_8_616 r0 *1 0,0
Xsg13cmos5l_decap_8_616 VPWR VGND sg13cmos5l_decap_8
* cell instance sg13cmos5l_decap_8_617 r0 *1 0,0
Xsg13cmos5l_decap_8_617 VPWR VGND sg13cmos5l_decap_8
* cell instance sg13cmos5l_decap_8_618 r0 *1 0,0
Xsg13cmos5l_decap_8_618 VPWR VGND sg13cmos5l_decap_8
* cell instance sg13cmos5l_decap_8_619 r0 *1 0,0
Xsg13cmos5l_decap_8_619 VPWR VGND sg13cmos5l_decap_8
* cell instance sg13cmos5l_decap_8_620 r0 *1 0,0
Xsg13cmos5l_decap_8_620 VPWR VGND sg13cmos5l_decap_8
* cell instance sg13cmos5l_decap_8_621 r0 *1 0,0
Xsg13cmos5l_decap_8_621 VPWR VGND sg13cmos5l_decap_8
* cell instance sg13cmos5l_decap_8_622 r0 *1 0,0
Xsg13cmos5l_decap_8_622 VPWR VGND sg13cmos5l_decap_8
* cell instance sg13cmos5l_decap_8_623 r0 *1 0,0
Xsg13cmos5l_decap_8_623 VPWR VGND sg13cmos5l_decap_8
* cell instance sg13cmos5l_decap_8_624 r0 *1 0,0
Xsg13cmos5l_decap_8_624 VPWR VGND sg13cmos5l_decap_8
* cell instance sg13cmos5l_decap_8_625 r0 *1 0,0
Xsg13cmos5l_decap_8_625 VPWR VGND sg13cmos5l_decap_8
* cell instance sg13cmos5l_decap_8_626 r0 *1 0,0
Xsg13cmos5l_decap_8_626 VPWR VGND sg13cmos5l_decap_8
* cell instance sg13cmos5l_decap_8_627 r0 *1 0,0
Xsg13cmos5l_decap_8_627 VPWR VGND sg13cmos5l_decap_8
* cell instance sg13cmos5l_decap_8_628 r0 *1 0,0
Xsg13cmos5l_decap_8_628 VPWR VGND sg13cmos5l_decap_8
* cell instance sg13cmos5l_decap_8_629 r0 *1 0,0
Xsg13cmos5l_decap_8_629 VPWR VGND sg13cmos5l_decap_8
* cell instance sg13cmos5l_decap_8_630 r0 *1 0,0
Xsg13cmos5l_decap_8_630 VPWR VGND sg13cmos5l_decap_8
* cell instance sg13cmos5l_decap_8_631 r0 *1 0,0
Xsg13cmos5l_decap_8_631 VPWR VGND sg13cmos5l_decap_8
* cell instance sg13cmos5l_decap_8_632 r0 *1 0,0
Xsg13cmos5l_decap_8_632 VPWR VGND sg13cmos5l_decap_8
* cell instance sg13cmos5l_decap_8_633 r0 *1 0,0
Xsg13cmos5l_decap_8_633 VPWR VGND sg13cmos5l_decap_8
* cell instance sg13cmos5l_decap_8_634 r0 *1 0,0
Xsg13cmos5l_decap_8_634 VPWR VGND sg13cmos5l_decap_8
* cell instance sg13cmos5l_decap_8_635 r0 *1 0,0
Xsg13cmos5l_decap_8_635 VPWR VGND sg13cmos5l_decap_8
* cell instance sg13cmos5l_decap_8_636 r0 *1 0,0
Xsg13cmos5l_decap_8_636 VPWR VGND sg13cmos5l_decap_8
* cell instance sg13cmos5l_decap_8_637 r0 *1 0,0
Xsg13cmos5l_decap_8_637 VPWR VGND sg13cmos5l_decap_8
* cell instance sg13cmos5l_decap_8_638 r0 *1 0,0
Xsg13cmos5l_decap_8_638 VPWR VGND sg13cmos5l_decap_8
* cell instance sg13cmos5l_decap_8_639 r0 *1 0,0
Xsg13cmos5l_decap_8_639 VPWR VGND sg13cmos5l_decap_8
* cell instance sg13cmos5l_decap_8_640 r0 *1 0,0
Xsg13cmos5l_decap_8_640 VPWR VGND sg13cmos5l_decap_8
* cell instance sg13cmos5l_decap_8_641 r0 *1 0,0
Xsg13cmos5l_decap_8_641 VPWR VGND sg13cmos5l_decap_8
* cell instance sg13cmos5l_decap_8_642 r0 *1 0,0
Xsg13cmos5l_decap_8_642 VPWR VGND sg13cmos5l_decap_8
* cell instance sg13cmos5l_decap_8_643 r0 *1 0,0
Xsg13cmos5l_decap_8_643 VPWR VGND sg13cmos5l_decap_8
* cell instance sg13cmos5l_decap_8_644 r0 *1 0,0
Xsg13cmos5l_decap_8_644 VPWR VGND sg13cmos5l_decap_8
* cell instance sg13cmos5l_decap_8_645 r0 *1 0,0
Xsg13cmos5l_decap_8_645 VPWR VGND sg13cmos5l_decap_8
* cell instance sg13cmos5l_decap_8_646 r0 *1 0,0
Xsg13cmos5l_decap_8_646 VPWR VGND sg13cmos5l_decap_8
* cell instance sg13cmos5l_decap_8_647 r0 *1 0,0
Xsg13cmos5l_decap_8_647 VPWR VGND sg13cmos5l_decap_8
* cell instance sg13cmos5l_decap_8_648 r0 *1 0,0
Xsg13cmos5l_decap_8_648 VPWR VGND sg13cmos5l_decap_8
* cell instance sg13cmos5l_decap_8_649 r0 *1 0,0
Xsg13cmos5l_decap_8_649 VPWR VGND sg13cmos5l_decap_8
* cell instance sg13cmos5l_decap_8_650 r0 *1 0,0
Xsg13cmos5l_decap_8_650 VPWR VGND sg13cmos5l_decap_8
* cell instance sg13cmos5l_decap_8_651 r0 *1 0,0
Xsg13cmos5l_decap_8_651 VPWR VGND sg13cmos5l_decap_8
* cell instance sg13cmos5l_decap_8_652 r0 *1 0,0
Xsg13cmos5l_decap_8_652 VPWR VGND sg13cmos5l_decap_8
* cell instance sg13cmos5l_decap_8_653 r0 *1 0,0
Xsg13cmos5l_decap_8_653 VPWR VGND sg13cmos5l_decap_8
* cell instance sg13cmos5l_decap_8_654 r0 *1 0,0
Xsg13cmos5l_decap_8_654 VPWR VGND sg13cmos5l_decap_8
* cell instance sg13cmos5l_decap_8_655 r0 *1 0,0
Xsg13cmos5l_decap_8_655 VPWR VGND sg13cmos5l_decap_8
* cell instance sg13cmos5l_decap_8_656 r0 *1 0,0
Xsg13cmos5l_decap_8_656 VPWR VGND sg13cmos5l_decap_8
* cell instance sg13cmos5l_decap_8_657 r0 *1 0,0
Xsg13cmos5l_decap_8_657 VPWR VGND sg13cmos5l_decap_8
* cell instance sg13cmos5l_decap_8_658 r0 *1 0,0
Xsg13cmos5l_decap_8_658 VPWR VGND sg13cmos5l_decap_8
* cell instance sg13cmos5l_decap_8_659 r0 *1 0,0
Xsg13cmos5l_decap_8_659 VPWR VGND sg13cmos5l_decap_8
* cell instance sg13cmos5l_decap_8_660 r0 *1 0,0
Xsg13cmos5l_decap_8_660 VPWR VGND sg13cmos5l_decap_8
* cell instance sg13cmos5l_decap_8_661 r0 *1 0,0
Xsg13cmos5l_decap_8_661 VPWR VGND sg13cmos5l_decap_8
* cell instance sg13cmos5l_decap_8_662 r0 *1 0,0
Xsg13cmos5l_decap_8_662 VPWR VGND sg13cmos5l_decap_8
* cell instance sg13cmos5l_decap_8_663 r0 *1 0,0
Xsg13cmos5l_decap_8_663 VPWR VGND sg13cmos5l_decap_8
* cell instance sg13cmos5l_decap_8_664 r0 *1 0,0
Xsg13cmos5l_decap_8_664 VPWR VGND sg13cmos5l_decap_8
* cell instance sg13cmos5l_decap_8_665 r0 *1 0,0
Xsg13cmos5l_decap_8_665 VPWR VGND sg13cmos5l_decap_8
* cell instance sg13cmos5l_decap_8_666 r0 *1 0,0
Xsg13cmos5l_decap_8_666 VPWR VGND sg13cmos5l_decap_8
* cell instance sg13cmos5l_decap_8_667 r0 *1 0,0
Xsg13cmos5l_decap_8_667 VPWR VGND sg13cmos5l_decap_8
* cell instance sg13cmos5l_decap_8_668 r0 *1 0,0
Xsg13cmos5l_decap_8_668 VPWR VGND sg13cmos5l_decap_8
* cell instance sg13cmos5l_decap_8_669 r0 *1 0,0
Xsg13cmos5l_decap_8_669 VPWR VGND sg13cmos5l_decap_8
* cell instance sg13cmos5l_decap_8_670 r0 *1 0,0
Xsg13cmos5l_decap_8_670 VPWR VGND sg13cmos5l_decap_8
* cell instance sg13cmos5l_decap_8_671 r0 *1 0,0
Xsg13cmos5l_decap_8_671 VPWR VGND sg13cmos5l_decap_8
* cell instance sg13cmos5l_decap_8_672 r0 *1 0,0
Xsg13cmos5l_decap_8_672 VPWR VGND sg13cmos5l_decap_8
* cell instance sg13cmos5l_decap_8_673 r0 *1 0,0
Xsg13cmos5l_decap_8_673 VPWR VGND sg13cmos5l_decap_8
* cell instance sg13cmos5l_decap_8_674 r0 *1 0,0
Xsg13cmos5l_decap_8_674 VPWR VGND sg13cmos5l_decap_8
* cell instance sg13cmos5l_decap_8_675 r0 *1 0,0
Xsg13cmos5l_decap_8_675 VPWR VGND sg13cmos5l_decap_8
* cell instance sg13cmos5l_decap_8_676 r0 *1 0,0
Xsg13cmos5l_decap_8_676 VPWR VGND sg13cmos5l_decap_8
* cell instance sg13cmos5l_decap_8_677 r0 *1 0,0
Xsg13cmos5l_decap_8_677 VPWR VGND sg13cmos5l_decap_8
* cell instance sg13cmos5l_decap_8_678 r0 *1 0,0
Xsg13cmos5l_decap_8_678 VPWR VGND sg13cmos5l_decap_8
* cell instance sg13cmos5l_decap_8_679 r0 *1 0,0
Xsg13cmos5l_decap_8_679 VPWR VGND sg13cmos5l_decap_8
* cell instance sg13cmos5l_decap_8_680 r0 *1 0,0
Xsg13cmos5l_decap_8_680 VPWR VGND sg13cmos5l_decap_8
* cell instance sg13cmos5l_decap_8_681 r0 *1 0,0
Xsg13cmos5l_decap_8_681 VPWR VGND sg13cmos5l_decap_8
* cell instance sg13cmos5l_decap_8_682 r0 *1 0,0
Xsg13cmos5l_decap_8_682 VPWR VGND sg13cmos5l_decap_8
* cell instance sg13cmos5l_decap_8_683 r0 *1 0,0
Xsg13cmos5l_decap_8_683 VPWR VGND sg13cmos5l_decap_8
* cell instance sg13cmos5l_decap_8_684 r0 *1 0,0
Xsg13cmos5l_decap_8_684 VPWR VGND sg13cmos5l_decap_8
* cell instance sg13cmos5l_decap_8_685 r0 *1 0,0
Xsg13cmos5l_decap_8_685 VPWR VGND sg13cmos5l_decap_8
* cell instance sg13cmos5l_decap_8_686 r0 *1 0,0
Xsg13cmos5l_decap_8_686 VPWR VGND sg13cmos5l_decap_8
* cell instance sg13cmos5l_decap_8_687 r0 *1 0,0
Xsg13cmos5l_decap_8_687 VPWR VGND sg13cmos5l_decap_8
* cell instance sg13cmos5l_decap_8_688 r0 *1 0,0
Xsg13cmos5l_decap_8_688 VPWR VGND sg13cmos5l_decap_8
* cell instance sg13cmos5l_decap_8_689 r0 *1 0,0
Xsg13cmos5l_decap_8_689 VPWR VGND sg13cmos5l_decap_8
* cell instance sg13cmos5l_decap_8_690 r0 *1 0,0
Xsg13cmos5l_decap_8_690 VPWR VGND sg13cmos5l_decap_8
* cell instance sg13cmos5l_decap_8_691 r0 *1 0,0
Xsg13cmos5l_decap_8_691 VPWR VGND sg13cmos5l_decap_8
* cell instance sg13cmos5l_decap_8_692 r0 *1 0,0
Xsg13cmos5l_decap_8_692 VPWR VGND sg13cmos5l_decap_8
* cell instance sg13cmos5l_decap_8_693 r0 *1 0,0
Xsg13cmos5l_decap_8_693 VPWR VGND sg13cmos5l_decap_8
* cell instance sg13cmos5l_decap_8_694 r0 *1 0,0
Xsg13cmos5l_decap_8_694 VPWR VGND sg13cmos5l_decap_8
* cell instance sg13cmos5l_decap_8_695 r0 *1 0,0
Xsg13cmos5l_decap_8_695 VPWR VGND sg13cmos5l_decap_8
* cell instance sg13cmos5l_decap_8_696 r0 *1 0,0
Xsg13cmos5l_decap_8_696 VPWR VGND sg13cmos5l_decap_8
* cell instance sg13cmos5l_decap_8_697 r0 *1 0,0
Xsg13cmos5l_decap_8_697 VPWR VGND sg13cmos5l_decap_8
* cell instance sg13cmos5l_decap_8_698 r0 *1 0,0
Xsg13cmos5l_decap_8_698 VPWR VGND sg13cmos5l_decap_8
* cell instance sg13cmos5l_decap_8_699 r0 *1 0,0
Xsg13cmos5l_decap_8_699 VPWR VGND sg13cmos5l_decap_8
* cell instance sg13cmos5l_decap_8_700 r0 *1 0,0
Xsg13cmos5l_decap_8_700 VPWR VGND sg13cmos5l_decap_8
* cell instance sg13cmos5l_decap_8_701 r0 *1 0,0
Xsg13cmos5l_decap_8_701 VPWR VGND sg13cmos5l_decap_8
* cell instance sg13cmos5l_decap_8_702 r0 *1 0,0
Xsg13cmos5l_decap_8_702 VPWR VGND sg13cmos5l_decap_8
* cell instance sg13cmos5l_decap_8_703 r0 *1 0,0
Xsg13cmos5l_decap_8_703 VPWR VGND sg13cmos5l_decap_8
* cell instance sg13cmos5l_decap_8_704 r0 *1 0,0
Xsg13cmos5l_decap_8_704 VPWR VGND sg13cmos5l_decap_8
* cell instance sg13cmos5l_decap_8_705 r0 *1 0,0
Xsg13cmos5l_decap_8_705 VPWR VGND sg13cmos5l_decap_8
* cell instance sg13cmos5l_decap_8_706 r0 *1 0,0
Xsg13cmos5l_decap_8_706 VPWR VGND sg13cmos5l_decap_8
* cell instance sg13cmos5l_decap_8_707 r0 *1 0,0
Xsg13cmos5l_decap_8_707 VPWR VGND sg13cmos5l_decap_8
* cell instance sg13cmos5l_decap_8_708 r0 *1 0,0
Xsg13cmos5l_decap_8_708 VPWR VGND sg13cmos5l_decap_8
* cell instance sg13cmos5l_decap_8_709 r0 *1 0,0
Xsg13cmos5l_decap_8_709 VPWR VGND sg13cmos5l_decap_8
* cell instance sg13cmos5l_decap_8_710 r0 *1 0,0
Xsg13cmos5l_decap_8_710 VPWR VGND sg13cmos5l_decap_8
* cell instance sg13cmos5l_decap_8_711 r0 *1 0,0
Xsg13cmos5l_decap_8_711 VPWR VGND sg13cmos5l_decap_8
* cell instance sg13cmos5l_decap_8_712 r0 *1 0,0
Xsg13cmos5l_decap_8_712 VPWR VGND sg13cmos5l_decap_8
* cell instance sg13cmos5l_decap_8_713 r0 *1 0,0
Xsg13cmos5l_decap_8_713 VPWR VGND sg13cmos5l_decap_8
* cell instance sg13cmos5l_decap_8_714 r0 *1 0,0
Xsg13cmos5l_decap_8_714 VPWR VGND sg13cmos5l_decap_8
* cell instance sg13cmos5l_decap_8_715 r0 *1 0,0
Xsg13cmos5l_decap_8_715 VPWR VGND sg13cmos5l_decap_8
* cell instance sg13cmos5l_decap_8_716 r0 *1 0,0
Xsg13cmos5l_decap_8_716 VPWR VGND sg13cmos5l_decap_8
* cell instance sg13cmos5l_decap_8_717 r0 *1 0,0
Xsg13cmos5l_decap_8_717 VPWR VGND sg13cmos5l_decap_8
* cell instance sg13cmos5l_decap_8_718 r0 *1 0,0
Xsg13cmos5l_decap_8_718 VPWR VGND sg13cmos5l_decap_8
* cell instance sg13cmos5l_decap_8_719 r0 *1 0,0
Xsg13cmos5l_decap_8_719 VPWR VGND sg13cmos5l_decap_8
* cell instance sg13cmos5l_decap_8_720 r0 *1 0,0
Xsg13cmos5l_decap_8_720 VPWR VGND sg13cmos5l_decap_8
* cell instance sg13cmos5l_decap_8_721 r0 *1 0,0
Xsg13cmos5l_decap_8_721 VPWR VGND sg13cmos5l_decap_8
* cell instance sg13cmos5l_decap_8_722 r0 *1 0,0
Xsg13cmos5l_decap_8_722 VPWR VGND sg13cmos5l_decap_8
* cell instance sg13cmos5l_decap_8_723 r0 *1 0,0
Xsg13cmos5l_decap_8_723 VPWR VGND sg13cmos5l_decap_8
* cell instance sg13cmos5l_decap_8_724 r0 *1 0,0
Xsg13cmos5l_decap_8_724 VPWR VGND sg13cmos5l_decap_8
* cell instance sg13cmos5l_decap_8_725 r0 *1 0,0
Xsg13cmos5l_decap_8_725 VPWR VGND sg13cmos5l_decap_8
* cell instance sg13cmos5l_decap_8_726 r0 *1 0,0
Xsg13cmos5l_decap_8_726 VPWR VGND sg13cmos5l_decap_8
* cell instance sg13cmos5l_decap_8_727 r0 *1 0,0
Xsg13cmos5l_decap_8_727 VPWR VGND sg13cmos5l_decap_8
* cell instance sg13cmos5l_decap_8_728 r0 *1 0,0
Xsg13cmos5l_decap_8_728 VPWR VGND sg13cmos5l_decap_8
* cell instance sg13cmos5l_decap_8_729 r0 *1 0,0
Xsg13cmos5l_decap_8_729 VPWR VGND sg13cmos5l_decap_8
* cell instance sg13cmos5l_decap_8_730 r0 *1 0,0
Xsg13cmos5l_decap_8_730 VPWR VGND sg13cmos5l_decap_8
* cell instance sg13cmos5l_decap_8_731 r0 *1 0,0
Xsg13cmos5l_decap_8_731 VPWR VGND sg13cmos5l_decap_8
* cell instance sg13cmos5l_decap_8_732 r0 *1 0,0
Xsg13cmos5l_decap_8_732 VPWR VGND sg13cmos5l_decap_8
* cell instance sg13cmos5l_decap_8_733 r0 *1 0,0
Xsg13cmos5l_decap_8_733 VPWR VGND sg13cmos5l_decap_8
* cell instance sg13cmos5l_decap_8_734 r0 *1 0,0
Xsg13cmos5l_decap_8_734 VPWR VGND sg13cmos5l_decap_8
* cell instance sg13cmos5l_decap_8_735 r0 *1 0,0
Xsg13cmos5l_decap_8_735 VPWR VGND sg13cmos5l_decap_8
* cell instance sg13cmos5l_decap_8_736 r0 *1 0,0
Xsg13cmos5l_decap_8_736 VPWR VGND sg13cmos5l_decap_8
* cell instance sg13cmos5l_decap_8_737 r0 *1 0,0
Xsg13cmos5l_decap_8_737 VPWR VGND sg13cmos5l_decap_8
* cell instance sg13cmos5l_decap_8_738 r0 *1 0,0
Xsg13cmos5l_decap_8_738 VPWR VGND sg13cmos5l_decap_8
* cell instance sg13cmos5l_decap_8_739 r0 *1 0,0
Xsg13cmos5l_decap_8_739 VPWR VGND sg13cmos5l_decap_8
* cell instance sg13cmos5l_decap_8_740 r0 *1 0,0
Xsg13cmos5l_decap_8_740 VPWR VGND sg13cmos5l_decap_8
* cell instance sg13cmos5l_decap_8_741 r0 *1 0,0
Xsg13cmos5l_decap_8_741 VPWR VGND sg13cmos5l_decap_8
* cell instance sg13cmos5l_decap_8_742 r0 *1 0,0
Xsg13cmos5l_decap_8_742 VPWR VGND sg13cmos5l_decap_8
* cell instance sg13cmos5l_decap_8_743 r0 *1 0,0
Xsg13cmos5l_decap_8_743 VPWR VGND sg13cmos5l_decap_8
* cell instance sg13cmos5l_decap_8_744 r0 *1 0,0
Xsg13cmos5l_decap_8_744 VPWR VGND sg13cmos5l_decap_8
* cell instance sg13cmos5l_decap_8_745 r0 *1 0,0
Xsg13cmos5l_decap_8_745 VPWR VGND sg13cmos5l_decap_8
* cell instance sg13cmos5l_decap_8_746 r0 *1 0,0
Xsg13cmos5l_decap_8_746 VPWR VGND sg13cmos5l_decap_8
* cell instance sg13cmos5l_decap_8_747 r0 *1 0,0
Xsg13cmos5l_decap_8_747 VPWR VGND sg13cmos5l_decap_8
* cell instance sg13cmos5l_decap_8_748 r0 *1 0,0
Xsg13cmos5l_decap_8_748 VPWR VGND sg13cmos5l_decap_8
* cell instance sg13cmos5l_decap_8_749 r0 *1 0,0
Xsg13cmos5l_decap_8_749 VPWR VGND sg13cmos5l_decap_8
* cell instance sg13cmos5l_decap_8_750 r0 *1 0,0
Xsg13cmos5l_decap_8_750 VPWR VGND sg13cmos5l_decap_8
* cell instance sg13cmos5l_decap_8_751 r0 *1 0,0
Xsg13cmos5l_decap_8_751 VPWR VGND sg13cmos5l_decap_8
* cell instance sg13cmos5l_decap_8_752 r0 *1 0,0
Xsg13cmos5l_decap_8_752 VPWR VGND sg13cmos5l_decap_8
* cell instance sg13cmos5l_decap_8_753 r0 *1 0,0
Xsg13cmos5l_decap_8_753 VPWR VGND sg13cmos5l_decap_8
* cell instance sg13cmos5l_decap_8_754 r0 *1 0,0
Xsg13cmos5l_decap_8_754 VPWR VGND sg13cmos5l_decap_8
* cell instance sg13cmos5l_decap_8_755 r0 *1 0,0
Xsg13cmos5l_decap_8_755 VPWR VGND sg13cmos5l_decap_8
* cell instance sg13cmos5l_decap_8_756 r0 *1 0,0
Xsg13cmos5l_decap_8_756 VPWR VGND sg13cmos5l_decap_8
* cell instance sg13cmos5l_decap_8_757 r0 *1 0,0
Xsg13cmos5l_decap_8_757 VPWR VGND sg13cmos5l_decap_8
* cell instance sg13cmos5l_decap_8_758 r0 *1 0,0
Xsg13cmos5l_decap_8_758 VPWR VGND sg13cmos5l_decap_8
* cell instance sg13cmos5l_decap_8_759 r0 *1 0,0
Xsg13cmos5l_decap_8_759 VPWR VGND sg13cmos5l_decap_8
* cell instance sg13cmos5l_decap_8_760 r0 *1 0,0
Xsg13cmos5l_decap_8_760 VPWR VGND sg13cmos5l_decap_8
* cell instance sg13cmos5l_decap_8_761 r0 *1 0,0
Xsg13cmos5l_decap_8_761 VPWR VGND sg13cmos5l_decap_8
* cell instance sg13cmos5l_decap_8_762 r0 *1 0,0
Xsg13cmos5l_decap_8_762 VPWR VGND sg13cmos5l_decap_8
* cell instance sg13cmos5l_decap_8_763 r0 *1 0,0
Xsg13cmos5l_decap_8_763 VPWR VGND sg13cmos5l_decap_8
* cell instance sg13cmos5l_decap_8_764 r0 *1 0,0
Xsg13cmos5l_decap_8_764 VPWR VGND sg13cmos5l_decap_8
* cell instance sg13cmos5l_decap_8_765 r0 *1 0,0
Xsg13cmos5l_decap_8_765 VPWR VGND sg13cmos5l_decap_8
* cell instance sg13cmos5l_decap_8_766 r0 *1 0,0
Xsg13cmos5l_decap_8_766 VPWR VGND sg13cmos5l_decap_8
* cell instance sg13cmos5l_decap_8_767 r0 *1 0,0
Xsg13cmos5l_decap_8_767 VPWR VGND sg13cmos5l_decap_8
* cell instance sg13cmos5l_decap_8_768 r0 *1 0,0
Xsg13cmos5l_decap_8_768 VPWR VGND sg13cmos5l_decap_8
* cell instance sg13cmos5l_decap_8_769 r0 *1 0,0
Xsg13cmos5l_decap_8_769 VPWR VGND sg13cmos5l_decap_8
* cell instance sg13cmos5l_decap_8_770 r0 *1 0,0
Xsg13cmos5l_decap_8_770 VPWR VGND sg13cmos5l_decap_8
* cell instance sg13cmos5l_decap_8_771 r0 *1 0,0
Xsg13cmos5l_decap_8_771 VPWR VGND sg13cmos5l_decap_8
* cell instance sg13cmos5l_decap_8_772 r0 *1 0,0
Xsg13cmos5l_decap_8_772 VPWR VGND sg13cmos5l_decap_8
* cell instance sg13cmos5l_decap_8_773 r0 *1 0,0
Xsg13cmos5l_decap_8_773 VPWR VGND sg13cmos5l_decap_8
* cell instance sg13cmos5l_decap_8_774 r0 *1 0,0
Xsg13cmos5l_decap_8_774 VPWR VGND sg13cmos5l_decap_8
* cell instance sg13cmos5l_decap_8_775 r0 *1 0,0
Xsg13cmos5l_decap_8_775 VPWR VGND sg13cmos5l_decap_8
* cell instance sg13cmos5l_decap_8_776 r0 *1 0,0
Xsg13cmos5l_decap_8_776 VPWR VGND sg13cmos5l_decap_8
* cell instance sg13cmos5l_decap_8_777 r0 *1 0,0
Xsg13cmos5l_decap_8_777 VPWR VGND sg13cmos5l_decap_8
* cell instance sg13cmos5l_decap_8_778 r0 *1 0,0
Xsg13cmos5l_decap_8_778 VPWR VGND sg13cmos5l_decap_8
* cell instance sg13cmos5l_decap_8_779 r0 *1 0,0
Xsg13cmos5l_decap_8_779 VPWR VGND sg13cmos5l_decap_8
* cell instance sg13cmos5l_decap_8_780 r0 *1 0,0
Xsg13cmos5l_decap_8_780 VPWR VGND sg13cmos5l_decap_8
* cell instance sg13cmos5l_decap_8_781 r0 *1 0,0
Xsg13cmos5l_decap_8_781 VPWR VGND sg13cmos5l_decap_8
* cell instance sg13cmos5l_decap_8_782 r0 *1 0,0
Xsg13cmos5l_decap_8_782 VPWR VGND sg13cmos5l_decap_8
* cell instance sg13cmos5l_decap_8_783 r0 *1 0,0
Xsg13cmos5l_decap_8_783 VPWR VGND sg13cmos5l_decap_8
* cell instance sg13cmos5l_decap_8_784 r0 *1 0,0
Xsg13cmos5l_decap_8_784 VPWR VGND sg13cmos5l_decap_8
* cell instance sg13cmos5l_decap_8_785 r0 *1 0,0
Xsg13cmos5l_decap_8_785 VPWR VGND sg13cmos5l_decap_8
* cell instance sg13cmos5l_decap_8_786 r0 *1 0,0
Xsg13cmos5l_decap_8_786 VPWR VGND sg13cmos5l_decap_8
* cell instance sg13cmos5l_decap_8_787 r0 *1 0,0
Xsg13cmos5l_decap_8_787 VPWR VGND sg13cmos5l_decap_8
* cell instance sg13cmos5l_decap_8_788 r0 *1 0,0
Xsg13cmos5l_decap_8_788 VPWR VGND sg13cmos5l_decap_8
* cell instance sg13cmos5l_decap_8_789 r0 *1 0,0
Xsg13cmos5l_decap_8_789 VPWR VGND sg13cmos5l_decap_8
* cell instance sg13cmos5l_decap_8_790 r0 *1 0,0
Xsg13cmos5l_decap_8_790 VPWR VGND sg13cmos5l_decap_8
* cell instance sg13cmos5l_decap_8_791 r0 *1 0,0
Xsg13cmos5l_decap_8_791 VPWR VGND sg13cmos5l_decap_8
* cell instance sg13cmos5l_decap_8_792 r0 *1 0,0
Xsg13cmos5l_decap_8_792 VPWR VGND sg13cmos5l_decap_8
* cell instance sg13cmos5l_decap_8_793 r0 *1 0,0
Xsg13cmos5l_decap_8_793 VPWR VGND sg13cmos5l_decap_8
* cell instance sg13cmos5l_decap_8_794 r0 *1 0,0
Xsg13cmos5l_decap_8_794 VPWR VGND sg13cmos5l_decap_8
* cell instance sg13cmos5l_decap_8_795 r0 *1 0,0
Xsg13cmos5l_decap_8_795 VPWR VGND sg13cmos5l_decap_8
* cell instance sg13cmos5l_decap_8_796 r0 *1 0,0
Xsg13cmos5l_decap_8_796 VPWR VGND sg13cmos5l_decap_8
* cell instance sg13cmos5l_decap_8_797 r0 *1 0,0
Xsg13cmos5l_decap_8_797 VPWR VGND sg13cmos5l_decap_8
* cell instance sg13cmos5l_decap_8_798 r0 *1 0,0
Xsg13cmos5l_decap_8_798 VPWR VGND sg13cmos5l_decap_8
* cell instance sg13cmos5l_decap_8_799 r0 *1 0,0
Xsg13cmos5l_decap_8_799 VPWR VGND sg13cmos5l_decap_8
* cell instance sg13cmos5l_decap_8_800 r0 *1 0,0
Xsg13cmos5l_decap_8_800 VPWR VGND sg13cmos5l_decap_8
* cell instance sg13cmos5l_decap_8_801 r0 *1 0,0
Xsg13cmos5l_decap_8_801 VPWR VGND sg13cmos5l_decap_8
* cell instance sg13cmos5l_decap_8_802 r0 *1 0,0
Xsg13cmos5l_decap_8_802 VPWR VGND sg13cmos5l_decap_8
* cell instance sg13cmos5l_decap_8_803 r0 *1 0,0
Xsg13cmos5l_decap_8_803 VPWR VGND sg13cmos5l_decap_8
* cell instance sg13cmos5l_decap_8_804 r0 *1 0,0
Xsg13cmos5l_decap_8_804 VPWR VGND sg13cmos5l_decap_8
* cell instance sg13cmos5l_decap_8_805 r0 *1 0,0
Xsg13cmos5l_decap_8_805 VPWR VGND sg13cmos5l_decap_8
* cell instance sg13cmos5l_decap_8_806 r0 *1 0,0
Xsg13cmos5l_decap_8_806 VPWR VGND sg13cmos5l_decap_8
* cell instance sg13cmos5l_decap_8_807 r0 *1 0,0
Xsg13cmos5l_decap_8_807 VPWR VGND sg13cmos5l_decap_8
* cell instance sg13cmos5l_decap_8_808 r0 *1 0,0
Xsg13cmos5l_decap_8_808 VPWR VGND sg13cmos5l_decap_8
* cell instance sg13cmos5l_decap_8_809 r0 *1 0,0
Xsg13cmos5l_decap_8_809 VPWR VGND sg13cmos5l_decap_8
* cell instance sg13cmos5l_decap_8_810 r0 *1 0,0
Xsg13cmos5l_decap_8_810 VPWR VGND sg13cmos5l_decap_8
* cell instance sg13cmos5l_decap_8_811 r0 *1 0,0
Xsg13cmos5l_decap_8_811 VPWR VGND sg13cmos5l_decap_8
* cell instance sg13cmos5l_decap_8_812 r0 *1 0,0
Xsg13cmos5l_decap_8_812 VPWR VGND sg13cmos5l_decap_8
* cell instance sg13cmos5l_decap_8_813 r0 *1 0,0
Xsg13cmos5l_decap_8_813 VPWR VGND sg13cmos5l_decap_8
* cell instance sg13cmos5l_decap_8_814 r0 *1 0,0
Xsg13cmos5l_decap_8_814 VPWR VGND sg13cmos5l_decap_8
* cell instance sg13cmos5l_decap_8_815 r0 *1 0,0
Xsg13cmos5l_decap_8_815 VPWR VGND sg13cmos5l_decap_8
* cell instance sg13cmos5l_decap_8_816 r0 *1 0,0
Xsg13cmos5l_decap_8_816 VPWR VGND sg13cmos5l_decap_8
* cell instance sg13cmos5l_decap_8_817 r0 *1 0,0
Xsg13cmos5l_decap_8_817 VPWR VGND sg13cmos5l_decap_8
* cell instance sg13cmos5l_decap_8_818 r0 *1 0,0
Xsg13cmos5l_decap_8_818 VPWR VGND sg13cmos5l_decap_8
* cell instance sg13cmos5l_decap_8_819 r0 *1 0,0
Xsg13cmos5l_decap_8_819 VPWR VGND sg13cmos5l_decap_8
* cell instance sg13cmos5l_decap_8_820 r0 *1 0,0
Xsg13cmos5l_decap_8_820 VPWR VGND sg13cmos5l_decap_8
* cell instance sg13cmos5l_decap_8_821 r0 *1 0,0
Xsg13cmos5l_decap_8_821 VPWR VGND sg13cmos5l_decap_8
* cell instance sg13cmos5l_decap_8_822 r0 *1 0,0
Xsg13cmos5l_decap_8_822 VPWR VGND sg13cmos5l_decap_8
* cell instance sg13cmos5l_decap_8_823 r0 *1 0,0
Xsg13cmos5l_decap_8_823 VPWR VGND sg13cmos5l_decap_8
* cell instance sg13cmos5l_decap_8_824 r0 *1 0,0
Xsg13cmos5l_decap_8_824 VPWR VGND sg13cmos5l_decap_8
* cell instance sg13cmos5l_decap_8_825 r0 *1 0,0
Xsg13cmos5l_decap_8_825 VPWR VGND sg13cmos5l_decap_8
* cell instance sg13cmos5l_decap_8_826 r0 *1 0,0
Xsg13cmos5l_decap_8_826 VPWR VGND sg13cmos5l_decap_8
* cell instance sg13cmos5l_decap_8_827 r0 *1 0,0
Xsg13cmos5l_decap_8_827 VPWR VGND sg13cmos5l_decap_8
* cell instance sg13cmos5l_decap_8_828 r0 *1 0,0
Xsg13cmos5l_decap_8_828 VPWR VGND sg13cmos5l_decap_8
* cell instance sg13cmos5l_decap_8_829 r0 *1 0,0
Xsg13cmos5l_decap_8_829 VPWR VGND sg13cmos5l_decap_8
* cell instance sg13cmos5l_decap_8_830 r0 *1 0,0
Xsg13cmos5l_decap_8_830 VPWR VGND sg13cmos5l_decap_8
* cell instance sg13cmos5l_decap_8_831 r0 *1 0,0
Xsg13cmos5l_decap_8_831 VPWR VGND sg13cmos5l_decap_8
* cell instance sg13cmos5l_decap_8_832 r0 *1 0,0
Xsg13cmos5l_decap_8_832 VPWR VGND sg13cmos5l_decap_8
* cell instance sg13cmos5l_decap_8_833 r0 *1 0,0
Xsg13cmos5l_decap_8_833 VPWR VGND sg13cmos5l_decap_8
* cell instance sg13cmos5l_decap_8_834 r0 *1 0,0
Xsg13cmos5l_decap_8_834 VPWR VGND sg13cmos5l_decap_8
* cell instance sg13cmos5l_decap_8_835 r0 *1 0,0
Xsg13cmos5l_decap_8_835 VPWR VGND sg13cmos5l_decap_8
* cell instance sg13cmos5l_decap_8_836 r0 *1 0,0
Xsg13cmos5l_decap_8_836 VPWR VGND sg13cmos5l_decap_8
* cell instance sg13cmos5l_decap_8_837 r0 *1 0,0
Xsg13cmos5l_decap_8_837 VPWR VGND sg13cmos5l_decap_8
* cell instance sg13cmos5l_decap_8_838 r0 *1 0,0
Xsg13cmos5l_decap_8_838 VPWR VGND sg13cmos5l_decap_8
* cell instance sg13cmos5l_decap_8_839 r0 *1 0,0
Xsg13cmos5l_decap_8_839 VPWR VGND sg13cmos5l_decap_8
* cell instance sg13cmos5l_decap_8_840 r0 *1 0,0
Xsg13cmos5l_decap_8_840 VPWR VGND sg13cmos5l_decap_8
* cell instance sg13cmos5l_decap_8_841 r0 *1 0,0
Xsg13cmos5l_decap_8_841 VPWR VGND sg13cmos5l_decap_8
* cell instance sg13cmos5l_decap_8_842 r0 *1 0,0
Xsg13cmos5l_decap_8_842 VPWR VGND sg13cmos5l_decap_8
* cell instance sg13cmos5l_decap_8_843 r0 *1 0,0
Xsg13cmos5l_decap_8_843 VPWR VGND sg13cmos5l_decap_8
* cell instance sg13cmos5l_decap_8_844 r0 *1 0,0
Xsg13cmos5l_decap_8_844 VPWR VGND sg13cmos5l_decap_8
* cell instance sg13cmos5l_decap_8_845 r0 *1 0,0
Xsg13cmos5l_decap_8_845 VPWR VGND sg13cmos5l_decap_8
* cell instance sg13cmos5l_decap_8_846 r0 *1 0,0
Xsg13cmos5l_decap_8_846 VPWR VGND sg13cmos5l_decap_8
* cell instance sg13cmos5l_decap_8_847 r0 *1 0,0
Xsg13cmos5l_decap_8_847 VPWR VGND sg13cmos5l_decap_8
* cell instance sg13cmos5l_decap_8_848 r0 *1 0,0
Xsg13cmos5l_decap_8_848 VPWR VGND sg13cmos5l_decap_8
* cell instance sg13cmos5l_decap_8_849 r0 *1 0,0
Xsg13cmos5l_decap_8_849 VPWR VGND sg13cmos5l_decap_8
* cell instance sg13cmos5l_decap_8_850 r0 *1 0,0
Xsg13cmos5l_decap_8_850 VPWR VGND sg13cmos5l_decap_8
* cell instance sg13cmos5l_decap_8_851 r0 *1 0,0
Xsg13cmos5l_decap_8_851 VPWR VGND sg13cmos5l_decap_8
* cell instance sg13cmos5l_decap_8_852 r0 *1 0,0
Xsg13cmos5l_decap_8_852 VPWR VGND sg13cmos5l_decap_8
* cell instance sg13cmos5l_decap_8_853 r0 *1 0,0
Xsg13cmos5l_decap_8_853 VPWR VGND sg13cmos5l_decap_8
* cell instance sg13cmos5l_decap_8_854 r0 *1 0,0
Xsg13cmos5l_decap_8_854 VPWR VGND sg13cmos5l_decap_8
* cell instance sg13cmos5l_decap_8_855 r0 *1 0,0
Xsg13cmos5l_decap_8_855 VPWR VGND sg13cmos5l_decap_8
* cell instance sg13cmos5l_decap_8_856 r0 *1 0,0
Xsg13cmos5l_decap_8_856 VPWR VGND sg13cmos5l_decap_8
* cell instance sg13cmos5l_decap_8_857 r0 *1 0,0
Xsg13cmos5l_decap_8_857 VPWR VGND sg13cmos5l_decap_8
* cell instance sg13cmos5l_decap_8_858 r0 *1 0,0
Xsg13cmos5l_decap_8_858 VPWR VGND sg13cmos5l_decap_8
* cell instance sg13cmos5l_decap_8_859 r0 *1 0,0
Xsg13cmos5l_decap_8_859 VPWR VGND sg13cmos5l_decap_8
* cell instance sg13cmos5l_decap_8_860 r0 *1 0,0
Xsg13cmos5l_decap_8_860 VPWR VGND sg13cmos5l_decap_8
* cell instance sg13cmos5l_decap_8_861 r0 *1 0,0
Xsg13cmos5l_decap_8_861 VPWR VGND sg13cmos5l_decap_8
* cell instance sg13cmos5l_decap_8_862 r0 *1 0,0
Xsg13cmos5l_decap_8_862 VPWR VGND sg13cmos5l_decap_8
* cell instance sg13cmos5l_decap_8_863 r0 *1 0,0
Xsg13cmos5l_decap_8_863 VPWR VGND sg13cmos5l_decap_8
* cell instance sg13cmos5l_decap_8_864 r0 *1 0,0
Xsg13cmos5l_decap_8_864 VPWR VGND sg13cmos5l_decap_8
* cell instance sg13cmos5l_decap_8_865 r0 *1 0,0
Xsg13cmos5l_decap_8_865 VPWR VGND sg13cmos5l_decap_8
* cell instance sg13cmos5l_decap_8_866 r0 *1 0,0
Xsg13cmos5l_decap_8_866 VPWR VGND sg13cmos5l_decap_8
* cell instance sg13cmos5l_decap_8_867 r0 *1 0,0
Xsg13cmos5l_decap_8_867 VPWR VGND sg13cmos5l_decap_8
* cell instance sg13cmos5l_decap_8_868 r0 *1 0,0
Xsg13cmos5l_decap_8_868 VPWR VGND sg13cmos5l_decap_8
* cell instance sg13cmos5l_decap_8_869 r0 *1 0,0
Xsg13cmos5l_decap_8_869 VPWR VGND sg13cmos5l_decap_8
* cell instance sg13cmos5l_decap_8_870 r0 *1 0,0
Xsg13cmos5l_decap_8_870 VPWR VGND sg13cmos5l_decap_8
* cell instance sg13cmos5l_decap_8_871 r0 *1 0,0
Xsg13cmos5l_decap_8_871 VPWR VGND sg13cmos5l_decap_8
* cell instance sg13cmos5l_decap_8_872 r0 *1 0,0
Xsg13cmos5l_decap_8_872 VPWR VGND sg13cmos5l_decap_8
* cell instance sg13cmos5l_decap_8_873 r0 *1 0,0
Xsg13cmos5l_decap_8_873 VPWR VGND sg13cmos5l_decap_8
* cell instance sg13cmos5l_decap_8_874 r0 *1 0,0
Xsg13cmos5l_decap_8_874 VPWR VGND sg13cmos5l_decap_8
* cell instance sg13cmos5l_decap_8_875 r0 *1 0,0
Xsg13cmos5l_decap_8_875 VPWR VGND sg13cmos5l_decap_8
* cell instance sg13cmos5l_decap_8_876 r0 *1 0,0
Xsg13cmos5l_decap_8_876 VPWR VGND sg13cmos5l_decap_8
* cell instance sg13cmos5l_decap_8_877 r0 *1 0,0
Xsg13cmos5l_decap_8_877 VPWR VGND sg13cmos5l_decap_8
* cell instance sg13cmos5l_decap_8_878 r0 *1 0,0
Xsg13cmos5l_decap_8_878 VPWR VGND sg13cmos5l_decap_8
* cell instance sg13cmos5l_decap_8_879 r0 *1 0,0
Xsg13cmos5l_decap_8_879 VPWR VGND sg13cmos5l_decap_8
* cell instance sg13cmos5l_decap_8_880 r0 *1 0,0
Xsg13cmos5l_decap_8_880 VPWR VGND sg13cmos5l_decap_8
* cell instance sg13cmos5l_decap_8_881 r0 *1 0,0
Xsg13cmos5l_decap_8_881 VPWR VGND sg13cmos5l_decap_8
* cell instance sg13cmos5l_decap_8_882 r0 *1 0,0
Xsg13cmos5l_decap_8_882 VPWR VGND sg13cmos5l_decap_8
* cell instance sg13cmos5l_decap_8_883 r0 *1 0,0
Xsg13cmos5l_decap_8_883 VPWR VGND sg13cmos5l_decap_8
* cell instance sg13cmos5l_decap_8_884 r0 *1 0,0
Xsg13cmos5l_decap_8_884 VPWR VGND sg13cmos5l_decap_8
* cell instance sg13cmos5l_decap_8_885 r0 *1 0,0
Xsg13cmos5l_decap_8_885 VPWR VGND sg13cmos5l_decap_8
* cell instance sg13cmos5l_decap_8_886 r0 *1 0,0
Xsg13cmos5l_decap_8_886 VPWR VGND sg13cmos5l_decap_8
* cell instance sg13cmos5l_decap_8_887 r0 *1 0,0
Xsg13cmos5l_decap_8_887 VPWR VGND sg13cmos5l_decap_8
* cell instance sg13cmos5l_decap_8_888 r0 *1 0,0
Xsg13cmos5l_decap_8_888 VPWR VGND sg13cmos5l_decap_8
* cell instance sg13cmos5l_decap_8_889 r0 *1 0,0
Xsg13cmos5l_decap_8_889 VPWR VGND sg13cmos5l_decap_8
* cell instance sg13cmos5l_decap_8_890 r0 *1 0,0
Xsg13cmos5l_decap_8_890 VPWR VGND sg13cmos5l_decap_8
* cell instance sg13cmos5l_decap_8_891 r0 *1 0,0
Xsg13cmos5l_decap_8_891 VPWR VGND sg13cmos5l_decap_8
* cell instance sg13cmos5l_decap_8_892 r0 *1 0,0
Xsg13cmos5l_decap_8_892 VPWR VGND sg13cmos5l_decap_8
* cell instance sg13cmos5l_decap_8_893 r0 *1 0,0
Xsg13cmos5l_decap_8_893 VPWR VGND sg13cmos5l_decap_8
* cell instance sg13cmos5l_decap_8_894 r0 *1 0,0
Xsg13cmos5l_decap_8_894 VPWR VGND sg13cmos5l_decap_8
* cell instance sg13cmos5l_decap_8_895 r0 *1 0,0
Xsg13cmos5l_decap_8_895 VPWR VGND sg13cmos5l_decap_8
* cell instance sg13cmos5l_decap_8_896 r0 *1 0,0
Xsg13cmos5l_decap_8_896 VPWR VGND sg13cmos5l_decap_8
* cell instance sg13cmos5l_decap_8_897 r0 *1 0,0
Xsg13cmos5l_decap_8_897 VPWR VGND sg13cmos5l_decap_8
* cell instance sg13cmos5l_decap_8_898 r0 *1 0,0
Xsg13cmos5l_decap_8_898 VPWR VGND sg13cmos5l_decap_8
* cell instance sg13cmos5l_decap_8_899 r0 *1 0,0
Xsg13cmos5l_decap_8_899 VPWR VGND sg13cmos5l_decap_8
* cell instance sg13cmos5l_decap_8_900 r0 *1 0,0
Xsg13cmos5l_decap_8_900 VPWR VGND sg13cmos5l_decap_8
* cell instance sg13cmos5l_decap_8_901 r0 *1 0,0
Xsg13cmos5l_decap_8_901 VPWR VGND sg13cmos5l_decap_8
* cell instance sg13cmos5l_decap_8_902 r0 *1 0,0
Xsg13cmos5l_decap_8_902 VPWR VGND sg13cmos5l_decap_8
* cell instance sg13cmos5l_decap_8_903 r0 *1 0,0
Xsg13cmos5l_decap_8_903 VPWR VGND sg13cmos5l_decap_8
* cell instance sg13cmos5l_decap_8_904 r0 *1 0,0
Xsg13cmos5l_decap_8_904 VPWR VGND sg13cmos5l_decap_8
* cell instance sg13cmos5l_decap_8_905 r0 *1 0,0
Xsg13cmos5l_decap_8_905 VPWR VGND sg13cmos5l_decap_8
* cell instance sg13cmos5l_decap_8_906 r0 *1 0,0
Xsg13cmos5l_decap_8_906 VPWR VGND sg13cmos5l_decap_8
* cell instance sg13cmos5l_decap_8_907 r0 *1 0,0
Xsg13cmos5l_decap_8_907 VPWR VGND sg13cmos5l_decap_8
* cell instance sg13cmos5l_decap_8_908 r0 *1 0,0
Xsg13cmos5l_decap_8_908 VPWR VGND sg13cmos5l_decap_8
* cell instance sg13cmos5l_decap_8_909 r0 *1 0,0
Xsg13cmos5l_decap_8_909 VPWR VGND sg13cmos5l_decap_8
* cell instance sg13cmos5l_decap_8_910 r0 *1 0,0
Xsg13cmos5l_decap_8_910 VPWR VGND sg13cmos5l_decap_8
* cell instance sg13cmos5l_decap_8_911 r0 *1 0,0
Xsg13cmos5l_decap_8_911 VPWR VGND sg13cmos5l_decap_8
* cell instance sg13cmos5l_decap_8_912 r0 *1 0,0
Xsg13cmos5l_decap_8_912 VPWR VGND sg13cmos5l_decap_8
* cell instance sg13cmos5l_decap_8_913 r0 *1 0,0
Xsg13cmos5l_decap_8_913 VPWR VGND sg13cmos5l_decap_8
* cell instance sg13cmos5l_decap_8_914 r0 *1 0,0
Xsg13cmos5l_decap_8_914 VPWR VGND sg13cmos5l_decap_8
* cell instance sg13cmos5l_decap_8_915 r0 *1 0,0
Xsg13cmos5l_decap_8_915 VPWR VGND sg13cmos5l_decap_8
* cell instance sg13cmos5l_decap_8_916 r0 *1 0,0
Xsg13cmos5l_decap_8_916 VPWR VGND sg13cmos5l_decap_8
* cell instance sg13cmos5l_decap_8_917 r0 *1 0,0
Xsg13cmos5l_decap_8_917 VPWR VGND sg13cmos5l_decap_8
* cell instance sg13cmos5l_decap_8_918 r0 *1 0,0
Xsg13cmos5l_decap_8_918 VPWR VGND sg13cmos5l_decap_8
* cell instance sg13cmos5l_decap_8_919 r0 *1 0,0
Xsg13cmos5l_decap_8_919 VPWR VGND sg13cmos5l_decap_8
* cell instance sg13cmos5l_decap_8_920 r0 *1 0,0
Xsg13cmos5l_decap_8_920 VPWR VGND sg13cmos5l_decap_8
* cell instance sg13cmos5l_decap_8_921 r0 *1 0,0
Xsg13cmos5l_decap_8_921 VPWR VGND sg13cmos5l_decap_8
* cell instance sg13cmos5l_decap_8_922 r0 *1 0,0
Xsg13cmos5l_decap_8_922 VPWR VGND sg13cmos5l_decap_8
* cell instance sg13cmos5l_decap_8_923 r0 *1 0,0
Xsg13cmos5l_decap_8_923 VPWR VGND sg13cmos5l_decap_8
* cell instance sg13cmos5l_decap_8_924 r0 *1 0,0
Xsg13cmos5l_decap_8_924 VPWR VGND sg13cmos5l_decap_8
* cell instance sg13cmos5l_decap_8_925 r0 *1 0,0
Xsg13cmos5l_decap_8_925 VPWR VGND sg13cmos5l_decap_8
* cell instance sg13cmos5l_decap_8_926 r0 *1 0,0
Xsg13cmos5l_decap_8_926 VPWR VGND sg13cmos5l_decap_8
* cell instance sg13cmos5l_decap_8_927 r0 *1 0,0
Xsg13cmos5l_decap_8_927 VPWR VGND sg13cmos5l_decap_8
* cell instance sg13cmos5l_decap_8_928 r0 *1 0,0
Xsg13cmos5l_decap_8_928 VPWR VGND sg13cmos5l_decap_8
* cell instance sg13cmos5l_decap_8_929 r0 *1 0,0
Xsg13cmos5l_decap_8_929 VPWR VGND sg13cmos5l_decap_8
* cell instance sg13cmos5l_decap_8_930 r0 *1 0,0
Xsg13cmos5l_decap_8_930 VPWR VGND sg13cmos5l_decap_8
* cell instance sg13cmos5l_decap_8_931 r0 *1 0,0
Xsg13cmos5l_decap_8_931 VPWR VGND sg13cmos5l_decap_8
* cell instance sg13cmos5l_decap_8_932 r0 *1 0,0
Xsg13cmos5l_decap_8_932 VPWR VGND sg13cmos5l_decap_8
* cell instance sg13cmos5l_decap_8_933 r0 *1 0,0
Xsg13cmos5l_decap_8_933 VPWR VGND sg13cmos5l_decap_8
* cell instance sg13cmos5l_decap_8_934 r0 *1 0,0
Xsg13cmos5l_decap_8_934 VPWR VGND sg13cmos5l_decap_8
* cell instance sg13cmos5l_decap_8_935 r0 *1 0,0
Xsg13cmos5l_decap_8_935 VPWR VGND sg13cmos5l_decap_8
* cell instance sg13cmos5l_decap_8_936 r0 *1 0,0
Xsg13cmos5l_decap_8_936 VPWR VGND sg13cmos5l_decap_8
* cell instance sg13cmos5l_decap_8_937 r0 *1 0,0
Xsg13cmos5l_decap_8_937 VPWR VGND sg13cmos5l_decap_8
* cell instance sg13cmos5l_decap_8_938 r0 *1 0,0
Xsg13cmos5l_decap_8_938 VPWR VGND sg13cmos5l_decap_8
* cell instance sg13cmos5l_decap_8_939 r0 *1 0,0
Xsg13cmos5l_decap_8_939 VPWR VGND sg13cmos5l_decap_8
* cell instance sg13cmos5l_decap_8_940 r0 *1 0,0
Xsg13cmos5l_decap_8_940 VPWR VGND sg13cmos5l_decap_8
* cell instance sg13cmos5l_decap_8_941 r0 *1 0,0
Xsg13cmos5l_decap_8_941 VPWR VGND sg13cmos5l_decap_8
* cell instance sg13cmos5l_decap_8_942 r0 *1 0,0
Xsg13cmos5l_decap_8_942 VPWR VGND sg13cmos5l_decap_8
* cell instance sg13cmos5l_decap_8_943 r0 *1 0,0
Xsg13cmos5l_decap_8_943 VPWR VGND sg13cmos5l_decap_8
* cell instance sg13cmos5l_decap_8_944 r0 *1 0,0
Xsg13cmos5l_decap_8_944 VPWR VGND sg13cmos5l_decap_8
* cell instance sg13cmos5l_decap_8_945 r0 *1 0,0
Xsg13cmos5l_decap_8_945 VPWR VGND sg13cmos5l_decap_8
* cell instance sg13cmos5l_decap_8_946 r0 *1 0,0
Xsg13cmos5l_decap_8_946 VPWR VGND sg13cmos5l_decap_8
* cell instance sg13cmos5l_decap_8_947 r0 *1 0,0
Xsg13cmos5l_decap_8_947 VPWR VGND sg13cmos5l_decap_8
* cell instance sg13cmos5l_decap_8_948 r0 *1 0,0
Xsg13cmos5l_decap_8_948 VPWR VGND sg13cmos5l_decap_8
* cell instance sg13cmos5l_decap_8_949 r0 *1 0,0
Xsg13cmos5l_decap_8_949 VPWR VGND sg13cmos5l_decap_8
* cell instance sg13cmos5l_decap_8_950 r0 *1 0,0
Xsg13cmos5l_decap_8_950 VPWR VGND sg13cmos5l_decap_8
* cell instance sg13cmos5l_decap_8_951 r0 *1 0,0
Xsg13cmos5l_decap_8_951 VPWR VGND sg13cmos5l_decap_8
* cell instance sg13cmos5l_decap_8_952 r0 *1 0,0
Xsg13cmos5l_decap_8_952 VPWR VGND sg13cmos5l_decap_8
* cell instance sg13cmos5l_decap_8_953 r0 *1 0,0
Xsg13cmos5l_decap_8_953 VPWR VGND sg13cmos5l_decap_8
* cell instance sg13cmos5l_decap_8_954 r0 *1 0,0
Xsg13cmos5l_decap_8_954 VPWR VGND sg13cmos5l_decap_8
* cell instance sg13cmos5l_decap_8_955 r0 *1 0,0
Xsg13cmos5l_decap_8_955 VPWR VGND sg13cmos5l_decap_8
* cell instance sg13cmos5l_decap_8_956 r0 *1 0,0
Xsg13cmos5l_decap_8_956 VPWR VGND sg13cmos5l_decap_8
* cell instance sg13cmos5l_decap_8_957 r0 *1 0,0
Xsg13cmos5l_decap_8_957 VPWR VGND sg13cmos5l_decap_8
* cell instance sg13cmos5l_decap_8_958 r0 *1 0,0
Xsg13cmos5l_decap_8_958 VPWR VGND sg13cmos5l_decap_8
* cell instance sg13cmos5l_decap_8_959 r0 *1 0,0
Xsg13cmos5l_decap_8_959 VPWR VGND sg13cmos5l_decap_8
* cell instance sg13cmos5l_decap_8_960 r0 *1 0,0
Xsg13cmos5l_decap_8_960 VPWR VGND sg13cmos5l_decap_8
* cell instance sg13cmos5l_decap_8_961 r0 *1 0,0
Xsg13cmos5l_decap_8_961 VPWR VGND sg13cmos5l_decap_8
* cell instance sg13cmos5l_decap_8_962 r0 *1 0,0
Xsg13cmos5l_decap_8_962 VPWR VGND sg13cmos5l_decap_8
* cell instance sg13cmos5l_decap_8_963 r0 *1 0,0
Xsg13cmos5l_decap_8_963 VPWR VGND sg13cmos5l_decap_8
* cell instance sg13cmos5l_decap_8_964 r0 *1 0,0
Xsg13cmos5l_decap_8_964 VPWR VGND sg13cmos5l_decap_8
* cell instance sg13cmos5l_decap_8_965 r0 *1 0,0
Xsg13cmos5l_decap_8_965 VPWR VGND sg13cmos5l_decap_8
* cell instance sg13cmos5l_decap_8_966 r0 *1 0,0
Xsg13cmos5l_decap_8_966 VPWR VGND sg13cmos5l_decap_8
* cell instance sg13cmos5l_decap_8_967 r0 *1 0,0
Xsg13cmos5l_decap_8_967 VPWR VGND sg13cmos5l_decap_8
* cell instance sg13cmos5l_decap_8_968 r0 *1 0,0
Xsg13cmos5l_decap_8_968 VPWR VGND sg13cmos5l_decap_8
* cell instance sg13cmos5l_decap_8_969 r0 *1 0,0
Xsg13cmos5l_decap_8_969 VPWR VGND sg13cmos5l_decap_8
* cell instance sg13cmos5l_decap_8_970 r0 *1 0,0
Xsg13cmos5l_decap_8_970 VPWR VGND sg13cmos5l_decap_8
* cell instance sg13cmos5l_decap_8_971 r0 *1 0,0
Xsg13cmos5l_decap_8_971 VPWR VGND sg13cmos5l_decap_8
* cell instance sg13cmos5l_decap_8_972 r0 *1 0,0
Xsg13cmos5l_decap_8_972 VPWR VGND sg13cmos5l_decap_8
* cell instance sg13cmos5l_decap_8_973 r0 *1 0,0
Xsg13cmos5l_decap_8_973 VPWR VGND sg13cmos5l_decap_8
* cell instance sg13cmos5l_decap_8_974 r0 *1 0,0
Xsg13cmos5l_decap_8_974 VPWR VGND sg13cmos5l_decap_8
* cell instance sg13cmos5l_decap_8_975 r0 *1 0,0
Xsg13cmos5l_decap_8_975 VPWR VGND sg13cmos5l_decap_8
* cell instance sg13cmos5l_decap_8_976 r0 *1 0,0
Xsg13cmos5l_decap_8_976 VPWR VGND sg13cmos5l_decap_8
* cell instance sg13cmos5l_decap_8_977 r0 *1 0,0
Xsg13cmos5l_decap_8_977 VPWR VGND sg13cmos5l_decap_8
* cell instance sg13cmos5l_decap_8_978 r0 *1 0,0
Xsg13cmos5l_decap_8_978 VPWR VGND sg13cmos5l_decap_8
* cell instance sg13cmos5l_decap_8_979 r0 *1 0,0
Xsg13cmos5l_decap_8_979 VPWR VGND sg13cmos5l_decap_8
* cell instance sg13cmos5l_decap_8_980 r0 *1 0,0
Xsg13cmos5l_decap_8_980 VPWR VGND sg13cmos5l_decap_8
* cell instance sg13cmos5l_decap_8_981 r0 *1 0,0
Xsg13cmos5l_decap_8_981 VPWR VGND sg13cmos5l_decap_8
* cell instance sg13cmos5l_decap_8_982 r0 *1 0,0
Xsg13cmos5l_decap_8_982 VPWR VGND sg13cmos5l_decap_8
* cell instance sg13cmos5l_decap_8_983 r0 *1 0,0
Xsg13cmos5l_decap_8_983 VPWR VGND sg13cmos5l_decap_8
* cell instance sg13cmos5l_decap_8_984 r0 *1 0,0
Xsg13cmos5l_decap_8_984 VPWR VGND sg13cmos5l_decap_8
* cell instance sg13cmos5l_decap_8_985 r0 *1 0,0
Xsg13cmos5l_decap_8_985 VPWR VGND sg13cmos5l_decap_8
* cell instance sg13cmos5l_decap_8_986 r0 *1 0,0
Xsg13cmos5l_decap_8_986 VPWR VGND sg13cmos5l_decap_8
* cell instance sg13cmos5l_decap_8_987 r0 *1 0,0
Xsg13cmos5l_decap_8_987 VPWR VGND sg13cmos5l_decap_8
* cell instance sg13cmos5l_decap_8_988 r0 *1 0,0
Xsg13cmos5l_decap_8_988 VPWR VGND sg13cmos5l_decap_8
* cell instance sg13cmos5l_decap_8_989 r0 *1 0,0
Xsg13cmos5l_decap_8_989 VPWR VGND sg13cmos5l_decap_8
* cell instance sg13cmos5l_decap_8_990 r0 *1 0,0
Xsg13cmos5l_decap_8_990 VPWR VGND sg13cmos5l_decap_8
* cell instance sg13cmos5l_decap_8_991 r0 *1 0,0
Xsg13cmos5l_decap_8_991 VPWR VGND sg13cmos5l_decap_8
* cell instance sg13cmos5l_decap_8_992 r0 *1 0,0
Xsg13cmos5l_decap_8_992 VPWR VGND sg13cmos5l_decap_8
* cell instance sg13cmos5l_decap_8_993 r0 *1 0,0
Xsg13cmos5l_decap_8_993 VPWR VGND sg13cmos5l_decap_8
* cell instance sg13cmos5l_decap_8_994 r0 *1 0,0
Xsg13cmos5l_decap_8_994 VPWR VGND sg13cmos5l_decap_8
* cell instance sg13cmos5l_decap_8_995 r0 *1 0,0
Xsg13cmos5l_decap_8_995 VPWR VGND sg13cmos5l_decap_8
* cell instance sg13cmos5l_decap_8_996 r0 *1 0,0
Xsg13cmos5l_decap_8_996 VPWR VGND sg13cmos5l_decap_8
* cell instance sg13cmos5l_decap_8_997 r0 *1 0,0
Xsg13cmos5l_decap_8_997 VPWR VGND sg13cmos5l_decap_8
* cell instance sg13cmos5l_decap_8_998 r0 *1 0,0
Xsg13cmos5l_decap_8_998 VPWR VGND sg13cmos5l_decap_8
* cell instance sg13cmos5l_decap_8_999 r0 *1 0,0
Xsg13cmos5l_decap_8_999 VPWR VGND sg13cmos5l_decap_8
* cell instance sg13cmos5l_decap_8_1000 r0 *1 0,0
Xsg13cmos5l_decap_8_1000 VPWR VGND sg13cmos5l_decap_8
* cell instance sg13cmos5l_decap_8_1001 r0 *1 0,0
Xsg13cmos5l_decap_8_1001 VPWR VGND sg13cmos5l_decap_8
* cell instance sg13cmos5l_decap_8_1002 r0 *1 0,0
Xsg13cmos5l_decap_8_1002 VPWR VGND sg13cmos5l_decap_8
* cell instance sg13cmos5l_decap_8_1003 r0 *1 0,0
Xsg13cmos5l_decap_8_1003 VPWR VGND sg13cmos5l_decap_8
* cell instance sg13cmos5l_decap_8_1004 r0 *1 0,0
Xsg13cmos5l_decap_8_1004 VPWR VGND sg13cmos5l_decap_8
* cell instance sg13cmos5l_decap_8_1005 r0 *1 0,0
Xsg13cmos5l_decap_8_1005 VPWR VGND sg13cmos5l_decap_8
* cell instance sg13cmos5l_decap_8_1006 r0 *1 0,0
Xsg13cmos5l_decap_8_1006 VPWR VGND sg13cmos5l_decap_8
* cell instance sg13cmos5l_decap_8_1007 r0 *1 0,0
Xsg13cmos5l_decap_8_1007 VPWR VGND sg13cmos5l_decap_8
* cell instance sg13cmos5l_decap_8_1008 r0 *1 0,0
Xsg13cmos5l_decap_8_1008 VPWR VGND sg13cmos5l_decap_8
* cell instance sg13cmos5l_decap_8_1009 r0 *1 0,0
Xsg13cmos5l_decap_8_1009 VPWR VGND sg13cmos5l_decap_8
* cell instance sg13cmos5l_decap_8_1010 r0 *1 0,0
Xsg13cmos5l_decap_8_1010 VPWR VGND sg13cmos5l_decap_8
* cell instance sg13cmos5l_decap_8_1011 r0 *1 0,0
Xsg13cmos5l_decap_8_1011 VPWR VGND sg13cmos5l_decap_8
* cell instance sg13cmos5l_decap_8_1012 r0 *1 0,0
Xsg13cmos5l_decap_8_1012 VPWR VGND sg13cmos5l_decap_8
* cell instance sg13cmos5l_decap_8_1013 r0 *1 0,0
Xsg13cmos5l_decap_8_1013 VPWR VGND sg13cmos5l_decap_8
* cell instance sg13cmos5l_decap_8_1014 r0 *1 0,0
Xsg13cmos5l_decap_8_1014 VPWR VGND sg13cmos5l_decap_8
* cell instance sg13cmos5l_decap_8_1015 r0 *1 0,0
Xsg13cmos5l_decap_8_1015 VPWR VGND sg13cmos5l_decap_8
* cell instance sg13cmos5l_decap_8_1016 r0 *1 0,0
Xsg13cmos5l_decap_8_1016 VPWR VGND sg13cmos5l_decap_8
* cell instance sg13cmos5l_decap_8_1017 r0 *1 0,0
Xsg13cmos5l_decap_8_1017 VPWR VGND sg13cmos5l_decap_8
* cell instance sg13cmos5l_decap_8_1018 r0 *1 0,0
Xsg13cmos5l_decap_8_1018 VPWR VGND sg13cmos5l_decap_8
* cell instance sg13cmos5l_decap_8_1019 r0 *1 0,0
Xsg13cmos5l_decap_8_1019 VPWR VGND sg13cmos5l_decap_8
* cell instance sg13cmos5l_decap_8_1020 r0 *1 0,0
Xsg13cmos5l_decap_8_1020 VPWR VGND sg13cmos5l_decap_8
* cell instance sg13cmos5l_decap_8_1021 r0 *1 0,0
Xsg13cmos5l_decap_8_1021 VPWR VGND sg13cmos5l_decap_8
* cell instance sg13cmos5l_decap_8_1022 r0 *1 0,0
Xsg13cmos5l_decap_8_1022 VPWR VGND sg13cmos5l_decap_8
* cell instance sg13cmos5l_decap_8_1023 r0 *1 0,0
Xsg13cmos5l_decap_8_1023 VPWR VGND sg13cmos5l_decap_8
* cell instance sg13cmos5l_decap_8_1024 r0 *1 0,0
Xsg13cmos5l_decap_8_1024 VPWR VGND sg13cmos5l_decap_8
* cell instance sg13cmos5l_decap_8_1025 r0 *1 0,0
Xsg13cmos5l_decap_8_1025 VPWR VGND sg13cmos5l_decap_8
* cell instance sg13cmos5l_decap_8_1026 r0 *1 0,0
Xsg13cmos5l_decap_8_1026 VPWR VGND sg13cmos5l_decap_8
* cell instance sg13cmos5l_decap_8_1027 r0 *1 0,0
Xsg13cmos5l_decap_8_1027 VPWR VGND sg13cmos5l_decap_8
* cell instance sg13cmos5l_decap_8_1028 r0 *1 0,0
Xsg13cmos5l_decap_8_1028 VPWR VGND sg13cmos5l_decap_8
* cell instance sg13cmos5l_decap_8_1029 r0 *1 0,0
Xsg13cmos5l_decap_8_1029 VPWR VGND sg13cmos5l_decap_8
* cell instance sg13cmos5l_decap_8_1030 r0 *1 0,0
Xsg13cmos5l_decap_8_1030 VPWR VGND sg13cmos5l_decap_8
* cell instance sg13cmos5l_decap_8_1031 r0 *1 0,0
Xsg13cmos5l_decap_8_1031 VPWR VGND sg13cmos5l_decap_8
* cell instance sg13cmos5l_decap_8_1032 r0 *1 0,0
Xsg13cmos5l_decap_8_1032 VPWR VGND sg13cmos5l_decap_8
* cell instance sg13cmos5l_decap_8_1033 r0 *1 0,0
Xsg13cmos5l_decap_8_1033 VPWR VGND sg13cmos5l_decap_8
* cell instance sg13cmos5l_decap_8_1034 r0 *1 0,0
Xsg13cmos5l_decap_8_1034 VPWR VGND sg13cmos5l_decap_8
* cell instance sg13cmos5l_decap_8_1035 r0 *1 0,0
Xsg13cmos5l_decap_8_1035 VPWR VGND sg13cmos5l_decap_8
* cell instance sg13cmos5l_decap_8_1036 r0 *1 0,0
Xsg13cmos5l_decap_8_1036 VPWR VGND sg13cmos5l_decap_8
* cell instance sg13cmos5l_decap_8_1037 r0 *1 0,0
Xsg13cmos5l_decap_8_1037 VPWR VGND sg13cmos5l_decap_8
* cell instance sg13cmos5l_decap_8_1038 r0 *1 0,0
Xsg13cmos5l_decap_8_1038 VPWR VGND sg13cmos5l_decap_8
* cell instance sg13cmos5l_decap_8_1039 r0 *1 0,0
Xsg13cmos5l_decap_8_1039 VPWR VGND sg13cmos5l_decap_8
* cell instance sg13cmos5l_decap_8_1040 r0 *1 0,0
Xsg13cmos5l_decap_8_1040 VPWR VGND sg13cmos5l_decap_8
* cell instance sg13cmos5l_decap_8_1041 r0 *1 0,0
Xsg13cmos5l_decap_8_1041 VPWR VGND sg13cmos5l_decap_8
* cell instance sg13cmos5l_decap_8_1042 r0 *1 0,0
Xsg13cmos5l_decap_8_1042 VPWR VGND sg13cmos5l_decap_8
* cell instance sg13cmos5l_decap_8_1043 r0 *1 0,0
Xsg13cmos5l_decap_8_1043 VPWR VGND sg13cmos5l_decap_8
* cell instance sg13cmos5l_decap_8_1044 r0 *1 0,0
Xsg13cmos5l_decap_8_1044 VPWR VGND sg13cmos5l_decap_8
* cell instance sg13cmos5l_decap_8_1045 r0 *1 0,0
Xsg13cmos5l_decap_8_1045 VPWR VGND sg13cmos5l_decap_8
* cell instance sg13cmos5l_decap_8_1046 r0 *1 0,0
Xsg13cmos5l_decap_8_1046 VPWR VGND sg13cmos5l_decap_8
* cell instance sg13cmos5l_decap_8_1047 r0 *1 0,0
Xsg13cmos5l_decap_8_1047 VPWR VGND sg13cmos5l_decap_8
* cell instance sg13cmos5l_decap_8_1048 r0 *1 0,0
Xsg13cmos5l_decap_8_1048 VPWR VGND sg13cmos5l_decap_8
* cell instance sg13cmos5l_decap_8_1049 r0 *1 0,0
Xsg13cmos5l_decap_8_1049 VPWR VGND sg13cmos5l_decap_8
* cell instance sg13cmos5l_decap_8_1050 r0 *1 0,0
Xsg13cmos5l_decap_8_1050 VPWR VGND sg13cmos5l_decap_8
* cell instance sg13cmos5l_decap_8_1051 r0 *1 0,0
Xsg13cmos5l_decap_8_1051 VPWR VGND sg13cmos5l_decap_8
* cell instance sg13cmos5l_decap_8_1052 r0 *1 0,0
Xsg13cmos5l_decap_8_1052 VPWR VGND sg13cmos5l_decap_8
* cell instance sg13cmos5l_decap_8_1053 r0 *1 0,0
Xsg13cmos5l_decap_8_1053 VPWR VGND sg13cmos5l_decap_8
* cell instance sg13cmos5l_decap_8_1054 r0 *1 0,0
Xsg13cmos5l_decap_8_1054 VPWR VGND sg13cmos5l_decap_8
* cell instance sg13cmos5l_decap_8_1055 r0 *1 0,0
Xsg13cmos5l_decap_8_1055 VPWR VGND sg13cmos5l_decap_8
* cell instance sg13cmos5l_decap_8_1056 r0 *1 0,0
Xsg13cmos5l_decap_8_1056 VPWR VGND sg13cmos5l_decap_8
* cell instance sg13cmos5l_decap_8_1057 r0 *1 0,0
Xsg13cmos5l_decap_8_1057 VPWR VGND sg13cmos5l_decap_8
* cell instance sg13cmos5l_decap_8_1058 r0 *1 0,0
Xsg13cmos5l_decap_8_1058 VPWR VGND sg13cmos5l_decap_8
* cell instance sg13cmos5l_decap_8_1059 r0 *1 0,0
Xsg13cmos5l_decap_8_1059 VPWR VGND sg13cmos5l_decap_8
* cell instance sg13cmos5l_decap_8_1060 r0 *1 0,0
Xsg13cmos5l_decap_8_1060 VPWR VGND sg13cmos5l_decap_8
* cell instance sg13cmos5l_decap_8_1061 r0 *1 0,0
Xsg13cmos5l_decap_8_1061 VPWR VGND sg13cmos5l_decap_8
* cell instance sg13cmos5l_decap_8_1062 r0 *1 0,0
Xsg13cmos5l_decap_8_1062 VPWR VGND sg13cmos5l_decap_8
* cell instance sg13cmos5l_decap_8_1063 r0 *1 0,0
Xsg13cmos5l_decap_8_1063 VPWR VGND sg13cmos5l_decap_8
* cell instance sg13cmos5l_decap_8_1064 r0 *1 0,0
Xsg13cmos5l_decap_8_1064 VPWR VGND sg13cmos5l_decap_8
* cell instance sg13cmos5l_decap_8_1065 r0 *1 0,0
Xsg13cmos5l_decap_8_1065 VPWR VGND sg13cmos5l_decap_8
* cell instance sg13cmos5l_decap_8_1066 r0 *1 0,0
Xsg13cmos5l_decap_8_1066 VPWR VGND sg13cmos5l_decap_8
* cell instance sg13cmos5l_decap_8_1067 r0 *1 0,0
Xsg13cmos5l_decap_8_1067 VPWR VGND sg13cmos5l_decap_8
* cell instance sg13cmos5l_decap_8_1068 r0 *1 0,0
Xsg13cmos5l_decap_8_1068 VPWR VGND sg13cmos5l_decap_8
* cell instance sg13cmos5l_decap_8_1069 r0 *1 0,0
Xsg13cmos5l_decap_8_1069 VPWR VGND sg13cmos5l_decap_8
* cell instance sg13cmos5l_decap_8_1070 r0 *1 0,0
Xsg13cmos5l_decap_8_1070 VPWR VGND sg13cmos5l_decap_8
* cell instance sg13cmos5l_decap_8_1071 r0 *1 0,0
Xsg13cmos5l_decap_8_1071 VPWR VGND sg13cmos5l_decap_8
* cell instance sg13cmos5l_decap_8_1072 r0 *1 0,0
Xsg13cmos5l_decap_8_1072 VPWR VGND sg13cmos5l_decap_8
* cell instance sg13cmos5l_decap_8_1073 r0 *1 0,0
Xsg13cmos5l_decap_8_1073 VPWR VGND sg13cmos5l_decap_8
* cell instance sg13cmos5l_decap_8_1074 r0 *1 0,0
Xsg13cmos5l_decap_8_1074 VPWR VGND sg13cmos5l_decap_8
* cell instance sg13cmos5l_decap_8_1075 r0 *1 0,0
Xsg13cmos5l_decap_8_1075 VPWR VGND sg13cmos5l_decap_8
* cell instance sg13cmos5l_decap_8_1076 r0 *1 0,0
Xsg13cmos5l_decap_8_1076 VPWR VGND sg13cmos5l_decap_8
* cell instance sg13cmos5l_decap_8_1077 r0 *1 0,0
Xsg13cmos5l_decap_8_1077 VPWR VGND sg13cmos5l_decap_8
* cell instance sg13cmos5l_decap_8_1078 r0 *1 0,0
Xsg13cmos5l_decap_8_1078 VPWR VGND sg13cmos5l_decap_8
* cell instance sg13cmos5l_decap_8_1079 r0 *1 0,0
Xsg13cmos5l_decap_8_1079 VPWR VGND sg13cmos5l_decap_8
* cell instance sg13cmos5l_decap_8_1080 r0 *1 0,0
Xsg13cmos5l_decap_8_1080 VPWR VGND sg13cmos5l_decap_8
* cell instance sg13cmos5l_decap_8_1081 r0 *1 0,0
Xsg13cmos5l_decap_8_1081 VPWR VGND sg13cmos5l_decap_8
* cell instance sg13cmos5l_decap_8_1082 r0 *1 0,0
Xsg13cmos5l_decap_8_1082 VPWR VGND sg13cmos5l_decap_8
* cell instance sg13cmos5l_decap_8_1083 r0 *1 0,0
Xsg13cmos5l_decap_8_1083 VPWR VGND sg13cmos5l_decap_8
* cell instance sg13cmos5l_decap_8_1084 r0 *1 0,0
Xsg13cmos5l_decap_8_1084 VPWR VGND sg13cmos5l_decap_8
* cell instance sg13cmos5l_decap_8_1085 r0 *1 0,0
Xsg13cmos5l_decap_8_1085 VPWR VGND sg13cmos5l_decap_8
* cell instance sg13cmos5l_decap_8_1086 r0 *1 0,0
Xsg13cmos5l_decap_8_1086 VPWR VGND sg13cmos5l_decap_8
* cell instance sg13cmos5l_decap_8_1087 r0 *1 0,0
Xsg13cmos5l_decap_8_1087 VPWR VGND sg13cmos5l_decap_8
* cell instance sg13cmos5l_decap_8_1088 r0 *1 0,0
Xsg13cmos5l_decap_8_1088 VPWR VGND sg13cmos5l_decap_8
* cell instance sg13cmos5l_decap_8_1089 r0 *1 0,0
Xsg13cmos5l_decap_8_1089 VPWR VGND sg13cmos5l_decap_8
* cell instance sg13cmos5l_decap_8_1090 r0 *1 0,0
Xsg13cmos5l_decap_8_1090 VPWR VGND sg13cmos5l_decap_8
* cell instance sg13cmos5l_decap_8_1091 r0 *1 0,0
Xsg13cmos5l_decap_8_1091 VPWR VGND sg13cmos5l_decap_8
* cell instance sg13cmos5l_decap_8_1092 r0 *1 0,0
Xsg13cmos5l_decap_8_1092 VPWR VGND sg13cmos5l_decap_8
* cell instance sg13cmos5l_decap_8_1093 r0 *1 0,0
Xsg13cmos5l_decap_8_1093 VPWR VGND sg13cmos5l_decap_8
* cell instance sg13cmos5l_decap_8_1094 r0 *1 0,0
Xsg13cmos5l_decap_8_1094 VPWR VGND sg13cmos5l_decap_8
* cell instance sg13cmos5l_decap_8_1095 r0 *1 0,0
Xsg13cmos5l_decap_8_1095 VPWR VGND sg13cmos5l_decap_8
* cell instance sg13cmos5l_decap_8_1096 r0 *1 0,0
Xsg13cmos5l_decap_8_1096 VPWR VGND sg13cmos5l_decap_8
* cell instance sg13cmos5l_decap_8_1097 r0 *1 0,0
Xsg13cmos5l_decap_8_1097 VPWR VGND sg13cmos5l_decap_8
* cell instance sg13cmos5l_decap_8_1098 r0 *1 0,0
Xsg13cmos5l_decap_8_1098 VPWR VGND sg13cmos5l_decap_8
* cell instance sg13cmos5l_decap_8_1099 r0 *1 0,0
Xsg13cmos5l_decap_8_1099 VPWR VGND sg13cmos5l_decap_8
* cell instance sg13cmos5l_decap_8_1100 r0 *1 0,0
Xsg13cmos5l_decap_8_1100 VPWR VGND sg13cmos5l_decap_8
* cell instance sg13cmos5l_decap_8_1101 r0 *1 0,0
Xsg13cmos5l_decap_8_1101 VPWR VGND sg13cmos5l_decap_8
* cell instance sg13cmos5l_decap_8_1102 r0 *1 0,0
Xsg13cmos5l_decap_8_1102 VPWR VGND sg13cmos5l_decap_8
* cell instance sg13cmos5l_decap_8_1103 r0 *1 0,0
Xsg13cmos5l_decap_8_1103 VPWR VGND sg13cmos5l_decap_8
* cell instance sg13cmos5l_decap_8_1104 r0 *1 0,0
Xsg13cmos5l_decap_8_1104 VPWR VGND sg13cmos5l_decap_8
* cell instance sg13cmos5l_decap_8_1105 r0 *1 0,0
Xsg13cmos5l_decap_8_1105 VPWR VGND sg13cmos5l_decap_8
* cell instance sg13cmos5l_decap_8_1106 r0 *1 0,0
Xsg13cmos5l_decap_8_1106 VPWR VGND sg13cmos5l_decap_8
* cell instance sg13cmos5l_decap_8_1107 r0 *1 0,0
Xsg13cmos5l_decap_8_1107 VPWR VGND sg13cmos5l_decap_8
* cell instance sg13cmos5l_decap_8_1108 r0 *1 0,0
Xsg13cmos5l_decap_8_1108 VPWR VGND sg13cmos5l_decap_8
* cell instance sg13cmos5l_decap_8_1109 r0 *1 0,0
Xsg13cmos5l_decap_8_1109 VPWR VGND sg13cmos5l_decap_8
* cell instance sg13cmos5l_decap_8_1110 r0 *1 0,0
Xsg13cmos5l_decap_8_1110 VPWR VGND sg13cmos5l_decap_8
* cell instance sg13cmos5l_decap_8_1111 r0 *1 0,0
Xsg13cmos5l_decap_8_1111 VPWR VGND sg13cmos5l_decap_8
* cell instance sg13cmos5l_decap_8_1112 r0 *1 0,0
Xsg13cmos5l_decap_8_1112 VPWR VGND sg13cmos5l_decap_8
* cell instance sg13cmos5l_decap_8_1113 r0 *1 0,0
Xsg13cmos5l_decap_8_1113 VPWR VGND sg13cmos5l_decap_8
* cell instance sg13cmos5l_decap_8_1114 r0 *1 0,0
Xsg13cmos5l_decap_8_1114 VPWR VGND sg13cmos5l_decap_8
* cell instance sg13cmos5l_decap_8_1115 r0 *1 0,0
Xsg13cmos5l_decap_8_1115 VPWR VGND sg13cmos5l_decap_8
* cell instance sg13cmos5l_decap_8_1116 r0 *1 0,0
Xsg13cmos5l_decap_8_1116 VPWR VGND sg13cmos5l_decap_8
* cell instance sg13cmos5l_decap_8_1117 r0 *1 0,0
Xsg13cmos5l_decap_8_1117 VPWR VGND sg13cmos5l_decap_8
* cell instance sg13cmos5l_decap_8_1118 r0 *1 0,0
Xsg13cmos5l_decap_8_1118 VPWR VGND sg13cmos5l_decap_8
* cell instance sg13cmos5l_decap_8_1119 r0 *1 0,0
Xsg13cmos5l_decap_8_1119 VPWR VGND sg13cmos5l_decap_8
* cell instance sg13cmos5l_decap_8_1120 r0 *1 0,0
Xsg13cmos5l_decap_8_1120 VPWR VGND sg13cmos5l_decap_8
* cell instance sg13cmos5l_decap_8_1121 r0 *1 0,0
Xsg13cmos5l_decap_8_1121 VPWR VGND sg13cmos5l_decap_8
* cell instance sg13cmos5l_decap_8_1122 r0 *1 0,0
Xsg13cmos5l_decap_8_1122 VPWR VGND sg13cmos5l_decap_8
* cell instance sg13cmos5l_decap_8_1123 r0 *1 0,0
Xsg13cmos5l_decap_8_1123 VPWR VGND sg13cmos5l_decap_8
* cell instance sg13cmos5l_decap_8_1124 r0 *1 0,0
Xsg13cmos5l_decap_8_1124 VPWR VGND sg13cmos5l_decap_8
* cell instance sg13cmos5l_decap_8_1125 r0 *1 0,0
Xsg13cmos5l_decap_8_1125 VPWR VGND sg13cmos5l_decap_8
* cell instance sg13cmos5l_decap_8_1126 r0 *1 0,0
Xsg13cmos5l_decap_8_1126 VPWR VGND sg13cmos5l_decap_8
* cell instance sg13cmos5l_decap_8_1127 r0 *1 0,0
Xsg13cmos5l_decap_8_1127 VPWR VGND sg13cmos5l_decap_8
* cell instance sg13cmos5l_decap_8_1128 r0 *1 0,0
Xsg13cmos5l_decap_8_1128 VPWR VGND sg13cmos5l_decap_8
* cell instance sg13cmos5l_decap_8_1129 r0 *1 0,0
Xsg13cmos5l_decap_8_1129 VPWR VGND sg13cmos5l_decap_8
* cell instance sg13cmos5l_decap_8_1130 r0 *1 0,0
Xsg13cmos5l_decap_8_1130 VPWR VGND sg13cmos5l_decap_8
* cell instance sg13cmos5l_decap_8_1131 r0 *1 0,0
Xsg13cmos5l_decap_8_1131 VPWR VGND sg13cmos5l_decap_8
* cell instance sg13cmos5l_decap_8_1132 r0 *1 0,0
Xsg13cmos5l_decap_8_1132 VPWR VGND sg13cmos5l_decap_8
* cell instance sg13cmos5l_decap_8_1133 r0 *1 0,0
Xsg13cmos5l_decap_8_1133 VPWR VGND sg13cmos5l_decap_8
* cell instance sg13cmos5l_decap_8_1134 r0 *1 0,0
Xsg13cmos5l_decap_8_1134 VPWR VGND sg13cmos5l_decap_8
* cell instance sg13cmos5l_decap_8_1135 r0 *1 0,0
Xsg13cmos5l_decap_8_1135 VPWR VGND sg13cmos5l_decap_8
* cell instance sg13cmos5l_decap_8_1136 r0 *1 0,0
Xsg13cmos5l_decap_8_1136 VPWR VGND sg13cmos5l_decap_8
* cell instance sg13cmos5l_decap_8_1137 r0 *1 0,0
Xsg13cmos5l_decap_8_1137 VPWR VGND sg13cmos5l_decap_8
* cell instance sg13cmos5l_decap_8_1138 r0 *1 0,0
Xsg13cmos5l_decap_8_1138 VPWR VGND sg13cmos5l_decap_8
* cell instance sg13cmos5l_decap_8_1139 r0 *1 0,0
Xsg13cmos5l_decap_8_1139 VPWR VGND sg13cmos5l_decap_8
* cell instance sg13cmos5l_decap_8_1140 r0 *1 0,0
Xsg13cmos5l_decap_8_1140 VPWR VGND sg13cmos5l_decap_8
* cell instance sg13cmos5l_decap_8_1141 r0 *1 0,0
Xsg13cmos5l_decap_8_1141 VPWR VGND sg13cmos5l_decap_8
* cell instance sg13cmos5l_decap_8_1142 r0 *1 0,0
Xsg13cmos5l_decap_8_1142 VPWR VGND sg13cmos5l_decap_8
* cell instance sg13cmos5l_decap_8_1143 r0 *1 0,0
Xsg13cmos5l_decap_8_1143 VPWR VGND sg13cmos5l_decap_8
* cell instance sg13cmos5l_decap_8_1144 r0 *1 0,0
Xsg13cmos5l_decap_8_1144 VPWR VGND sg13cmos5l_decap_8
* cell instance sg13cmos5l_decap_8_1145 r0 *1 0,0
Xsg13cmos5l_decap_8_1145 VPWR VGND sg13cmos5l_decap_8
* cell instance sg13cmos5l_decap_8_1146 r0 *1 0,0
Xsg13cmos5l_decap_8_1146 VPWR VGND sg13cmos5l_decap_8
* cell instance sg13cmos5l_decap_8_1147 r0 *1 0,0
Xsg13cmos5l_decap_8_1147 VPWR VGND sg13cmos5l_decap_8
* cell instance sg13cmos5l_decap_8_1148 r0 *1 0,0
Xsg13cmos5l_decap_8_1148 VPWR VGND sg13cmos5l_decap_8
* cell instance sg13cmos5l_decap_8_1149 r0 *1 0,0
Xsg13cmos5l_decap_8_1149 VPWR VGND sg13cmos5l_decap_8
* cell instance sg13cmos5l_decap_8_1150 r0 *1 0,0
Xsg13cmos5l_decap_8_1150 VPWR VGND sg13cmos5l_decap_8
* cell instance sg13cmos5l_decap_8_1151 r0 *1 0,0
Xsg13cmos5l_decap_8_1151 VPWR VGND sg13cmos5l_decap_8
* cell instance sg13cmos5l_decap_8_1152 r0 *1 0,0
Xsg13cmos5l_decap_8_1152 VPWR VGND sg13cmos5l_decap_8
* cell instance sg13cmos5l_decap_8_1153 r0 *1 0,0
Xsg13cmos5l_decap_8_1153 VPWR VGND sg13cmos5l_decap_8
* cell instance sg13cmos5l_decap_8_1154 r0 *1 0,0
Xsg13cmos5l_decap_8_1154 VPWR VGND sg13cmos5l_decap_8
* cell instance sg13cmos5l_decap_8_1155 r0 *1 0,0
Xsg13cmos5l_decap_8_1155 VPWR VGND sg13cmos5l_decap_8
* cell instance sg13cmos5l_decap_8_1156 r0 *1 0,0
Xsg13cmos5l_decap_8_1156 VPWR VGND sg13cmos5l_decap_8
* cell instance sg13cmos5l_decap_8_1157 r0 *1 0,0
Xsg13cmos5l_decap_8_1157 VPWR VGND sg13cmos5l_decap_8
* cell instance sg13cmos5l_decap_8_1158 r0 *1 0,0
Xsg13cmos5l_decap_8_1158 VPWR VGND sg13cmos5l_decap_8
* cell instance sg13cmos5l_decap_8_1159 r0 *1 0,0
Xsg13cmos5l_decap_8_1159 VPWR VGND sg13cmos5l_decap_8
* cell instance sg13cmos5l_decap_8_1160 r0 *1 0,0
Xsg13cmos5l_decap_8_1160 VPWR VGND sg13cmos5l_decap_8
* cell instance sg13cmos5l_decap_8_1161 r0 *1 0,0
Xsg13cmos5l_decap_8_1161 VPWR VGND sg13cmos5l_decap_8
* cell instance sg13cmos5l_decap_8_1162 r0 *1 0,0
Xsg13cmos5l_decap_8_1162 VPWR VGND sg13cmos5l_decap_8
* cell instance sg13cmos5l_decap_8_1163 r0 *1 0,0
Xsg13cmos5l_decap_8_1163 VPWR VGND sg13cmos5l_decap_8
* cell instance sg13cmos5l_decap_8_1164 r0 *1 0,0
Xsg13cmos5l_decap_8_1164 VPWR VGND sg13cmos5l_decap_8
* cell instance sg13cmos5l_decap_8_1165 r0 *1 0,0
Xsg13cmos5l_decap_8_1165 VPWR VGND sg13cmos5l_decap_8
* cell instance sg13cmos5l_decap_8_1166 r0 *1 0,0
Xsg13cmos5l_decap_8_1166 VPWR VGND sg13cmos5l_decap_8
* cell instance sg13cmos5l_decap_8_1167 r0 *1 0,0
Xsg13cmos5l_decap_8_1167 VPWR VGND sg13cmos5l_decap_8
* cell instance sg13cmos5l_decap_8_1168 r0 *1 0,0
Xsg13cmos5l_decap_8_1168 VPWR VGND sg13cmos5l_decap_8
* cell instance sg13cmos5l_decap_8_1169 r0 *1 0,0
Xsg13cmos5l_decap_8_1169 VPWR VGND sg13cmos5l_decap_8
* cell instance sg13cmos5l_decap_8_1170 r0 *1 0,0
Xsg13cmos5l_decap_8_1170 VPWR VGND sg13cmos5l_decap_8
* cell instance sg13cmos5l_decap_8_1171 r0 *1 0,0
Xsg13cmos5l_decap_8_1171 VPWR VGND sg13cmos5l_decap_8
* cell instance sg13cmos5l_decap_8_1172 r0 *1 0,0
Xsg13cmos5l_decap_8_1172 VPWR VGND sg13cmos5l_decap_8
* cell instance sg13cmos5l_decap_8_1173 r0 *1 0,0
Xsg13cmos5l_decap_8_1173 VPWR VGND sg13cmos5l_decap_8
* cell instance sg13cmos5l_decap_8_1174 r0 *1 0,0
Xsg13cmos5l_decap_8_1174 VPWR VGND sg13cmos5l_decap_8
* cell instance sg13cmos5l_decap_8_1175 r0 *1 0,0
Xsg13cmos5l_decap_8_1175 VPWR VGND sg13cmos5l_decap_8
* cell instance sg13cmos5l_decap_8_1176 r0 *1 0,0
Xsg13cmos5l_decap_8_1176 VPWR VGND sg13cmos5l_decap_8
* cell instance sg13cmos5l_decap_8_1177 r0 *1 0,0
Xsg13cmos5l_decap_8_1177 VPWR VGND sg13cmos5l_decap_8
* cell instance sg13cmos5l_decap_8_1178 r0 *1 0,0
Xsg13cmos5l_decap_8_1178 VPWR VGND sg13cmos5l_decap_8
* cell instance sg13cmos5l_decap_8_1179 r0 *1 0,0
Xsg13cmos5l_decap_8_1179 VPWR VGND sg13cmos5l_decap_8
* cell instance sg13cmos5l_decap_8_1180 r0 *1 0,0
Xsg13cmos5l_decap_8_1180 VPWR VGND sg13cmos5l_decap_8
* cell instance sg13cmos5l_decap_8_1181 r0 *1 0,0
Xsg13cmos5l_decap_8_1181 VPWR VGND sg13cmos5l_decap_8
* cell instance sg13cmos5l_decap_8_1182 r0 *1 0,0
Xsg13cmos5l_decap_8_1182 VPWR VGND sg13cmos5l_decap_8
* cell instance sg13cmos5l_decap_8_1183 r0 *1 0,0
Xsg13cmos5l_decap_8_1183 VPWR VGND sg13cmos5l_decap_8
* cell instance sg13cmos5l_decap_8_1184 r0 *1 0,0
Xsg13cmos5l_decap_8_1184 VPWR VGND sg13cmos5l_decap_8
* cell instance sg13cmos5l_decap_8_1185 r0 *1 0,0
Xsg13cmos5l_decap_8_1185 VPWR VGND sg13cmos5l_decap_8
* cell instance sg13cmos5l_decap_8_1186 r0 *1 0,0
Xsg13cmos5l_decap_8_1186 VPWR VGND sg13cmos5l_decap_8
* cell instance sg13cmos5l_decap_8_1187 r0 *1 0,0
Xsg13cmos5l_decap_8_1187 VPWR VGND sg13cmos5l_decap_8
* cell instance sg13cmos5l_decap_8_1188 r0 *1 0,0
Xsg13cmos5l_decap_8_1188 VPWR VGND sg13cmos5l_decap_8
* cell instance sg13cmos5l_decap_8_1189 r0 *1 0,0
Xsg13cmos5l_decap_8_1189 VPWR VGND sg13cmos5l_decap_8
* cell instance sg13cmos5l_decap_8_1190 r0 *1 0,0
Xsg13cmos5l_decap_8_1190 VPWR VGND sg13cmos5l_decap_8
* cell instance sg13cmos5l_decap_8_1191 r0 *1 0,0
Xsg13cmos5l_decap_8_1191 VPWR VGND sg13cmos5l_decap_8
* cell instance sg13cmos5l_decap_8_1192 r0 *1 0,0
Xsg13cmos5l_decap_8_1192 VPWR VGND sg13cmos5l_decap_8
* cell instance sg13cmos5l_decap_8_1193 r0 *1 0,0
Xsg13cmos5l_decap_8_1193 VPWR VGND sg13cmos5l_decap_8
* cell instance sg13cmos5l_decap_8_1194 r0 *1 0,0
Xsg13cmos5l_decap_8_1194 VPWR VGND sg13cmos5l_decap_8
* cell instance sg13cmos5l_decap_8_1195 r0 *1 0,0
Xsg13cmos5l_decap_8_1195 VPWR VGND sg13cmos5l_decap_8
* cell instance sg13cmos5l_decap_8_1196 r0 *1 0,0
Xsg13cmos5l_decap_8_1196 VPWR VGND sg13cmos5l_decap_8
* cell instance sg13cmos5l_decap_8_1197 r0 *1 0,0
Xsg13cmos5l_decap_8_1197 VPWR VGND sg13cmos5l_decap_8
* cell instance sg13cmos5l_decap_8_1198 r0 *1 0,0
Xsg13cmos5l_decap_8_1198 VPWR VGND sg13cmos5l_decap_8
* cell instance sg13cmos5l_decap_8_1199 r0 *1 0,0
Xsg13cmos5l_decap_8_1199 VPWR VGND sg13cmos5l_decap_8
* cell instance sg13cmos5l_decap_8_1200 r0 *1 0,0
Xsg13cmos5l_decap_8_1200 VPWR VGND sg13cmos5l_decap_8
* cell instance sg13cmos5l_decap_8_1201 r0 *1 0,0
Xsg13cmos5l_decap_8_1201 VPWR VGND sg13cmos5l_decap_8
* cell instance sg13cmos5l_decap_8_1202 r0 *1 0,0
Xsg13cmos5l_decap_8_1202 VPWR VGND sg13cmos5l_decap_8
* cell instance sg13cmos5l_decap_8_1203 r0 *1 0,0
Xsg13cmos5l_decap_8_1203 VPWR VGND sg13cmos5l_decap_8
* cell instance sg13cmos5l_decap_8_1204 r0 *1 0,0
Xsg13cmos5l_decap_8_1204 VPWR VGND sg13cmos5l_decap_8
* cell instance sg13cmos5l_decap_8_1205 r0 *1 0,0
Xsg13cmos5l_decap_8_1205 VPWR VGND sg13cmos5l_decap_8
* cell instance sg13cmos5l_decap_8_1206 r0 *1 0,0
Xsg13cmos5l_decap_8_1206 VPWR VGND sg13cmos5l_decap_8
* cell instance sg13cmos5l_decap_8_1207 r0 *1 0,0
Xsg13cmos5l_decap_8_1207 VPWR VGND sg13cmos5l_decap_8
* cell instance sg13cmos5l_decap_8_1208 r0 *1 0,0
Xsg13cmos5l_decap_8_1208 VPWR VGND sg13cmos5l_decap_8
* cell instance sg13cmos5l_decap_8_1209 r0 *1 0,0
Xsg13cmos5l_decap_8_1209 VPWR VGND sg13cmos5l_decap_8
* cell instance sg13cmos5l_decap_8_1210 r0 *1 0,0
Xsg13cmos5l_decap_8_1210 VPWR VGND sg13cmos5l_decap_8
* cell instance sg13cmos5l_decap_8_1211 r0 *1 0,0
Xsg13cmos5l_decap_8_1211 VPWR VGND sg13cmos5l_decap_8
* cell instance sg13cmos5l_decap_8_1212 r0 *1 0,0
Xsg13cmos5l_decap_8_1212 VPWR VGND sg13cmos5l_decap_8
* cell instance sg13cmos5l_decap_8_1213 r0 *1 0,0
Xsg13cmos5l_decap_8_1213 VPWR VGND sg13cmos5l_decap_8
* cell instance sg13cmos5l_decap_8_1214 r0 *1 0,0
Xsg13cmos5l_decap_8_1214 VPWR VGND sg13cmos5l_decap_8
* cell instance sg13cmos5l_decap_8_1215 r0 *1 0,0
Xsg13cmos5l_decap_8_1215 VPWR VGND sg13cmos5l_decap_8
* cell instance sg13cmos5l_decap_8_1216 r0 *1 0,0
Xsg13cmos5l_decap_8_1216 VPWR VGND sg13cmos5l_decap_8
* cell instance sg13cmos5l_decap_8_1217 r0 *1 0,0
Xsg13cmos5l_decap_8_1217 VPWR VGND sg13cmos5l_decap_8
* cell instance sg13cmos5l_decap_8_1218 r0 *1 0,0
Xsg13cmos5l_decap_8_1218 VPWR VGND sg13cmos5l_decap_8
* cell instance sg13cmos5l_decap_8_1219 r0 *1 0,0
Xsg13cmos5l_decap_8_1219 VPWR VGND sg13cmos5l_decap_8
* cell instance sg13cmos5l_decap_8_1220 r0 *1 0,0
Xsg13cmos5l_decap_8_1220 VPWR VGND sg13cmos5l_decap_8
* cell instance sg13cmos5l_decap_8_1221 r0 *1 0,0
Xsg13cmos5l_decap_8_1221 VPWR VGND sg13cmos5l_decap_8
* cell instance sg13cmos5l_decap_8_1222 r0 *1 0,0
Xsg13cmos5l_decap_8_1222 VPWR VGND sg13cmos5l_decap_8
* cell instance sg13cmos5l_decap_8_1223 r0 *1 0,0
Xsg13cmos5l_decap_8_1223 VPWR VGND sg13cmos5l_decap_8
* cell instance sg13cmos5l_decap_8_1224 r0 *1 0,0
Xsg13cmos5l_decap_8_1224 VPWR VGND sg13cmos5l_decap_8
* cell instance sg13cmos5l_decap_8_1225 r0 *1 0,0
Xsg13cmos5l_decap_8_1225 VPWR VGND sg13cmos5l_decap_8
* cell instance sg13cmos5l_decap_8_1226 r0 *1 0,0
Xsg13cmos5l_decap_8_1226 VPWR VGND sg13cmos5l_decap_8
* cell instance sg13cmos5l_decap_8_1227 r0 *1 0,0
Xsg13cmos5l_decap_8_1227 VPWR VGND sg13cmos5l_decap_8
* cell instance sg13cmos5l_decap_8_1228 r0 *1 0,0
Xsg13cmos5l_decap_8_1228 VPWR VGND sg13cmos5l_decap_8
* cell instance sg13cmos5l_decap_8_1229 r0 *1 0,0
Xsg13cmos5l_decap_8_1229 VPWR VGND sg13cmos5l_decap_8
* cell instance sg13cmos5l_decap_8_1230 r0 *1 0,0
Xsg13cmos5l_decap_8_1230 VPWR VGND sg13cmos5l_decap_8
* cell instance sg13cmos5l_decap_8_1231 r0 *1 0,0
Xsg13cmos5l_decap_8_1231 VPWR VGND sg13cmos5l_decap_8
* cell instance sg13cmos5l_decap_8_1232 r0 *1 0,0
Xsg13cmos5l_decap_8_1232 VPWR VGND sg13cmos5l_decap_8
* cell instance sg13cmos5l_decap_8_1233 r0 *1 0,0
Xsg13cmos5l_decap_8_1233 VPWR VGND sg13cmos5l_decap_8
* cell instance sg13cmos5l_decap_8_1234 r0 *1 0,0
Xsg13cmos5l_decap_8_1234 VPWR VGND sg13cmos5l_decap_8
* cell instance sg13cmos5l_decap_8_1235 r0 *1 0,0
Xsg13cmos5l_decap_8_1235 VPWR VGND sg13cmos5l_decap_8
* cell instance sg13cmos5l_decap_8_1236 r0 *1 0,0
Xsg13cmos5l_decap_8_1236 VPWR VGND sg13cmos5l_decap_8
* cell instance sg13cmos5l_decap_8_1237 r0 *1 0,0
Xsg13cmos5l_decap_8_1237 VPWR VGND sg13cmos5l_decap_8
* cell instance sg13cmos5l_decap_8_1238 r0 *1 0,0
Xsg13cmos5l_decap_8_1238 VPWR VGND sg13cmos5l_decap_8
* cell instance sg13cmos5l_decap_8_1239 r0 *1 0,0
Xsg13cmos5l_decap_8_1239 VPWR VGND sg13cmos5l_decap_8
* cell instance sg13cmos5l_decap_8_1240 r0 *1 0,0
Xsg13cmos5l_decap_8_1240 VPWR VGND sg13cmos5l_decap_8
* cell instance sg13cmos5l_decap_8_1241 r0 *1 0,0
Xsg13cmos5l_decap_8_1241 VPWR VGND sg13cmos5l_decap_8
* cell instance sg13cmos5l_decap_8_1242 r0 *1 0,0
Xsg13cmos5l_decap_8_1242 VPWR VGND sg13cmos5l_decap_8
* cell instance sg13cmos5l_decap_8_1243 r0 *1 0,0
Xsg13cmos5l_decap_8_1243 VPWR VGND sg13cmos5l_decap_8
* cell instance sg13cmos5l_decap_8_1244 r0 *1 0,0
Xsg13cmos5l_decap_8_1244 VPWR VGND sg13cmos5l_decap_8
* cell instance sg13cmos5l_decap_8_1245 r0 *1 0,0
Xsg13cmos5l_decap_8_1245 VPWR VGND sg13cmos5l_decap_8
* cell instance sg13cmos5l_decap_8_1246 r0 *1 0,0
Xsg13cmos5l_decap_8_1246 VPWR VGND sg13cmos5l_decap_8
* cell instance sg13cmos5l_decap_8_1247 r0 *1 0,0
Xsg13cmos5l_decap_8_1247 VPWR VGND sg13cmos5l_decap_8
* cell instance sg13cmos5l_decap_8_1248 r0 *1 0,0
Xsg13cmos5l_decap_8_1248 VPWR VGND sg13cmos5l_decap_8
* cell instance sg13cmos5l_decap_8_1249 r0 *1 0,0
Xsg13cmos5l_decap_8_1249 VPWR VGND sg13cmos5l_decap_8
* cell instance sg13cmos5l_decap_8_1250 r0 *1 0,0
Xsg13cmos5l_decap_8_1250 VPWR VGND sg13cmos5l_decap_8
* cell instance sg13cmos5l_decap_8_1251 r0 *1 0,0
Xsg13cmos5l_decap_8_1251 VPWR VGND sg13cmos5l_decap_8
* cell instance sg13cmos5l_decap_8_1252 r0 *1 0,0
Xsg13cmos5l_decap_8_1252 VPWR VGND sg13cmos5l_decap_8
* cell instance sg13cmos5l_decap_8_1253 r0 *1 0,0
Xsg13cmos5l_decap_8_1253 VPWR VGND sg13cmos5l_decap_8
* cell instance sg13cmos5l_decap_8_1254 r0 *1 0,0
Xsg13cmos5l_decap_8_1254 VPWR VGND sg13cmos5l_decap_8
* cell instance sg13cmos5l_decap_8_1255 r0 *1 0,0
Xsg13cmos5l_decap_8_1255 VPWR VGND sg13cmos5l_decap_8
* cell instance sg13cmos5l_decap_8_1256 r0 *1 0,0
Xsg13cmos5l_decap_8_1256 VPWR VGND sg13cmos5l_decap_8
* cell instance sg13cmos5l_decap_8_1257 r0 *1 0,0
Xsg13cmos5l_decap_8_1257 VPWR VGND sg13cmos5l_decap_8
* cell instance sg13cmos5l_decap_8_1258 r0 *1 0,0
Xsg13cmos5l_decap_8_1258 VPWR VGND sg13cmos5l_decap_8
* cell instance sg13cmos5l_decap_8_1259 r0 *1 0,0
Xsg13cmos5l_decap_8_1259 VPWR VGND sg13cmos5l_decap_8
* cell instance sg13cmos5l_decap_8_1260 r0 *1 0,0
Xsg13cmos5l_decap_8_1260 VPWR VGND sg13cmos5l_decap_8
* cell instance sg13cmos5l_decap_8_1261 r0 *1 0,0
Xsg13cmos5l_decap_8_1261 VPWR VGND sg13cmos5l_decap_8
* cell instance sg13cmos5l_decap_8_1262 r0 *1 0,0
Xsg13cmos5l_decap_8_1262 VPWR VGND sg13cmos5l_decap_8
* cell instance sg13cmos5l_decap_8_1263 r0 *1 0,0
Xsg13cmos5l_decap_8_1263 VPWR VGND sg13cmos5l_decap_8
* cell instance sg13cmos5l_decap_8_1264 r0 *1 0,0
Xsg13cmos5l_decap_8_1264 VPWR VGND sg13cmos5l_decap_8
* cell instance sg13cmos5l_decap_8_1265 r0 *1 0,0
Xsg13cmos5l_decap_8_1265 VPWR VGND sg13cmos5l_decap_8
* cell instance sg13cmos5l_decap_8_1266 r0 *1 0,0
Xsg13cmos5l_decap_8_1266 VPWR VGND sg13cmos5l_decap_8
* cell instance sg13cmos5l_decap_8_1267 r0 *1 0,0
Xsg13cmos5l_decap_8_1267 VPWR VGND sg13cmos5l_decap_8
* cell instance sg13cmos5l_decap_8_1268 r0 *1 0,0
Xsg13cmos5l_decap_8_1268 VPWR VGND sg13cmos5l_decap_8
* cell instance sg13cmos5l_decap_8_1269 r0 *1 0,0
Xsg13cmos5l_decap_8_1269 VPWR VGND sg13cmos5l_decap_8
* cell instance sg13cmos5l_decap_8_1270 r0 *1 0,0
Xsg13cmos5l_decap_8_1270 VPWR VGND sg13cmos5l_decap_8
* cell instance sg13cmos5l_decap_8_1271 r0 *1 0,0
Xsg13cmos5l_decap_8_1271 VPWR VGND sg13cmos5l_decap_8
* cell instance sg13cmos5l_decap_8_1272 r0 *1 0,0
Xsg13cmos5l_decap_8_1272 VPWR VGND sg13cmos5l_decap_8
* cell instance sg13cmos5l_decap_8_1273 r0 *1 0,0
Xsg13cmos5l_decap_8_1273 VPWR VGND sg13cmos5l_decap_8
* cell instance sg13cmos5l_decap_8_1274 r0 *1 0,0
Xsg13cmos5l_decap_8_1274 VPWR VGND sg13cmos5l_decap_8
* cell instance sg13cmos5l_decap_8_1275 r0 *1 0,0
Xsg13cmos5l_decap_8_1275 VPWR VGND sg13cmos5l_decap_8
* cell instance sg13cmos5l_decap_8_1276 r0 *1 0,0
Xsg13cmos5l_decap_8_1276 VPWR VGND sg13cmos5l_decap_8
* cell instance sg13cmos5l_decap_8_1277 r0 *1 0,0
Xsg13cmos5l_decap_8_1277 VPWR VGND sg13cmos5l_decap_8
* cell instance sg13cmos5l_decap_8_1278 r0 *1 0,0
Xsg13cmos5l_decap_8_1278 VPWR VGND sg13cmos5l_decap_8
* cell instance sg13cmos5l_decap_8_1279 r0 *1 0,0
Xsg13cmos5l_decap_8_1279 VPWR VGND sg13cmos5l_decap_8
* cell instance sg13cmos5l_decap_8_1280 r0 *1 0,0
Xsg13cmos5l_decap_8_1280 VPWR VGND sg13cmos5l_decap_8
* cell instance sg13cmos5l_decap_8_1281 r0 *1 0,0
Xsg13cmos5l_decap_8_1281 VPWR VGND sg13cmos5l_decap_8
* cell instance sg13cmos5l_decap_8_1282 r0 *1 0,0
Xsg13cmos5l_decap_8_1282 VPWR VGND sg13cmos5l_decap_8
* cell instance sg13cmos5l_decap_8_1283 r0 *1 0,0
Xsg13cmos5l_decap_8_1283 VPWR VGND sg13cmos5l_decap_8
* cell instance sg13cmos5l_decap_8_1284 r0 *1 0,0
Xsg13cmos5l_decap_8_1284 VPWR VGND sg13cmos5l_decap_8
* cell instance sg13cmos5l_decap_8_1285 r0 *1 0,0
Xsg13cmos5l_decap_8_1285 VPWR VGND sg13cmos5l_decap_8
* cell instance sg13cmos5l_decap_8_1286 r0 *1 0,0
Xsg13cmos5l_decap_8_1286 VPWR VGND sg13cmos5l_decap_8
* cell instance sg13cmos5l_decap_8_1287 r0 *1 0,0
Xsg13cmos5l_decap_8_1287 VPWR VGND sg13cmos5l_decap_8
* cell instance sg13cmos5l_decap_8_1288 r0 *1 0,0
Xsg13cmos5l_decap_8_1288 VPWR VGND sg13cmos5l_decap_8
* cell instance sg13cmos5l_decap_8_1289 r0 *1 0,0
Xsg13cmos5l_decap_8_1289 VPWR VGND sg13cmos5l_decap_8
* cell instance sg13cmos5l_decap_8_1290 r0 *1 0,0
Xsg13cmos5l_decap_8_1290 VPWR VGND sg13cmos5l_decap_8
* cell instance sg13cmos5l_decap_8_1291 r0 *1 0,0
Xsg13cmos5l_decap_8_1291 VPWR VGND sg13cmos5l_decap_8
* cell instance sg13cmos5l_decap_8_1292 r0 *1 0,0
Xsg13cmos5l_decap_8_1292 VPWR VGND sg13cmos5l_decap_8
* cell instance sg13cmos5l_decap_8_1293 r0 *1 0,0
Xsg13cmos5l_decap_8_1293 VPWR VGND sg13cmos5l_decap_8
* cell instance sg13cmos5l_decap_8_1294 r0 *1 0,0
Xsg13cmos5l_decap_8_1294 VPWR VGND sg13cmos5l_decap_8
* cell instance sg13cmos5l_decap_8_1295 r0 *1 0,0
Xsg13cmos5l_decap_8_1295 VPWR VGND sg13cmos5l_decap_8
* cell instance sg13cmos5l_decap_8_1296 r0 *1 0,0
Xsg13cmos5l_decap_8_1296 VPWR VGND sg13cmos5l_decap_8
* cell instance sg13cmos5l_decap_8_1297 r0 *1 0,0
Xsg13cmos5l_decap_8_1297 VPWR VGND sg13cmos5l_decap_8
* cell instance sg13cmos5l_decap_8_1298 r0 *1 0,0
Xsg13cmos5l_decap_8_1298 VPWR VGND sg13cmos5l_decap_8
* cell instance sg13cmos5l_decap_8_1299 r0 *1 0,0
Xsg13cmos5l_decap_8_1299 VPWR VGND sg13cmos5l_decap_8
* cell instance sg13cmos5l_decap_8_1300 r0 *1 0,0
Xsg13cmos5l_decap_8_1300 VPWR VGND sg13cmos5l_decap_8
* cell instance sg13cmos5l_decap_8_1301 r0 *1 0,0
Xsg13cmos5l_decap_8_1301 VPWR VGND sg13cmos5l_decap_8
* cell instance sg13cmos5l_decap_8_1302 r0 *1 0,0
Xsg13cmos5l_decap_8_1302 VPWR VGND sg13cmos5l_decap_8
* cell instance sg13cmos5l_decap_8_1303 r0 *1 0,0
Xsg13cmos5l_decap_8_1303 VPWR VGND sg13cmos5l_decap_8
* cell instance sg13cmos5l_decap_8_1304 r0 *1 0,0
Xsg13cmos5l_decap_8_1304 VPWR VGND sg13cmos5l_decap_8
* cell instance sg13cmos5l_decap_8_1305 r0 *1 0,0
Xsg13cmos5l_decap_8_1305 VPWR VGND sg13cmos5l_decap_8
* cell instance sg13cmos5l_decap_8_1306 r0 *1 0,0
Xsg13cmos5l_decap_8_1306 VPWR VGND sg13cmos5l_decap_8
* cell instance sg13cmos5l_decap_8_1307 r0 *1 0,0
Xsg13cmos5l_decap_8_1307 VPWR VGND sg13cmos5l_decap_8
* cell instance sg13cmos5l_decap_8_1308 r0 *1 0,0
Xsg13cmos5l_decap_8_1308 VPWR VGND sg13cmos5l_decap_8
* cell instance sg13cmos5l_decap_8_1309 r0 *1 0,0
Xsg13cmos5l_decap_8_1309 VPWR VGND sg13cmos5l_decap_8
* cell instance sg13cmos5l_decap_8_1310 r0 *1 0,0
Xsg13cmos5l_decap_8_1310 VPWR VGND sg13cmos5l_decap_8
* cell instance sg13cmos5l_decap_8_1311 r0 *1 0,0
Xsg13cmos5l_decap_8_1311 VPWR VGND sg13cmos5l_decap_8
* cell instance sg13cmos5l_decap_8_1312 r0 *1 0,0
Xsg13cmos5l_decap_8_1312 VPWR VGND sg13cmos5l_decap_8
* cell instance sg13cmos5l_decap_8_1313 r0 *1 0,0
Xsg13cmos5l_decap_8_1313 VPWR VGND sg13cmos5l_decap_8
* cell instance sg13cmos5l_decap_8_1314 r0 *1 0,0
Xsg13cmos5l_decap_8_1314 VPWR VGND sg13cmos5l_decap_8
* cell instance sg13cmos5l_decap_8_1315 r0 *1 0,0
Xsg13cmos5l_decap_8_1315 VPWR VGND sg13cmos5l_decap_8
* cell instance sg13cmos5l_decap_8_1316 r0 *1 0,0
Xsg13cmos5l_decap_8_1316 VPWR VGND sg13cmos5l_decap_8
* cell instance sg13cmos5l_decap_8_1317 r0 *1 0,0
Xsg13cmos5l_decap_8_1317 VPWR VGND sg13cmos5l_decap_8
* cell instance sg13cmos5l_decap_8_1318 r0 *1 0,0
Xsg13cmos5l_decap_8_1318 VPWR VGND sg13cmos5l_decap_8
* cell instance sg13cmos5l_decap_8_1319 r0 *1 0,0
Xsg13cmos5l_decap_8_1319 VPWR VGND sg13cmos5l_decap_8
* cell instance sg13cmos5l_decap_8_1320 r0 *1 0,0
Xsg13cmos5l_decap_8_1320 VPWR VGND sg13cmos5l_decap_8
* cell instance sg13cmos5l_decap_8_1321 r0 *1 0,0
Xsg13cmos5l_decap_8_1321 VPWR VGND sg13cmos5l_decap_8
* cell instance sg13cmos5l_decap_8_1322 r0 *1 0,0
Xsg13cmos5l_decap_8_1322 VPWR VGND sg13cmos5l_decap_8
* cell instance sg13cmos5l_decap_8_1323 r0 *1 0,0
Xsg13cmos5l_decap_8_1323 VPWR VGND sg13cmos5l_decap_8
* cell instance sg13cmos5l_decap_8_1324 r0 *1 0,0
Xsg13cmos5l_decap_8_1324 VPWR VGND sg13cmos5l_decap_8
* cell instance sg13cmos5l_decap_8_1325 r0 *1 0,0
Xsg13cmos5l_decap_8_1325 VPWR VGND sg13cmos5l_decap_8
* cell instance sg13cmos5l_decap_8_1326 r0 *1 0,0
Xsg13cmos5l_decap_8_1326 VPWR VGND sg13cmos5l_decap_8
* cell instance sg13cmos5l_decap_8_1327 r0 *1 0,0
Xsg13cmos5l_decap_8_1327 VPWR VGND sg13cmos5l_decap_8
* cell instance sg13cmos5l_decap_8_1328 r0 *1 0,0
Xsg13cmos5l_decap_8_1328 VPWR VGND sg13cmos5l_decap_8
* cell instance sg13cmos5l_decap_8_1329 r0 *1 0,0
Xsg13cmos5l_decap_8_1329 VPWR VGND sg13cmos5l_decap_8
* cell instance sg13cmos5l_decap_8_1330 r0 *1 0,0
Xsg13cmos5l_decap_8_1330 VPWR VGND sg13cmos5l_decap_8
* cell instance sg13cmos5l_decap_8_1331 r0 *1 0,0
Xsg13cmos5l_decap_8_1331 VPWR VGND sg13cmos5l_decap_8
* cell instance sg13cmos5l_decap_8_1332 r0 *1 0,0
Xsg13cmos5l_decap_8_1332 VPWR VGND sg13cmos5l_decap_8
* cell instance sg13cmos5l_decap_8_1333 r0 *1 0,0
Xsg13cmos5l_decap_8_1333 VPWR VGND sg13cmos5l_decap_8
* cell instance sg13cmos5l_decap_8_1334 r0 *1 0,0
Xsg13cmos5l_decap_8_1334 VPWR VGND sg13cmos5l_decap_8
* cell instance sg13cmos5l_decap_8_1335 r0 *1 0,0
Xsg13cmos5l_decap_8_1335 VPWR VGND sg13cmos5l_decap_8
* cell instance sg13cmos5l_decap_8_1336 r0 *1 0,0
Xsg13cmos5l_decap_8_1336 VPWR VGND sg13cmos5l_decap_8
* cell instance sg13cmos5l_decap_8_1337 r0 *1 0,0
Xsg13cmos5l_decap_8_1337 VPWR VGND sg13cmos5l_decap_8
* cell instance sg13cmos5l_decap_8_1338 r0 *1 0,0
Xsg13cmos5l_decap_8_1338 VPWR VGND sg13cmos5l_decap_8
* cell instance sg13cmos5l_decap_8_1339 r0 *1 0,0
Xsg13cmos5l_decap_8_1339 VPWR VGND sg13cmos5l_decap_8
* cell instance sg13cmos5l_decap_8_1340 r0 *1 0,0
Xsg13cmos5l_decap_8_1340 VPWR VGND sg13cmos5l_decap_8
* cell instance sg13cmos5l_decap_8_1341 r0 *1 0,0
Xsg13cmos5l_decap_8_1341 VPWR VGND sg13cmos5l_decap_8
* cell instance sg13cmos5l_decap_8_1342 r0 *1 0,0
Xsg13cmos5l_decap_8_1342 VPWR VGND sg13cmos5l_decap_8
* cell instance sg13cmos5l_decap_8_1343 r0 *1 0,0
Xsg13cmos5l_decap_8_1343 VPWR VGND sg13cmos5l_decap_8
* cell instance sg13cmos5l_decap_8_1344 r0 *1 0,0
Xsg13cmos5l_decap_8_1344 VPWR VGND sg13cmos5l_decap_8
* cell instance sg13cmos5l_decap_8_1345 r0 *1 0,0
Xsg13cmos5l_decap_8_1345 VPWR VGND sg13cmos5l_decap_8
* cell instance sg13cmos5l_decap_8_1346 r0 *1 0,0
Xsg13cmos5l_decap_8_1346 VPWR VGND sg13cmos5l_decap_8
* cell instance sg13cmos5l_decap_8_1347 r0 *1 0,0
Xsg13cmos5l_decap_8_1347 VPWR VGND sg13cmos5l_decap_8
* cell instance sg13cmos5l_decap_8_1348 r0 *1 0,0
Xsg13cmos5l_decap_8_1348 VPWR VGND sg13cmos5l_decap_8
* cell instance sg13cmos5l_decap_8_1349 r0 *1 0,0
Xsg13cmos5l_decap_8_1349 VPWR VGND sg13cmos5l_decap_8
* cell instance sg13cmos5l_decap_8_1350 r0 *1 0,0
Xsg13cmos5l_decap_8_1350 VPWR VGND sg13cmos5l_decap_8
* cell instance sg13cmos5l_decap_8_1351 r0 *1 0,0
Xsg13cmos5l_decap_8_1351 VPWR VGND sg13cmos5l_decap_8
* cell instance sg13cmos5l_decap_8_1352 r0 *1 0,0
Xsg13cmos5l_decap_8_1352 VPWR VGND sg13cmos5l_decap_8
* cell instance sg13cmos5l_decap_8_1353 r0 *1 0,0
Xsg13cmos5l_decap_8_1353 VPWR VGND sg13cmos5l_decap_8
* cell instance sg13cmos5l_decap_8_1354 r0 *1 0,0
Xsg13cmos5l_decap_8_1354 VPWR VGND sg13cmos5l_decap_8
* cell instance sg13cmos5l_decap_8_1355 r0 *1 0,0
Xsg13cmos5l_decap_8_1355 VPWR VGND sg13cmos5l_decap_8
* cell instance sg13cmos5l_decap_8_1356 r0 *1 0,0
Xsg13cmos5l_decap_8_1356 VPWR VGND sg13cmos5l_decap_8
* cell instance sg13cmos5l_decap_8_1357 r0 *1 0,0
Xsg13cmos5l_decap_8_1357 VPWR VGND sg13cmos5l_decap_8
* cell instance sg13cmos5l_decap_8_1358 r0 *1 0,0
Xsg13cmos5l_decap_8_1358 VPWR VGND sg13cmos5l_decap_8
* cell instance sg13cmos5l_decap_8_1359 r0 *1 0,0
Xsg13cmos5l_decap_8_1359 VPWR VGND sg13cmos5l_decap_8
* cell instance sg13cmos5l_decap_8_1360 r0 *1 0,0
Xsg13cmos5l_decap_8_1360 VPWR VGND sg13cmos5l_decap_8
* cell instance sg13cmos5l_decap_8_1361 r0 *1 0,0
Xsg13cmos5l_decap_8_1361 VPWR VGND sg13cmos5l_decap_8
* cell instance sg13cmos5l_decap_8_1362 r0 *1 0,0
Xsg13cmos5l_decap_8_1362 VPWR VGND sg13cmos5l_decap_8
* cell instance sg13cmos5l_decap_8_1363 r0 *1 0,0
Xsg13cmos5l_decap_8_1363 VPWR VGND sg13cmos5l_decap_8
* cell instance sg13cmos5l_decap_8_1364 r0 *1 0,0
Xsg13cmos5l_decap_8_1364 VPWR VGND sg13cmos5l_decap_8
* cell instance sg13cmos5l_decap_8_1365 r0 *1 0,0
Xsg13cmos5l_decap_8_1365 VPWR VGND sg13cmos5l_decap_8
* cell instance sg13cmos5l_decap_8_1366 r0 *1 0,0
Xsg13cmos5l_decap_8_1366 VPWR VGND sg13cmos5l_decap_8
* cell instance sg13cmos5l_decap_8_1367 r0 *1 0,0
Xsg13cmos5l_decap_8_1367 VPWR VGND sg13cmos5l_decap_8
* cell instance sg13cmos5l_decap_8_1368 r0 *1 0,0
Xsg13cmos5l_decap_8_1368 VPWR VGND sg13cmos5l_decap_8
* cell instance sg13cmos5l_decap_8_1369 r0 *1 0,0
Xsg13cmos5l_decap_8_1369 VPWR VGND sg13cmos5l_decap_8
* cell instance sg13cmos5l_decap_8_1370 r0 *1 0,0
Xsg13cmos5l_decap_8_1370 VPWR VGND sg13cmos5l_decap_8
* cell instance sg13cmos5l_decap_8_1371 r0 *1 0,0
Xsg13cmos5l_decap_8_1371 VPWR VGND sg13cmos5l_decap_8
* cell instance sg13cmos5l_decap_8_1372 r0 *1 0,0
Xsg13cmos5l_decap_8_1372 VPWR VGND sg13cmos5l_decap_8
* cell instance sg13cmos5l_decap_8_1373 r0 *1 0,0
Xsg13cmos5l_decap_8_1373 VPWR VGND sg13cmos5l_decap_8
* cell instance sg13cmos5l_decap_8_1374 r0 *1 0,0
Xsg13cmos5l_decap_8_1374 VPWR VGND sg13cmos5l_decap_8
* cell instance sg13cmos5l_decap_8_1375 r0 *1 0,0
Xsg13cmos5l_decap_8_1375 VPWR VGND sg13cmos5l_decap_8
* cell instance sg13cmos5l_decap_8_1376 r0 *1 0,0
Xsg13cmos5l_decap_8_1376 VPWR VGND sg13cmos5l_decap_8
* cell instance sg13cmos5l_decap_8_1377 r0 *1 0,0
Xsg13cmos5l_decap_8_1377 VPWR VGND sg13cmos5l_decap_8
* cell instance sg13cmos5l_decap_8_1378 r0 *1 0,0
Xsg13cmos5l_decap_8_1378 VPWR VGND sg13cmos5l_decap_8
* cell instance sg13cmos5l_decap_8_1379 r0 *1 0,0
Xsg13cmos5l_decap_8_1379 VPWR VGND sg13cmos5l_decap_8
* cell instance sg13cmos5l_decap_8_1380 r0 *1 0,0
Xsg13cmos5l_decap_8_1380 VPWR VGND sg13cmos5l_decap_8
* cell instance sg13cmos5l_decap_8_1381 r0 *1 0,0
Xsg13cmos5l_decap_8_1381 VPWR VGND sg13cmos5l_decap_8
* cell instance sg13cmos5l_decap_8_1382 r0 *1 0,0
Xsg13cmos5l_decap_8_1382 VPWR VGND sg13cmos5l_decap_8
* cell instance sg13cmos5l_decap_8_1383 r0 *1 0,0
Xsg13cmos5l_decap_8_1383 VPWR VGND sg13cmos5l_decap_8
* cell instance sg13cmos5l_decap_8_1384 r0 *1 0,0
Xsg13cmos5l_decap_8_1384 VPWR VGND sg13cmos5l_decap_8
* cell instance sg13cmos5l_decap_8_1385 r0 *1 0,0
Xsg13cmos5l_decap_8_1385 VPWR VGND sg13cmos5l_decap_8
* cell instance sg13cmos5l_decap_8_1386 r0 *1 0,0
Xsg13cmos5l_decap_8_1386 VPWR VGND sg13cmos5l_decap_8
* cell instance sg13cmos5l_decap_8_1387 r0 *1 0,0
Xsg13cmos5l_decap_8_1387 VPWR VGND sg13cmos5l_decap_8
* cell instance sg13cmos5l_decap_8_1388 r0 *1 0,0
Xsg13cmos5l_decap_8_1388 VPWR VGND sg13cmos5l_decap_8
* cell instance sg13cmos5l_decap_8_1389 r0 *1 0,0
Xsg13cmos5l_decap_8_1389 VPWR VGND sg13cmos5l_decap_8
* cell instance sg13cmos5l_decap_8_1390 r0 *1 0,0
Xsg13cmos5l_decap_8_1390 VPWR VGND sg13cmos5l_decap_8
* cell instance sg13cmos5l_decap_8_1391 r0 *1 0,0
Xsg13cmos5l_decap_8_1391 VPWR VGND sg13cmos5l_decap_8
* cell instance sg13cmos5l_decap_8_1392 r0 *1 0,0
Xsg13cmos5l_decap_8_1392 VPWR VGND sg13cmos5l_decap_8
* cell instance sg13cmos5l_decap_8_1393 r0 *1 0,0
Xsg13cmos5l_decap_8_1393 VPWR VGND sg13cmos5l_decap_8
* cell instance sg13cmos5l_decap_8_1394 r0 *1 0,0
Xsg13cmos5l_decap_8_1394 VPWR VGND sg13cmos5l_decap_8
* cell instance sg13cmos5l_decap_8_1395 r0 *1 0,0
Xsg13cmos5l_decap_8_1395 VPWR VGND sg13cmos5l_decap_8
* cell instance sg13cmos5l_decap_8_1396 r0 *1 0,0
Xsg13cmos5l_decap_8_1396 VPWR VGND sg13cmos5l_decap_8
* cell instance sg13cmos5l_decap_8_1397 r0 *1 0,0
Xsg13cmos5l_decap_8_1397 VPWR VGND sg13cmos5l_decap_8
* cell instance sg13cmos5l_decap_8_1398 r0 *1 0,0
Xsg13cmos5l_decap_8_1398 VPWR VGND sg13cmos5l_decap_8
* cell instance sg13cmos5l_decap_8_1399 r0 *1 0,0
Xsg13cmos5l_decap_8_1399 VPWR VGND sg13cmos5l_decap_8
* cell instance sg13cmos5l_decap_8_1400 r0 *1 0,0
Xsg13cmos5l_decap_8_1400 VPWR VGND sg13cmos5l_decap_8
* cell instance sg13cmos5l_decap_8_1401 r0 *1 0,0
Xsg13cmos5l_decap_8_1401 VPWR VGND sg13cmos5l_decap_8
* cell instance sg13cmos5l_decap_8_1402 r0 *1 0,0
Xsg13cmos5l_decap_8_1402 VPWR VGND sg13cmos5l_decap_8
* cell instance sg13cmos5l_decap_8_1403 r0 *1 0,0
Xsg13cmos5l_decap_8_1403 VPWR VGND sg13cmos5l_decap_8
* cell instance sg13cmos5l_decap_8_1404 r0 *1 0,0
Xsg13cmos5l_decap_8_1404 VPWR VGND sg13cmos5l_decap_8
* cell instance sg13cmos5l_decap_8_1405 r0 *1 0,0
Xsg13cmos5l_decap_8_1405 VPWR VGND sg13cmos5l_decap_8
* cell instance sg13cmos5l_decap_8_1406 r0 *1 0,0
Xsg13cmos5l_decap_8_1406 VPWR VGND sg13cmos5l_decap_8
* cell instance sg13cmos5l_decap_8_1407 r0 *1 0,0
Xsg13cmos5l_decap_8_1407 VPWR VGND sg13cmos5l_decap_8
* cell instance sg13cmos5l_decap_8_1408 r0 *1 0,0
Xsg13cmos5l_decap_8_1408 VPWR VGND sg13cmos5l_decap_8
* cell instance sg13cmos5l_decap_8_1409 r0 *1 0,0
Xsg13cmos5l_decap_8_1409 VPWR VGND sg13cmos5l_decap_8
* cell instance sg13cmos5l_decap_8_1410 r0 *1 0,0
Xsg13cmos5l_decap_8_1410 VPWR VGND sg13cmos5l_decap_8
* cell instance sg13cmos5l_decap_8_1411 r0 *1 0,0
Xsg13cmos5l_decap_8_1411 VPWR VGND sg13cmos5l_decap_8
* cell instance sg13cmos5l_decap_8_1412 r0 *1 0,0
Xsg13cmos5l_decap_8_1412 VPWR VGND sg13cmos5l_decap_8
* cell instance sg13cmos5l_decap_8_1413 r0 *1 0,0
Xsg13cmos5l_decap_8_1413 VPWR VGND sg13cmos5l_decap_8
* cell instance sg13cmos5l_decap_8_1414 r0 *1 0,0
Xsg13cmos5l_decap_8_1414 VPWR VGND sg13cmos5l_decap_8
* cell instance sg13cmos5l_decap_8_1415 r0 *1 0,0
Xsg13cmos5l_decap_8_1415 VPWR VGND sg13cmos5l_decap_8
* cell instance sg13cmos5l_decap_8_1416 r0 *1 0,0
Xsg13cmos5l_decap_8_1416 VPWR VGND sg13cmos5l_decap_8
* cell instance sg13cmos5l_decap_8_1417 r0 *1 0,0
Xsg13cmos5l_decap_8_1417 VPWR VGND sg13cmos5l_decap_8
* cell instance sg13cmos5l_decap_8_1418 r0 *1 0,0
Xsg13cmos5l_decap_8_1418 VPWR VGND sg13cmos5l_decap_8
* cell instance sg13cmos5l_decap_8_1419 r0 *1 0,0
Xsg13cmos5l_decap_8_1419 VPWR VGND sg13cmos5l_decap_8
* cell instance sg13cmos5l_decap_8_1420 r0 *1 0,0
Xsg13cmos5l_decap_8_1420 VPWR VGND sg13cmos5l_decap_8
* cell instance sg13cmos5l_decap_8_1421 r0 *1 0,0
Xsg13cmos5l_decap_8_1421 VPWR VGND sg13cmos5l_decap_8
* cell instance sg13cmos5l_decap_8_1422 r0 *1 0,0
Xsg13cmos5l_decap_8_1422 VPWR VGND sg13cmos5l_decap_8
* cell instance sg13cmos5l_decap_8_1423 r0 *1 0,0
Xsg13cmos5l_decap_8_1423 VPWR VGND sg13cmos5l_decap_8
* cell instance sg13cmos5l_decap_8_1424 r0 *1 0,0
Xsg13cmos5l_decap_8_1424 VPWR VGND sg13cmos5l_decap_8
* cell instance sg13cmos5l_decap_8_1425 r0 *1 0,0
Xsg13cmos5l_decap_8_1425 VPWR VGND sg13cmos5l_decap_8
* cell instance sg13cmos5l_decap_8_1426 r0 *1 0,0
Xsg13cmos5l_decap_8_1426 VPWR VGND sg13cmos5l_decap_8
* cell instance sg13cmos5l_decap_8_1427 r0 *1 0,0
Xsg13cmos5l_decap_8_1427 VPWR VGND sg13cmos5l_decap_8
* cell instance sg13cmos5l_decap_8_1428 r0 *1 0,0
Xsg13cmos5l_decap_8_1428 VPWR VGND sg13cmos5l_decap_8
* cell instance sg13cmos5l_decap_8_1429 r0 *1 0,0
Xsg13cmos5l_decap_8_1429 VPWR VGND sg13cmos5l_decap_8
* cell instance sg13cmos5l_decap_8_1430 r0 *1 0,0
Xsg13cmos5l_decap_8_1430 VPWR VGND sg13cmos5l_decap_8
* cell instance sg13cmos5l_decap_8_1431 r0 *1 0,0
Xsg13cmos5l_decap_8_1431 VPWR VGND sg13cmos5l_decap_8
* cell instance sg13cmos5l_decap_8_1432 r0 *1 0,0
Xsg13cmos5l_decap_8_1432 VPWR VGND sg13cmos5l_decap_8
* cell instance sg13cmos5l_decap_8_1433 r0 *1 0,0
Xsg13cmos5l_decap_8_1433 VPWR VGND sg13cmos5l_decap_8
* cell instance sg13cmos5l_decap_8_1434 r0 *1 0,0
Xsg13cmos5l_decap_8_1434 VPWR VGND sg13cmos5l_decap_8
* cell instance sg13cmos5l_decap_8_1435 r0 *1 0,0
Xsg13cmos5l_decap_8_1435 VPWR VGND sg13cmos5l_decap_8
* cell instance sg13cmos5l_decap_8_1436 r0 *1 0,0
Xsg13cmos5l_decap_8_1436 VPWR VGND sg13cmos5l_decap_8
* cell instance sg13cmos5l_decap_8_1437 r0 *1 0,0
Xsg13cmos5l_decap_8_1437 VPWR VGND sg13cmos5l_decap_8
* cell instance sg13cmos5l_decap_8_1438 r0 *1 0,0
Xsg13cmos5l_decap_8_1438 VPWR VGND sg13cmos5l_decap_8
* cell instance sg13cmos5l_decap_8_1439 r0 *1 0,0
Xsg13cmos5l_decap_8_1439 VPWR VGND sg13cmos5l_decap_8
* cell instance sg13cmos5l_decap_8_1440 r0 *1 0,0
Xsg13cmos5l_decap_8_1440 VPWR VGND sg13cmos5l_decap_8
* cell instance sg13cmos5l_decap_8_1441 r0 *1 0,0
Xsg13cmos5l_decap_8_1441 VPWR VGND sg13cmos5l_decap_8
* cell instance sg13cmos5l_decap_8_1442 r0 *1 0,0
Xsg13cmos5l_decap_8_1442 VPWR VGND sg13cmos5l_decap_8
* cell instance sg13cmos5l_decap_8_1443 r0 *1 0,0
Xsg13cmos5l_decap_8_1443 VPWR VGND sg13cmos5l_decap_8
* cell instance sg13cmos5l_decap_8_1444 r0 *1 0,0
Xsg13cmos5l_decap_8_1444 VPWR VGND sg13cmos5l_decap_8
* cell instance sg13cmos5l_decap_8_1445 r0 *1 0,0
Xsg13cmos5l_decap_8_1445 VPWR VGND sg13cmos5l_decap_8
* cell instance sg13cmos5l_decap_8_1446 r0 *1 0,0
Xsg13cmos5l_decap_8_1446 VPWR VGND sg13cmos5l_decap_8
* cell instance sg13cmos5l_decap_8_1447 r0 *1 0,0
Xsg13cmos5l_decap_8_1447 VPWR VGND sg13cmos5l_decap_8
* cell instance sg13cmos5l_decap_8_1448 r0 *1 0,0
Xsg13cmos5l_decap_8_1448 VPWR VGND sg13cmos5l_decap_8
* cell instance sg13cmos5l_decap_8_1449 r0 *1 0,0
Xsg13cmos5l_decap_8_1449 VPWR VGND sg13cmos5l_decap_8
* cell instance sg13cmos5l_decap_8_1450 r0 *1 0,0
Xsg13cmos5l_decap_8_1450 VPWR VGND sg13cmos5l_decap_8
* cell instance sg13cmos5l_decap_8_1451 r0 *1 0,0
Xsg13cmos5l_decap_8_1451 VPWR VGND sg13cmos5l_decap_8
* cell instance sg13cmos5l_decap_8_1452 r0 *1 0,0
Xsg13cmos5l_decap_8_1452 VPWR VGND sg13cmos5l_decap_8
* cell instance sg13cmos5l_decap_8_1453 r0 *1 0,0
Xsg13cmos5l_decap_8_1453 VPWR VGND sg13cmos5l_decap_8
* cell instance sg13cmos5l_decap_8_1454 r0 *1 0,0
Xsg13cmos5l_decap_8_1454 VPWR VGND sg13cmos5l_decap_8
* cell instance sg13cmos5l_decap_8_1455 r0 *1 0,0
Xsg13cmos5l_decap_8_1455 VPWR VGND sg13cmos5l_decap_8
* cell instance sg13cmos5l_decap_8_1456 r0 *1 0,0
Xsg13cmos5l_decap_8_1456 VPWR VGND sg13cmos5l_decap_8
* cell instance sg13cmos5l_decap_8_1457 r0 *1 0,0
Xsg13cmos5l_decap_8_1457 VPWR VGND sg13cmos5l_decap_8
* cell instance sg13cmos5l_decap_8_1458 r0 *1 0,0
Xsg13cmos5l_decap_8_1458 VPWR VGND sg13cmos5l_decap_8
* cell instance sg13cmos5l_decap_8_1459 r0 *1 0,0
Xsg13cmos5l_decap_8_1459 VPWR VGND sg13cmos5l_decap_8
* cell instance sg13cmos5l_decap_8_1460 r0 *1 0,0
Xsg13cmos5l_decap_8_1460 VPWR VGND sg13cmos5l_decap_8
* cell instance sg13cmos5l_decap_8_1461 r0 *1 0,0
Xsg13cmos5l_decap_8_1461 VPWR VGND sg13cmos5l_decap_8
* cell instance sg13cmos5l_decap_8_1462 r0 *1 0,0
Xsg13cmos5l_decap_8_1462 VPWR VGND sg13cmos5l_decap_8
* cell instance sg13cmos5l_decap_8_1463 r0 *1 0,0
Xsg13cmos5l_decap_8_1463 VPWR VGND sg13cmos5l_decap_8
* cell instance sg13cmos5l_decap_8_1464 r0 *1 0,0
Xsg13cmos5l_decap_8_1464 VPWR VGND sg13cmos5l_decap_8
* cell instance sg13cmos5l_decap_8_1465 r0 *1 0,0
Xsg13cmos5l_decap_8_1465 VPWR VGND sg13cmos5l_decap_8
* cell instance sg13cmos5l_decap_8_1466 r0 *1 0,0
Xsg13cmos5l_decap_8_1466 VPWR VGND sg13cmos5l_decap_8
* cell instance sg13cmos5l_decap_8_1467 r0 *1 0,0
Xsg13cmos5l_decap_8_1467 VPWR VGND sg13cmos5l_decap_8
* cell instance sg13cmos5l_decap_8_1468 r0 *1 0,0
Xsg13cmos5l_decap_8_1468 VPWR VGND sg13cmos5l_decap_8
* cell instance sg13cmos5l_decap_8_1469 r0 *1 0,0
Xsg13cmos5l_decap_8_1469 VPWR VGND sg13cmos5l_decap_8
* cell instance sg13cmos5l_decap_8_1470 r0 *1 0,0
Xsg13cmos5l_decap_8_1470 VPWR VGND sg13cmos5l_decap_8
* cell instance sg13cmos5l_decap_8_1471 r0 *1 0,0
Xsg13cmos5l_decap_8_1471 VPWR VGND sg13cmos5l_decap_8
* cell instance sg13cmos5l_decap_8_1472 r0 *1 0,0
Xsg13cmos5l_decap_8_1472 VPWR VGND sg13cmos5l_decap_8
* cell instance sg13cmos5l_decap_8_1473 r0 *1 0,0
Xsg13cmos5l_decap_8_1473 VPWR VGND sg13cmos5l_decap_8
* cell instance sg13cmos5l_decap_8_1474 r0 *1 0,0
Xsg13cmos5l_decap_8_1474 VPWR VGND sg13cmos5l_decap_8
* cell instance sg13cmos5l_decap_8_1475 r0 *1 0,0
Xsg13cmos5l_decap_8_1475 VPWR VGND sg13cmos5l_decap_8
* cell instance sg13cmos5l_decap_8_1476 r0 *1 0,0
Xsg13cmos5l_decap_8_1476 VPWR VGND sg13cmos5l_decap_8
* cell instance sg13cmos5l_decap_8_1477 r0 *1 0,0
Xsg13cmos5l_decap_8_1477 VPWR VGND sg13cmos5l_decap_8
* cell instance sg13cmos5l_decap_8_1478 r0 *1 0,0
Xsg13cmos5l_decap_8_1478 VPWR VGND sg13cmos5l_decap_8
* cell instance sg13cmos5l_decap_8_1479 r0 *1 0,0
Xsg13cmos5l_decap_8_1479 VPWR VGND sg13cmos5l_decap_8
* cell instance sg13cmos5l_decap_8_1480 r0 *1 0,0
Xsg13cmos5l_decap_8_1480 VPWR VGND sg13cmos5l_decap_8
* cell instance sg13cmos5l_decap_8_1481 r0 *1 0,0
Xsg13cmos5l_decap_8_1481 VPWR VGND sg13cmos5l_decap_8
* cell instance sg13cmos5l_decap_8_1482 r0 *1 0,0
Xsg13cmos5l_decap_8_1482 VPWR VGND sg13cmos5l_decap_8
* cell instance sg13cmos5l_decap_8_1483 r0 *1 0,0
Xsg13cmos5l_decap_8_1483 VPWR VGND sg13cmos5l_decap_8
* cell instance sg13cmos5l_decap_8_1484 r0 *1 0,0
Xsg13cmos5l_decap_8_1484 VPWR VGND sg13cmos5l_decap_8
* cell instance sg13cmos5l_decap_8_1485 r0 *1 0,0
Xsg13cmos5l_decap_8_1485 VPWR VGND sg13cmos5l_decap_8
* cell instance sg13cmos5l_decap_8_1486 r0 *1 0,0
Xsg13cmos5l_decap_8_1486 VPWR VGND sg13cmos5l_decap_8
* cell instance sg13cmos5l_decap_8_1487 r0 *1 0,0
Xsg13cmos5l_decap_8_1487 VPWR VGND sg13cmos5l_decap_8
* cell instance sg13cmos5l_decap_8_1488 r0 *1 0,0
Xsg13cmos5l_decap_8_1488 VPWR VGND sg13cmos5l_decap_8
* cell instance sg13cmos5l_decap_8_1489 r0 *1 0,0
Xsg13cmos5l_decap_8_1489 VPWR VGND sg13cmos5l_decap_8
* cell instance sg13cmos5l_decap_8_1490 r0 *1 0,0
Xsg13cmos5l_decap_8_1490 VPWR VGND sg13cmos5l_decap_8
* cell instance sg13cmos5l_decap_8_1491 r0 *1 0,0
Xsg13cmos5l_decap_8_1491 VPWR VGND sg13cmos5l_decap_8
* cell instance sg13cmos5l_decap_8_1492 r0 *1 0,0
Xsg13cmos5l_decap_8_1492 VPWR VGND sg13cmos5l_decap_8
* cell instance sg13cmos5l_decap_8_1493 r0 *1 0,0
Xsg13cmos5l_decap_8_1493 VPWR VGND sg13cmos5l_decap_8
* cell instance sg13cmos5l_decap_8_1494 r0 *1 0,0
Xsg13cmos5l_decap_8_1494 VPWR VGND sg13cmos5l_decap_8
* cell instance sg13cmos5l_decap_8_1495 r0 *1 0,0
Xsg13cmos5l_decap_8_1495 VPWR VGND sg13cmos5l_decap_8
* cell instance sg13cmos5l_decap_8_1496 r0 *1 0,0
Xsg13cmos5l_decap_8_1496 VPWR VGND sg13cmos5l_decap_8
* cell instance sg13cmos5l_decap_8_1497 r0 *1 0,0
Xsg13cmos5l_decap_8_1497 VPWR VGND sg13cmos5l_decap_8
* cell instance sg13cmos5l_decap_8_1498 r0 *1 0,0
Xsg13cmos5l_decap_8_1498 VPWR VGND sg13cmos5l_decap_8
* cell instance sg13cmos5l_decap_8_1499 r0 *1 0,0
Xsg13cmos5l_decap_8_1499 VPWR VGND sg13cmos5l_decap_8
* cell instance sg13cmos5l_decap_8_1500 r0 *1 0,0
Xsg13cmos5l_decap_8_1500 VPWR VGND sg13cmos5l_decap_8
* cell instance sg13cmos5l_decap_8_1501 r0 *1 0,0
Xsg13cmos5l_decap_8_1501 VPWR VGND sg13cmos5l_decap_8
* cell instance sg13cmos5l_decap_8_1502 r0 *1 0,0
Xsg13cmos5l_decap_8_1502 VPWR VGND sg13cmos5l_decap_8
* cell instance sg13cmos5l_decap_8_1503 r0 *1 0,0
Xsg13cmos5l_decap_8_1503 VPWR VGND sg13cmos5l_decap_8
* cell instance sg13cmos5l_decap_8_1504 r0 *1 0,0
Xsg13cmos5l_decap_8_1504 VPWR VGND sg13cmos5l_decap_8
* cell instance sg13cmos5l_decap_8_1505 r0 *1 0,0
Xsg13cmos5l_decap_8_1505 VPWR VGND sg13cmos5l_decap_8
* cell instance sg13cmos5l_decap_8_1506 r0 *1 0,0
Xsg13cmos5l_decap_8_1506 VPWR VGND sg13cmos5l_decap_8
* cell instance sg13cmos5l_decap_8_1507 r0 *1 0,0
Xsg13cmos5l_decap_8_1507 VPWR VGND sg13cmos5l_decap_8
* cell instance sg13cmos5l_decap_8_1508 r0 *1 0,0
Xsg13cmos5l_decap_8_1508 VPWR VGND sg13cmos5l_decap_8
* cell instance sg13cmos5l_decap_8_1509 r0 *1 0,0
Xsg13cmos5l_decap_8_1509 VPWR VGND sg13cmos5l_decap_8
* cell instance sg13cmos5l_decap_8_1510 r0 *1 0,0
Xsg13cmos5l_decap_8_1510 VPWR VGND sg13cmos5l_decap_8
* cell instance sg13cmos5l_decap_8_1511 r0 *1 0,0
Xsg13cmos5l_decap_8_1511 VPWR VGND sg13cmos5l_decap_8
* cell instance sg13cmos5l_decap_8_1512 r0 *1 0,0
Xsg13cmos5l_decap_8_1512 VPWR VGND sg13cmos5l_decap_8
* cell instance sg13cmos5l_decap_8_1513 r0 *1 0,0
Xsg13cmos5l_decap_8_1513 VPWR VGND sg13cmos5l_decap_8
* cell instance sg13cmos5l_decap_8_1514 r0 *1 0,0
Xsg13cmos5l_decap_8_1514 VPWR VGND sg13cmos5l_decap_8
* cell instance sg13cmos5l_decap_8_1515 r0 *1 0,0
Xsg13cmos5l_decap_8_1515 VPWR VGND sg13cmos5l_decap_8
* cell instance sg13cmos5l_decap_8_1516 r0 *1 0,0
Xsg13cmos5l_decap_8_1516 VPWR VGND sg13cmos5l_decap_8
* cell instance sg13cmos5l_decap_8_1517 r0 *1 0,0
Xsg13cmos5l_decap_8_1517 VPWR VGND sg13cmos5l_decap_8
* cell instance sg13cmos5l_decap_8_1518 r0 *1 0,0
Xsg13cmos5l_decap_8_1518 VPWR VGND sg13cmos5l_decap_8
* cell instance sg13cmos5l_decap_8_1519 r0 *1 0,0
Xsg13cmos5l_decap_8_1519 VPWR VGND sg13cmos5l_decap_8
* cell instance sg13cmos5l_decap_8_1520 r0 *1 0,0
Xsg13cmos5l_decap_8_1520 VPWR VGND sg13cmos5l_decap_8
* cell instance sg13cmos5l_decap_8_1521 r0 *1 0,0
Xsg13cmos5l_decap_8_1521 VPWR VGND sg13cmos5l_decap_8
* cell instance sg13cmos5l_decap_8_1522 r0 *1 0,0
Xsg13cmos5l_decap_8_1522 VPWR VGND sg13cmos5l_decap_8
* cell instance sg13cmos5l_decap_8_1523 r0 *1 0,0
Xsg13cmos5l_decap_8_1523 VPWR VGND sg13cmos5l_decap_8
* cell instance sg13cmos5l_decap_8_1524 r0 *1 0,0
Xsg13cmos5l_decap_8_1524 VPWR VGND sg13cmos5l_decap_8
* cell instance sg13cmos5l_decap_8_1525 r0 *1 0,0
Xsg13cmos5l_decap_8_1525 VPWR VGND sg13cmos5l_decap_8
* cell instance sg13cmos5l_decap_8_1526 r0 *1 0,0
Xsg13cmos5l_decap_8_1526 VPWR VGND sg13cmos5l_decap_8
* cell instance sg13cmos5l_decap_8_1527 r0 *1 0,0
Xsg13cmos5l_decap_8_1527 VPWR VGND sg13cmos5l_decap_8
* cell instance sg13cmos5l_decap_8_1528 r0 *1 0,0
Xsg13cmos5l_decap_8_1528 VPWR VGND sg13cmos5l_decap_8
* cell instance sg13cmos5l_decap_8_1529 r0 *1 0,0
Xsg13cmos5l_decap_8_1529 VPWR VGND sg13cmos5l_decap_8
* cell instance sg13cmos5l_decap_8_1530 r0 *1 0,0
Xsg13cmos5l_decap_8_1530 VPWR VGND sg13cmos5l_decap_8
* cell instance sg13cmos5l_decap_8_1531 r0 *1 0,0
Xsg13cmos5l_decap_8_1531 VPWR VGND sg13cmos5l_decap_8
* cell instance sg13cmos5l_decap_8_1532 r0 *1 0,0
Xsg13cmos5l_decap_8_1532 VPWR VGND sg13cmos5l_decap_8
* cell instance sg13cmos5l_decap_8_1533 r0 *1 0,0
Xsg13cmos5l_decap_8_1533 VPWR VGND sg13cmos5l_decap_8
* cell instance sg13cmos5l_decap_8_1534 r0 *1 0,0
Xsg13cmos5l_decap_8_1534 VPWR VGND sg13cmos5l_decap_8
* cell instance sg13cmos5l_decap_8_1535 r0 *1 0,0
Xsg13cmos5l_decap_8_1535 VPWR VGND sg13cmos5l_decap_8
* cell instance sg13cmos5l_decap_8_1536 r0 *1 0,0
Xsg13cmos5l_decap_8_1536 VPWR VGND sg13cmos5l_decap_8
* cell instance sg13cmos5l_decap_8_1537 r0 *1 0,0
Xsg13cmos5l_decap_8_1537 VPWR VGND sg13cmos5l_decap_8
* cell instance sg13cmos5l_decap_8_1538 r0 *1 0,0
Xsg13cmos5l_decap_8_1538 VPWR VGND sg13cmos5l_decap_8
* cell instance sg13cmos5l_decap_8_1539 r0 *1 0,0
Xsg13cmos5l_decap_8_1539 VPWR VGND sg13cmos5l_decap_8
* cell instance sg13cmos5l_decap_8_1540 r0 *1 0,0
Xsg13cmos5l_decap_8_1540 VPWR VGND sg13cmos5l_decap_8
* cell instance sg13cmos5l_decap_8_1541 r0 *1 0,0
Xsg13cmos5l_decap_8_1541 VPWR VGND sg13cmos5l_decap_8
* cell instance sg13cmos5l_decap_8_1542 r0 *1 0,0
Xsg13cmos5l_decap_8_1542 VPWR VGND sg13cmos5l_decap_8
* cell instance sg13cmos5l_decap_8_1543 r0 *1 0,0
Xsg13cmos5l_decap_8_1543 VPWR VGND sg13cmos5l_decap_8
* cell instance sg13cmos5l_decap_8_1544 r0 *1 0,0
Xsg13cmos5l_decap_8_1544 VPWR VGND sg13cmos5l_decap_8
* cell instance sg13cmos5l_decap_8_1545 r0 *1 0,0
Xsg13cmos5l_decap_8_1545 VPWR VGND sg13cmos5l_decap_8
* cell instance sg13cmos5l_decap_8_1546 r0 *1 0,0
Xsg13cmos5l_decap_8_1546 VPWR VGND sg13cmos5l_decap_8
* cell instance sg13cmos5l_decap_8_1547 r0 *1 0,0
Xsg13cmos5l_decap_8_1547 VPWR VGND sg13cmos5l_decap_8
* cell instance sg13cmos5l_decap_8_1548 r0 *1 0,0
Xsg13cmos5l_decap_8_1548 VPWR VGND sg13cmos5l_decap_8
* cell instance sg13cmos5l_decap_8_1549 r0 *1 0,0
Xsg13cmos5l_decap_8_1549 VPWR VGND sg13cmos5l_decap_8
* cell instance sg13cmos5l_decap_8_1550 r0 *1 0,0
Xsg13cmos5l_decap_8_1550 VPWR VGND sg13cmos5l_decap_8
* cell instance sg13cmos5l_decap_8_1551 r0 *1 0,0
Xsg13cmos5l_decap_8_1551 VPWR VGND sg13cmos5l_decap_8
* cell instance sg13cmos5l_decap_8_1552 r0 *1 0,0
Xsg13cmos5l_decap_8_1552 VPWR VGND sg13cmos5l_decap_8
* cell instance sg13cmos5l_decap_8_1553 r0 *1 0,0
Xsg13cmos5l_decap_8_1553 VPWR VGND sg13cmos5l_decap_8
* cell instance sg13cmos5l_decap_8_1554 r0 *1 0,0
Xsg13cmos5l_decap_8_1554 VPWR VGND sg13cmos5l_decap_8
* cell instance sg13cmos5l_decap_8_1555 r0 *1 0,0
Xsg13cmos5l_decap_8_1555 VPWR VGND sg13cmos5l_decap_8
* cell instance sg13cmos5l_decap_8_1556 r0 *1 0,0
Xsg13cmos5l_decap_8_1556 VPWR VGND sg13cmos5l_decap_8
* cell instance sg13cmos5l_decap_8_1557 r0 *1 0,0
Xsg13cmos5l_decap_8_1557 VPWR VGND sg13cmos5l_decap_8
* cell instance sg13cmos5l_decap_8_1558 r0 *1 0,0
Xsg13cmos5l_decap_8_1558 VPWR VGND sg13cmos5l_decap_8
* cell instance sg13cmos5l_decap_8_1559 r0 *1 0,0
Xsg13cmos5l_decap_8_1559 VPWR VGND sg13cmos5l_decap_8
* cell instance sg13cmos5l_decap_8_1560 r0 *1 0,0
Xsg13cmos5l_decap_8_1560 VPWR VGND sg13cmos5l_decap_8
* cell instance sg13cmos5l_decap_8_1561 r0 *1 0,0
Xsg13cmos5l_decap_8_1561 VPWR VGND sg13cmos5l_decap_8
* cell instance sg13cmos5l_decap_8_1562 r0 *1 0,0
Xsg13cmos5l_decap_8_1562 VPWR VGND sg13cmos5l_decap_8
* cell instance sg13cmos5l_decap_8_1563 r0 *1 0,0
Xsg13cmos5l_decap_8_1563 VPWR VGND sg13cmos5l_decap_8
* cell instance sg13cmos5l_decap_8_1564 r0 *1 0,0
Xsg13cmos5l_decap_8_1564 VPWR VGND sg13cmos5l_decap_8
* cell instance sg13cmos5l_decap_8_1565 r0 *1 0,0
Xsg13cmos5l_decap_8_1565 VPWR VGND sg13cmos5l_decap_8
* cell instance sg13cmos5l_decap_8_1566 r0 *1 0,0
Xsg13cmos5l_decap_8_1566 VPWR VGND sg13cmos5l_decap_8
* cell instance sg13cmos5l_decap_8_1567 r0 *1 0,0
Xsg13cmos5l_decap_8_1567 VPWR VGND sg13cmos5l_decap_8
* cell instance sg13cmos5l_decap_8_1568 r0 *1 0,0
Xsg13cmos5l_decap_8_1568 VPWR VGND sg13cmos5l_decap_8
* cell instance sg13cmos5l_decap_8_1569 r0 *1 0,0
Xsg13cmos5l_decap_8_1569 VPWR VGND sg13cmos5l_decap_8
* cell instance sg13cmos5l_decap_8_1570 r0 *1 0,0
Xsg13cmos5l_decap_8_1570 VPWR VGND sg13cmos5l_decap_8
* cell instance sg13cmos5l_decap_8_1571 r0 *1 0,0
Xsg13cmos5l_decap_8_1571 VPWR VGND sg13cmos5l_decap_8
* cell instance sg13cmos5l_decap_8_1572 r0 *1 0,0
Xsg13cmos5l_decap_8_1572 VPWR VGND sg13cmos5l_decap_8
* cell instance sg13cmos5l_decap_8_1573 r0 *1 0,0
Xsg13cmos5l_decap_8_1573 VPWR VGND sg13cmos5l_decap_8
* cell instance sg13cmos5l_decap_8_1574 r0 *1 0,0
Xsg13cmos5l_decap_8_1574 VPWR VGND sg13cmos5l_decap_8
* cell instance sg13cmos5l_decap_8_1575 r0 *1 0,0
Xsg13cmos5l_decap_8_1575 VPWR VGND sg13cmos5l_decap_8
* cell instance sg13cmos5l_decap_8_1576 r0 *1 0,0
Xsg13cmos5l_decap_8_1576 VPWR VGND sg13cmos5l_decap_8
* cell instance sg13cmos5l_decap_8_1577 r0 *1 0,0
Xsg13cmos5l_decap_8_1577 VPWR VGND sg13cmos5l_decap_8
* cell instance sg13cmos5l_decap_8_1578 r0 *1 0,0
Xsg13cmos5l_decap_8_1578 VPWR VGND sg13cmos5l_decap_8
* cell instance sg13cmos5l_decap_8_1579 r0 *1 0,0
Xsg13cmos5l_decap_8_1579 VPWR VGND sg13cmos5l_decap_8
* cell instance sg13cmos5l_decap_8_1580 r0 *1 0,0
Xsg13cmos5l_decap_8_1580 VPWR VGND sg13cmos5l_decap_8
* cell instance sg13cmos5l_decap_8_1581 r0 *1 0,0
Xsg13cmos5l_decap_8_1581 VPWR VGND sg13cmos5l_decap_8
* cell instance sg13cmos5l_decap_8_1582 r0 *1 0,0
Xsg13cmos5l_decap_8_1582 VPWR VGND sg13cmos5l_decap_8
* cell instance sg13cmos5l_decap_8_1583 r0 *1 0,0
Xsg13cmos5l_decap_8_1583 VPWR VGND sg13cmos5l_decap_8
* cell instance sg13cmos5l_decap_8_1584 r0 *1 0,0
Xsg13cmos5l_decap_8_1584 VPWR VGND sg13cmos5l_decap_8
* cell instance sg13cmos5l_decap_8_1585 r0 *1 0,0
Xsg13cmos5l_decap_8_1585 VPWR VGND sg13cmos5l_decap_8
* cell instance sg13cmos5l_decap_8_1586 r0 *1 0,0
Xsg13cmos5l_decap_8_1586 VPWR VGND sg13cmos5l_decap_8
* cell instance sg13cmos5l_decap_8_1587 r0 *1 0,0
Xsg13cmos5l_decap_8_1587 VPWR VGND sg13cmos5l_decap_8
* cell instance sg13cmos5l_decap_8_1588 r0 *1 0,0
Xsg13cmos5l_decap_8_1588 VPWR VGND sg13cmos5l_decap_8
* cell instance sg13cmos5l_decap_8_1589 r0 *1 0,0
Xsg13cmos5l_decap_8_1589 VPWR VGND sg13cmos5l_decap_8
* cell instance sg13cmos5l_decap_8_1590 r0 *1 0,0
Xsg13cmos5l_decap_8_1590 VPWR VGND sg13cmos5l_decap_8
* cell instance sg13cmos5l_decap_8_1591 r0 *1 0,0
Xsg13cmos5l_decap_8_1591 VPWR VGND sg13cmos5l_decap_8
* cell instance sg13cmos5l_decap_8_1592 r0 *1 0,0
Xsg13cmos5l_decap_8_1592 VPWR VGND sg13cmos5l_decap_8
* cell instance sg13cmos5l_decap_8_1593 r0 *1 0,0
Xsg13cmos5l_decap_8_1593 VPWR VGND sg13cmos5l_decap_8
* cell instance sg13cmos5l_decap_8_1594 r0 *1 0,0
Xsg13cmos5l_decap_8_1594 VPWR VGND sg13cmos5l_decap_8
* cell instance sg13cmos5l_decap_8_1595 r0 *1 0,0
Xsg13cmos5l_decap_8_1595 VPWR VGND sg13cmos5l_decap_8
* cell instance sg13cmos5l_decap_8_1596 r0 *1 0,0
Xsg13cmos5l_decap_8_1596 VPWR VGND sg13cmos5l_decap_8
* cell instance sg13cmos5l_decap_8_1597 r0 *1 0,0
Xsg13cmos5l_decap_8_1597 VPWR VGND sg13cmos5l_decap_8
* cell instance sg13cmos5l_decap_8_1598 r0 *1 0,0
Xsg13cmos5l_decap_8_1598 VPWR VGND sg13cmos5l_decap_8
* cell instance sg13cmos5l_decap_8_1599 r0 *1 0,0
Xsg13cmos5l_decap_8_1599 VPWR VGND sg13cmos5l_decap_8
* cell instance sg13cmos5l_decap_8_1600 r0 *1 0,0
Xsg13cmos5l_decap_8_1600 VPWR VGND sg13cmos5l_decap_8
* cell instance sg13cmos5l_decap_8_1601 r0 *1 0,0
Xsg13cmos5l_decap_8_1601 VPWR VGND sg13cmos5l_decap_8
* cell instance sg13cmos5l_decap_8_1602 r0 *1 0,0
Xsg13cmos5l_decap_8_1602 VPWR VGND sg13cmos5l_decap_8
* cell instance sg13cmos5l_decap_8_1603 r0 *1 0,0
Xsg13cmos5l_decap_8_1603 VPWR VGND sg13cmos5l_decap_8
* cell instance sg13cmos5l_decap_8_1604 r0 *1 0,0
Xsg13cmos5l_decap_8_1604 VPWR VGND sg13cmos5l_decap_8
* cell instance sg13cmos5l_decap_8_1605 r0 *1 0,0
Xsg13cmos5l_decap_8_1605 VPWR VGND sg13cmos5l_decap_8
* cell instance sg13cmos5l_decap_8_1606 r0 *1 0,0
Xsg13cmos5l_decap_8_1606 VPWR VGND sg13cmos5l_decap_8
* cell instance sg13cmos5l_decap_8_1607 r0 *1 0,0
Xsg13cmos5l_decap_8_1607 VPWR VGND sg13cmos5l_decap_8
* cell instance sg13cmos5l_decap_8_1608 r0 *1 0,0
Xsg13cmos5l_decap_8_1608 VPWR VGND sg13cmos5l_decap_8
* cell instance sg13cmos5l_decap_8_1609 r0 *1 0,0
Xsg13cmos5l_decap_8_1609 VPWR VGND sg13cmos5l_decap_8
* cell instance sg13cmos5l_decap_8_1610 r0 *1 0,0
Xsg13cmos5l_decap_8_1610 VPWR VGND sg13cmos5l_decap_8
* cell instance sg13cmos5l_decap_8_1611 r0 *1 0,0
Xsg13cmos5l_decap_8_1611 VPWR VGND sg13cmos5l_decap_8
* cell instance sg13cmos5l_decap_8_1612 r0 *1 0,0
Xsg13cmos5l_decap_8_1612 VPWR VGND sg13cmos5l_decap_8
* cell instance sg13cmos5l_decap_8_1613 r0 *1 0,0
Xsg13cmos5l_decap_8_1613 VPWR VGND sg13cmos5l_decap_8
* cell instance sg13cmos5l_decap_8_1614 r0 *1 0,0
Xsg13cmos5l_decap_8_1614 VPWR VGND sg13cmos5l_decap_8
* cell instance sg13cmos5l_decap_8_1615 r0 *1 0,0
Xsg13cmos5l_decap_8_1615 VPWR VGND sg13cmos5l_decap_8
* cell instance sg13cmos5l_decap_8_1616 r0 *1 0,0
Xsg13cmos5l_decap_8_1616 VPWR VGND sg13cmos5l_decap_8
* cell instance sg13cmos5l_decap_8_1617 r0 *1 0,0
Xsg13cmos5l_decap_8_1617 VPWR VGND sg13cmos5l_decap_8
* cell instance sg13cmos5l_decap_8_1618 r0 *1 0,0
Xsg13cmos5l_decap_8_1618 VPWR VGND sg13cmos5l_decap_8
* cell instance sg13cmos5l_decap_8_1619 r0 *1 0,0
Xsg13cmos5l_decap_8_1619 VPWR VGND sg13cmos5l_decap_8
* cell instance sg13cmos5l_decap_8_1620 r0 *1 0,0
Xsg13cmos5l_decap_8_1620 VPWR VGND sg13cmos5l_decap_8
* cell instance sg13cmos5l_decap_8_1621 r0 *1 0,0
Xsg13cmos5l_decap_8_1621 VPWR VGND sg13cmos5l_decap_8
* cell instance sg13cmos5l_decap_8_1622 r0 *1 0,0
Xsg13cmos5l_decap_8_1622 VPWR VGND sg13cmos5l_decap_8
* cell instance sg13cmos5l_decap_8_1623 r0 *1 0,0
Xsg13cmos5l_decap_8_1623 VPWR VGND sg13cmos5l_decap_8
* cell instance sg13cmos5l_decap_8_1624 r0 *1 0,0
Xsg13cmos5l_decap_8_1624 VPWR VGND sg13cmos5l_decap_8
* cell instance sg13cmos5l_decap_8_1625 r0 *1 0,0
Xsg13cmos5l_decap_8_1625 VPWR VGND sg13cmos5l_decap_8
* cell instance sg13cmos5l_decap_8_1626 r0 *1 0,0
Xsg13cmos5l_decap_8_1626 VPWR VGND sg13cmos5l_decap_8
* cell instance sg13cmos5l_decap_8_1627 r0 *1 0,0
Xsg13cmos5l_decap_8_1627 VPWR VGND sg13cmos5l_decap_8
* cell instance sg13cmos5l_decap_8_1628 r0 *1 0,0
Xsg13cmos5l_decap_8_1628 VPWR VGND sg13cmos5l_decap_8
* cell instance sg13cmos5l_decap_8_1629 r0 *1 0,0
Xsg13cmos5l_decap_8_1629 VPWR VGND sg13cmos5l_decap_8
* cell instance sg13cmos5l_decap_8_1630 r0 *1 0,0
Xsg13cmos5l_decap_8_1630 VPWR VGND sg13cmos5l_decap_8
* cell instance sg13cmos5l_decap_8_1631 r0 *1 0,0
Xsg13cmos5l_decap_8_1631 VPWR VGND sg13cmos5l_decap_8
* cell instance sg13cmos5l_decap_8_1632 r0 *1 0,0
Xsg13cmos5l_decap_8_1632 VPWR VGND sg13cmos5l_decap_8
* cell instance sg13cmos5l_decap_8_1633 r0 *1 0,0
Xsg13cmos5l_decap_8_1633 VPWR VGND sg13cmos5l_decap_8
* cell instance sg13cmos5l_decap_8_1634 r0 *1 0,0
Xsg13cmos5l_decap_8_1634 VPWR VGND sg13cmos5l_decap_8
* cell instance sg13cmos5l_decap_8_1635 r0 *1 0,0
Xsg13cmos5l_decap_8_1635 VPWR VGND sg13cmos5l_decap_8
* cell instance sg13cmos5l_decap_8_1636 r0 *1 0,0
Xsg13cmos5l_decap_8_1636 VPWR VGND sg13cmos5l_decap_8
* cell instance sg13cmos5l_decap_8_1637 r0 *1 0,0
Xsg13cmos5l_decap_8_1637 VPWR VGND sg13cmos5l_decap_8
* cell instance sg13cmos5l_decap_8_1638 r0 *1 0,0
Xsg13cmos5l_decap_8_1638 VPWR VGND sg13cmos5l_decap_8
* cell instance sg13cmos5l_decap_8_1639 r0 *1 0,0
Xsg13cmos5l_decap_8_1639 VPWR VGND sg13cmos5l_decap_8
* cell instance sg13cmos5l_decap_8_1640 r0 *1 0,0
Xsg13cmos5l_decap_8_1640 VPWR VGND sg13cmos5l_decap_8
* cell instance sg13cmos5l_decap_8_1641 r0 *1 0,0
Xsg13cmos5l_decap_8_1641 VPWR VGND sg13cmos5l_decap_8
* cell instance sg13cmos5l_decap_8_1642 r0 *1 0,0
Xsg13cmos5l_decap_8_1642 VPWR VGND sg13cmos5l_decap_8
* cell instance sg13cmos5l_decap_8_1643 r0 *1 0,0
Xsg13cmos5l_decap_8_1643 VPWR VGND sg13cmos5l_decap_8
* cell instance sg13cmos5l_decap_8_1644 r0 *1 0,0
Xsg13cmos5l_decap_8_1644 VPWR VGND sg13cmos5l_decap_8
* cell instance sg13cmos5l_decap_8_1645 r0 *1 0,0
Xsg13cmos5l_decap_8_1645 VPWR VGND sg13cmos5l_decap_8
* cell instance sg13cmos5l_decap_8_1646 r0 *1 0,0
Xsg13cmos5l_decap_8_1646 VPWR VGND sg13cmos5l_decap_8
* cell instance sg13cmos5l_decap_8_1647 r0 *1 0,0
Xsg13cmos5l_decap_8_1647 VPWR VGND sg13cmos5l_decap_8
* cell instance sg13cmos5l_decap_8_1648 r0 *1 0,0
Xsg13cmos5l_decap_8_1648 VPWR VGND sg13cmos5l_decap_8
* cell instance sg13cmos5l_decap_8_1649 r0 *1 0,0
Xsg13cmos5l_decap_8_1649 VPWR VGND sg13cmos5l_decap_8
* cell instance sg13cmos5l_decap_8_1650 r0 *1 0,0
Xsg13cmos5l_decap_8_1650 VPWR VGND sg13cmos5l_decap_8
* cell instance sg13cmos5l_decap_8_1651 r0 *1 0,0
Xsg13cmos5l_decap_8_1651 VPWR VGND sg13cmos5l_decap_8
* cell instance sg13cmos5l_decap_8_1652 r0 *1 0,0
Xsg13cmos5l_decap_8_1652 VPWR VGND sg13cmos5l_decap_8
* cell instance sg13cmos5l_decap_8_1653 r0 *1 0,0
Xsg13cmos5l_decap_8_1653 VPWR VGND sg13cmos5l_decap_8
* cell instance sg13cmos5l_decap_8_1654 r0 *1 0,0
Xsg13cmos5l_decap_8_1654 VPWR VGND sg13cmos5l_decap_8
* cell instance sg13cmos5l_decap_8_1655 r0 *1 0,0
Xsg13cmos5l_decap_8_1655 VPWR VGND sg13cmos5l_decap_8
* cell instance sg13cmos5l_decap_8_1656 r0 *1 0,0
Xsg13cmos5l_decap_8_1656 VPWR VGND sg13cmos5l_decap_8
* cell instance sg13cmos5l_decap_8_1657 r0 *1 0,0
Xsg13cmos5l_decap_8_1657 VPWR VGND sg13cmos5l_decap_8
* cell instance sg13cmos5l_decap_8_1658 r0 *1 0,0
Xsg13cmos5l_decap_8_1658 VPWR VGND sg13cmos5l_decap_8
* cell instance sg13cmos5l_decap_8_1659 r0 *1 0,0
Xsg13cmos5l_decap_8_1659 VPWR VGND sg13cmos5l_decap_8
* cell instance sg13cmos5l_decap_8_1660 r0 *1 0,0
Xsg13cmos5l_decap_8_1660 VPWR VGND sg13cmos5l_decap_8
* cell instance sg13cmos5l_decap_8_1661 r0 *1 0,0
Xsg13cmos5l_decap_8_1661 VPWR VGND sg13cmos5l_decap_8
* cell instance sg13cmos5l_decap_8_1662 r0 *1 0,0
Xsg13cmos5l_decap_8_1662 VPWR VGND sg13cmos5l_decap_8
* cell instance sg13cmos5l_decap_8_1663 r0 *1 0,0
Xsg13cmos5l_decap_8_1663 VPWR VGND sg13cmos5l_decap_8
* cell instance sg13cmos5l_decap_8_1664 r0 *1 0,0
Xsg13cmos5l_decap_8_1664 VPWR VGND sg13cmos5l_decap_8
* cell instance sg13cmos5l_decap_8_1665 r0 *1 0,0
Xsg13cmos5l_decap_8_1665 VPWR VGND sg13cmos5l_decap_8
* cell instance sg13cmos5l_decap_8_1666 r0 *1 0,0
Xsg13cmos5l_decap_8_1666 VPWR VGND sg13cmos5l_decap_8
* cell instance sg13cmos5l_decap_8_1667 r0 *1 0,0
Xsg13cmos5l_decap_8_1667 VPWR VGND sg13cmos5l_decap_8
* cell instance sg13cmos5l_decap_8_1668 r0 *1 0,0
Xsg13cmos5l_decap_8_1668 VPWR VGND sg13cmos5l_decap_8
* cell instance sg13cmos5l_decap_8_1669 r0 *1 0,0
Xsg13cmos5l_decap_8_1669 VPWR VGND sg13cmos5l_decap_8
* cell instance sg13cmos5l_decap_8_1670 r0 *1 0,0
Xsg13cmos5l_decap_8_1670 VPWR VGND sg13cmos5l_decap_8
* cell instance sg13cmos5l_decap_8_1671 r0 *1 0,0
Xsg13cmos5l_decap_8_1671 VPWR VGND sg13cmos5l_decap_8
* cell instance sg13cmos5l_decap_8_1672 r0 *1 0,0
Xsg13cmos5l_decap_8_1672 VPWR VGND sg13cmos5l_decap_8
* cell instance sg13cmos5l_decap_8_1673 r0 *1 0,0
Xsg13cmos5l_decap_8_1673 VPWR VGND sg13cmos5l_decap_8
* cell instance sg13cmos5l_decap_8_1674 r0 *1 0,0
Xsg13cmos5l_decap_8_1674 VPWR VGND sg13cmos5l_decap_8
* cell instance sg13cmos5l_decap_8_1675 r0 *1 0,0
Xsg13cmos5l_decap_8_1675 VPWR VGND sg13cmos5l_decap_8
* cell instance sg13cmos5l_decap_8_1676 r0 *1 0,0
Xsg13cmos5l_decap_8_1676 VPWR VGND sg13cmos5l_decap_8
* cell instance sg13cmos5l_decap_8_1677 r0 *1 0,0
Xsg13cmos5l_decap_8_1677 VPWR VGND sg13cmos5l_decap_8
* cell instance sg13cmos5l_decap_8_1678 r0 *1 0,0
Xsg13cmos5l_decap_8_1678 VPWR VGND sg13cmos5l_decap_8
* cell instance sg13cmos5l_decap_8_1679 r0 *1 0,0
Xsg13cmos5l_decap_8_1679 VPWR VGND sg13cmos5l_decap_8
* cell instance sg13cmos5l_decap_8_1680 r0 *1 0,0
Xsg13cmos5l_decap_8_1680 VPWR VGND sg13cmos5l_decap_8
* cell instance sg13cmos5l_decap_8_1681 r0 *1 0,0
Xsg13cmos5l_decap_8_1681 VPWR VGND sg13cmos5l_decap_8
* cell instance sg13cmos5l_decap_8_1682 r0 *1 0,0
Xsg13cmos5l_decap_8_1682 VPWR VGND sg13cmos5l_decap_8
* cell instance sg13cmos5l_decap_8_1683 r0 *1 0,0
Xsg13cmos5l_decap_8_1683 VPWR VGND sg13cmos5l_decap_8
* cell instance sg13cmos5l_decap_8_1684 r0 *1 0,0
Xsg13cmos5l_decap_8_1684 VPWR VGND sg13cmos5l_decap_8
* cell instance sg13cmos5l_decap_8_1685 r0 *1 0,0
Xsg13cmos5l_decap_8_1685 VPWR VGND sg13cmos5l_decap_8
* cell instance sg13cmos5l_decap_8_1686 r0 *1 0,0
Xsg13cmos5l_decap_8_1686 VPWR VGND sg13cmos5l_decap_8
* cell instance sg13cmos5l_decap_8_1687 r0 *1 0,0
Xsg13cmos5l_decap_8_1687 VPWR VGND sg13cmos5l_decap_8
* cell instance sg13cmos5l_decap_8_1688 r0 *1 0,0
Xsg13cmos5l_decap_8_1688 VPWR VGND sg13cmos5l_decap_8
* cell instance sg13cmos5l_decap_8_1689 r0 *1 0,0
Xsg13cmos5l_decap_8_1689 VPWR VGND sg13cmos5l_decap_8
* cell instance sg13cmos5l_decap_8_1690 r0 *1 0,0
Xsg13cmos5l_decap_8_1690 VPWR VGND sg13cmos5l_decap_8
* cell instance sg13cmos5l_decap_8_1691 r0 *1 0,0
Xsg13cmos5l_decap_8_1691 VPWR VGND sg13cmos5l_decap_8
* cell instance sg13cmos5l_decap_8_1692 r0 *1 0,0
Xsg13cmos5l_decap_8_1692 VPWR VGND sg13cmos5l_decap_8
* cell instance sg13cmos5l_decap_8_1693 r0 *1 0,0
Xsg13cmos5l_decap_8_1693 VPWR VGND sg13cmos5l_decap_8
* cell instance sg13cmos5l_decap_8_1694 r0 *1 0,0
Xsg13cmos5l_decap_8_1694 VPWR VGND sg13cmos5l_decap_8
* cell instance sg13cmos5l_decap_8_1695 r0 *1 0,0
Xsg13cmos5l_decap_8_1695 VPWR VGND sg13cmos5l_decap_8
* cell instance sg13cmos5l_decap_8_1696 r0 *1 0,0
Xsg13cmos5l_decap_8_1696 VPWR VGND sg13cmos5l_decap_8
* cell instance sg13cmos5l_decap_8_1697 r0 *1 0,0
Xsg13cmos5l_decap_8_1697 VPWR VGND sg13cmos5l_decap_8
* cell instance sg13cmos5l_decap_8_1698 r0 *1 0,0
Xsg13cmos5l_decap_8_1698 VPWR VGND sg13cmos5l_decap_8
* cell instance sg13cmos5l_decap_8_1699 r0 *1 0,0
Xsg13cmos5l_decap_8_1699 VPWR VGND sg13cmos5l_decap_8
* cell instance sg13cmos5l_decap_8_1700 r0 *1 0,0
Xsg13cmos5l_decap_8_1700 VPWR VGND sg13cmos5l_decap_8
* cell instance sg13cmos5l_decap_8_1701 r0 *1 0,0
Xsg13cmos5l_decap_8_1701 VPWR VGND sg13cmos5l_decap_8
* cell instance sg13cmos5l_decap_8_1702 r0 *1 0,0
Xsg13cmos5l_decap_8_1702 VPWR VGND sg13cmos5l_decap_8
* cell instance sg13cmos5l_decap_8_1703 r0 *1 0,0
Xsg13cmos5l_decap_8_1703 VPWR VGND sg13cmos5l_decap_8
* cell instance sg13cmos5l_decap_8_1704 r0 *1 0,0
Xsg13cmos5l_decap_8_1704 VPWR VGND sg13cmos5l_decap_8
* cell instance sg13cmos5l_decap_8_1705 r0 *1 0,0
Xsg13cmos5l_decap_8_1705 VPWR VGND sg13cmos5l_decap_8
* cell instance sg13cmos5l_decap_8_1706 r0 *1 0,0
Xsg13cmos5l_decap_8_1706 VPWR VGND sg13cmos5l_decap_8
* cell instance sg13cmos5l_decap_8_1707 r0 *1 0,0
Xsg13cmos5l_decap_8_1707 VPWR VGND sg13cmos5l_decap_8
* cell instance sg13cmos5l_decap_8_1708 r0 *1 0,0
Xsg13cmos5l_decap_8_1708 VPWR VGND sg13cmos5l_decap_8
* cell instance sg13cmos5l_decap_8_1709 r0 *1 0,0
Xsg13cmos5l_decap_8_1709 VPWR VGND sg13cmos5l_decap_8
* cell instance sg13cmos5l_decap_8_1710 r0 *1 0,0
Xsg13cmos5l_decap_8_1710 VPWR VGND sg13cmos5l_decap_8
* cell instance sg13cmos5l_decap_8_1711 r0 *1 0,0
Xsg13cmos5l_decap_8_1711 VPWR VGND sg13cmos5l_decap_8
* cell instance sg13cmos5l_decap_8_1712 r0 *1 0,0
Xsg13cmos5l_decap_8_1712 VPWR VGND sg13cmos5l_decap_8
* cell instance sg13cmos5l_decap_8_1713 r0 *1 0,0
Xsg13cmos5l_decap_8_1713 VPWR VGND sg13cmos5l_decap_8
* cell instance sg13cmos5l_decap_8_1714 r0 *1 0,0
Xsg13cmos5l_decap_8_1714 VPWR VGND sg13cmos5l_decap_8
* cell instance sg13cmos5l_decap_8_1715 r0 *1 0,0
Xsg13cmos5l_decap_8_1715 VPWR VGND sg13cmos5l_decap_8
* cell instance sg13cmos5l_decap_8_1716 r0 *1 0,0
Xsg13cmos5l_decap_8_1716 VPWR VGND sg13cmos5l_decap_8
* cell instance sg13cmos5l_decap_8_1717 r0 *1 0,0
Xsg13cmos5l_decap_8_1717 VPWR VGND sg13cmos5l_decap_8
* cell instance sg13cmos5l_decap_8_1718 r0 *1 0,0
Xsg13cmos5l_decap_8_1718 VPWR VGND sg13cmos5l_decap_8
* cell instance sg13cmos5l_decap_8_1719 r0 *1 0,0
Xsg13cmos5l_decap_8_1719 VPWR VGND sg13cmos5l_decap_8
* cell instance sg13cmos5l_decap_8_1720 r0 *1 0,0
Xsg13cmos5l_decap_8_1720 VPWR VGND sg13cmos5l_decap_8
* cell instance sg13cmos5l_decap_8_1721 r0 *1 0,0
Xsg13cmos5l_decap_8_1721 VPWR VGND sg13cmos5l_decap_8
* cell instance sg13cmos5l_decap_8_1722 r0 *1 0,0
Xsg13cmos5l_decap_8_1722 VPWR VGND sg13cmos5l_decap_8
* cell instance sg13cmos5l_decap_8_1723 r0 *1 0,0
Xsg13cmos5l_decap_8_1723 VPWR VGND sg13cmos5l_decap_8
* cell instance sg13cmos5l_decap_8_1724 r0 *1 0,0
Xsg13cmos5l_decap_8_1724 VPWR VGND sg13cmos5l_decap_8
* cell instance sg13cmos5l_decap_8_1725 r0 *1 0,0
Xsg13cmos5l_decap_8_1725 VPWR VGND sg13cmos5l_decap_8
* cell instance sg13cmos5l_decap_8_1726 r0 *1 0,0
Xsg13cmos5l_decap_8_1726 VPWR VGND sg13cmos5l_decap_8
* cell instance sg13cmos5l_decap_8_1727 r0 *1 0,0
Xsg13cmos5l_decap_8_1727 VPWR VGND sg13cmos5l_decap_8
* cell instance sg13cmos5l_decap_8_1728 r0 *1 0,0
Xsg13cmos5l_decap_8_1728 VPWR VGND sg13cmos5l_decap_8
* cell instance sg13cmos5l_decap_8_1729 r0 *1 0,0
Xsg13cmos5l_decap_8_1729 VPWR VGND sg13cmos5l_decap_8
* cell instance sg13cmos5l_decap_8_1730 r0 *1 0,0
Xsg13cmos5l_decap_8_1730 VPWR VGND sg13cmos5l_decap_8
* cell instance sg13cmos5l_decap_8_1731 r0 *1 0,0
Xsg13cmos5l_decap_8_1731 VPWR VGND sg13cmos5l_decap_8
* cell instance sg13cmos5l_decap_8_1732 r0 *1 0,0
Xsg13cmos5l_decap_8_1732 VPWR VGND sg13cmos5l_decap_8
* cell instance sg13cmos5l_decap_8_1733 r0 *1 0,0
Xsg13cmos5l_decap_8_1733 VPWR VGND sg13cmos5l_decap_8
* cell instance sg13cmos5l_decap_8_1734 r0 *1 0,0
Xsg13cmos5l_decap_8_1734 VPWR VGND sg13cmos5l_decap_8
* cell instance sg13cmos5l_decap_8_1735 r0 *1 0,0
Xsg13cmos5l_decap_8_1735 VPWR VGND sg13cmos5l_decap_8
* cell instance sg13cmos5l_decap_8_1736 r0 *1 0,0
Xsg13cmos5l_decap_8_1736 VPWR VGND sg13cmos5l_decap_8
* cell instance sg13cmos5l_decap_8_1737 r0 *1 0,0
Xsg13cmos5l_decap_8_1737 VPWR VGND sg13cmos5l_decap_8
* cell instance sg13cmos5l_decap_8_1738 r0 *1 0,0
Xsg13cmos5l_decap_8_1738 VPWR VGND sg13cmos5l_decap_8
* cell instance sg13cmos5l_decap_8_1739 r0 *1 0,0
Xsg13cmos5l_decap_8_1739 VPWR VGND sg13cmos5l_decap_8
* cell instance sg13cmos5l_decap_8_1740 r0 *1 0,0
Xsg13cmos5l_decap_8_1740 VPWR VGND sg13cmos5l_decap_8
* cell instance sg13cmos5l_decap_8_1741 r0 *1 0,0
Xsg13cmos5l_decap_8_1741 VPWR VGND sg13cmos5l_decap_8
* cell instance sg13cmos5l_decap_8_1742 r0 *1 0,0
Xsg13cmos5l_decap_8_1742 VPWR VGND sg13cmos5l_decap_8
* cell instance sg13cmos5l_decap_8_1743 r0 *1 0,0
Xsg13cmos5l_decap_8_1743 VPWR VGND sg13cmos5l_decap_8
* cell instance sg13cmos5l_decap_8_1744 r0 *1 0,0
Xsg13cmos5l_decap_8_1744 VPWR VGND sg13cmos5l_decap_8
* cell instance sg13cmos5l_decap_8_1745 r0 *1 0,0
Xsg13cmos5l_decap_8_1745 VPWR VGND sg13cmos5l_decap_8
* cell instance sg13cmos5l_decap_8_1746 r0 *1 0,0
Xsg13cmos5l_decap_8_1746 VPWR VGND sg13cmos5l_decap_8
* cell instance sg13cmos5l_decap_8_1747 r0 *1 0,0
Xsg13cmos5l_decap_8_1747 VPWR VGND sg13cmos5l_decap_8
* cell instance sg13cmos5l_decap_8_1748 r0 *1 0,0
Xsg13cmos5l_decap_8_1748 VPWR VGND sg13cmos5l_decap_8
* cell instance sg13cmos5l_decap_8_1749 r0 *1 0,0
Xsg13cmos5l_decap_8_1749 VPWR VGND sg13cmos5l_decap_8
* cell instance sg13cmos5l_decap_8_1750 r0 *1 0,0
Xsg13cmos5l_decap_8_1750 VPWR VGND sg13cmos5l_decap_8
* cell instance sg13cmos5l_decap_8_1751 r0 *1 0,0
Xsg13cmos5l_decap_8_1751 VPWR VGND sg13cmos5l_decap_8
* cell instance sg13cmos5l_decap_8_1752 r0 *1 0,0
Xsg13cmos5l_decap_8_1752 VPWR VGND sg13cmos5l_decap_8
* cell instance sg13cmos5l_decap_8_1753 r0 *1 0,0
Xsg13cmos5l_decap_8_1753 VPWR VGND sg13cmos5l_decap_8
* cell instance sg13cmos5l_decap_8_1754 r0 *1 0,0
Xsg13cmos5l_decap_8_1754 VPWR VGND sg13cmos5l_decap_8
* cell instance sg13cmos5l_decap_8_1755 r0 *1 0,0
Xsg13cmos5l_decap_8_1755 VPWR VGND sg13cmos5l_decap_8
* cell instance sg13cmos5l_decap_8_1756 r0 *1 0,0
Xsg13cmos5l_decap_8_1756 VPWR VGND sg13cmos5l_decap_8
* cell instance sg13cmos5l_decap_8_1757 r0 *1 0,0
Xsg13cmos5l_decap_8_1757 VPWR VGND sg13cmos5l_decap_8
* cell instance sg13cmos5l_decap_8_1758 r0 *1 0,0
Xsg13cmos5l_decap_8_1758 VPWR VGND sg13cmos5l_decap_8
* cell instance sg13cmos5l_decap_8_1759 r0 *1 0,0
Xsg13cmos5l_decap_8_1759 VPWR VGND sg13cmos5l_decap_8
* cell instance sg13cmos5l_decap_8_1760 r0 *1 0,0
Xsg13cmos5l_decap_8_1760 VPWR VGND sg13cmos5l_decap_8
* cell instance sg13cmos5l_decap_8_1761 r0 *1 0,0
Xsg13cmos5l_decap_8_1761 VPWR VGND sg13cmos5l_decap_8
* cell instance sg13cmos5l_decap_8_1762 r0 *1 0,0
Xsg13cmos5l_decap_8_1762 VPWR VGND sg13cmos5l_decap_8
* cell instance sg13cmos5l_decap_8_1763 r0 *1 0,0
Xsg13cmos5l_decap_8_1763 VPWR VGND sg13cmos5l_decap_8
* cell instance sg13cmos5l_decap_8_1764 r0 *1 0,0
Xsg13cmos5l_decap_8_1764 VPWR VGND sg13cmos5l_decap_8
* cell instance sg13cmos5l_decap_8_1765 r0 *1 0,0
Xsg13cmos5l_decap_8_1765 VPWR VGND sg13cmos5l_decap_8
* cell instance sg13cmos5l_decap_8_1766 r0 *1 0,0
Xsg13cmos5l_decap_8_1766 VPWR VGND sg13cmos5l_decap_8
* cell instance sg13cmos5l_decap_8_1767 r0 *1 0,0
Xsg13cmos5l_decap_8_1767 VPWR VGND sg13cmos5l_decap_8
* cell instance sg13cmos5l_decap_8_1768 r0 *1 0,0
Xsg13cmos5l_decap_8_1768 VPWR VGND sg13cmos5l_decap_8
* cell instance sg13cmos5l_decap_8_1769 r0 *1 0,0
Xsg13cmos5l_decap_8_1769 VPWR VGND sg13cmos5l_decap_8
* cell instance sg13cmos5l_decap_8_1770 r0 *1 0,0
Xsg13cmos5l_decap_8_1770 VPWR VGND sg13cmos5l_decap_8
* cell instance sg13cmos5l_decap_8_1771 r0 *1 0,0
Xsg13cmos5l_decap_8_1771 VPWR VGND sg13cmos5l_decap_8
* cell instance sg13cmos5l_decap_8_1772 r0 *1 0,0
Xsg13cmos5l_decap_8_1772 VPWR VGND sg13cmos5l_decap_8
* cell instance sg13cmos5l_decap_8_1773 r0 *1 0,0
Xsg13cmos5l_decap_8_1773 VPWR VGND sg13cmos5l_decap_8
* cell instance sg13cmos5l_decap_8_1774 r0 *1 0,0
Xsg13cmos5l_decap_8_1774 VPWR VGND sg13cmos5l_decap_8
* cell instance sg13cmos5l_decap_8_1775 r0 *1 0,0
Xsg13cmos5l_decap_8_1775 VPWR VGND sg13cmos5l_decap_8
* cell instance sg13cmos5l_decap_8_1776 r0 *1 0,0
Xsg13cmos5l_decap_8_1776 VPWR VGND sg13cmos5l_decap_8
* cell instance sg13cmos5l_decap_8_1777 r0 *1 0,0
Xsg13cmos5l_decap_8_1777 VPWR VGND sg13cmos5l_decap_8
* cell instance sg13cmos5l_decap_8_1778 r0 *1 0,0
Xsg13cmos5l_decap_8_1778 VPWR VGND sg13cmos5l_decap_8
* cell instance sg13cmos5l_decap_8_1779 r0 *1 0,0
Xsg13cmos5l_decap_8_1779 VPWR VGND sg13cmos5l_decap_8
* cell instance sg13cmos5l_decap_8_1780 r0 *1 0,0
Xsg13cmos5l_decap_8_1780 VPWR VGND sg13cmos5l_decap_8
* cell instance sg13cmos5l_decap_8_1781 r0 *1 0,0
Xsg13cmos5l_decap_8_1781 VPWR VGND sg13cmos5l_decap_8
* cell instance sg13cmos5l_decap_8_1782 r0 *1 0,0
Xsg13cmos5l_decap_8_1782 VPWR VGND sg13cmos5l_decap_8
* cell instance sg13cmos5l_decap_8_1783 r0 *1 0,0
Xsg13cmos5l_decap_8_1783 VPWR VGND sg13cmos5l_decap_8
* cell instance sg13cmos5l_decap_8_1784 r0 *1 0,0
Xsg13cmos5l_decap_8_1784 VPWR VGND sg13cmos5l_decap_8
* cell instance sg13cmos5l_decap_8_1785 r0 *1 0,0
Xsg13cmos5l_decap_8_1785 VPWR VGND sg13cmos5l_decap_8
* cell instance sg13cmos5l_decap_8_1786 r0 *1 0,0
Xsg13cmos5l_decap_8_1786 VPWR VGND sg13cmos5l_decap_8
* cell instance sg13cmos5l_decap_8_1787 r0 *1 0,0
Xsg13cmos5l_decap_8_1787 VPWR VGND sg13cmos5l_decap_8
* cell instance sg13cmos5l_decap_8_1788 r0 *1 0,0
Xsg13cmos5l_decap_8_1788 VPWR VGND sg13cmos5l_decap_8
* cell instance sg13cmos5l_decap_8_1789 r0 *1 0,0
Xsg13cmos5l_decap_8_1789 VPWR VGND sg13cmos5l_decap_8
* cell instance sg13cmos5l_decap_8_1790 r0 *1 0,0
Xsg13cmos5l_decap_8_1790 VPWR VGND sg13cmos5l_decap_8
* cell instance sg13cmos5l_decap_8_1791 r0 *1 0,0
Xsg13cmos5l_decap_8_1791 VPWR VGND sg13cmos5l_decap_8
* cell instance sg13cmos5l_decap_8_1792 r0 *1 0,0
Xsg13cmos5l_decap_8_1792 VPWR VGND sg13cmos5l_decap_8
* cell instance sg13cmos5l_decap_8_1793 r0 *1 0,0
Xsg13cmos5l_decap_8_1793 VPWR VGND sg13cmos5l_decap_8
* cell instance sg13cmos5l_decap_8_1794 r0 *1 0,0
Xsg13cmos5l_decap_8_1794 VPWR VGND sg13cmos5l_decap_8
* cell instance sg13cmos5l_decap_8_1795 r0 *1 0,0
Xsg13cmos5l_decap_8_1795 VPWR VGND sg13cmos5l_decap_8
* cell instance sg13cmos5l_decap_8_1796 r0 *1 0,0
Xsg13cmos5l_decap_8_1796 VPWR VGND sg13cmos5l_decap_8
* cell instance sg13cmos5l_decap_8_1797 r0 *1 0,0
Xsg13cmos5l_decap_8_1797 VPWR VGND sg13cmos5l_decap_8
* cell instance sg13cmos5l_decap_8_1798 r0 *1 0,0
Xsg13cmos5l_decap_8_1798 VPWR VGND sg13cmos5l_decap_8
* cell instance sg13cmos5l_decap_8_1799 r0 *1 0,0
Xsg13cmos5l_decap_8_1799 VPWR VGND sg13cmos5l_decap_8
* cell instance sg13cmos5l_decap_8_1800 r0 *1 0,0
Xsg13cmos5l_decap_8_1800 VPWR VGND sg13cmos5l_decap_8
* cell instance sg13cmos5l_decap_8_1801 r0 *1 0,0
Xsg13cmos5l_decap_8_1801 VPWR VGND sg13cmos5l_decap_8
* cell instance sg13cmos5l_decap_8_1802 r0 *1 0,0
Xsg13cmos5l_decap_8_1802 VPWR VGND sg13cmos5l_decap_8
* cell instance sg13cmos5l_decap_8_1803 r0 *1 0,0
Xsg13cmos5l_decap_8_1803 VPWR VGND sg13cmos5l_decap_8
* cell instance sg13cmos5l_decap_8_1804 r0 *1 0,0
Xsg13cmos5l_decap_8_1804 VPWR VGND sg13cmos5l_decap_8
* cell instance sg13cmos5l_decap_8_1805 r0 *1 0,0
Xsg13cmos5l_decap_8_1805 VPWR VGND sg13cmos5l_decap_8
* cell instance sg13cmos5l_decap_8_1806 r0 *1 0,0
Xsg13cmos5l_decap_8_1806 VPWR VGND sg13cmos5l_decap_8
* cell instance sg13cmos5l_decap_8_1807 r0 *1 0,0
Xsg13cmos5l_decap_8_1807 VPWR VGND sg13cmos5l_decap_8
* cell instance sg13cmos5l_decap_8_1808 r0 *1 0,0
Xsg13cmos5l_decap_8_1808 VPWR VGND sg13cmos5l_decap_8
* cell instance sg13cmos5l_decap_8_1809 r0 *1 0,0
Xsg13cmos5l_decap_8_1809 VPWR VGND sg13cmos5l_decap_8
* cell instance sg13cmos5l_decap_8_1810 r0 *1 0,0
Xsg13cmos5l_decap_8_1810 VPWR VGND sg13cmos5l_decap_8
* cell instance sg13cmos5l_decap_8_1811 r0 *1 0,0
Xsg13cmos5l_decap_8_1811 VPWR VGND sg13cmos5l_decap_8
* cell instance sg13cmos5l_decap_8_1812 r0 *1 0,0
Xsg13cmos5l_decap_8_1812 VPWR VGND sg13cmos5l_decap_8
* cell instance sg13cmos5l_decap_8_1813 r0 *1 0,0
Xsg13cmos5l_decap_8_1813 VPWR VGND sg13cmos5l_decap_8
* cell instance sg13cmos5l_decap_8_1814 r0 *1 0,0
Xsg13cmos5l_decap_8_1814 VPWR VGND sg13cmos5l_decap_8
* cell instance sg13cmos5l_decap_8_1815 r0 *1 0,0
Xsg13cmos5l_decap_8_1815 VPWR VGND sg13cmos5l_decap_8
* cell instance sg13cmos5l_decap_8_1816 r0 *1 0,0
Xsg13cmos5l_decap_8_1816 VPWR VGND sg13cmos5l_decap_8
* cell instance sg13cmos5l_decap_8_1817 r0 *1 0,0
Xsg13cmos5l_decap_8_1817 VPWR VGND sg13cmos5l_decap_8
* cell instance sg13cmos5l_decap_8_1818 r0 *1 0,0
Xsg13cmos5l_decap_8_1818 VPWR VGND sg13cmos5l_decap_8
* cell instance sg13cmos5l_decap_8_1819 r0 *1 0,0
Xsg13cmos5l_decap_8_1819 VPWR VGND sg13cmos5l_decap_8
* cell instance sg13cmos5l_decap_8_1820 r0 *1 0,0
Xsg13cmos5l_decap_8_1820 VPWR VGND sg13cmos5l_decap_8
* cell instance sg13cmos5l_decap_8_1821 r0 *1 0,0
Xsg13cmos5l_decap_8_1821 VPWR VGND sg13cmos5l_decap_8
* cell instance sg13cmos5l_decap_8_1822 r0 *1 0,0
Xsg13cmos5l_decap_8_1822 VPWR VGND sg13cmos5l_decap_8
* cell instance sg13cmos5l_decap_8_1823 r0 *1 0,0
Xsg13cmos5l_decap_8_1823 VPWR VGND sg13cmos5l_decap_8
* cell instance sg13cmos5l_decap_8_1824 r0 *1 0,0
Xsg13cmos5l_decap_8_1824 VPWR VGND sg13cmos5l_decap_8
* cell instance sg13cmos5l_decap_8_1825 r0 *1 0,0
Xsg13cmos5l_decap_8_1825 VPWR VGND sg13cmos5l_decap_8
* cell instance sg13cmos5l_decap_8_1826 r0 *1 0,0
Xsg13cmos5l_decap_8_1826 VPWR VGND sg13cmos5l_decap_8
* cell instance sg13cmos5l_decap_8_1827 r0 *1 0,0
Xsg13cmos5l_decap_8_1827 VPWR VGND sg13cmos5l_decap_8
* cell instance sg13cmos5l_decap_8_1828 r0 *1 0,0
Xsg13cmos5l_decap_8_1828 VPWR VGND sg13cmos5l_decap_8
* cell instance sg13cmos5l_decap_8_1829 r0 *1 0,0
Xsg13cmos5l_decap_8_1829 VPWR VGND sg13cmos5l_decap_8
* cell instance sg13cmos5l_decap_8_1830 r0 *1 0,0
Xsg13cmos5l_decap_8_1830 VPWR VGND sg13cmos5l_decap_8
* cell instance sg13cmos5l_decap_8_1831 r0 *1 0,0
Xsg13cmos5l_decap_8_1831 VPWR VGND sg13cmos5l_decap_8
* cell instance sg13cmos5l_decap_8_1832 r0 *1 0,0
Xsg13cmos5l_decap_8_1832 VPWR VGND sg13cmos5l_decap_8
* cell instance sg13cmos5l_decap_8_1833 r0 *1 0,0
Xsg13cmos5l_decap_8_1833 VPWR VGND sg13cmos5l_decap_8
* cell instance sg13cmos5l_decap_8_1834 r0 *1 0,0
Xsg13cmos5l_decap_8_1834 VPWR VGND sg13cmos5l_decap_8
* cell instance sg13cmos5l_decap_8_1835 r0 *1 0,0
Xsg13cmos5l_decap_8_1835 VPWR VGND sg13cmos5l_decap_8
* cell instance sg13cmos5l_decap_8_1836 r0 *1 0,0
Xsg13cmos5l_decap_8_1836 VPWR VGND sg13cmos5l_decap_8
* cell instance sg13cmos5l_decap_8_1837 r0 *1 0,0
Xsg13cmos5l_decap_8_1837 VPWR VGND sg13cmos5l_decap_8
* cell instance sg13cmos5l_decap_8_1838 r0 *1 0,0
Xsg13cmos5l_decap_8_1838 VPWR VGND sg13cmos5l_decap_8
* cell instance sg13cmos5l_decap_8_1839 r0 *1 0,0
Xsg13cmos5l_decap_8_1839 VPWR VGND sg13cmos5l_decap_8
* cell instance sg13cmos5l_decap_8_1840 r0 *1 0,0
Xsg13cmos5l_decap_8_1840 VPWR VGND sg13cmos5l_decap_8
* cell instance sg13cmos5l_decap_8_1841 r0 *1 0,0
Xsg13cmos5l_decap_8_1841 VPWR VGND sg13cmos5l_decap_8
* cell instance sg13cmos5l_decap_8_1842 r0 *1 0,0
Xsg13cmos5l_decap_8_1842 VPWR VGND sg13cmos5l_decap_8
* cell instance sg13cmos5l_decap_8_1843 r0 *1 0,0
Xsg13cmos5l_decap_8_1843 VPWR VGND sg13cmos5l_decap_8
* cell instance sg13cmos5l_decap_8_1844 r0 *1 0,0
Xsg13cmos5l_decap_8_1844 VPWR VGND sg13cmos5l_decap_8
* cell instance sg13cmos5l_decap_8_1845 r0 *1 0,0
Xsg13cmos5l_decap_8_1845 VPWR VGND sg13cmos5l_decap_8
* cell instance sg13cmos5l_decap_8_1846 r0 *1 0,0
Xsg13cmos5l_decap_8_1846 VPWR VGND sg13cmos5l_decap_8
* cell instance sg13cmos5l_decap_8_1847 r0 *1 0,0
Xsg13cmos5l_decap_8_1847 VPWR VGND sg13cmos5l_decap_8
* cell instance sg13cmos5l_decap_8_1848 r0 *1 0,0
Xsg13cmos5l_decap_8_1848 VPWR VGND sg13cmos5l_decap_8
* cell instance sg13cmos5l_decap_8_1849 r0 *1 0,0
Xsg13cmos5l_decap_8_1849 VPWR VGND sg13cmos5l_decap_8
* cell instance sg13cmos5l_decap_8_1850 r0 *1 0,0
Xsg13cmos5l_decap_8_1850 VPWR VGND sg13cmos5l_decap_8
* cell instance sg13cmos5l_decap_8_1851 r0 *1 0,0
Xsg13cmos5l_decap_8_1851 VPWR VGND sg13cmos5l_decap_8
* cell instance sg13cmos5l_decap_8_1852 r0 *1 0,0
Xsg13cmos5l_decap_8_1852 VPWR VGND sg13cmos5l_decap_8
* cell instance sg13cmos5l_decap_8_1853 r0 *1 0,0
Xsg13cmos5l_decap_8_1853 VPWR VGND sg13cmos5l_decap_8
* cell instance sg13cmos5l_decap_8_1854 r0 *1 0,0
Xsg13cmos5l_decap_8_1854 VPWR VGND sg13cmos5l_decap_8
* cell instance sg13cmos5l_decap_8_1855 r0 *1 0,0
Xsg13cmos5l_decap_8_1855 VPWR VGND sg13cmos5l_decap_8
* cell instance sg13cmos5l_decap_8_1856 r0 *1 0,0
Xsg13cmos5l_decap_8_1856 VPWR VGND sg13cmos5l_decap_8
* cell instance sg13cmos5l_decap_8_1857 r0 *1 0,0
Xsg13cmos5l_decap_8_1857 VPWR VGND sg13cmos5l_decap_8
* cell instance sg13cmos5l_decap_8_1858 r0 *1 0,0
Xsg13cmos5l_decap_8_1858 VPWR VGND sg13cmos5l_decap_8
* cell instance sg13cmos5l_decap_8_1859 r0 *1 0,0
Xsg13cmos5l_decap_8_1859 VPWR VGND sg13cmos5l_decap_8
* cell instance sg13cmos5l_decap_8_1860 r0 *1 0,0
Xsg13cmos5l_decap_8_1860 VPWR VGND sg13cmos5l_decap_8
* cell instance sg13cmos5l_decap_8_1861 r0 *1 0,0
Xsg13cmos5l_decap_8_1861 VPWR VGND sg13cmos5l_decap_8
* cell instance sg13cmos5l_decap_8_1862 r0 *1 0,0
Xsg13cmos5l_decap_8_1862 VPWR VGND sg13cmos5l_decap_8
* cell instance sg13cmos5l_decap_8_1863 r0 *1 0,0
Xsg13cmos5l_decap_8_1863 VPWR VGND sg13cmos5l_decap_8
* cell instance sg13cmos5l_decap_8_1864 r0 *1 0,0
Xsg13cmos5l_decap_8_1864 VPWR VGND sg13cmos5l_decap_8
* cell instance sg13cmos5l_decap_8_1865 r0 *1 0,0
Xsg13cmos5l_decap_8_1865 VPWR VGND sg13cmos5l_decap_8
* cell instance sg13cmos5l_decap_8_1866 r0 *1 0,0
Xsg13cmos5l_decap_8_1866 VPWR VGND sg13cmos5l_decap_8
* cell instance sg13cmos5l_decap_8_1867 r0 *1 0,0
Xsg13cmos5l_decap_8_1867 VPWR VGND sg13cmos5l_decap_8
* cell instance sg13cmos5l_decap_8_1868 r0 *1 0,0
Xsg13cmos5l_decap_8_1868 VPWR VGND sg13cmos5l_decap_8
* cell instance sg13cmos5l_decap_8_1869 r0 *1 0,0
Xsg13cmos5l_decap_8_1869 VPWR VGND sg13cmos5l_decap_8
* cell instance sg13cmos5l_decap_8_1870 r0 *1 0,0
Xsg13cmos5l_decap_8_1870 VPWR VGND sg13cmos5l_decap_8
* cell instance sg13cmos5l_decap_8_1871 r0 *1 0,0
Xsg13cmos5l_decap_8_1871 VPWR VGND sg13cmos5l_decap_8
* cell instance sg13cmos5l_decap_8_1872 r0 *1 0,0
Xsg13cmos5l_decap_8_1872 VPWR VGND sg13cmos5l_decap_8
* cell instance sg13cmos5l_decap_8_1873 r0 *1 0,0
Xsg13cmos5l_decap_8_1873 VPWR VGND sg13cmos5l_decap_8
* cell instance sg13cmos5l_decap_8_1874 r0 *1 0,0
Xsg13cmos5l_decap_8_1874 VPWR VGND sg13cmos5l_decap_8
* cell instance sg13cmos5l_decap_8_1875 r0 *1 0,0
Xsg13cmos5l_decap_8_1875 VPWR VGND sg13cmos5l_decap_8
* cell instance sg13cmos5l_decap_8_1876 r0 *1 0,0
Xsg13cmos5l_decap_8_1876 VPWR VGND sg13cmos5l_decap_8
* cell instance sg13cmos5l_decap_8_1877 r0 *1 0,0
Xsg13cmos5l_decap_8_1877 VPWR VGND sg13cmos5l_decap_8
* cell instance sg13cmos5l_decap_8_1878 r0 *1 0,0
Xsg13cmos5l_decap_8_1878 VPWR VGND sg13cmos5l_decap_8
* cell instance sg13cmos5l_decap_8_1879 r0 *1 0,0
Xsg13cmos5l_decap_8_1879 VPWR VGND sg13cmos5l_decap_8
* cell instance sg13cmos5l_decap_8_1880 r0 *1 0,0
Xsg13cmos5l_decap_8_1880 VPWR VGND sg13cmos5l_decap_8
* cell instance sg13cmos5l_decap_8_1881 r0 *1 0,0
Xsg13cmos5l_decap_8_1881 VPWR VGND sg13cmos5l_decap_8
* cell instance sg13cmos5l_decap_8_1882 r0 *1 0,0
Xsg13cmos5l_decap_8_1882 VPWR VGND sg13cmos5l_decap_8
* cell instance sg13cmos5l_decap_8_1883 r0 *1 0,0
Xsg13cmos5l_decap_8_1883 VPWR VGND sg13cmos5l_decap_8
* cell instance sg13cmos5l_decap_8_1884 r0 *1 0,0
Xsg13cmos5l_decap_8_1884 VPWR VGND sg13cmos5l_decap_8
* cell instance sg13cmos5l_decap_8_1885 r0 *1 0,0
Xsg13cmos5l_decap_8_1885 VPWR VGND sg13cmos5l_decap_8
* cell instance sg13cmos5l_decap_8_1886 r0 *1 0,0
Xsg13cmos5l_decap_8_1886 VPWR VGND sg13cmos5l_decap_8
* cell instance sg13cmos5l_decap_8_1887 r0 *1 0,0
Xsg13cmos5l_decap_8_1887 VPWR VGND sg13cmos5l_decap_8
* cell instance sg13cmos5l_decap_8_1888 r0 *1 0,0
Xsg13cmos5l_decap_8_1888 VPWR VGND sg13cmos5l_decap_8
* cell instance sg13cmos5l_decap_8_1889 r0 *1 0,0
Xsg13cmos5l_decap_8_1889 VPWR VGND sg13cmos5l_decap_8
* cell instance sg13cmos5l_decap_8_1890 r0 *1 0,0
Xsg13cmos5l_decap_8_1890 VPWR VGND sg13cmos5l_decap_8
* cell instance sg13cmos5l_decap_8_1891 r0 *1 0,0
Xsg13cmos5l_decap_8_1891 VPWR VGND sg13cmos5l_decap_8
* cell instance sg13cmos5l_decap_8_1892 r0 *1 0,0
Xsg13cmos5l_decap_8_1892 VPWR VGND sg13cmos5l_decap_8
* cell instance sg13cmos5l_decap_8_1893 r0 *1 0,0
Xsg13cmos5l_decap_8_1893 VPWR VGND sg13cmos5l_decap_8
* cell instance sg13cmos5l_decap_8_1894 r0 *1 0,0
Xsg13cmos5l_decap_8_1894 VPWR VGND sg13cmos5l_decap_8
* cell instance sg13cmos5l_decap_8_1895 r0 *1 0,0
Xsg13cmos5l_decap_8_1895 VPWR VGND sg13cmos5l_decap_8
* cell instance sg13cmos5l_decap_8_1896 r0 *1 0,0
Xsg13cmos5l_decap_8_1896 VPWR VGND sg13cmos5l_decap_8
* cell instance sg13cmos5l_decap_8_1897 r0 *1 0,0
Xsg13cmos5l_decap_8_1897 VPWR VGND sg13cmos5l_decap_8
* cell instance sg13cmos5l_decap_8_1898 r0 *1 0,0
Xsg13cmos5l_decap_8_1898 VPWR VGND sg13cmos5l_decap_8
* cell instance sg13cmos5l_decap_8_1899 r0 *1 0,0
Xsg13cmos5l_decap_8_1899 VPWR VGND sg13cmos5l_decap_8
* cell instance sg13cmos5l_decap_8_1900 r0 *1 0,0
Xsg13cmos5l_decap_8_1900 VPWR VGND sg13cmos5l_decap_8
* cell instance sg13cmos5l_decap_8_1901 r0 *1 0,0
Xsg13cmos5l_decap_8_1901 VPWR VGND sg13cmos5l_decap_8
* cell instance sg13cmos5l_decap_8_1902 r0 *1 0,0
Xsg13cmos5l_decap_8_1902 VPWR VGND sg13cmos5l_decap_8
* cell instance sg13cmos5l_decap_8_1903 r0 *1 0,0
Xsg13cmos5l_decap_8_1903 VPWR VGND sg13cmos5l_decap_8
* cell instance sg13cmos5l_decap_8_1904 r0 *1 0,0
Xsg13cmos5l_decap_8_1904 VPWR VGND sg13cmos5l_decap_8
* cell instance sg13cmos5l_decap_8_1905 r0 *1 0,0
Xsg13cmos5l_decap_8_1905 VPWR VGND sg13cmos5l_decap_8
* cell instance sg13cmos5l_decap_8_1906 r0 *1 0,0
Xsg13cmos5l_decap_8_1906 VPWR VGND sg13cmos5l_decap_8
* cell instance sg13cmos5l_decap_8_1907 r0 *1 0,0
Xsg13cmos5l_decap_8_1907 VPWR VGND sg13cmos5l_decap_8
* cell instance sg13cmos5l_decap_8_1908 r0 *1 0,0
Xsg13cmos5l_decap_8_1908 VPWR VGND sg13cmos5l_decap_8
* cell instance sg13cmos5l_decap_8_1909 r0 *1 0,0
Xsg13cmos5l_decap_8_1909 VPWR VGND sg13cmos5l_decap_8
* cell instance sg13cmos5l_decap_8_1910 r0 *1 0,0
Xsg13cmos5l_decap_8_1910 VPWR VGND sg13cmos5l_decap_8
* cell instance sg13cmos5l_decap_8_1911 r0 *1 0,0
Xsg13cmos5l_decap_8_1911 VPWR VGND sg13cmos5l_decap_8
* cell instance sg13cmos5l_decap_8_1912 r0 *1 0,0
Xsg13cmos5l_decap_8_1912 VPWR VGND sg13cmos5l_decap_8
* cell instance sg13cmos5l_decap_8_1913 r0 *1 0,0
Xsg13cmos5l_decap_8_1913 VPWR VGND sg13cmos5l_decap_8
* cell instance sg13cmos5l_decap_8_1914 r0 *1 0,0
Xsg13cmos5l_decap_8_1914 VPWR VGND sg13cmos5l_decap_8
* cell instance sg13cmos5l_decap_8_1915 r0 *1 0,0
Xsg13cmos5l_decap_8_1915 VPWR VGND sg13cmos5l_decap_8
* cell instance sg13cmos5l_decap_8_1916 r0 *1 0,0
Xsg13cmos5l_decap_8_1916 VPWR VGND sg13cmos5l_decap_8
* cell instance sg13cmos5l_decap_8_1917 r0 *1 0,0
Xsg13cmos5l_decap_8_1917 VPWR VGND sg13cmos5l_decap_8
* cell instance sg13cmos5l_decap_8_1918 r0 *1 0,0
Xsg13cmos5l_decap_8_1918 VPWR VGND sg13cmos5l_decap_8
* cell instance sg13cmos5l_decap_8_1919 r0 *1 0,0
Xsg13cmos5l_decap_8_1919 VPWR VGND sg13cmos5l_decap_8
* cell instance sg13cmos5l_decap_8_1920 r0 *1 0,0
Xsg13cmos5l_decap_8_1920 VPWR VGND sg13cmos5l_decap_8
* cell instance sg13cmos5l_decap_8_1921 r0 *1 0,0
Xsg13cmos5l_decap_8_1921 VPWR VGND sg13cmos5l_decap_8
* cell instance sg13cmos5l_decap_8_1922 r0 *1 0,0
Xsg13cmos5l_decap_8_1922 VPWR VGND sg13cmos5l_decap_8
* cell instance sg13cmos5l_decap_8_1923 r0 *1 0,0
Xsg13cmos5l_decap_8_1923 VPWR VGND sg13cmos5l_decap_8
* cell instance sg13cmos5l_decap_8_1924 r0 *1 0,0
Xsg13cmos5l_decap_8_1924 VPWR VGND sg13cmos5l_decap_8
* cell instance sg13cmos5l_decap_8_1925 r0 *1 0,0
Xsg13cmos5l_decap_8_1925 VPWR VGND sg13cmos5l_decap_8
* cell instance sg13cmos5l_decap_8_1926 r0 *1 0,0
Xsg13cmos5l_decap_8_1926 VPWR VGND sg13cmos5l_decap_8
* cell instance sg13cmos5l_decap_8_1927 r0 *1 0,0
Xsg13cmos5l_decap_8_1927 VPWR VGND sg13cmos5l_decap_8
* cell instance sg13cmos5l_decap_8_1928 r0 *1 0,0
Xsg13cmos5l_decap_8_1928 VPWR VGND sg13cmos5l_decap_8
* cell instance sg13cmos5l_decap_8_1929 r0 *1 0,0
Xsg13cmos5l_decap_8_1929 VPWR VGND sg13cmos5l_decap_8
* cell instance sg13cmos5l_decap_8_1930 r0 *1 0,0
Xsg13cmos5l_decap_8_1930 VPWR VGND sg13cmos5l_decap_8
* cell instance sg13cmos5l_decap_8_1931 r0 *1 0,0
Xsg13cmos5l_decap_8_1931 VPWR VGND sg13cmos5l_decap_8
* cell instance sg13cmos5l_decap_8_1932 r0 *1 0,0
Xsg13cmos5l_decap_8_1932 VPWR VGND sg13cmos5l_decap_8
* cell instance sg13cmos5l_decap_8_1933 r0 *1 0,0
Xsg13cmos5l_decap_8_1933 VPWR VGND sg13cmos5l_decap_8
* cell instance sg13cmos5l_decap_8_1934 r0 *1 0,0
Xsg13cmos5l_decap_8_1934 VPWR VGND sg13cmos5l_decap_8
* cell instance sg13cmos5l_decap_8_1935 r0 *1 0,0
Xsg13cmos5l_decap_8_1935 VPWR VGND sg13cmos5l_decap_8
* cell instance sg13cmos5l_decap_8_1936 r0 *1 0,0
Xsg13cmos5l_decap_8_1936 VPWR VGND sg13cmos5l_decap_8
* cell instance sg13cmos5l_decap_8_1937 r0 *1 0,0
Xsg13cmos5l_decap_8_1937 VPWR VGND sg13cmos5l_decap_8
* cell instance sg13cmos5l_decap_8_1938 r0 *1 0,0
Xsg13cmos5l_decap_8_1938 VPWR VGND sg13cmos5l_decap_8
* cell instance sg13cmos5l_decap_8_1939 r0 *1 0,0
Xsg13cmos5l_decap_8_1939 VPWR VGND sg13cmos5l_decap_8
* cell instance sg13cmos5l_decap_8_1940 r0 *1 0,0
Xsg13cmos5l_decap_8_1940 VPWR VGND sg13cmos5l_decap_8
* cell instance sg13cmos5l_decap_8_1941 r0 *1 0,0
Xsg13cmos5l_decap_8_1941 VPWR VGND sg13cmos5l_decap_8
* cell instance sg13cmos5l_decap_8_1942 r0 *1 0,0
Xsg13cmos5l_decap_8_1942 VPWR VGND sg13cmos5l_decap_8
* cell instance sg13cmos5l_decap_8_1943 r0 *1 0,0
Xsg13cmos5l_decap_8_1943 VPWR VGND sg13cmos5l_decap_8
* cell instance sg13cmos5l_decap_8_1944 r0 *1 0,0
Xsg13cmos5l_decap_8_1944 VPWR VGND sg13cmos5l_decap_8
* cell instance sg13cmos5l_decap_8_1945 r0 *1 0,0
Xsg13cmos5l_decap_8_1945 VPWR VGND sg13cmos5l_decap_8
* cell instance sg13cmos5l_decap_8_1946 r0 *1 0,0
Xsg13cmos5l_decap_8_1946 VPWR VGND sg13cmos5l_decap_8
* cell instance sg13cmos5l_decap_8_1947 r0 *1 0,0
Xsg13cmos5l_decap_8_1947 VPWR VGND sg13cmos5l_decap_8
* cell instance sg13cmos5l_decap_8_1948 r0 *1 0,0
Xsg13cmos5l_decap_8_1948 VPWR VGND sg13cmos5l_decap_8
* cell instance sg13cmos5l_decap_8_1949 r0 *1 0,0
Xsg13cmos5l_decap_8_1949 VPWR VGND sg13cmos5l_decap_8
* cell instance sg13cmos5l_decap_8_1950 r0 *1 0,0
Xsg13cmos5l_decap_8_1950 VPWR VGND sg13cmos5l_decap_8
* cell instance sg13cmos5l_decap_8_1951 r0 *1 0,0
Xsg13cmos5l_decap_8_1951 VPWR VGND sg13cmos5l_decap_8
* cell instance sg13cmos5l_decap_8_1952 r0 *1 0,0
Xsg13cmos5l_decap_8_1952 VPWR VGND sg13cmos5l_decap_8
* cell instance sg13cmos5l_decap_8_1953 r0 *1 0,0
Xsg13cmos5l_decap_8_1953 VPWR VGND sg13cmos5l_decap_8
* cell instance sg13cmos5l_decap_8_1954 r0 *1 0,0
Xsg13cmos5l_decap_8_1954 VPWR VGND sg13cmos5l_decap_8
* cell instance sg13cmos5l_decap_8_1955 r0 *1 0,0
Xsg13cmos5l_decap_8_1955 VPWR VGND sg13cmos5l_decap_8
* cell instance sg13cmos5l_decap_8_1956 r0 *1 0,0
Xsg13cmos5l_decap_8_1956 VPWR VGND sg13cmos5l_decap_8
* cell instance sg13cmos5l_decap_8_1957 r0 *1 0,0
Xsg13cmos5l_decap_8_1957 VPWR VGND sg13cmos5l_decap_8
* cell instance sg13cmos5l_decap_8_1958 r0 *1 0,0
Xsg13cmos5l_decap_8_1958 VPWR VGND sg13cmos5l_decap_8
* cell instance sg13cmos5l_decap_8_1959 r0 *1 0,0
Xsg13cmos5l_decap_8_1959 VPWR VGND sg13cmos5l_decap_8
* cell instance sg13cmos5l_decap_8_1960 r0 *1 0,0
Xsg13cmos5l_decap_8_1960 VPWR VGND sg13cmos5l_decap_8
* cell instance sg13cmos5l_decap_8_1961 r0 *1 0,0
Xsg13cmos5l_decap_8_1961 VPWR VGND sg13cmos5l_decap_8
* cell instance sg13cmos5l_decap_8_1962 r0 *1 0,0
Xsg13cmos5l_decap_8_1962 VPWR VGND sg13cmos5l_decap_8
* cell instance sg13cmos5l_decap_8_1963 r0 *1 0,0
Xsg13cmos5l_decap_8_1963 VPWR VGND sg13cmos5l_decap_8
* cell instance sg13cmos5l_decap_8_1964 r0 *1 0,0
Xsg13cmos5l_decap_8_1964 VPWR VGND sg13cmos5l_decap_8
* cell instance sg13cmos5l_decap_8_1965 r0 *1 0,0
Xsg13cmos5l_decap_8_1965 VPWR VGND sg13cmos5l_decap_8
* cell instance sg13cmos5l_decap_8_1966 r0 *1 0,0
Xsg13cmos5l_decap_8_1966 VPWR VGND sg13cmos5l_decap_8
* cell instance sg13cmos5l_decap_8_1967 r0 *1 0,0
Xsg13cmos5l_decap_8_1967 VPWR VGND sg13cmos5l_decap_8
* cell instance sg13cmos5l_decap_8_1968 r0 *1 0,0
Xsg13cmos5l_decap_8_1968 VPWR VGND sg13cmos5l_decap_8
* cell instance sg13cmos5l_decap_8_1969 r0 *1 0,0
Xsg13cmos5l_decap_8_1969 VPWR VGND sg13cmos5l_decap_8
* cell instance sg13cmos5l_decap_8_1970 r0 *1 0,0
Xsg13cmos5l_decap_8_1970 VPWR VGND sg13cmos5l_decap_8
* cell instance sg13cmos5l_decap_8_1971 r0 *1 0,0
Xsg13cmos5l_decap_8_1971 VPWR VGND sg13cmos5l_decap_8
* cell instance sg13cmos5l_decap_8_1972 r0 *1 0,0
Xsg13cmos5l_decap_8_1972 VPWR VGND sg13cmos5l_decap_8
* cell instance sg13cmos5l_decap_8_1973 r0 *1 0,0
Xsg13cmos5l_decap_8_1973 VPWR VGND sg13cmos5l_decap_8
* cell instance sg13cmos5l_decap_8_1974 r0 *1 0,0
Xsg13cmos5l_decap_8_1974 VPWR VGND sg13cmos5l_decap_8
* cell instance sg13cmos5l_decap_8_1975 r0 *1 0,0
Xsg13cmos5l_decap_8_1975 VPWR VGND sg13cmos5l_decap_8
* cell instance sg13cmos5l_decap_8_1976 r0 *1 0,0
Xsg13cmos5l_decap_8_1976 VPWR VGND sg13cmos5l_decap_8
* cell instance sg13cmos5l_decap_8_1977 r0 *1 0,0
Xsg13cmos5l_decap_8_1977 VPWR VGND sg13cmos5l_decap_8
* cell instance sg13cmos5l_decap_8_1978 r0 *1 0,0
Xsg13cmos5l_decap_8_1978 VPWR VGND sg13cmos5l_decap_8
* cell instance sg13cmos5l_decap_8_1979 r0 *1 0,0
Xsg13cmos5l_decap_8_1979 VPWR VGND sg13cmos5l_decap_8
* cell instance sg13cmos5l_decap_8_1980 r0 *1 0,0
Xsg13cmos5l_decap_8_1980 VPWR VGND sg13cmos5l_decap_8
* cell instance sg13cmos5l_decap_8_1981 r0 *1 0,0
Xsg13cmos5l_decap_8_1981 VPWR VGND sg13cmos5l_decap_8
* cell instance sg13cmos5l_decap_8_1982 r0 *1 0,0
Xsg13cmos5l_decap_8_1982 VPWR VGND sg13cmos5l_decap_8
* cell instance sg13cmos5l_decap_8_1983 r0 *1 0,0
Xsg13cmos5l_decap_8_1983 VPWR VGND sg13cmos5l_decap_8
* cell instance sg13cmos5l_decap_8_1984 r0 *1 0,0
Xsg13cmos5l_decap_8_1984 VPWR VGND sg13cmos5l_decap_8
* cell instance sg13cmos5l_decap_8_1985 r0 *1 0,0
Xsg13cmos5l_decap_8_1985 VPWR VGND sg13cmos5l_decap_8
* cell instance sg13cmos5l_decap_8_1986 r0 *1 0,0
Xsg13cmos5l_decap_8_1986 VPWR VGND sg13cmos5l_decap_8
* cell instance sg13cmos5l_decap_8_1987 r0 *1 0,0
Xsg13cmos5l_decap_8_1987 VPWR VGND sg13cmos5l_decap_8
* cell instance sg13cmos5l_decap_8_1988 r0 *1 0,0
Xsg13cmos5l_decap_8_1988 VPWR VGND sg13cmos5l_decap_8
* cell instance sg13cmos5l_decap_8_1989 r0 *1 0,0
Xsg13cmos5l_decap_8_1989 VPWR VGND sg13cmos5l_decap_8
* cell instance sg13cmos5l_decap_8_1990 r0 *1 0,0
Xsg13cmos5l_decap_8_1990 VPWR VGND sg13cmos5l_decap_8
* cell instance sg13cmos5l_decap_8_1991 r0 *1 0,0
Xsg13cmos5l_decap_8_1991 VPWR VGND sg13cmos5l_decap_8
* cell instance sg13cmos5l_decap_8_1992 r0 *1 0,0
Xsg13cmos5l_decap_8_1992 VPWR VGND sg13cmos5l_decap_8
* cell instance sg13cmos5l_decap_8_1993 r0 *1 0,0
Xsg13cmos5l_decap_8_1993 VPWR VGND sg13cmos5l_decap_8
* cell instance sg13cmos5l_decap_8_1994 r0 *1 0,0
Xsg13cmos5l_decap_8_1994 VPWR VGND sg13cmos5l_decap_8
* cell instance sg13cmos5l_decap_8_1995 r0 *1 0,0
Xsg13cmos5l_decap_8_1995 VPWR VGND sg13cmos5l_decap_8
* cell instance sg13cmos5l_decap_8_1996 r0 *1 0,0
Xsg13cmos5l_decap_8_1996 VPWR VGND sg13cmos5l_decap_8
* cell instance sg13cmos5l_decap_8_1997 r0 *1 0,0
Xsg13cmos5l_decap_8_1997 VPWR VGND sg13cmos5l_decap_8
* cell instance sg13cmos5l_decap_8_1998 r0 *1 0,0
Xsg13cmos5l_decap_8_1998 VPWR VGND sg13cmos5l_decap_8
* cell instance sg13cmos5l_decap_8_1999 r0 *1 0,0
Xsg13cmos5l_decap_8_1999 VPWR VGND sg13cmos5l_decap_8
* cell instance sg13cmos5l_decap_8_2000 r0 *1 0,0
Xsg13cmos5l_decap_8_2000 VPWR VGND sg13cmos5l_decap_8
* cell instance sg13cmos5l_decap_8_2001 r0 *1 0,0
Xsg13cmos5l_decap_8_2001 VPWR VGND sg13cmos5l_decap_8
* cell instance sg13cmos5l_decap_8_2002 r0 *1 0,0
Xsg13cmos5l_decap_8_2002 VPWR VGND sg13cmos5l_decap_8
* cell instance sg13cmos5l_decap_8_2003 r0 *1 0,0
Xsg13cmos5l_decap_8_2003 VPWR VGND sg13cmos5l_decap_8
* cell instance sg13cmos5l_decap_8_2004 r0 *1 0,0
Xsg13cmos5l_decap_8_2004 VPWR VGND sg13cmos5l_decap_8
* cell instance sg13cmos5l_decap_8_2005 r0 *1 0,0
Xsg13cmos5l_decap_8_2005 VPWR VGND sg13cmos5l_decap_8
* cell instance sg13cmos5l_decap_8_2006 r0 *1 0,0
Xsg13cmos5l_decap_8_2006 VPWR VGND sg13cmos5l_decap_8
* cell instance sg13cmos5l_decap_8_2007 r0 *1 0,0
Xsg13cmos5l_decap_8_2007 VPWR VGND sg13cmos5l_decap_8
* cell instance sg13cmos5l_decap_8_2008 r0 *1 0,0
Xsg13cmos5l_decap_8_2008 VPWR VGND sg13cmos5l_decap_8
* cell instance sg13cmos5l_decap_8_2009 r0 *1 0,0
Xsg13cmos5l_decap_8_2009 VPWR VGND sg13cmos5l_decap_8
* cell instance sg13cmos5l_decap_8_2010 r0 *1 0,0
Xsg13cmos5l_decap_8_2010 VPWR VGND sg13cmos5l_decap_8
* cell instance sg13cmos5l_decap_8_2011 r0 *1 0,0
Xsg13cmos5l_decap_8_2011 VPWR VGND sg13cmos5l_decap_8
* cell instance sg13cmos5l_decap_8_2012 r0 *1 0,0
Xsg13cmos5l_decap_8_2012 VPWR VGND sg13cmos5l_decap_8
* cell instance sg13cmos5l_decap_8_2013 r0 *1 0,0
Xsg13cmos5l_decap_8_2013 VPWR VGND sg13cmos5l_decap_8
* cell instance sg13cmos5l_decap_8_2014 r0 *1 0,0
Xsg13cmos5l_decap_8_2014 VPWR VGND sg13cmos5l_decap_8
* cell instance sg13cmos5l_decap_8_2015 r0 *1 0,0
Xsg13cmos5l_decap_8_2015 VPWR VGND sg13cmos5l_decap_8
* cell instance sg13cmos5l_decap_8_2016 r0 *1 0,0
Xsg13cmos5l_decap_8_2016 VPWR VGND sg13cmos5l_decap_8
* cell instance sg13cmos5l_decap_8_2017 r0 *1 0,0
Xsg13cmos5l_decap_8_2017 VPWR VGND sg13cmos5l_decap_8
* cell instance sg13cmos5l_decap_8_2018 r0 *1 0,0
Xsg13cmos5l_decap_8_2018 VPWR VGND sg13cmos5l_decap_8
* cell instance sg13cmos5l_decap_8_2019 r0 *1 0,0
Xsg13cmos5l_decap_8_2019 VPWR VGND sg13cmos5l_decap_8
* cell instance sg13cmos5l_decap_8_2020 r0 *1 0,0
Xsg13cmos5l_decap_8_2020 VPWR VGND sg13cmos5l_decap_8
* cell instance sg13cmos5l_decap_8_2021 r0 *1 0,0
Xsg13cmos5l_decap_8_2021 VPWR VGND sg13cmos5l_decap_8
* cell instance sg13cmos5l_decap_8_2022 r0 *1 0,0
Xsg13cmos5l_decap_8_2022 VPWR VGND sg13cmos5l_decap_8
* cell instance sg13cmos5l_decap_8_2023 r0 *1 0,0
Xsg13cmos5l_decap_8_2023 VPWR VGND sg13cmos5l_decap_8
* cell instance sg13cmos5l_decap_8_2024 r0 *1 0,0
Xsg13cmos5l_decap_8_2024 VPWR VGND sg13cmos5l_decap_8
* cell instance sg13cmos5l_decap_8_2025 r0 *1 0,0
Xsg13cmos5l_decap_8_2025 VPWR VGND sg13cmos5l_decap_8
* cell instance sg13cmos5l_decap_8_2026 r0 *1 0,0
Xsg13cmos5l_decap_8_2026 VPWR VGND sg13cmos5l_decap_8
* cell instance sg13cmos5l_decap_8_2027 r0 *1 0,0
Xsg13cmos5l_decap_8_2027 VPWR VGND sg13cmos5l_decap_8
* cell instance sg13cmos5l_decap_8_2028 r0 *1 0,0
Xsg13cmos5l_decap_8_2028 VPWR VGND sg13cmos5l_decap_8
* cell instance sg13cmos5l_decap_8_2029 r0 *1 0,0
Xsg13cmos5l_decap_8_2029 VPWR VGND sg13cmos5l_decap_8
* cell instance sg13cmos5l_decap_8_2030 r0 *1 0,0
Xsg13cmos5l_decap_8_2030 VPWR VGND sg13cmos5l_decap_8
* cell instance sg13cmos5l_decap_8_2031 r0 *1 0,0
Xsg13cmos5l_decap_8_2031 VPWR VGND sg13cmos5l_decap_8
* cell instance sg13cmos5l_decap_8_2032 r0 *1 0,0
Xsg13cmos5l_decap_8_2032 VPWR VGND sg13cmos5l_decap_8
* cell instance sg13cmos5l_decap_8_2033 r0 *1 0,0
Xsg13cmos5l_decap_8_2033 VPWR VGND sg13cmos5l_decap_8
* cell instance sg13cmos5l_decap_8_2034 r0 *1 0,0
Xsg13cmos5l_decap_8_2034 VPWR VGND sg13cmos5l_decap_8
* cell instance sg13cmos5l_decap_8_2035 r0 *1 0,0
Xsg13cmos5l_decap_8_2035 VPWR VGND sg13cmos5l_decap_8
* cell instance sg13cmos5l_decap_8_2036 r0 *1 0,0
Xsg13cmos5l_decap_8_2036 VPWR VGND sg13cmos5l_decap_8
* cell instance sg13cmos5l_decap_8_2037 r0 *1 0,0
Xsg13cmos5l_decap_8_2037 VPWR VGND sg13cmos5l_decap_8
* cell instance sg13cmos5l_decap_8_2038 r0 *1 0,0
Xsg13cmos5l_decap_8_2038 VPWR VGND sg13cmos5l_decap_8
* cell instance sg13cmos5l_decap_8_2039 r0 *1 0,0
Xsg13cmos5l_decap_8_2039 VPWR VGND sg13cmos5l_decap_8
* cell instance sg13cmos5l_decap_8_2040 r0 *1 0,0
Xsg13cmos5l_decap_8_2040 VPWR VGND sg13cmos5l_decap_8
* cell instance sg13cmos5l_decap_8_2041 r0 *1 0,0
Xsg13cmos5l_decap_8_2041 VPWR VGND sg13cmos5l_decap_8
* cell instance sg13cmos5l_decap_8_2042 r0 *1 0,0
Xsg13cmos5l_decap_8_2042 VPWR VGND sg13cmos5l_decap_8
* cell instance sg13cmos5l_decap_8_2043 r0 *1 0,0
Xsg13cmos5l_decap_8_2043 VPWR VGND sg13cmos5l_decap_8
* cell instance sg13cmos5l_decap_8_2044 r0 *1 0,0
Xsg13cmos5l_decap_8_2044 VPWR VGND sg13cmos5l_decap_8
* cell instance sg13cmos5l_decap_8_2045 r0 *1 0,0
Xsg13cmos5l_decap_8_2045 VPWR VGND sg13cmos5l_decap_8
* cell instance sg13cmos5l_decap_8_2046 r0 *1 0,0
Xsg13cmos5l_decap_8_2046 VPWR VGND sg13cmos5l_decap_8
* cell instance sg13cmos5l_decap_8_2047 r0 *1 0,0
Xsg13cmos5l_decap_8_2047 VPWR VGND sg13cmos5l_decap_8
* cell instance sg13cmos5l_decap_8_2048 r0 *1 0,0
Xsg13cmos5l_decap_8_2048 VPWR VGND sg13cmos5l_decap_8
* cell instance sg13cmos5l_decap_8_2049 r0 *1 0,0
Xsg13cmos5l_decap_8_2049 VPWR VGND sg13cmos5l_decap_8
* cell instance sg13cmos5l_decap_8_2050 r0 *1 0,0
Xsg13cmos5l_decap_8_2050 VPWR VGND sg13cmos5l_decap_8
* cell instance sg13cmos5l_decap_8_2051 r0 *1 0,0
Xsg13cmos5l_decap_8_2051 VPWR VGND sg13cmos5l_decap_8
* cell instance sg13cmos5l_decap_8_2052 r0 *1 0,0
Xsg13cmos5l_decap_8_2052 VPWR VGND sg13cmos5l_decap_8
* cell instance sg13cmos5l_decap_8_2053 r0 *1 0,0
Xsg13cmos5l_decap_8_2053 VPWR VGND sg13cmos5l_decap_8
* cell instance sg13cmos5l_decap_8_2054 r0 *1 0,0
Xsg13cmos5l_decap_8_2054 VPWR VGND sg13cmos5l_decap_8
* cell instance sg13cmos5l_decap_8_2055 r0 *1 0,0
Xsg13cmos5l_decap_8_2055 VPWR VGND sg13cmos5l_decap_8
* cell instance sg13cmos5l_decap_8_2056 r0 *1 0,0
Xsg13cmos5l_decap_8_2056 VPWR VGND sg13cmos5l_decap_8
* cell instance sg13cmos5l_decap_8_2057 r0 *1 0,0
Xsg13cmos5l_decap_8_2057 VPWR VGND sg13cmos5l_decap_8
* cell instance sg13cmos5l_decap_8_2058 r0 *1 0,0
Xsg13cmos5l_decap_8_2058 VPWR VGND sg13cmos5l_decap_8
* cell instance sg13cmos5l_decap_8_2059 r0 *1 0,0
Xsg13cmos5l_decap_8_2059 VPWR VGND sg13cmos5l_decap_8
* cell instance sg13cmos5l_decap_8_2060 r0 *1 0,0
Xsg13cmos5l_decap_8_2060 VPWR VGND sg13cmos5l_decap_8
* cell instance sg13cmos5l_decap_8_2061 r0 *1 0,0
Xsg13cmos5l_decap_8_2061 VPWR VGND sg13cmos5l_decap_8
* cell instance sg13cmos5l_decap_8_2062 r0 *1 0,0
Xsg13cmos5l_decap_8_2062 VPWR VGND sg13cmos5l_decap_8
* cell instance sg13cmos5l_decap_8_2063 r0 *1 0,0
Xsg13cmos5l_decap_8_2063 VPWR VGND sg13cmos5l_decap_8
* cell instance sg13cmos5l_decap_8_2064 r0 *1 0,0
Xsg13cmos5l_decap_8_2064 VPWR VGND sg13cmos5l_decap_8
* cell instance sg13cmos5l_decap_8_2065 r0 *1 0,0
Xsg13cmos5l_decap_8_2065 VPWR VGND sg13cmos5l_decap_8
* cell instance sg13cmos5l_decap_8_2066 r0 *1 0,0
Xsg13cmos5l_decap_8_2066 VPWR VGND sg13cmos5l_decap_8
* cell instance sg13cmos5l_decap_8_2067 r0 *1 0,0
Xsg13cmos5l_decap_8_2067 VPWR VGND sg13cmos5l_decap_8
* cell instance sg13cmos5l_decap_8_2068 r0 *1 0,0
Xsg13cmos5l_decap_8_2068 VPWR VGND sg13cmos5l_decap_8
* cell instance sg13cmos5l_decap_8_2069 r0 *1 0,0
Xsg13cmos5l_decap_8_2069 VPWR VGND sg13cmos5l_decap_8
* cell instance sg13cmos5l_decap_8_2070 r0 *1 0,0
Xsg13cmos5l_decap_8_2070 VPWR VGND sg13cmos5l_decap_8
* cell instance sg13cmos5l_decap_8_2071 r0 *1 0,0
Xsg13cmos5l_decap_8_2071 VPWR VGND sg13cmos5l_decap_8
* cell instance sg13cmos5l_decap_8_2072 r0 *1 0,0
Xsg13cmos5l_decap_8_2072 VPWR VGND sg13cmos5l_decap_8
* cell instance sg13cmos5l_decap_8_2073 r0 *1 0,0
Xsg13cmos5l_decap_8_2073 VPWR VGND sg13cmos5l_decap_8
* cell instance sg13cmos5l_decap_8_2074 r0 *1 0,0
Xsg13cmos5l_decap_8_2074 VPWR VGND sg13cmos5l_decap_8
* cell instance sg13cmos5l_decap_8_2075 r0 *1 0,0
Xsg13cmos5l_decap_8_2075 VPWR VGND sg13cmos5l_decap_8
* cell instance sg13cmos5l_decap_8_2076 r0 *1 0,0
Xsg13cmos5l_decap_8_2076 VPWR VGND sg13cmos5l_decap_8
* cell instance sg13cmos5l_decap_8_2077 r0 *1 0,0
Xsg13cmos5l_decap_8_2077 VPWR VGND sg13cmos5l_decap_8
* cell instance sg13cmos5l_decap_8_2078 r0 *1 0,0
Xsg13cmos5l_decap_8_2078 VPWR VGND sg13cmos5l_decap_8
* cell instance sg13cmos5l_decap_8_2079 r0 *1 0,0
Xsg13cmos5l_decap_8_2079 VPWR VGND sg13cmos5l_decap_8
* cell instance sg13cmos5l_decap_8_2080 r0 *1 0,0
Xsg13cmos5l_decap_8_2080 VPWR VGND sg13cmos5l_decap_8
* cell instance sg13cmos5l_decap_8_2081 r0 *1 0,0
Xsg13cmos5l_decap_8_2081 VPWR VGND sg13cmos5l_decap_8
* cell instance sg13cmos5l_decap_8_2082 r0 *1 0,0
Xsg13cmos5l_decap_8_2082 VPWR VGND sg13cmos5l_decap_8
* cell instance sg13cmos5l_decap_8_2083 r0 *1 0,0
Xsg13cmos5l_decap_8_2083 VPWR VGND sg13cmos5l_decap_8
* cell instance sg13cmos5l_decap_8_2084 r0 *1 0,0
Xsg13cmos5l_decap_8_2084 VPWR VGND sg13cmos5l_decap_8
* cell instance sg13cmos5l_decap_8_2085 r0 *1 0,0
Xsg13cmos5l_decap_8_2085 VPWR VGND sg13cmos5l_decap_8
* cell instance sg13cmos5l_decap_8_2086 r0 *1 0,0
Xsg13cmos5l_decap_8_2086 VPWR VGND sg13cmos5l_decap_8
* cell instance sg13cmos5l_decap_8_2087 r0 *1 0,0
Xsg13cmos5l_decap_8_2087 VPWR VGND sg13cmos5l_decap_8
* cell instance sg13cmos5l_decap_8_2088 r0 *1 0,0
Xsg13cmos5l_decap_8_2088 VPWR VGND sg13cmos5l_decap_8
* cell instance sg13cmos5l_decap_8_2089 r0 *1 0,0
Xsg13cmos5l_decap_8_2089 VPWR VGND sg13cmos5l_decap_8
* cell instance sg13cmos5l_decap_8_2090 r0 *1 0,0
Xsg13cmos5l_decap_8_2090 VPWR VGND sg13cmos5l_decap_8
* cell instance sg13cmos5l_decap_8_2091 r0 *1 0,0
Xsg13cmos5l_decap_8_2091 VPWR VGND sg13cmos5l_decap_8
* cell instance sg13cmos5l_decap_8_2092 r0 *1 0,0
Xsg13cmos5l_decap_8_2092 VPWR VGND sg13cmos5l_decap_8
* cell instance sg13cmos5l_decap_8_2093 r0 *1 0,0
Xsg13cmos5l_decap_8_2093 VPWR VGND sg13cmos5l_decap_8
* cell instance sg13cmos5l_decap_8_2094 r0 *1 0,0
Xsg13cmos5l_decap_8_2094 VPWR VGND sg13cmos5l_decap_8
* cell instance sg13cmos5l_decap_8_2095 r0 *1 0,0
Xsg13cmos5l_decap_8_2095 VPWR VGND sg13cmos5l_decap_8
* cell instance sg13cmos5l_decap_8_2096 r0 *1 0,0
Xsg13cmos5l_decap_8_2096 VPWR VGND sg13cmos5l_decap_8
* cell instance sg13cmos5l_decap_8_2097 r0 *1 0,0
Xsg13cmos5l_decap_8_2097 VPWR VGND sg13cmos5l_decap_8
* cell instance sg13cmos5l_decap_8_2098 r0 *1 0,0
Xsg13cmos5l_decap_8_2098 VPWR VGND sg13cmos5l_decap_8
* cell instance sg13cmos5l_decap_8_2099 r0 *1 0,0
Xsg13cmos5l_decap_8_2099 VPWR VGND sg13cmos5l_decap_8
* cell instance sg13cmos5l_decap_8_2100 r0 *1 0,0
Xsg13cmos5l_decap_8_2100 VPWR VGND sg13cmos5l_decap_8
* cell instance sg13cmos5l_decap_8_2101 r0 *1 0,0
Xsg13cmos5l_decap_8_2101 VPWR VGND sg13cmos5l_decap_8
* cell instance sg13cmos5l_decap_8_2102 r0 *1 0,0
Xsg13cmos5l_decap_8_2102 VPWR VGND sg13cmos5l_decap_8
* cell instance sg13cmos5l_decap_8_2103 r0 *1 0,0
Xsg13cmos5l_decap_8_2103 VPWR VGND sg13cmos5l_decap_8
* cell instance sg13cmos5l_decap_8_2104 r0 *1 0,0
Xsg13cmos5l_decap_8_2104 VPWR VGND sg13cmos5l_decap_8
* cell instance sg13cmos5l_decap_8_2105 r0 *1 0,0
Xsg13cmos5l_decap_8_2105 VPWR VGND sg13cmos5l_decap_8
* cell instance sg13cmos5l_decap_8_2106 r0 *1 0,0
Xsg13cmos5l_decap_8_2106 VPWR VGND sg13cmos5l_decap_8
* cell instance sg13cmos5l_decap_8_2107 r0 *1 0,0
Xsg13cmos5l_decap_8_2107 VPWR VGND sg13cmos5l_decap_8
* cell instance sg13cmos5l_decap_8_2108 r0 *1 0,0
Xsg13cmos5l_decap_8_2108 VPWR VGND sg13cmos5l_decap_8
* cell instance sg13cmos5l_decap_8_2109 r0 *1 0,0
Xsg13cmos5l_decap_8_2109 VPWR VGND sg13cmos5l_decap_8
* cell instance sg13cmos5l_decap_8_2110 r0 *1 0,0
Xsg13cmos5l_decap_8_2110 VPWR VGND sg13cmos5l_decap_8
* cell instance sg13cmos5l_decap_8_2111 r0 *1 0,0
Xsg13cmos5l_decap_8_2111 VPWR VGND sg13cmos5l_decap_8
* cell instance sg13cmos5l_decap_8_2112 r0 *1 0,0
Xsg13cmos5l_decap_8_2112 VPWR VGND sg13cmos5l_decap_8
* cell instance sg13cmos5l_decap_8_2113 r0 *1 0,0
Xsg13cmos5l_decap_8_2113 VPWR VGND sg13cmos5l_decap_8
* cell instance sg13cmos5l_decap_8_2114 r0 *1 0,0
Xsg13cmos5l_decap_8_2114 VPWR VGND sg13cmos5l_decap_8
* cell instance sg13cmos5l_decap_8_2115 r0 *1 0,0
Xsg13cmos5l_decap_8_2115 VPWR VGND sg13cmos5l_decap_8
* cell instance sg13cmos5l_decap_8_2116 r0 *1 0,0
Xsg13cmos5l_decap_8_2116 VPWR VGND sg13cmos5l_decap_8
* cell instance sg13cmos5l_decap_8_2117 r0 *1 0,0
Xsg13cmos5l_decap_8_2117 VPWR VGND sg13cmos5l_decap_8
* cell instance sg13cmos5l_decap_8_2118 r0 *1 0,0
Xsg13cmos5l_decap_8_2118 VPWR VGND sg13cmos5l_decap_8
* cell instance sg13cmos5l_decap_8_2119 r0 *1 0,0
Xsg13cmos5l_decap_8_2119 VPWR VGND sg13cmos5l_decap_8
* cell instance sg13cmos5l_decap_8_2120 r0 *1 0,0
Xsg13cmos5l_decap_8_2120 VPWR VGND sg13cmos5l_decap_8
* cell instance sg13cmos5l_decap_8_2121 r0 *1 0,0
Xsg13cmos5l_decap_8_2121 VPWR VGND sg13cmos5l_decap_8
* cell instance sg13cmos5l_decap_8_2122 r0 *1 0,0
Xsg13cmos5l_decap_8_2122 VPWR VGND sg13cmos5l_decap_8
* cell instance sg13cmos5l_decap_8_2123 r0 *1 0,0
Xsg13cmos5l_decap_8_2123 VPWR VGND sg13cmos5l_decap_8
* cell instance sg13cmos5l_decap_8_2124 r0 *1 0,0
Xsg13cmos5l_decap_8_2124 VPWR VGND sg13cmos5l_decap_8
* cell instance sg13cmos5l_decap_8_2125 r0 *1 0,0
Xsg13cmos5l_decap_8_2125 VPWR VGND sg13cmos5l_decap_8
* cell instance sg13cmos5l_decap_8_2126 r0 *1 0,0
Xsg13cmos5l_decap_8_2126 VPWR VGND sg13cmos5l_decap_8
* cell instance sg13cmos5l_decap_8_2127 r0 *1 0,0
Xsg13cmos5l_decap_8_2127 VPWR VGND sg13cmos5l_decap_8
* cell instance sg13cmos5l_decap_8_2128 r0 *1 0,0
Xsg13cmos5l_decap_8_2128 VPWR VGND sg13cmos5l_decap_8
* cell instance sg13cmos5l_decap_8_2129 r0 *1 0,0
Xsg13cmos5l_decap_8_2129 VPWR VGND sg13cmos5l_decap_8
* cell instance sg13cmos5l_decap_8_2130 r0 *1 0,0
Xsg13cmos5l_decap_8_2130 VPWR VGND sg13cmos5l_decap_8
* cell instance sg13cmos5l_decap_8_2131 r0 *1 0,0
Xsg13cmos5l_decap_8_2131 VPWR VGND sg13cmos5l_decap_8
* cell instance sg13cmos5l_decap_8_2132 r0 *1 0,0
Xsg13cmos5l_decap_8_2132 VPWR VGND sg13cmos5l_decap_8
* cell instance sg13cmos5l_decap_8_2133 r0 *1 0,0
Xsg13cmos5l_decap_8_2133 VPWR VGND sg13cmos5l_decap_8
* cell instance sg13cmos5l_decap_8_2134 r0 *1 0,0
Xsg13cmos5l_decap_8_2134 VPWR VGND sg13cmos5l_decap_8
* cell instance sg13cmos5l_decap_8_2135 r0 *1 0,0
Xsg13cmos5l_decap_8_2135 VPWR VGND sg13cmos5l_decap_8
* cell instance sg13cmos5l_decap_8_2136 r0 *1 0,0
Xsg13cmos5l_decap_8_2136 VPWR VGND sg13cmos5l_decap_8
* cell instance sg13cmos5l_decap_8_2137 r0 *1 0,0
Xsg13cmos5l_decap_8_2137 VPWR VGND sg13cmos5l_decap_8
* cell instance sg13cmos5l_decap_8_2138 r0 *1 0,0
Xsg13cmos5l_decap_8_2138 VPWR VGND sg13cmos5l_decap_8
* cell instance sg13cmos5l_decap_8_2139 r0 *1 0,0
Xsg13cmos5l_decap_8_2139 VPWR VGND sg13cmos5l_decap_8
* cell instance sg13cmos5l_decap_8_2140 r0 *1 0,0
Xsg13cmos5l_decap_8_2140 VPWR VGND sg13cmos5l_decap_8
* cell instance sg13cmos5l_decap_8_2141 r0 *1 0,0
Xsg13cmos5l_decap_8_2141 VPWR VGND sg13cmos5l_decap_8
* cell instance sg13cmos5l_decap_8_2142 r0 *1 0,0
Xsg13cmos5l_decap_8_2142 VPWR VGND sg13cmos5l_decap_8
* cell instance sg13cmos5l_decap_8_2143 r0 *1 0,0
Xsg13cmos5l_decap_8_2143 VPWR VGND sg13cmos5l_decap_8
* cell instance sg13cmos5l_decap_8_2144 r0 *1 0,0
Xsg13cmos5l_decap_8_2144 VPWR VGND sg13cmos5l_decap_8
* cell instance sg13cmos5l_decap_8_2145 r0 *1 0,0
Xsg13cmos5l_decap_8_2145 VPWR VGND sg13cmos5l_decap_8
* cell instance sg13cmos5l_decap_8_2146 r0 *1 0,0
Xsg13cmos5l_decap_8_2146 VPWR VGND sg13cmos5l_decap_8
* cell instance sg13cmos5l_decap_8_2147 r0 *1 0,0
Xsg13cmos5l_decap_8_2147 VPWR VGND sg13cmos5l_decap_8
* cell instance sg13cmos5l_decap_8_2148 r0 *1 0,0
Xsg13cmos5l_decap_8_2148 VPWR VGND sg13cmos5l_decap_8
* cell instance sg13cmos5l_decap_8_2149 r0 *1 0,0
Xsg13cmos5l_decap_8_2149 VPWR VGND sg13cmos5l_decap_8
* cell instance sg13cmos5l_decap_8_2150 r0 *1 0,0
Xsg13cmos5l_decap_8_2150 VPWR VGND sg13cmos5l_decap_8
* cell instance sg13cmos5l_decap_8_2151 r0 *1 0,0
Xsg13cmos5l_decap_8_2151 VPWR VGND sg13cmos5l_decap_8
* cell instance sg13cmos5l_decap_8_2152 r0 *1 0,0
Xsg13cmos5l_decap_8_2152 VPWR VGND sg13cmos5l_decap_8
* cell instance sg13cmos5l_decap_8_2153 r0 *1 0,0
Xsg13cmos5l_decap_8_2153 VPWR VGND sg13cmos5l_decap_8
* cell instance sg13cmos5l_decap_8_2154 r0 *1 0,0
Xsg13cmos5l_decap_8_2154 VPWR VGND sg13cmos5l_decap_8
* cell instance sg13cmos5l_decap_8_2155 r0 *1 0,0
Xsg13cmos5l_decap_8_2155 VPWR VGND sg13cmos5l_decap_8
* cell instance sg13cmos5l_decap_8_2156 r0 *1 0,0
Xsg13cmos5l_decap_8_2156 VPWR VGND sg13cmos5l_decap_8
* cell instance sg13cmos5l_decap_8_2157 r0 *1 0,0
Xsg13cmos5l_decap_8_2157 VPWR VGND sg13cmos5l_decap_8
* cell instance sg13cmos5l_decap_8_2158 r0 *1 0,0
Xsg13cmos5l_decap_8_2158 VPWR VGND sg13cmos5l_decap_8
* cell instance sg13cmos5l_decap_8_2159 r0 *1 0,0
Xsg13cmos5l_decap_8_2159 VPWR VGND sg13cmos5l_decap_8
* cell instance sg13cmos5l_decap_8_2160 r0 *1 0,0
Xsg13cmos5l_decap_8_2160 VPWR VGND sg13cmos5l_decap_8
* cell instance sg13cmos5l_decap_8_2161 r0 *1 0,0
Xsg13cmos5l_decap_8_2161 VPWR VGND sg13cmos5l_decap_8
* cell instance sg13cmos5l_decap_8_2162 r0 *1 0,0
Xsg13cmos5l_decap_8_2162 VPWR VGND sg13cmos5l_decap_8
* cell instance sg13cmos5l_decap_8_2163 r0 *1 0,0
Xsg13cmos5l_decap_8_2163 VPWR VGND sg13cmos5l_decap_8
* cell instance sg13cmos5l_decap_8_2164 r0 *1 0,0
Xsg13cmos5l_decap_8_2164 VPWR VGND sg13cmos5l_decap_8
* cell instance sg13cmos5l_decap_8_2165 r0 *1 0,0
Xsg13cmos5l_decap_8_2165 VPWR VGND sg13cmos5l_decap_8
* cell instance sg13cmos5l_decap_8_2166 r0 *1 0,0
Xsg13cmos5l_decap_8_2166 VPWR VGND sg13cmos5l_decap_8
* cell instance sg13cmos5l_decap_8_2167 r0 *1 0,0
Xsg13cmos5l_decap_8_2167 VPWR VGND sg13cmos5l_decap_8
* cell instance sg13cmos5l_decap_8_2168 r0 *1 0,0
Xsg13cmos5l_decap_8_2168 VPWR VGND sg13cmos5l_decap_8
* cell instance sg13cmos5l_decap_8_2169 r0 *1 0,0
Xsg13cmos5l_decap_8_2169 VPWR VGND sg13cmos5l_decap_8
* cell instance sg13cmos5l_decap_8_2170 r0 *1 0,0
Xsg13cmos5l_decap_8_2170 VPWR VGND sg13cmos5l_decap_8
* cell instance sg13cmos5l_decap_8_2171 r0 *1 0,0
Xsg13cmos5l_decap_8_2171 VPWR VGND sg13cmos5l_decap_8
* cell instance sg13cmos5l_decap_8_2172 r0 *1 0,0
Xsg13cmos5l_decap_8_2172 VPWR VGND sg13cmos5l_decap_8
* cell instance sg13cmos5l_decap_8_2173 r0 *1 0,0
Xsg13cmos5l_decap_8_2173 VPWR VGND sg13cmos5l_decap_8
* cell instance sg13cmos5l_decap_8_2174 r0 *1 0,0
Xsg13cmos5l_decap_8_2174 VPWR VGND sg13cmos5l_decap_8
* cell instance sg13cmos5l_decap_8_2175 r0 *1 0,0
Xsg13cmos5l_decap_8_2175 VPWR VGND sg13cmos5l_decap_8
* cell instance sg13cmos5l_decap_8_2176 r0 *1 0,0
Xsg13cmos5l_decap_8_2176 VPWR VGND sg13cmos5l_decap_8
* cell instance sg13cmos5l_decap_8_2177 r0 *1 0,0
Xsg13cmos5l_decap_8_2177 VPWR VGND sg13cmos5l_decap_8
* cell instance sg13cmos5l_decap_8_2178 r0 *1 0,0
Xsg13cmos5l_decap_8_2178 VPWR VGND sg13cmos5l_decap_8
* cell instance sg13cmos5l_decap_8_2179 r0 *1 0,0
Xsg13cmos5l_decap_8_2179 VPWR VGND sg13cmos5l_decap_8
* cell instance sg13cmos5l_decap_8_2180 r0 *1 0,0
Xsg13cmos5l_decap_8_2180 VPWR VGND sg13cmos5l_decap_8
* cell instance sg13cmos5l_decap_8_2181 r0 *1 0,0
Xsg13cmos5l_decap_8_2181 VPWR VGND sg13cmos5l_decap_8
* cell instance sg13cmos5l_decap_8_2182 r0 *1 0,0
Xsg13cmos5l_decap_8_2182 VPWR VGND sg13cmos5l_decap_8
* cell instance sg13cmos5l_decap_8_2183 r0 *1 0,0
Xsg13cmos5l_decap_8_2183 VPWR VGND sg13cmos5l_decap_8
* cell instance sg13cmos5l_decap_8_2184 r0 *1 0,0
Xsg13cmos5l_decap_8_2184 VPWR VGND sg13cmos5l_decap_8
* cell instance sg13cmos5l_decap_8_2185 r0 *1 0,0
Xsg13cmos5l_decap_8_2185 VPWR VGND sg13cmos5l_decap_8
* cell instance sg13cmos5l_decap_8_2186 r0 *1 0,0
Xsg13cmos5l_decap_8_2186 VPWR VGND sg13cmos5l_decap_8
* cell instance sg13cmos5l_decap_8_2187 r0 *1 0,0
Xsg13cmos5l_decap_8_2187 VPWR VGND sg13cmos5l_decap_8
* cell instance sg13cmos5l_decap_8_2188 r0 *1 0,0
Xsg13cmos5l_decap_8_2188 VPWR VGND sg13cmos5l_decap_8
* cell instance sg13cmos5l_decap_8_2189 r0 *1 0,0
Xsg13cmos5l_decap_8_2189 VPWR VGND sg13cmos5l_decap_8
* cell instance sg13cmos5l_decap_8_2190 r0 *1 0,0
Xsg13cmos5l_decap_8_2190 VPWR VGND sg13cmos5l_decap_8
* cell instance sg13cmos5l_decap_8_2191 r0 *1 0,0
Xsg13cmos5l_decap_8_2191 VPWR VGND sg13cmos5l_decap_8
* cell instance sg13cmos5l_decap_8_2192 r0 *1 0,0
Xsg13cmos5l_decap_8_2192 VPWR VGND sg13cmos5l_decap_8
* cell instance sg13cmos5l_decap_8_2193 r0 *1 0,0
Xsg13cmos5l_decap_8_2193 VPWR VGND sg13cmos5l_decap_8
* cell instance sg13cmos5l_decap_8_2194 r0 *1 0,0
Xsg13cmos5l_decap_8_2194 VPWR VGND sg13cmos5l_decap_8
* cell instance sg13cmos5l_decap_8_2195 r0 *1 0,0
Xsg13cmos5l_decap_8_2195 VPWR VGND sg13cmos5l_decap_8
* cell instance sg13cmos5l_decap_8_2196 r0 *1 0,0
Xsg13cmos5l_decap_8_2196 VPWR VGND sg13cmos5l_decap_8
* cell instance sg13cmos5l_decap_8_2197 r0 *1 0,0
Xsg13cmos5l_decap_8_2197 VPWR VGND sg13cmos5l_decap_8
* cell instance sg13cmos5l_decap_8_2198 r0 *1 0,0
Xsg13cmos5l_decap_8_2198 VPWR VGND sg13cmos5l_decap_8
* cell instance sg13cmos5l_decap_8_2199 r0 *1 0,0
Xsg13cmos5l_decap_8_2199 VPWR VGND sg13cmos5l_decap_8
* cell instance sg13cmos5l_decap_8_2200 r0 *1 0,0
Xsg13cmos5l_decap_8_2200 VPWR VGND sg13cmos5l_decap_8
* cell instance sg13cmos5l_decap_8_2201 r0 *1 0,0
Xsg13cmos5l_decap_8_2201 VPWR VGND sg13cmos5l_decap_8
* cell instance sg13cmos5l_decap_8_2202 r0 *1 0,0
Xsg13cmos5l_decap_8_2202 VPWR VGND sg13cmos5l_decap_8
* cell instance sg13cmos5l_decap_8_2203 r0 *1 0,0
Xsg13cmos5l_decap_8_2203 VPWR VGND sg13cmos5l_decap_8
* cell instance sg13cmos5l_decap_8_2204 r0 *1 0,0
Xsg13cmos5l_decap_8_2204 VPWR VGND sg13cmos5l_decap_8
* cell instance sg13cmos5l_decap_8_2205 r0 *1 0,0
Xsg13cmos5l_decap_8_2205 VPWR VGND sg13cmos5l_decap_8
* cell instance sg13cmos5l_decap_8_2206 r0 *1 0,0
Xsg13cmos5l_decap_8_2206 VPWR VGND sg13cmos5l_decap_8
* cell instance sg13cmos5l_decap_8_2207 r0 *1 0,0
Xsg13cmos5l_decap_8_2207 VPWR VGND sg13cmos5l_decap_8
* cell instance sg13cmos5l_decap_8_2208 r0 *1 0,0
Xsg13cmos5l_decap_8_2208 VPWR VGND sg13cmos5l_decap_8
* cell instance sg13cmos5l_decap_8_2209 r0 *1 0,0
Xsg13cmos5l_decap_8_2209 VPWR VGND sg13cmos5l_decap_8
* cell instance sg13cmos5l_decap_8_2210 r0 *1 0,0
Xsg13cmos5l_decap_8_2210 VPWR VGND sg13cmos5l_decap_8
* cell instance sg13cmos5l_decap_8_2211 r0 *1 0,0
Xsg13cmos5l_decap_8_2211 VPWR VGND sg13cmos5l_decap_8
* cell instance sg13cmos5l_decap_8_2212 r0 *1 0,0
Xsg13cmos5l_decap_8_2212 VPWR VGND sg13cmos5l_decap_8
* cell instance sg13cmos5l_decap_8_2213 r0 *1 0,0
Xsg13cmos5l_decap_8_2213 VPWR VGND sg13cmos5l_decap_8
* cell instance sg13cmos5l_decap_8_2214 r0 *1 0,0
Xsg13cmos5l_decap_8_2214 VPWR VGND sg13cmos5l_decap_8
* cell instance sg13cmos5l_decap_8_2215 r0 *1 0,0
Xsg13cmos5l_decap_8_2215 VPWR VGND sg13cmos5l_decap_8
* cell instance sg13cmos5l_decap_8_2216 r0 *1 0,0
Xsg13cmos5l_decap_8_2216 VPWR VGND sg13cmos5l_decap_8
* cell instance sg13cmos5l_decap_8_2217 r0 *1 0,0
Xsg13cmos5l_decap_8_2217 VPWR VGND sg13cmos5l_decap_8
* cell instance sg13cmos5l_decap_8_2218 r0 *1 0,0
Xsg13cmos5l_decap_8_2218 VPWR VGND sg13cmos5l_decap_8
* cell instance sg13cmos5l_decap_8_2219 r0 *1 0,0
Xsg13cmos5l_decap_8_2219 VPWR VGND sg13cmos5l_decap_8
* cell instance sg13cmos5l_decap_8_2220 r0 *1 0,0
Xsg13cmos5l_decap_8_2220 VPWR VGND sg13cmos5l_decap_8
* cell instance sg13cmos5l_decap_8_2221 r0 *1 0,0
Xsg13cmos5l_decap_8_2221 VPWR VGND sg13cmos5l_decap_8
* cell instance sg13cmos5l_decap_8_2222 r0 *1 0,0
Xsg13cmos5l_decap_8_2222 VPWR VGND sg13cmos5l_decap_8
* cell instance sg13cmos5l_decap_8_2223 r0 *1 0,0
Xsg13cmos5l_decap_8_2223 VPWR VGND sg13cmos5l_decap_8
* cell instance sg13cmos5l_decap_8_2224 r0 *1 0,0
Xsg13cmos5l_decap_8_2224 VPWR VGND sg13cmos5l_decap_8
* cell instance sg13cmos5l_decap_8_2225 r0 *1 0,0
Xsg13cmos5l_decap_8_2225 VPWR VGND sg13cmos5l_decap_8
* cell instance sg13cmos5l_decap_8_2226 r0 *1 0,0
Xsg13cmos5l_decap_8_2226 VPWR VGND sg13cmos5l_decap_8
* cell instance sg13cmos5l_decap_8_2227 r0 *1 0,0
Xsg13cmos5l_decap_8_2227 VPWR VGND sg13cmos5l_decap_8
* cell instance sg13cmos5l_decap_8_2228 r0 *1 0,0
Xsg13cmos5l_decap_8_2228 VPWR VGND sg13cmos5l_decap_8
* cell instance sg13cmos5l_decap_8_2229 r0 *1 0,0
Xsg13cmos5l_decap_8_2229 VPWR VGND sg13cmos5l_decap_8
* cell instance sg13cmos5l_decap_8_2230 r0 *1 0,0
Xsg13cmos5l_decap_8_2230 VPWR VGND sg13cmos5l_decap_8
* cell instance sg13cmos5l_decap_8_2231 r0 *1 0,0
Xsg13cmos5l_decap_8_2231 VPWR VGND sg13cmos5l_decap_8
* cell instance sg13cmos5l_decap_8_2232 r0 *1 0,0
Xsg13cmos5l_decap_8_2232 VPWR VGND sg13cmos5l_decap_8
* cell instance sg13cmos5l_decap_8_2233 r0 *1 0,0
Xsg13cmos5l_decap_8_2233 VPWR VGND sg13cmos5l_decap_8
* cell instance sg13cmos5l_decap_8_2234 r0 *1 0,0
Xsg13cmos5l_decap_8_2234 VPWR VGND sg13cmos5l_decap_8
* cell instance sg13cmos5l_decap_8_2235 r0 *1 0,0
Xsg13cmos5l_decap_8_2235 VPWR VGND sg13cmos5l_decap_8
* cell instance sg13cmos5l_decap_8_2236 r0 *1 0,0
Xsg13cmos5l_decap_8_2236 VPWR VGND sg13cmos5l_decap_8
* cell instance sg13cmos5l_decap_8_2237 r0 *1 0,0
Xsg13cmos5l_decap_8_2237 VPWR VGND sg13cmos5l_decap_8
* cell instance sg13cmos5l_decap_8_2238 r0 *1 0,0
Xsg13cmos5l_decap_8_2238 VPWR VGND sg13cmos5l_decap_8
* cell instance sg13cmos5l_decap_8_2239 r0 *1 0,0
Xsg13cmos5l_decap_8_2239 VPWR VGND sg13cmos5l_decap_8
* cell instance sg13cmos5l_decap_8_2240 r0 *1 0,0
Xsg13cmos5l_decap_8_2240 VPWR VGND sg13cmos5l_decap_8
* cell instance sg13cmos5l_decap_8_2241 r0 *1 0,0
Xsg13cmos5l_decap_8_2241 VPWR VGND sg13cmos5l_decap_8
* cell instance sg13cmos5l_decap_8_2242 r0 *1 0,0
Xsg13cmos5l_decap_8_2242 VPWR VGND sg13cmos5l_decap_8
* cell instance sg13cmos5l_decap_8_2243 r0 *1 0,0
Xsg13cmos5l_decap_8_2243 VPWR VGND sg13cmos5l_decap_8
* cell instance sg13cmos5l_decap_8_2244 r0 *1 0,0
Xsg13cmos5l_decap_8_2244 VPWR VGND sg13cmos5l_decap_8
* cell instance sg13cmos5l_decap_8_2245 r0 *1 0,0
Xsg13cmos5l_decap_8_2245 VPWR VGND sg13cmos5l_decap_8
* cell instance sg13cmos5l_decap_8_2246 r0 *1 0,0
Xsg13cmos5l_decap_8_2246 VPWR VGND sg13cmos5l_decap_8
* cell instance sg13cmos5l_decap_8_2247 r0 *1 0,0
Xsg13cmos5l_decap_8_2247 VPWR VGND sg13cmos5l_decap_8
* cell instance sg13cmos5l_decap_8_2248 r0 *1 0,0
Xsg13cmos5l_decap_8_2248 VPWR VGND sg13cmos5l_decap_8
* cell instance sg13cmos5l_decap_8_2249 r0 *1 0,0
Xsg13cmos5l_decap_8_2249 VPWR VGND sg13cmos5l_decap_8
* cell instance sg13cmos5l_decap_8_2250 r0 *1 0,0
Xsg13cmos5l_decap_8_2250 VPWR VGND sg13cmos5l_decap_8
* cell instance sg13cmos5l_decap_8_2251 r0 *1 0,0
Xsg13cmos5l_decap_8_2251 VPWR VGND sg13cmos5l_decap_8
* cell instance sg13cmos5l_decap_8_2252 r0 *1 0,0
Xsg13cmos5l_decap_8_2252 VPWR VGND sg13cmos5l_decap_8
* cell instance sg13cmos5l_decap_8_2253 r0 *1 0,0
Xsg13cmos5l_decap_8_2253 VPWR VGND sg13cmos5l_decap_8
* cell instance sg13cmos5l_decap_8_2254 r0 *1 0,0
Xsg13cmos5l_decap_8_2254 VPWR VGND sg13cmos5l_decap_8
* cell instance sg13cmos5l_decap_8_2255 r0 *1 0,0
Xsg13cmos5l_decap_8_2255 VPWR VGND sg13cmos5l_decap_8
* cell instance sg13cmos5l_decap_8_2256 r0 *1 0,0
Xsg13cmos5l_decap_8_2256 VPWR VGND sg13cmos5l_decap_8
* cell instance sg13cmos5l_decap_8_2257 r0 *1 0,0
Xsg13cmos5l_decap_8_2257 VPWR VGND sg13cmos5l_decap_8
* cell instance sg13cmos5l_decap_8_2258 r0 *1 0,0
Xsg13cmos5l_decap_8_2258 VPWR VGND sg13cmos5l_decap_8
* cell instance sg13cmos5l_decap_8_2259 r0 *1 0,0
Xsg13cmos5l_decap_8_2259 VPWR VGND sg13cmos5l_decap_8
* cell instance sg13cmos5l_decap_8_2260 r0 *1 0,0
Xsg13cmos5l_decap_8_2260 VPWR VGND sg13cmos5l_decap_8
* cell instance sg13cmos5l_decap_8_2261 r0 *1 0,0
Xsg13cmos5l_decap_8_2261 VPWR VGND sg13cmos5l_decap_8
* cell instance sg13cmos5l_decap_8_2262 r0 *1 0,0
Xsg13cmos5l_decap_8_2262 VPWR VGND sg13cmos5l_decap_8
* cell instance sg13cmos5l_decap_8_2263 r0 *1 0,0
Xsg13cmos5l_decap_8_2263 VPWR VGND sg13cmos5l_decap_8
* cell instance sg13cmos5l_decap_8_2264 r0 *1 0,0
Xsg13cmos5l_decap_8_2264 VPWR VGND sg13cmos5l_decap_8
* cell instance sg13cmos5l_decap_8_2265 r0 *1 0,0
Xsg13cmos5l_decap_8_2265 VPWR VGND sg13cmos5l_decap_8
* cell instance sg13cmos5l_decap_8_2266 r0 *1 0,0
Xsg13cmos5l_decap_8_2266 VPWR VGND sg13cmos5l_decap_8
* cell instance sg13cmos5l_decap_8_2267 r0 *1 0,0
Xsg13cmos5l_decap_8_2267 VPWR VGND sg13cmos5l_decap_8
* cell instance sg13cmos5l_decap_8_2268 r0 *1 0,0
Xsg13cmos5l_decap_8_2268 VPWR VGND sg13cmos5l_decap_8
* cell instance sg13cmos5l_decap_8_2269 r0 *1 0,0
Xsg13cmos5l_decap_8_2269 VPWR VGND sg13cmos5l_decap_8
* cell instance sg13cmos5l_decap_8_2270 r0 *1 0,0
Xsg13cmos5l_decap_8_2270 VPWR VGND sg13cmos5l_decap_8
* cell instance sg13cmos5l_decap_8_2271 r0 *1 0,0
Xsg13cmos5l_decap_8_2271 VPWR VGND sg13cmos5l_decap_8
* cell instance sg13cmos5l_decap_8_2272 r0 *1 0,0
Xsg13cmos5l_decap_8_2272 VPWR VGND sg13cmos5l_decap_8
* cell instance sg13cmos5l_decap_8_2273 r0 *1 0,0
Xsg13cmos5l_decap_8_2273 VPWR VGND sg13cmos5l_decap_8
* cell instance sg13cmos5l_decap_8_2274 r0 *1 0,0
Xsg13cmos5l_decap_8_2274 VPWR VGND sg13cmos5l_decap_8
* cell instance sg13cmos5l_decap_8_2275 r0 *1 0,0
Xsg13cmos5l_decap_8_2275 VPWR VGND sg13cmos5l_decap_8
* cell instance sg13cmos5l_decap_8_2276 r0 *1 0,0
Xsg13cmos5l_decap_8_2276 VPWR VGND sg13cmos5l_decap_8
* cell instance sg13cmos5l_decap_8_2277 r0 *1 0,0
Xsg13cmos5l_decap_8_2277 VPWR VGND sg13cmos5l_decap_8
* cell instance sg13cmos5l_decap_8_2278 r0 *1 0,0
Xsg13cmos5l_decap_8_2278 VPWR VGND sg13cmos5l_decap_8
* cell instance sg13cmos5l_decap_8_2279 r0 *1 0,0
Xsg13cmos5l_decap_8_2279 VPWR VGND sg13cmos5l_decap_8
* cell instance sg13cmos5l_decap_8_2280 r0 *1 0,0
Xsg13cmos5l_decap_8_2280 VPWR VGND sg13cmos5l_decap_8
* cell instance sg13cmos5l_decap_8_2281 r0 *1 0,0
Xsg13cmos5l_decap_8_2281 VPWR VGND sg13cmos5l_decap_8
* cell instance sg13cmos5l_decap_8_2282 r0 *1 0,0
Xsg13cmos5l_decap_8_2282 VPWR VGND sg13cmos5l_decap_8
* cell instance sg13cmos5l_decap_8_2283 r0 *1 0,0
Xsg13cmos5l_decap_8_2283 VPWR VGND sg13cmos5l_decap_8
* cell instance sg13cmos5l_decap_8_2284 r0 *1 0,0
Xsg13cmos5l_decap_8_2284 VPWR VGND sg13cmos5l_decap_8
* cell instance sg13cmos5l_decap_8_2285 r0 *1 0,0
Xsg13cmos5l_decap_8_2285 VPWR VGND sg13cmos5l_decap_8
* cell instance sg13cmos5l_decap_8_2286 r0 *1 0,0
Xsg13cmos5l_decap_8_2286 VPWR VGND sg13cmos5l_decap_8
* cell instance sg13cmos5l_decap_8_2287 r0 *1 0,0
Xsg13cmos5l_decap_8_2287 VPWR VGND sg13cmos5l_decap_8
* cell instance sg13cmos5l_decap_8_2288 r0 *1 0,0
Xsg13cmos5l_decap_8_2288 VPWR VGND sg13cmos5l_decap_8
* cell instance sg13cmos5l_decap_8_2289 r0 *1 0,0
Xsg13cmos5l_decap_8_2289 VPWR VGND sg13cmos5l_decap_8
* cell instance sg13cmos5l_decap_8_2290 r0 *1 0,0
Xsg13cmos5l_decap_8_2290 VPWR VGND sg13cmos5l_decap_8
* cell instance sg13cmos5l_decap_8_2291 r0 *1 0,0
Xsg13cmos5l_decap_8_2291 VPWR VGND sg13cmos5l_decap_8
* cell instance sg13cmos5l_decap_8_2292 r0 *1 0,0
Xsg13cmos5l_decap_8_2292 VPWR VGND sg13cmos5l_decap_8
* cell instance sg13cmos5l_decap_8_2293 r0 *1 0,0
Xsg13cmos5l_decap_8_2293 VPWR VGND sg13cmos5l_decap_8
* cell instance sg13cmos5l_decap_8_2294 r0 *1 0,0
Xsg13cmos5l_decap_8_2294 VPWR VGND sg13cmos5l_decap_8
* cell instance sg13cmos5l_decap_8_2295 r0 *1 0,0
Xsg13cmos5l_decap_8_2295 VPWR VGND sg13cmos5l_decap_8
* cell instance sg13cmos5l_decap_8_2296 r0 *1 0,0
Xsg13cmos5l_decap_8_2296 VPWR VGND sg13cmos5l_decap_8
* cell instance sg13cmos5l_decap_8_2297 r0 *1 0,0
Xsg13cmos5l_decap_8_2297 VPWR VGND sg13cmos5l_decap_8
* cell instance sg13cmos5l_decap_8_2298 r0 *1 0,0
Xsg13cmos5l_decap_8_2298 VPWR VGND sg13cmos5l_decap_8
* cell instance sg13cmos5l_decap_8_2299 r0 *1 0,0
Xsg13cmos5l_decap_8_2299 VPWR VGND sg13cmos5l_decap_8
* cell instance sg13cmos5l_decap_8_2300 r0 *1 0,0
Xsg13cmos5l_decap_8_2300 VPWR VGND sg13cmos5l_decap_8
* cell instance sg13cmos5l_decap_8_2301 r0 *1 0,0
Xsg13cmos5l_decap_8_2301 VPWR VGND sg13cmos5l_decap_8
* cell instance sg13cmos5l_decap_8_2302 r0 *1 0,0
Xsg13cmos5l_decap_8_2302 VPWR VGND sg13cmos5l_decap_8
* cell instance sg13cmos5l_decap_8_2303 r0 *1 0,0
Xsg13cmos5l_decap_8_2303 VPWR VGND sg13cmos5l_decap_8
* cell instance sg13cmos5l_decap_8_2304 r0 *1 0,0
Xsg13cmos5l_decap_8_2304 VPWR VGND sg13cmos5l_decap_8
* cell instance sg13cmos5l_decap_8_2305 r0 *1 0,0
Xsg13cmos5l_decap_8_2305 VPWR VGND sg13cmos5l_decap_8
* cell instance sg13cmos5l_decap_8_2306 r0 *1 0,0
Xsg13cmos5l_decap_8_2306 VPWR VGND sg13cmos5l_decap_8
* cell instance sg13cmos5l_decap_8_2307 r0 *1 0,0
Xsg13cmos5l_decap_8_2307 VPWR VGND sg13cmos5l_decap_8
* cell instance sg13cmos5l_decap_8_2308 r0 *1 0,0
Xsg13cmos5l_decap_8_2308 VPWR VGND sg13cmos5l_decap_8
* cell instance sg13cmos5l_decap_8_2309 r0 *1 0,0
Xsg13cmos5l_decap_8_2309 VPWR VGND sg13cmos5l_decap_8
* cell instance sg13cmos5l_decap_8_2310 r0 *1 0,0
Xsg13cmos5l_decap_8_2310 VPWR VGND sg13cmos5l_decap_8
* cell instance sg13cmos5l_decap_8_2311 r0 *1 0,0
Xsg13cmos5l_decap_8_2311 VPWR VGND sg13cmos5l_decap_8
* cell instance sg13cmos5l_decap_8_2312 r0 *1 0,0
Xsg13cmos5l_decap_8_2312 VPWR VGND sg13cmos5l_decap_8
* cell instance sg13cmos5l_decap_8_2313 r0 *1 0,0
Xsg13cmos5l_decap_8_2313 VPWR VGND sg13cmos5l_decap_8
* cell instance sg13cmos5l_decap_8_2314 r0 *1 0,0
Xsg13cmos5l_decap_8_2314 VPWR VGND sg13cmos5l_decap_8
* cell instance sg13cmos5l_decap_8_2315 r0 *1 0,0
Xsg13cmos5l_decap_8_2315 VPWR VGND sg13cmos5l_decap_8
* cell instance sg13cmos5l_decap_8_2316 r0 *1 0,0
Xsg13cmos5l_decap_8_2316 VPWR VGND sg13cmos5l_decap_8
* cell instance sg13cmos5l_decap_8_2317 r0 *1 0,0
Xsg13cmos5l_decap_8_2317 VPWR VGND sg13cmos5l_decap_8
* cell instance sg13cmos5l_decap_8_2318 r0 *1 0,0
Xsg13cmos5l_decap_8_2318 VPWR VGND sg13cmos5l_decap_8
* cell instance sg13cmos5l_decap_8_2319 r0 *1 0,0
Xsg13cmos5l_decap_8_2319 VPWR VGND sg13cmos5l_decap_8
* cell instance sg13cmos5l_decap_8_2320 r0 *1 0,0
Xsg13cmos5l_decap_8_2320 VPWR VGND sg13cmos5l_decap_8
* cell instance sg13cmos5l_decap_8_2321 r0 *1 0,0
Xsg13cmos5l_decap_8_2321 VPWR VGND sg13cmos5l_decap_8
* cell instance sg13cmos5l_decap_8_2322 r0 *1 0,0
Xsg13cmos5l_decap_8_2322 VPWR VGND sg13cmos5l_decap_8
* cell instance sg13cmos5l_decap_8_2323 r0 *1 0,0
Xsg13cmos5l_decap_8_2323 VPWR VGND sg13cmos5l_decap_8
* cell instance sg13cmos5l_decap_8_2324 r0 *1 0,0
Xsg13cmos5l_decap_8_2324 VPWR VGND sg13cmos5l_decap_8
* cell instance sg13cmos5l_decap_8_2325 r0 *1 0,0
Xsg13cmos5l_decap_8_2325 VPWR VGND sg13cmos5l_decap_8
* cell instance sg13cmos5l_decap_8_2326 r0 *1 0,0
Xsg13cmos5l_decap_8_2326 VPWR VGND sg13cmos5l_decap_8
* cell instance sg13cmos5l_decap_8_2327 r0 *1 0,0
Xsg13cmos5l_decap_8_2327 VPWR VGND sg13cmos5l_decap_8
* cell instance sg13cmos5l_decap_8_2328 r0 *1 0,0
Xsg13cmos5l_decap_8_2328 VPWR VGND sg13cmos5l_decap_8
* cell instance sg13cmos5l_decap_8_2329 r0 *1 0,0
Xsg13cmos5l_decap_8_2329 VPWR VGND sg13cmos5l_decap_8
* cell instance sg13cmos5l_decap_8_2330 r0 *1 0,0
Xsg13cmos5l_decap_8_2330 VPWR VGND sg13cmos5l_decap_8
* cell instance sg13cmos5l_decap_8_2331 r0 *1 0,0
Xsg13cmos5l_decap_8_2331 VPWR VGND sg13cmos5l_decap_8
* cell instance sg13cmos5l_decap_8_2332 r0 *1 0,0
Xsg13cmos5l_decap_8_2332 VPWR VGND sg13cmos5l_decap_8
* cell instance sg13cmos5l_decap_8_2333 r0 *1 0,0
Xsg13cmos5l_decap_8_2333 VPWR VGND sg13cmos5l_decap_8
* cell instance sg13cmos5l_decap_8_2334 r0 *1 0,0
Xsg13cmos5l_decap_8_2334 VPWR VGND sg13cmos5l_decap_8
* cell instance sg13cmos5l_decap_8_2335 r0 *1 0,0
Xsg13cmos5l_decap_8_2335 VPWR VGND sg13cmos5l_decap_8
* cell instance sg13cmos5l_decap_8_2336 r0 *1 0,0
Xsg13cmos5l_decap_8_2336 VPWR VGND sg13cmos5l_decap_8
* cell instance sg13cmos5l_decap_8_2337 r0 *1 0,0
Xsg13cmos5l_decap_8_2337 VPWR VGND sg13cmos5l_decap_8
* cell instance sg13cmos5l_decap_8_2338 r0 *1 0,0
Xsg13cmos5l_decap_8_2338 VPWR VGND sg13cmos5l_decap_8
* cell instance sg13cmos5l_decap_8_2339 r0 *1 0,0
Xsg13cmos5l_decap_8_2339 VPWR VGND sg13cmos5l_decap_8
* cell instance sg13cmos5l_decap_8_2340 r0 *1 0,0
Xsg13cmos5l_decap_8_2340 VPWR VGND sg13cmos5l_decap_8
* cell instance sg13cmos5l_decap_8_2341 r0 *1 0,0
Xsg13cmos5l_decap_8_2341 VPWR VGND sg13cmos5l_decap_8
* cell instance sg13cmos5l_decap_8_2342 r0 *1 0,0
Xsg13cmos5l_decap_8_2342 VPWR VGND sg13cmos5l_decap_8
* cell instance sg13cmos5l_decap_8_2343 r0 *1 0,0
Xsg13cmos5l_decap_8_2343 VPWR VGND sg13cmos5l_decap_8
* cell instance sg13cmos5l_decap_8_2344 r0 *1 0,0
Xsg13cmos5l_decap_8_2344 VPWR VGND sg13cmos5l_decap_8
* cell instance sg13cmos5l_decap_8_2345 r0 *1 0,0
Xsg13cmos5l_decap_8_2345 VPWR VGND sg13cmos5l_decap_8
* cell instance sg13cmos5l_decap_8_2346 r0 *1 0,0
Xsg13cmos5l_decap_8_2346 VPWR VGND sg13cmos5l_decap_8
* cell instance sg13cmos5l_decap_8_2347 r0 *1 0,0
Xsg13cmos5l_decap_8_2347 VPWR VGND sg13cmos5l_decap_8
* cell instance sg13cmos5l_decap_8_2348 r0 *1 0,0
Xsg13cmos5l_decap_8_2348 VPWR VGND sg13cmos5l_decap_8
* cell instance sg13cmos5l_decap_8_2349 r0 *1 0,0
Xsg13cmos5l_decap_8_2349 VPWR VGND sg13cmos5l_decap_8
* cell instance sg13cmos5l_decap_8_2350 r0 *1 0,0
Xsg13cmos5l_decap_8_2350 VPWR VGND sg13cmos5l_decap_8
* cell instance sg13cmos5l_decap_8_2351 r0 *1 0,0
Xsg13cmos5l_decap_8_2351 VPWR VGND sg13cmos5l_decap_8
* cell instance sg13cmos5l_decap_8_2352 r0 *1 0,0
Xsg13cmos5l_decap_8_2352 VPWR VGND sg13cmos5l_decap_8
* cell instance sg13cmos5l_decap_8_2353 r0 *1 0,0
Xsg13cmos5l_decap_8_2353 VPWR VGND sg13cmos5l_decap_8
* cell instance sg13cmos5l_decap_8_2354 r0 *1 0,0
Xsg13cmos5l_decap_8_2354 VPWR VGND sg13cmos5l_decap_8
* cell instance sg13cmos5l_decap_8_2355 r0 *1 0,0
Xsg13cmos5l_decap_8_2355 VPWR VGND sg13cmos5l_decap_8
* cell instance sg13cmos5l_decap_8_2356 r0 *1 0,0
Xsg13cmos5l_decap_8_2356 VPWR VGND sg13cmos5l_decap_8
* cell instance sg13cmos5l_decap_8_2357 r0 *1 0,0
Xsg13cmos5l_decap_8_2357 VPWR VGND sg13cmos5l_decap_8
* cell instance sg13cmos5l_decap_8_2358 r0 *1 0,0
Xsg13cmos5l_decap_8_2358 VPWR VGND sg13cmos5l_decap_8
* cell instance sg13cmos5l_decap_8_2359 r0 *1 0,0
Xsg13cmos5l_decap_8_2359 VPWR VGND sg13cmos5l_decap_8
* cell instance sg13cmos5l_decap_8_2360 r0 *1 0,0
Xsg13cmos5l_decap_8_2360 VPWR VGND sg13cmos5l_decap_8
* cell instance sg13cmos5l_decap_8_2361 r0 *1 0,0
Xsg13cmos5l_decap_8_2361 VPWR VGND sg13cmos5l_decap_8
* cell instance sg13cmos5l_decap_8_2362 r0 *1 0,0
Xsg13cmos5l_decap_8_2362 VPWR VGND sg13cmos5l_decap_8
* cell instance sg13cmos5l_decap_8_2363 r0 *1 0,0
Xsg13cmos5l_decap_8_2363 VPWR VGND sg13cmos5l_decap_8
* cell instance sg13cmos5l_decap_8_2364 r0 *1 0,0
Xsg13cmos5l_decap_8_2364 VPWR VGND sg13cmos5l_decap_8
* cell instance sg13cmos5l_decap_8_2365 r0 *1 0,0
Xsg13cmos5l_decap_8_2365 VPWR VGND sg13cmos5l_decap_8
* cell instance sg13cmos5l_decap_8_2366 r0 *1 0,0
Xsg13cmos5l_decap_8_2366 VPWR VGND sg13cmos5l_decap_8
* cell instance sg13cmos5l_decap_8_2367 r0 *1 0,0
Xsg13cmos5l_decap_8_2367 VPWR VGND sg13cmos5l_decap_8
* cell instance sg13cmos5l_decap_8_2368 r0 *1 0,0
Xsg13cmos5l_decap_8_2368 VPWR VGND sg13cmos5l_decap_8
* cell instance sg13cmos5l_decap_8_2369 r0 *1 0,0
Xsg13cmos5l_decap_8_2369 VPWR VGND sg13cmos5l_decap_8
* cell instance sg13cmos5l_decap_8_2370 r0 *1 0,0
Xsg13cmos5l_decap_8_2370 VPWR VGND sg13cmos5l_decap_8
* cell instance sg13cmos5l_decap_8_2371 r0 *1 0,0
Xsg13cmos5l_decap_8_2371 VPWR VGND sg13cmos5l_decap_8
* cell instance sg13cmos5l_decap_8_2372 r0 *1 0,0
Xsg13cmos5l_decap_8_2372 VPWR VGND sg13cmos5l_decap_8
* cell instance sg13cmos5l_decap_8_2373 r0 *1 0,0
Xsg13cmos5l_decap_8_2373 VPWR VGND sg13cmos5l_decap_8
* cell instance sg13cmos5l_decap_8_2374 r0 *1 0,0
Xsg13cmos5l_decap_8_2374 VPWR VGND sg13cmos5l_decap_8
* cell instance sg13cmos5l_decap_8_2375 r0 *1 0,0
Xsg13cmos5l_decap_8_2375 VPWR VGND sg13cmos5l_decap_8
* cell instance sg13cmos5l_decap_8_2376 r0 *1 0,0
Xsg13cmos5l_decap_8_2376 VPWR VGND sg13cmos5l_decap_8
* cell instance sg13cmos5l_decap_8_2377 r0 *1 0,0
Xsg13cmos5l_decap_8_2377 VPWR VGND sg13cmos5l_decap_8
* cell instance sg13cmos5l_decap_8_2378 r0 *1 0,0
Xsg13cmos5l_decap_8_2378 VPWR VGND sg13cmos5l_decap_8
* cell instance sg13cmos5l_decap_8_2379 r0 *1 0,0
Xsg13cmos5l_decap_8_2379 VPWR VGND sg13cmos5l_decap_8
* cell instance sg13cmos5l_decap_8_2380 r0 *1 0,0
Xsg13cmos5l_decap_8_2380 VPWR VGND sg13cmos5l_decap_8
* cell instance sg13cmos5l_decap_8_2381 r0 *1 0,0
Xsg13cmos5l_decap_8_2381 VPWR VGND sg13cmos5l_decap_8
* cell instance sg13cmos5l_decap_8_2382 r0 *1 0,0
Xsg13cmos5l_decap_8_2382 VPWR VGND sg13cmos5l_decap_8
* cell instance sg13cmos5l_decap_8_2383 r0 *1 0,0
Xsg13cmos5l_decap_8_2383 VPWR VGND sg13cmos5l_decap_8
* cell instance sg13cmos5l_decap_8_2384 r0 *1 0,0
Xsg13cmos5l_decap_8_2384 VPWR VGND sg13cmos5l_decap_8
* cell instance sg13cmos5l_decap_8_2385 r0 *1 0,0
Xsg13cmos5l_decap_8_2385 VPWR VGND sg13cmos5l_decap_8
* cell instance sg13cmos5l_decap_8_2386 r0 *1 0,0
Xsg13cmos5l_decap_8_2386 VPWR VGND sg13cmos5l_decap_8
* cell instance sg13cmos5l_decap_8_2387 r0 *1 0,0
Xsg13cmos5l_decap_8_2387 VPWR VGND sg13cmos5l_decap_8
* cell instance sg13cmos5l_decap_8_2388 r0 *1 0,0
Xsg13cmos5l_decap_8_2388 VPWR VGND sg13cmos5l_decap_8
* cell instance sg13cmos5l_decap_8_2389 r0 *1 0,0
Xsg13cmos5l_decap_8_2389 VPWR VGND sg13cmos5l_decap_8
* cell instance sg13cmos5l_decap_8_2390 r0 *1 0,0
Xsg13cmos5l_decap_8_2390 VPWR VGND sg13cmos5l_decap_8
* cell instance sg13cmos5l_decap_8_2391 r0 *1 0,0
Xsg13cmos5l_decap_8_2391 VPWR VGND sg13cmos5l_decap_8
* cell instance sg13cmos5l_decap_8_2392 r0 *1 0,0
Xsg13cmos5l_decap_8_2392 VPWR VGND sg13cmos5l_decap_8
* cell instance sg13cmos5l_decap_8_2393 r0 *1 0,0
Xsg13cmos5l_decap_8_2393 VPWR VGND sg13cmos5l_decap_8
* cell instance sg13cmos5l_decap_8_2394 r0 *1 0,0
Xsg13cmos5l_decap_8_2394 VPWR VGND sg13cmos5l_decap_8
* cell instance sg13cmos5l_decap_8_2395 r0 *1 0,0
Xsg13cmos5l_decap_8_2395 VPWR VGND sg13cmos5l_decap_8
* cell instance sg13cmos5l_decap_8_2396 r0 *1 0,0
Xsg13cmos5l_decap_8_2396 VPWR VGND sg13cmos5l_decap_8
* cell instance sg13cmos5l_decap_8_2397 r0 *1 0,0
Xsg13cmos5l_decap_8_2397 VPWR VGND sg13cmos5l_decap_8
* cell instance sg13cmos5l_decap_8_2398 r0 *1 0,0
Xsg13cmos5l_decap_8_2398 VPWR VGND sg13cmos5l_decap_8
* cell instance sg13cmos5l_decap_8_2399 r0 *1 0,0
Xsg13cmos5l_decap_8_2399 VPWR VGND sg13cmos5l_decap_8
* cell instance sg13cmos5l_decap_8_2400 r0 *1 0,0
Xsg13cmos5l_decap_8_2400 VPWR VGND sg13cmos5l_decap_8
* cell instance sg13cmos5l_decap_8_2401 r0 *1 0,0
Xsg13cmos5l_decap_8_2401 VPWR VGND sg13cmos5l_decap_8
* cell instance sg13cmos5l_decap_8_2402 r0 *1 0,0
Xsg13cmos5l_decap_8_2402 VPWR VGND sg13cmos5l_decap_8
* cell instance sg13cmos5l_decap_8_2403 r0 *1 0,0
Xsg13cmos5l_decap_8_2403 VPWR VGND sg13cmos5l_decap_8
* cell instance sg13cmos5l_decap_8_2404 r0 *1 0,0
Xsg13cmos5l_decap_8_2404 VPWR VGND sg13cmos5l_decap_8
* cell instance sg13cmos5l_decap_8_2405 r0 *1 0,0
Xsg13cmos5l_decap_8_2405 VPWR VGND sg13cmos5l_decap_8
* cell instance sg13cmos5l_decap_8_2406 r0 *1 0,0
Xsg13cmos5l_decap_8_2406 VPWR VGND sg13cmos5l_decap_8
* cell instance sg13cmos5l_decap_8_2407 r0 *1 0,0
Xsg13cmos5l_decap_8_2407 VPWR VGND sg13cmos5l_decap_8
* cell instance sg13cmos5l_decap_8_2408 r0 *1 0,0
Xsg13cmos5l_decap_8_2408 VPWR VGND sg13cmos5l_decap_8
* cell instance sg13cmos5l_decap_8_2409 r0 *1 0,0
Xsg13cmos5l_decap_8_2409 VPWR VGND sg13cmos5l_decap_8
* cell instance sg13cmos5l_decap_8_2410 r0 *1 0,0
Xsg13cmos5l_decap_8_2410 VPWR VGND sg13cmos5l_decap_8
* cell instance sg13cmos5l_decap_8_2411 r0 *1 0,0
Xsg13cmos5l_decap_8_2411 VPWR VGND sg13cmos5l_decap_8
* cell instance sg13cmos5l_decap_8_2412 r0 *1 0,0
Xsg13cmos5l_decap_8_2412 VPWR VGND sg13cmos5l_decap_8
* cell instance sg13cmos5l_decap_8_2413 r0 *1 0,0
Xsg13cmos5l_decap_8_2413 VPWR VGND sg13cmos5l_decap_8
* cell instance sg13cmos5l_decap_8_2414 r0 *1 0,0
Xsg13cmos5l_decap_8_2414 VPWR VGND sg13cmos5l_decap_8
* cell instance sg13cmos5l_decap_8_2415 r0 *1 0,0
Xsg13cmos5l_decap_8_2415 VPWR VGND sg13cmos5l_decap_8
* cell instance sg13cmos5l_decap_8_2416 r0 *1 0,0
Xsg13cmos5l_decap_8_2416 VPWR VGND sg13cmos5l_decap_8
* cell instance sg13cmos5l_decap_8_2417 r0 *1 0,0
Xsg13cmos5l_decap_8_2417 VPWR VGND sg13cmos5l_decap_8
* cell instance sg13cmos5l_decap_8_2418 r0 *1 0,0
Xsg13cmos5l_decap_8_2418 VPWR VGND sg13cmos5l_decap_8
* cell instance sg13cmos5l_decap_8_2419 r0 *1 0,0
Xsg13cmos5l_decap_8_2419 VPWR VGND sg13cmos5l_decap_8
* cell instance sg13cmos5l_decap_8_2420 r0 *1 0,0
Xsg13cmos5l_decap_8_2420 VPWR VGND sg13cmos5l_decap_8
* cell instance sg13cmos5l_decap_8_2421 r0 *1 0,0
Xsg13cmos5l_decap_8_2421 VPWR VGND sg13cmos5l_decap_8
* cell instance sg13cmos5l_decap_8_2422 r0 *1 0,0
Xsg13cmos5l_decap_8_2422 VPWR VGND sg13cmos5l_decap_8
* cell instance sg13cmos5l_decap_8_2423 r0 *1 0,0
Xsg13cmos5l_decap_8_2423 VPWR VGND sg13cmos5l_decap_8
* cell instance sg13cmos5l_decap_8_2424 r0 *1 0,0
Xsg13cmos5l_decap_8_2424 VPWR VGND sg13cmos5l_decap_8
* cell instance sg13cmos5l_decap_8_2425 r0 *1 0,0
Xsg13cmos5l_decap_8_2425 VPWR VGND sg13cmos5l_decap_8
* cell instance sg13cmos5l_decap_8_2426 r0 *1 0,0
Xsg13cmos5l_decap_8_2426 VPWR VGND sg13cmos5l_decap_8
* cell instance sg13cmos5l_decap_8_2427 r0 *1 0,0
Xsg13cmos5l_decap_8_2427 VPWR VGND sg13cmos5l_decap_8
* cell instance sg13cmos5l_decap_8_2428 r0 *1 0,0
Xsg13cmos5l_decap_8_2428 VPWR VGND sg13cmos5l_decap_8
* cell instance sg13cmos5l_decap_8_2429 r0 *1 0,0
Xsg13cmos5l_decap_8_2429 VPWR VGND sg13cmos5l_decap_8
* cell instance sg13cmos5l_decap_8_2430 r0 *1 0,0
Xsg13cmos5l_decap_8_2430 VPWR VGND sg13cmos5l_decap_8
* cell instance sg13cmos5l_decap_8_2431 r0 *1 0,0
Xsg13cmos5l_decap_8_2431 VPWR VGND sg13cmos5l_decap_8
* cell instance sg13cmos5l_decap_8_2432 r0 *1 0,0
Xsg13cmos5l_decap_8_2432 VPWR VGND sg13cmos5l_decap_8
* cell instance sg13cmos5l_decap_8_2433 r0 *1 0,0
Xsg13cmos5l_decap_8_2433 VPWR VGND sg13cmos5l_decap_8
* cell instance sg13cmos5l_decap_8_2434 r0 *1 0,0
Xsg13cmos5l_decap_8_2434 VPWR VGND sg13cmos5l_decap_8
* cell instance sg13cmos5l_decap_8_2435 r0 *1 0,0
Xsg13cmos5l_decap_8_2435 VPWR VGND sg13cmos5l_decap_8
* cell instance sg13cmos5l_decap_8_2436 r0 *1 0,0
Xsg13cmos5l_decap_8_2436 VPWR VGND sg13cmos5l_decap_8
* cell instance sg13cmos5l_decap_8_2437 r0 *1 0,0
Xsg13cmos5l_decap_8_2437 VPWR VGND sg13cmos5l_decap_8
* cell instance sg13cmos5l_decap_8_2438 r0 *1 0,0
Xsg13cmos5l_decap_8_2438 VPWR VGND sg13cmos5l_decap_8
* cell instance sg13cmos5l_decap_8_2439 r0 *1 0,0
Xsg13cmos5l_decap_8_2439 VPWR VGND sg13cmos5l_decap_8
* cell instance sg13cmos5l_decap_8_2440 r0 *1 0,0
Xsg13cmos5l_decap_8_2440 VPWR VGND sg13cmos5l_decap_8
* cell instance sg13cmos5l_decap_8_2441 r0 *1 0,0
Xsg13cmos5l_decap_8_2441 VPWR VGND sg13cmos5l_decap_8
* cell instance sg13cmos5l_decap_8_2442 r0 *1 0,0
Xsg13cmos5l_decap_8_2442 VPWR VGND sg13cmos5l_decap_8
* cell instance sg13cmos5l_decap_8_2443 r0 *1 0,0
Xsg13cmos5l_decap_8_2443 VPWR VGND sg13cmos5l_decap_8
* cell instance sg13cmos5l_decap_8_2444 r0 *1 0,0
Xsg13cmos5l_decap_8_2444 VPWR VGND sg13cmos5l_decap_8
* cell instance sg13cmos5l_decap_8_2445 r0 *1 0,0
Xsg13cmos5l_decap_8_2445 VPWR VGND sg13cmos5l_decap_8
* cell instance sg13cmos5l_decap_8_2446 r0 *1 0,0
Xsg13cmos5l_decap_8_2446 VPWR VGND sg13cmos5l_decap_8
* cell instance sg13cmos5l_decap_8_2447 r0 *1 0,0
Xsg13cmos5l_decap_8_2447 VPWR VGND sg13cmos5l_decap_8
* cell instance sg13cmos5l_decap_8_2448 r0 *1 0,0
Xsg13cmos5l_decap_8_2448 VPWR VGND sg13cmos5l_decap_8
* cell instance sg13cmos5l_decap_8_2449 r0 *1 0,0
Xsg13cmos5l_decap_8_2449 VPWR VGND sg13cmos5l_decap_8
* cell instance sg13cmos5l_decap_8_2450 r0 *1 0,0
Xsg13cmos5l_decap_8_2450 VPWR VGND sg13cmos5l_decap_8
* cell instance sg13cmos5l_decap_8_2451 r0 *1 0,0
Xsg13cmos5l_decap_8_2451 VPWR VGND sg13cmos5l_decap_8
* cell instance sg13cmos5l_decap_8_2452 r0 *1 0,0
Xsg13cmos5l_decap_8_2452 VPWR VGND sg13cmos5l_decap_8
* cell instance sg13cmos5l_decap_8_2453 r0 *1 0,0
Xsg13cmos5l_decap_8_2453 VPWR VGND sg13cmos5l_decap_8
* cell instance sg13cmos5l_decap_8_2454 r0 *1 0,0
Xsg13cmos5l_decap_8_2454 VPWR VGND sg13cmos5l_decap_8
* cell instance sg13cmos5l_decap_8_2455 r0 *1 0,0
Xsg13cmos5l_decap_8_2455 VPWR VGND sg13cmos5l_decap_8
* cell instance sg13cmos5l_decap_8_2456 r0 *1 0,0
Xsg13cmos5l_decap_8_2456 VPWR VGND sg13cmos5l_decap_8
* cell instance sg13cmos5l_decap_8_2457 r0 *1 0,0
Xsg13cmos5l_decap_8_2457 VPWR VGND sg13cmos5l_decap_8
* cell instance sg13cmos5l_decap_8_2458 r0 *1 0,0
Xsg13cmos5l_decap_8_2458 VPWR VGND sg13cmos5l_decap_8
* cell instance sg13cmos5l_decap_8_2459 r0 *1 0,0
Xsg13cmos5l_decap_8_2459 VPWR VGND sg13cmos5l_decap_8
* cell instance sg13cmos5l_decap_8_2460 r0 *1 0,0
Xsg13cmos5l_decap_8_2460 VPWR VGND sg13cmos5l_decap_8
* cell instance sg13cmos5l_decap_8_2461 r0 *1 0,0
Xsg13cmos5l_decap_8_2461 VPWR VGND sg13cmos5l_decap_8
* cell instance sg13cmos5l_decap_8_2462 r0 *1 0,0
Xsg13cmos5l_decap_8_2462 VPWR VGND sg13cmos5l_decap_8
* cell instance sg13cmos5l_decap_8_2463 r0 *1 0,0
Xsg13cmos5l_decap_8_2463 VPWR VGND sg13cmos5l_decap_8
* cell instance sg13cmos5l_decap_8_2464 r0 *1 0,0
Xsg13cmos5l_decap_8_2464 VPWR VGND sg13cmos5l_decap_8
* cell instance sg13cmos5l_decap_8_2465 r0 *1 0,0
Xsg13cmos5l_decap_8_2465 VPWR VGND sg13cmos5l_decap_8
* cell instance sg13cmos5l_decap_8_2466 r0 *1 0,0
Xsg13cmos5l_decap_8_2466 VPWR VGND sg13cmos5l_decap_8
* cell instance sg13cmos5l_decap_8_2467 r0 *1 0,0
Xsg13cmos5l_decap_8_2467 VPWR VGND sg13cmos5l_decap_8
* cell instance sg13cmos5l_decap_8_2468 r0 *1 0,0
Xsg13cmos5l_decap_8_2468 VPWR VGND sg13cmos5l_decap_8
* cell instance sg13cmos5l_decap_8_2469 r0 *1 0,0
Xsg13cmos5l_decap_8_2469 VPWR VGND sg13cmos5l_decap_8
* cell instance sg13cmos5l_decap_8_2470 r0 *1 0,0
Xsg13cmos5l_decap_8_2470 VPWR VGND sg13cmos5l_decap_8
* cell instance sg13cmos5l_decap_8_2471 r0 *1 0,0
Xsg13cmos5l_decap_8_2471 VPWR VGND sg13cmos5l_decap_8
* cell instance sg13cmos5l_decap_8_2472 r0 *1 0,0
Xsg13cmos5l_decap_8_2472 VPWR VGND sg13cmos5l_decap_8
* cell instance sg13cmos5l_decap_8_2473 r0 *1 0,0
Xsg13cmos5l_decap_8_2473 VPWR VGND sg13cmos5l_decap_8
* cell instance sg13cmos5l_decap_8_2474 r0 *1 0,0
Xsg13cmos5l_decap_8_2474 VPWR VGND sg13cmos5l_decap_8
* cell instance sg13cmos5l_decap_8_2475 r0 *1 0,0
Xsg13cmos5l_decap_8_2475 VPWR VGND sg13cmos5l_decap_8
* cell instance sg13cmos5l_decap_8_2476 r0 *1 0,0
Xsg13cmos5l_decap_8_2476 VPWR VGND sg13cmos5l_decap_8
* cell instance sg13cmos5l_decap_8_2477 r0 *1 0,0
Xsg13cmos5l_decap_8_2477 VPWR VGND sg13cmos5l_decap_8
* cell instance sg13cmos5l_decap_8_2478 r0 *1 0,0
Xsg13cmos5l_decap_8_2478 VPWR VGND sg13cmos5l_decap_8
* cell instance sg13cmos5l_decap_8_2479 r0 *1 0,0
Xsg13cmos5l_decap_8_2479 VPWR VGND sg13cmos5l_decap_8
* cell instance sg13cmos5l_decap_8_2480 r0 *1 0,0
Xsg13cmos5l_decap_8_2480 VPWR VGND sg13cmos5l_decap_8
* cell instance sg13cmos5l_decap_8_2481 r0 *1 0,0
Xsg13cmos5l_decap_8_2481 VPWR VGND sg13cmos5l_decap_8
* cell instance sg13cmos5l_decap_8_2482 r0 *1 0,0
Xsg13cmos5l_decap_8_2482 VPWR VGND sg13cmos5l_decap_8
* cell instance sg13cmos5l_decap_8_2483 r0 *1 0,0
Xsg13cmos5l_decap_8_2483 VPWR VGND sg13cmos5l_decap_8
* cell instance sg13cmos5l_decap_8_2484 r0 *1 0,0
Xsg13cmos5l_decap_8_2484 VPWR VGND sg13cmos5l_decap_8
* cell instance sg13cmos5l_decap_8_2485 r0 *1 0,0
Xsg13cmos5l_decap_8_2485 VPWR VGND sg13cmos5l_decap_8
* cell instance sg13cmos5l_decap_8_2486 r0 *1 0,0
Xsg13cmos5l_decap_8_2486 VPWR VGND sg13cmos5l_decap_8
* cell instance sg13cmos5l_decap_8_2487 r0 *1 0,0
Xsg13cmos5l_decap_8_2487 VPWR VGND sg13cmos5l_decap_8
* cell instance sg13cmos5l_decap_8_2488 r0 *1 0,0
Xsg13cmos5l_decap_8_2488 VPWR VGND sg13cmos5l_decap_8
* cell instance sg13cmos5l_decap_8_2489 r0 *1 0,0
Xsg13cmos5l_decap_8_2489 VPWR VGND sg13cmos5l_decap_8
* cell instance sg13cmos5l_decap_8_2490 r0 *1 0,0
Xsg13cmos5l_decap_8_2490 VPWR VGND sg13cmos5l_decap_8
* cell instance sg13cmos5l_decap_8_2491 r0 *1 0,0
Xsg13cmos5l_decap_8_2491 VPWR VGND sg13cmos5l_decap_8
* cell instance sg13cmos5l_decap_8_2492 r0 *1 0,0
Xsg13cmos5l_decap_8_2492 VPWR VGND sg13cmos5l_decap_8
* cell instance sg13cmos5l_decap_8_2493 r0 *1 0,0
Xsg13cmos5l_decap_8_2493 VPWR VGND sg13cmos5l_decap_8
* cell instance sg13cmos5l_decap_8_2494 r0 *1 0,0
Xsg13cmos5l_decap_8_2494 VPWR VGND sg13cmos5l_decap_8
* cell instance sg13cmos5l_decap_8_2495 r0 *1 0,0
Xsg13cmos5l_decap_8_2495 VPWR VGND sg13cmos5l_decap_8
* cell instance sg13cmos5l_decap_8_2496 r0 *1 0,0
Xsg13cmos5l_decap_8_2496 VPWR VGND sg13cmos5l_decap_8
* cell instance sg13cmos5l_decap_8_2497 r0 *1 0,0
Xsg13cmos5l_decap_8_2497 VPWR VGND sg13cmos5l_decap_8
* cell instance sg13cmos5l_decap_8_2498 r0 *1 0,0
Xsg13cmos5l_decap_8_2498 VPWR VGND sg13cmos5l_decap_8
* cell instance sg13cmos5l_decap_8_2499 r0 *1 0,0
Xsg13cmos5l_decap_8_2499 VPWR VGND sg13cmos5l_decap_8
* cell instance sg13cmos5l_decap_8_2500 r0 *1 0,0
Xsg13cmos5l_decap_8_2500 VPWR VGND sg13cmos5l_decap_8
* cell instance sg13cmos5l_decap_8_2501 r0 *1 0,0
Xsg13cmos5l_decap_8_2501 VPWR VGND sg13cmos5l_decap_8
* cell instance sg13cmos5l_decap_8_2502 r0 *1 0,0
Xsg13cmos5l_decap_8_2502 VPWR VGND sg13cmos5l_decap_8
* cell instance sg13cmos5l_decap_8_2503 r0 *1 0,0
Xsg13cmos5l_decap_8_2503 VPWR VGND sg13cmos5l_decap_8
* cell instance sg13cmos5l_decap_8_2504 r0 *1 0,0
Xsg13cmos5l_decap_8_2504 VPWR VGND sg13cmos5l_decap_8
* cell instance sg13cmos5l_decap_8_2505 r0 *1 0,0
Xsg13cmos5l_decap_8_2505 VPWR VGND sg13cmos5l_decap_8
* cell instance sg13cmos5l_decap_8_2506 r0 *1 0,0
Xsg13cmos5l_decap_8_2506 VPWR VGND sg13cmos5l_decap_8
* cell instance sg13cmos5l_decap_8_2507 r0 *1 0,0
Xsg13cmos5l_decap_8_2507 VPWR VGND sg13cmos5l_decap_8
* cell instance sg13cmos5l_decap_8_2508 r0 *1 0,0
Xsg13cmos5l_decap_8_2508 VPWR VGND sg13cmos5l_decap_8
* cell instance sg13cmos5l_decap_8_2509 r0 *1 0,0
Xsg13cmos5l_decap_8_2509 VPWR VGND sg13cmos5l_decap_8
* cell instance sg13cmos5l_decap_8_2510 r0 *1 0,0
Xsg13cmos5l_decap_8_2510 VPWR VGND sg13cmos5l_decap_8
* cell instance sg13cmos5l_decap_8_2511 r0 *1 0,0
Xsg13cmos5l_decap_8_2511 VPWR VGND sg13cmos5l_decap_8
* cell instance sg13cmos5l_decap_8_2512 r0 *1 0,0
Xsg13cmos5l_decap_8_2512 VPWR VGND sg13cmos5l_decap_8
* cell instance sg13cmos5l_decap_8_2513 r0 *1 0,0
Xsg13cmos5l_decap_8_2513 VPWR VGND sg13cmos5l_decap_8
* cell instance sg13cmos5l_decap_8_2514 r0 *1 0,0
Xsg13cmos5l_decap_8_2514 VPWR VGND sg13cmos5l_decap_8
* cell instance sg13cmos5l_decap_8_2515 r0 *1 0,0
Xsg13cmos5l_decap_8_2515 VPWR VGND sg13cmos5l_decap_8
* cell instance sg13cmos5l_decap_8_2516 r0 *1 0,0
Xsg13cmos5l_decap_8_2516 VPWR VGND sg13cmos5l_decap_8
* cell instance sg13cmos5l_decap_8_2517 r0 *1 0,0
Xsg13cmos5l_decap_8_2517 VPWR VGND sg13cmos5l_decap_8
* cell instance sg13cmos5l_decap_8_2518 r0 *1 0,0
Xsg13cmos5l_decap_8_2518 VPWR VGND sg13cmos5l_decap_8
* cell instance sg13cmos5l_decap_8_2519 r0 *1 0,0
Xsg13cmos5l_decap_8_2519 VPWR VGND sg13cmos5l_decap_8
* cell instance sg13cmos5l_decap_8_2520 r0 *1 0,0
Xsg13cmos5l_decap_8_2520 VPWR VGND sg13cmos5l_decap_8
* cell instance sg13cmos5l_decap_8_2521 r0 *1 0,0
Xsg13cmos5l_decap_8_2521 VPWR VGND sg13cmos5l_decap_8
* cell instance sg13cmos5l_decap_8_2522 r0 *1 0,0
Xsg13cmos5l_decap_8_2522 VPWR VGND sg13cmos5l_decap_8
* cell instance sg13cmos5l_decap_8_2523 r0 *1 0,0
Xsg13cmos5l_decap_8_2523 VPWR VGND sg13cmos5l_decap_8
* cell instance sg13cmos5l_decap_8_2524 r0 *1 0,0
Xsg13cmos5l_decap_8_2524 VPWR VGND sg13cmos5l_decap_8
* cell instance sg13cmos5l_decap_8_2525 r0 *1 0,0
Xsg13cmos5l_decap_8_2525 VPWR VGND sg13cmos5l_decap_8
* cell instance sg13cmos5l_decap_8_2526 r0 *1 0,0
Xsg13cmos5l_decap_8_2526 VPWR VGND sg13cmos5l_decap_8
* cell instance sg13cmos5l_decap_8_2527 r0 *1 0,0
Xsg13cmos5l_decap_8_2527 VPWR VGND sg13cmos5l_decap_8
* cell instance sg13cmos5l_decap_8_2528 r0 *1 0,0
Xsg13cmos5l_decap_8_2528 VPWR VGND sg13cmos5l_decap_8
* cell instance sg13cmos5l_decap_8_2529 r0 *1 0,0
Xsg13cmos5l_decap_8_2529 VPWR VGND sg13cmos5l_decap_8
* cell instance sg13cmos5l_decap_8_2530 r0 *1 0,0
Xsg13cmos5l_decap_8_2530 VPWR VGND sg13cmos5l_decap_8
* cell instance sg13cmos5l_decap_8_2531 r0 *1 0,0
Xsg13cmos5l_decap_8_2531 VPWR VGND sg13cmos5l_decap_8
* cell instance sg13cmos5l_decap_8_2532 r0 *1 0,0
Xsg13cmos5l_decap_8_2532 VPWR VGND sg13cmos5l_decap_8
* cell instance sg13cmos5l_decap_8_2533 r0 *1 0,0
Xsg13cmos5l_decap_8_2533 VPWR VGND sg13cmos5l_decap_8
* cell instance sg13cmos5l_decap_8_2534 r0 *1 0,0
Xsg13cmos5l_decap_8_2534 VPWR VGND sg13cmos5l_decap_8
* cell instance sg13cmos5l_decap_8_2535 r0 *1 0,0
Xsg13cmos5l_decap_8_2535 VPWR VGND sg13cmos5l_decap_8
* cell instance sg13cmos5l_decap_8_2536 r0 *1 0,0
Xsg13cmos5l_decap_8_2536 VPWR VGND sg13cmos5l_decap_8
* cell instance sg13cmos5l_decap_8_2537 r0 *1 0,0
Xsg13cmos5l_decap_8_2537 VPWR VGND sg13cmos5l_decap_8
* cell instance sg13cmos5l_decap_8_2538 r0 *1 0,0
Xsg13cmos5l_decap_8_2538 VPWR VGND sg13cmos5l_decap_8
* cell instance sg13cmos5l_decap_8_2539 r0 *1 0,0
Xsg13cmos5l_decap_8_2539 VPWR VGND sg13cmos5l_decap_8
* cell instance sg13cmos5l_decap_8_2540 r0 *1 0,0
Xsg13cmos5l_decap_8_2540 VPWR VGND sg13cmos5l_decap_8
* cell instance sg13cmos5l_decap_8_2541 r0 *1 0,0
Xsg13cmos5l_decap_8_2541 VPWR VGND sg13cmos5l_decap_8
* cell instance sg13cmos5l_decap_8_2542 r0 *1 0,0
Xsg13cmos5l_decap_8_2542 VPWR VGND sg13cmos5l_decap_8
* cell instance sg13cmos5l_decap_8_2543 r0 *1 0,0
Xsg13cmos5l_decap_8_2543 VPWR VGND sg13cmos5l_decap_8
* cell instance sg13cmos5l_decap_8_2544 r0 *1 0,0
Xsg13cmos5l_decap_8_2544 VPWR VGND sg13cmos5l_decap_8
* cell instance sg13cmos5l_decap_8_2545 r0 *1 0,0
Xsg13cmos5l_decap_8_2545 VPWR VGND sg13cmos5l_decap_8
* cell instance sg13cmos5l_decap_8_2546 r0 *1 0,0
Xsg13cmos5l_decap_8_2546 VPWR VGND sg13cmos5l_decap_8
* cell instance sg13cmos5l_decap_8_2547 r0 *1 0,0
Xsg13cmos5l_decap_8_2547 VPWR VGND sg13cmos5l_decap_8
* cell instance sg13cmos5l_decap_8_2548 r0 *1 0,0
Xsg13cmos5l_decap_8_2548 VPWR VGND sg13cmos5l_decap_8
* cell instance sg13cmos5l_decap_8_2549 r0 *1 0,0
Xsg13cmos5l_decap_8_2549 VPWR VGND sg13cmos5l_decap_8
* cell instance sg13cmos5l_decap_8_2550 r0 *1 0,0
Xsg13cmos5l_decap_8_2550 VPWR VGND sg13cmos5l_decap_8
* cell instance sg13cmos5l_decap_8_2551 r0 *1 0,0
Xsg13cmos5l_decap_8_2551 VPWR VGND sg13cmos5l_decap_8
* cell instance sg13cmos5l_decap_8_2552 r0 *1 0,0
Xsg13cmos5l_decap_8_2552 VPWR VGND sg13cmos5l_decap_8
* cell instance sg13cmos5l_decap_8_2553 r0 *1 0,0
Xsg13cmos5l_decap_8_2553 VPWR VGND sg13cmos5l_decap_8
* cell instance sg13cmos5l_decap_8_2554 r0 *1 0,0
Xsg13cmos5l_decap_8_2554 VPWR VGND sg13cmos5l_decap_8
* cell instance sg13cmos5l_decap_8_2555 r0 *1 0,0
Xsg13cmos5l_decap_8_2555 VPWR VGND sg13cmos5l_decap_8
* cell instance sg13cmos5l_decap_8_2556 r0 *1 0,0
Xsg13cmos5l_decap_8_2556 VPWR VGND sg13cmos5l_decap_8
* cell instance sg13cmos5l_decap_8_2557 r0 *1 0,0
Xsg13cmos5l_decap_8_2557 VPWR VGND sg13cmos5l_decap_8
* cell instance sg13cmos5l_decap_8_2558 r0 *1 0,0
Xsg13cmos5l_decap_8_2558 VPWR VGND sg13cmos5l_decap_8
* cell instance sg13cmos5l_decap_8_2559 r0 *1 0,0
Xsg13cmos5l_decap_8_2559 VPWR VGND sg13cmos5l_decap_8
* cell instance sg13cmos5l_decap_8_2560 r0 *1 0,0
Xsg13cmos5l_decap_8_2560 VPWR VGND sg13cmos5l_decap_8
* cell instance sg13cmos5l_decap_8_2561 r0 *1 0,0
Xsg13cmos5l_decap_8_2561 VPWR VGND sg13cmos5l_decap_8
* cell instance sg13cmos5l_decap_8_2562 r0 *1 0,0
Xsg13cmos5l_decap_8_2562 VPWR VGND sg13cmos5l_decap_8
* cell instance sg13cmos5l_decap_8_2563 r0 *1 0,0
Xsg13cmos5l_decap_8_2563 VPWR VGND sg13cmos5l_decap_8
* cell instance sg13cmos5l_decap_8_2564 r0 *1 0,0
Xsg13cmos5l_decap_8_2564 VPWR VGND sg13cmos5l_decap_8
* cell instance sg13cmos5l_decap_8_2565 r0 *1 0,0
Xsg13cmos5l_decap_8_2565 VPWR VGND sg13cmos5l_decap_8
* cell instance sg13cmos5l_decap_8_2566 r0 *1 0,0
Xsg13cmos5l_decap_8_2566 VPWR VGND sg13cmos5l_decap_8
* cell instance sg13cmos5l_decap_8_2567 r0 *1 0,0
Xsg13cmos5l_decap_8_2567 VPWR VGND sg13cmos5l_decap_8
* cell instance sg13cmos5l_decap_8_2568 r0 *1 0,0
Xsg13cmos5l_decap_8_2568 VPWR VGND sg13cmos5l_decap_8
* cell instance sg13cmos5l_decap_8_2569 r0 *1 0,0
Xsg13cmos5l_decap_8_2569 VPWR VGND sg13cmos5l_decap_8
* cell instance sg13cmos5l_decap_8_2570 r0 *1 0,0
Xsg13cmos5l_decap_8_2570 VPWR VGND sg13cmos5l_decap_8
* cell instance sg13cmos5l_decap_8_2571 r0 *1 0,0
Xsg13cmos5l_decap_8_2571 VPWR VGND sg13cmos5l_decap_8
* cell instance sg13cmos5l_decap_8_2572 r0 *1 0,0
Xsg13cmos5l_decap_8_2572 VPWR VGND sg13cmos5l_decap_8
* cell instance sg13cmos5l_decap_8_2573 r0 *1 0,0
Xsg13cmos5l_decap_8_2573 VPWR VGND sg13cmos5l_decap_8
* cell instance sg13cmos5l_decap_8_2574 r0 *1 0,0
Xsg13cmos5l_decap_8_2574 VPWR VGND sg13cmos5l_decap_8
* cell instance sg13cmos5l_decap_8_2575 r0 *1 0,0
Xsg13cmos5l_decap_8_2575 VPWR VGND sg13cmos5l_decap_8
* cell instance sg13cmos5l_decap_8_2576 r0 *1 0,0
Xsg13cmos5l_decap_8_2576 VPWR VGND sg13cmos5l_decap_8
* cell instance sg13cmos5l_decap_8_2577 r0 *1 0,0
Xsg13cmos5l_decap_8_2577 VPWR VGND sg13cmos5l_decap_8
* cell instance sg13cmos5l_decap_8_2578 r0 *1 0,0
Xsg13cmos5l_decap_8_2578 VPWR VGND sg13cmos5l_decap_8
* cell instance sg13cmos5l_decap_8_2579 r0 *1 0,0
Xsg13cmos5l_decap_8_2579 VPWR VGND sg13cmos5l_decap_8
* cell instance sg13cmos5l_decap_8_2580 r0 *1 0,0
Xsg13cmos5l_decap_8_2580 VPWR VGND sg13cmos5l_decap_8
* cell instance sg13cmos5l_decap_8_2581 r0 *1 0,0
Xsg13cmos5l_decap_8_2581 VPWR VGND sg13cmos5l_decap_8
* cell instance sg13cmos5l_decap_8_2582 r0 *1 0,0
Xsg13cmos5l_decap_8_2582 VPWR VGND sg13cmos5l_decap_8
* cell instance sg13cmos5l_decap_8_2583 r0 *1 0,0
Xsg13cmos5l_decap_8_2583 VPWR VGND sg13cmos5l_decap_8
* cell instance sg13cmos5l_decap_8_2584 r0 *1 0,0
Xsg13cmos5l_decap_8_2584 VPWR VGND sg13cmos5l_decap_8
* cell instance sg13cmos5l_decap_8_2585 r0 *1 0,0
Xsg13cmos5l_decap_8_2585 VPWR VGND sg13cmos5l_decap_8
* cell instance sg13cmos5l_decap_8_2586 r0 *1 0,0
Xsg13cmos5l_decap_8_2586 VPWR VGND sg13cmos5l_decap_8
* cell instance sg13cmos5l_decap_8_2587 r0 *1 0,0
Xsg13cmos5l_decap_8_2587 VPWR VGND sg13cmos5l_decap_8
* cell instance sg13cmos5l_decap_8_2588 r0 *1 0,0
Xsg13cmos5l_decap_8_2588 VPWR VGND sg13cmos5l_decap_8
* cell instance sg13cmos5l_decap_8_2589 r0 *1 0,0
Xsg13cmos5l_decap_8_2589 VPWR VGND sg13cmos5l_decap_8
* cell instance sg13cmos5l_decap_8_2590 r0 *1 0,0
Xsg13cmos5l_decap_8_2590 VPWR VGND sg13cmos5l_decap_8
* cell instance sg13cmos5l_decap_8_2591 r0 *1 0,0
Xsg13cmos5l_decap_8_2591 VPWR VGND sg13cmos5l_decap_8
* cell instance sg13cmos5l_decap_8_2592 r0 *1 0,0
Xsg13cmos5l_decap_8_2592 VPWR VGND sg13cmos5l_decap_8
* cell instance sg13cmos5l_decap_8_2593 r0 *1 0,0
Xsg13cmos5l_decap_8_2593 VPWR VGND sg13cmos5l_decap_8
* cell instance sg13cmos5l_decap_8_2594 r0 *1 0,0
Xsg13cmos5l_decap_8_2594 VPWR VGND sg13cmos5l_decap_8
* cell instance sg13cmos5l_decap_8_2595 r0 *1 0,0
Xsg13cmos5l_decap_8_2595 VPWR VGND sg13cmos5l_decap_8
* cell instance sg13cmos5l_decap_8_2596 r0 *1 0,0
Xsg13cmos5l_decap_8_2596 VPWR VGND sg13cmos5l_decap_8
* cell instance sg13cmos5l_decap_8_2597 r0 *1 0,0
Xsg13cmos5l_decap_8_2597 VPWR VGND sg13cmos5l_decap_8
* cell instance sg13cmos5l_decap_8_2598 r0 *1 0,0
Xsg13cmos5l_decap_8_2598 VPWR VGND sg13cmos5l_decap_8
* cell instance sg13cmos5l_decap_8_2599 r0 *1 0,0
Xsg13cmos5l_decap_8_2599 VPWR VGND sg13cmos5l_decap_8
* cell instance sg13cmos5l_decap_8_2600 r0 *1 0,0
Xsg13cmos5l_decap_8_2600 VPWR VGND sg13cmos5l_decap_8
* cell instance sg13cmos5l_decap_8_2601 r0 *1 0,0
Xsg13cmos5l_decap_8_2601 VPWR VGND sg13cmos5l_decap_8
* cell instance sg13cmos5l_decap_8_2602 r0 *1 0,0
Xsg13cmos5l_decap_8_2602 VPWR VGND sg13cmos5l_decap_8
* cell instance sg13cmos5l_decap_8_2603 r0 *1 0,0
Xsg13cmos5l_decap_8_2603 VPWR VGND sg13cmos5l_decap_8
* cell instance sg13cmos5l_decap_8_2604 r0 *1 0,0
Xsg13cmos5l_decap_8_2604 VPWR VGND sg13cmos5l_decap_8
* cell instance sg13cmos5l_decap_8_2605 r0 *1 0,0
Xsg13cmos5l_decap_8_2605 VPWR VGND sg13cmos5l_decap_8
* cell instance sg13cmos5l_decap_8_2606 r0 *1 0,0
Xsg13cmos5l_decap_8_2606 VPWR VGND sg13cmos5l_decap_8
* cell instance sg13cmos5l_decap_8_2607 r0 *1 0,0
Xsg13cmos5l_decap_8_2607 VPWR VGND sg13cmos5l_decap_8
* cell instance sg13cmos5l_decap_8_2608 r0 *1 0,0
Xsg13cmos5l_decap_8_2608 VPWR VGND sg13cmos5l_decap_8
* cell instance sg13cmos5l_decap_8_2609 r0 *1 0,0
Xsg13cmos5l_decap_8_2609 VPWR VGND sg13cmos5l_decap_8
* cell instance sg13cmos5l_decap_8_2610 r0 *1 0,0
Xsg13cmos5l_decap_8_2610 VPWR VGND sg13cmos5l_decap_8
* cell instance sg13cmos5l_decap_8_2611 r0 *1 0,0
Xsg13cmos5l_decap_8_2611 VPWR VGND sg13cmos5l_decap_8
* cell instance sg13cmos5l_decap_8_2612 r0 *1 0,0
Xsg13cmos5l_decap_8_2612 VPWR VGND sg13cmos5l_decap_8
* cell instance sg13cmos5l_decap_8_2613 r0 *1 0,0
Xsg13cmos5l_decap_8_2613 VPWR VGND sg13cmos5l_decap_8
* cell instance sg13cmos5l_decap_8_2614 r0 *1 0,0
Xsg13cmos5l_decap_8_2614 VPWR VGND sg13cmos5l_decap_8
* cell instance sg13cmos5l_decap_8_2615 r0 *1 0,0
Xsg13cmos5l_decap_8_2615 VPWR VGND sg13cmos5l_decap_8
* cell instance sg13cmos5l_decap_8_2616 r0 *1 0,0
Xsg13cmos5l_decap_8_2616 VPWR VGND sg13cmos5l_decap_8
* cell instance sg13cmos5l_decap_8_2617 r0 *1 0,0
Xsg13cmos5l_decap_8_2617 VPWR VGND sg13cmos5l_decap_8
* cell instance sg13cmos5l_decap_8_2618 r0 *1 0,0
Xsg13cmos5l_decap_8_2618 VPWR VGND sg13cmos5l_decap_8
* cell instance sg13cmos5l_decap_8_2619 r0 *1 0,0
Xsg13cmos5l_decap_8_2619 VPWR VGND sg13cmos5l_decap_8
* cell instance sg13cmos5l_decap_8_2620 r0 *1 0,0
Xsg13cmos5l_decap_8_2620 VPWR VGND sg13cmos5l_decap_8
* cell instance sg13cmos5l_decap_8_2621 r0 *1 0,0
Xsg13cmos5l_decap_8_2621 VPWR VGND sg13cmos5l_decap_8
* cell instance sg13cmos5l_decap_8_2622 r0 *1 0,0
Xsg13cmos5l_decap_8_2622 VPWR VGND sg13cmos5l_decap_8
* cell instance sg13cmos5l_decap_8_2623 r0 *1 0,0
Xsg13cmos5l_decap_8_2623 VPWR VGND sg13cmos5l_decap_8
* cell instance sg13cmos5l_decap_8_2624 r0 *1 0,0
Xsg13cmos5l_decap_8_2624 VPWR VGND sg13cmos5l_decap_8
* cell instance sg13cmos5l_decap_8_2625 r0 *1 0,0
Xsg13cmos5l_decap_8_2625 VPWR VGND sg13cmos5l_decap_8
* cell instance sg13cmos5l_decap_8_2626 r0 *1 0,0
Xsg13cmos5l_decap_8_2626 VPWR VGND sg13cmos5l_decap_8
* cell instance sg13cmos5l_decap_8_2627 r0 *1 0,0
Xsg13cmos5l_decap_8_2627 VPWR VGND sg13cmos5l_decap_8
* cell instance sg13cmos5l_decap_8_2628 r0 *1 0,0
Xsg13cmos5l_decap_8_2628 VPWR VGND sg13cmos5l_decap_8
* cell instance sg13cmos5l_decap_8_2629 r0 *1 0,0
Xsg13cmos5l_decap_8_2629 VPWR VGND sg13cmos5l_decap_8
* cell instance sg13cmos5l_decap_8_2630 r0 *1 0,0
Xsg13cmos5l_decap_8_2630 VPWR VGND sg13cmos5l_decap_8
* cell instance sg13cmos5l_decap_8_2631 r0 *1 0,0
Xsg13cmos5l_decap_8_2631 VPWR VGND sg13cmos5l_decap_8
* cell instance sg13cmos5l_decap_8_2632 r0 *1 0,0
Xsg13cmos5l_decap_8_2632 VPWR VGND sg13cmos5l_decap_8
* cell instance sg13cmos5l_decap_8_2633 r0 *1 0,0
Xsg13cmos5l_decap_8_2633 VPWR VGND sg13cmos5l_decap_8
* cell instance sg13cmos5l_decap_8_2634 r0 *1 0,0
Xsg13cmos5l_decap_8_2634 VPWR VGND sg13cmos5l_decap_8
* cell instance sg13cmos5l_decap_8_2635 r0 *1 0,0
Xsg13cmos5l_decap_8_2635 VPWR VGND sg13cmos5l_decap_8
* cell instance sg13cmos5l_decap_8_2636 r0 *1 0,0
Xsg13cmos5l_decap_8_2636 VPWR VGND sg13cmos5l_decap_8
* cell instance sg13cmos5l_decap_8_2637 r0 *1 0,0
Xsg13cmos5l_decap_8_2637 VPWR VGND sg13cmos5l_decap_8
* cell instance sg13cmos5l_decap_8_2638 r0 *1 0,0
Xsg13cmos5l_decap_8_2638 VPWR VGND sg13cmos5l_decap_8
* cell instance sg13cmos5l_decap_8_2639 r0 *1 0,0
Xsg13cmos5l_decap_8_2639 VPWR VGND sg13cmos5l_decap_8
* cell instance sg13cmos5l_decap_8_2640 r0 *1 0,0
Xsg13cmos5l_decap_8_2640 VPWR VGND sg13cmos5l_decap_8
* cell instance sg13cmos5l_decap_8_2641 r0 *1 0,0
Xsg13cmos5l_decap_8_2641 VPWR VGND sg13cmos5l_decap_8
* cell instance sg13cmos5l_decap_8_2642 r0 *1 0,0
Xsg13cmos5l_decap_8_2642 VPWR VGND sg13cmos5l_decap_8
* cell instance sg13cmos5l_decap_8_2643 r0 *1 0,0
Xsg13cmos5l_decap_8_2643 VPWR VGND sg13cmos5l_decap_8
* cell instance sg13cmos5l_decap_8_2644 r0 *1 0,0
Xsg13cmos5l_decap_8_2644 VPWR VGND sg13cmos5l_decap_8
* cell instance sg13cmos5l_decap_8_2645 r0 *1 0,0
Xsg13cmos5l_decap_8_2645 VPWR VGND sg13cmos5l_decap_8
* cell instance sg13cmos5l_decap_8_2646 r0 *1 0,0
Xsg13cmos5l_decap_8_2646 VPWR VGND sg13cmos5l_decap_8
* cell instance sg13cmos5l_decap_8_2647 r0 *1 0,0
Xsg13cmos5l_decap_8_2647 VPWR VGND sg13cmos5l_decap_8
* cell instance sg13cmos5l_decap_8_2648 r0 *1 0,0
Xsg13cmos5l_decap_8_2648 VPWR VGND sg13cmos5l_decap_8
* cell instance sg13cmos5l_decap_8_2649 r0 *1 0,0
Xsg13cmos5l_decap_8_2649 VPWR VGND sg13cmos5l_decap_8
* cell instance sg13cmos5l_decap_8_2650 r0 *1 0,0
Xsg13cmos5l_decap_8_2650 VPWR VGND sg13cmos5l_decap_8
* cell instance sg13cmos5l_decap_8_2651 r0 *1 0,0
Xsg13cmos5l_decap_8_2651 VPWR VGND sg13cmos5l_decap_8
* cell instance sg13cmos5l_decap_8_2652 r0 *1 0,0
Xsg13cmos5l_decap_8_2652 VPWR VGND sg13cmos5l_decap_8
* cell instance sg13cmos5l_decap_8_2653 r0 *1 0,0
Xsg13cmos5l_decap_8_2653 VPWR VGND sg13cmos5l_decap_8
* cell instance sg13cmos5l_decap_8_2654 r0 *1 0,0
Xsg13cmos5l_decap_8_2654 VPWR VGND sg13cmos5l_decap_8
* cell instance sg13cmos5l_decap_8_2655 r0 *1 0,0
Xsg13cmos5l_decap_8_2655 VPWR VGND sg13cmos5l_decap_8
* cell instance sg13cmos5l_decap_8_2656 r0 *1 0,0
Xsg13cmos5l_decap_8_2656 VPWR VGND sg13cmos5l_decap_8
* cell instance sg13cmos5l_decap_8_2657 r0 *1 0,0
Xsg13cmos5l_decap_8_2657 VPWR VGND sg13cmos5l_decap_8
* cell instance sg13cmos5l_decap_8_2658 r0 *1 0,0
Xsg13cmos5l_decap_8_2658 VPWR VGND sg13cmos5l_decap_8
* cell instance sg13cmos5l_decap_8_2659 r0 *1 0,0
Xsg13cmos5l_decap_8_2659 VPWR VGND sg13cmos5l_decap_8
* cell instance sg13cmos5l_decap_8_2660 r0 *1 0,0
Xsg13cmos5l_decap_8_2660 VPWR VGND sg13cmos5l_decap_8
* cell instance sg13cmos5l_decap_8_2661 r0 *1 0,0
Xsg13cmos5l_decap_8_2661 VPWR VGND sg13cmos5l_decap_8
* cell instance sg13cmos5l_decap_8_2662 r0 *1 0,0
Xsg13cmos5l_decap_8_2662 VPWR VGND sg13cmos5l_decap_8
* cell instance sg13cmos5l_decap_8_2663 r0 *1 0,0
Xsg13cmos5l_decap_8_2663 VPWR VGND sg13cmos5l_decap_8
* cell instance sg13cmos5l_decap_8_2664 r0 *1 0,0
Xsg13cmos5l_decap_8_2664 VPWR VGND sg13cmos5l_decap_8
* cell instance sg13cmos5l_decap_8_2665 r0 *1 0,0
Xsg13cmos5l_decap_8_2665 VPWR VGND sg13cmos5l_decap_8
* cell instance sg13cmos5l_decap_8_2666 r0 *1 0,0
Xsg13cmos5l_decap_8_2666 VPWR VGND sg13cmos5l_decap_8
* cell instance sg13cmos5l_decap_8_2667 r0 *1 0,0
Xsg13cmos5l_decap_8_2667 VPWR VGND sg13cmos5l_decap_8
* cell instance sg13cmos5l_decap_8_2668 r0 *1 0,0
Xsg13cmos5l_decap_8_2668 VPWR VGND sg13cmos5l_decap_8
* cell instance sg13cmos5l_decap_8_2669 r0 *1 0,0
Xsg13cmos5l_decap_8_2669 VPWR VGND sg13cmos5l_decap_8
* cell instance sg13cmos5l_decap_8_2670 r0 *1 0,0
Xsg13cmos5l_decap_8_2670 VPWR VGND sg13cmos5l_decap_8
* cell instance sg13cmos5l_decap_8_2671 r0 *1 0,0
Xsg13cmos5l_decap_8_2671 VPWR VGND sg13cmos5l_decap_8
* cell instance sg13cmos5l_decap_8_2672 r0 *1 0,0
Xsg13cmos5l_decap_8_2672 VPWR VGND sg13cmos5l_decap_8
* cell instance sg13cmos5l_decap_8_2673 r0 *1 0,0
Xsg13cmos5l_decap_8_2673 VPWR VGND sg13cmos5l_decap_8
* cell instance sg13cmos5l_decap_8_2674 r0 *1 0,0
Xsg13cmos5l_decap_8_2674 VPWR VGND sg13cmos5l_decap_8
* cell instance sg13cmos5l_decap_8_2675 r0 *1 0,0
Xsg13cmos5l_decap_8_2675 VPWR VGND sg13cmos5l_decap_8
* cell instance sg13cmos5l_decap_8_2676 r0 *1 0,0
Xsg13cmos5l_decap_8_2676 VPWR VGND sg13cmos5l_decap_8
* cell instance sg13cmos5l_decap_8_2677 r0 *1 0,0
Xsg13cmos5l_decap_8_2677 VPWR VGND sg13cmos5l_decap_8
* cell instance sg13cmos5l_decap_8_2678 r0 *1 0,0
Xsg13cmos5l_decap_8_2678 VPWR VGND sg13cmos5l_decap_8
* cell instance sg13cmos5l_decap_8_2679 r0 *1 0,0
Xsg13cmos5l_decap_8_2679 VPWR VGND sg13cmos5l_decap_8
* cell instance sg13cmos5l_decap_8_2680 r0 *1 0,0
Xsg13cmos5l_decap_8_2680 VPWR VGND sg13cmos5l_decap_8
* cell instance sg13cmos5l_decap_8_2681 r0 *1 0,0
Xsg13cmos5l_decap_8_2681 VPWR VGND sg13cmos5l_decap_8
* cell instance sg13cmos5l_decap_8_2682 r0 *1 0,0
Xsg13cmos5l_decap_8_2682 VPWR VGND sg13cmos5l_decap_8
* cell instance sg13cmos5l_decap_8_2683 r0 *1 0,0
Xsg13cmos5l_decap_8_2683 VPWR VGND sg13cmos5l_decap_8
* cell instance sg13cmos5l_decap_8_2684 r0 *1 0,0
Xsg13cmos5l_decap_8_2684 VPWR VGND sg13cmos5l_decap_8
* cell instance sg13cmos5l_decap_8_2685 r0 *1 0,0
Xsg13cmos5l_decap_8_2685 VPWR VGND sg13cmos5l_decap_8
* cell instance sg13cmos5l_decap_8_2686 r0 *1 0,0
Xsg13cmos5l_decap_8_2686 VPWR VGND sg13cmos5l_decap_8
* cell instance sg13cmos5l_decap_8_2687 r0 *1 0,0
Xsg13cmos5l_decap_8_2687 VPWR VGND sg13cmos5l_decap_8
* cell instance sg13cmos5l_decap_8_2688 r0 *1 0,0
Xsg13cmos5l_decap_8_2688 VPWR VGND sg13cmos5l_decap_8
* cell instance sg13cmos5l_decap_8_2689 r0 *1 0,0
Xsg13cmos5l_decap_8_2689 VPWR VGND sg13cmos5l_decap_8
* cell instance sg13cmos5l_decap_8_2690 r0 *1 0,0
Xsg13cmos5l_decap_8_2690 VPWR VGND sg13cmos5l_decap_8
* cell instance sg13cmos5l_decap_8_2691 r0 *1 0,0
Xsg13cmos5l_decap_8_2691 VPWR VGND sg13cmos5l_decap_8
* cell instance sg13cmos5l_decap_8_2692 r0 *1 0,0
Xsg13cmos5l_decap_8_2692 VPWR VGND sg13cmos5l_decap_8
* cell instance sg13cmos5l_decap_8_2693 r0 *1 0,0
Xsg13cmos5l_decap_8_2693 VPWR VGND sg13cmos5l_decap_8
* cell instance sg13cmos5l_decap_8_2694 r0 *1 0,0
Xsg13cmos5l_decap_8_2694 VPWR VGND sg13cmos5l_decap_8
* cell instance sg13cmos5l_decap_8_2695 r0 *1 0,0
Xsg13cmos5l_decap_8_2695 VPWR VGND sg13cmos5l_decap_8
* cell instance sg13cmos5l_decap_8_2696 r0 *1 0,0
Xsg13cmos5l_decap_8_2696 VPWR VGND sg13cmos5l_decap_8
* cell instance sg13cmos5l_decap_8_2697 r0 *1 0,0
Xsg13cmos5l_decap_8_2697 VPWR VGND sg13cmos5l_decap_8
* cell instance sg13cmos5l_decap_8_2698 r0 *1 0,0
Xsg13cmos5l_decap_8_2698 VPWR VGND sg13cmos5l_decap_8
* cell instance sg13cmos5l_decap_8_2699 r0 *1 0,0
Xsg13cmos5l_decap_8_2699 VPWR VGND sg13cmos5l_decap_8
* cell instance sg13cmos5l_decap_8_2700 r0 *1 0,0
Xsg13cmos5l_decap_8_2700 VPWR VGND sg13cmos5l_decap_8
* cell instance sg13cmos5l_decap_8_2701 r0 *1 0,0
Xsg13cmos5l_decap_8_2701 VPWR VGND sg13cmos5l_decap_8
* cell instance sg13cmos5l_decap_8_2702 r0 *1 0,0
Xsg13cmos5l_decap_8_2702 VPWR VGND sg13cmos5l_decap_8
* cell instance sg13cmos5l_decap_8_2703 r0 *1 0,0
Xsg13cmos5l_decap_8_2703 VPWR VGND sg13cmos5l_decap_8
* cell instance sg13cmos5l_decap_8_2704 r0 *1 0,0
Xsg13cmos5l_decap_8_2704 VPWR VGND sg13cmos5l_decap_8
* cell instance sg13cmos5l_decap_8_2705 r0 *1 0,0
Xsg13cmos5l_decap_8_2705 VPWR VGND sg13cmos5l_decap_8
* cell instance sg13cmos5l_decap_8_2706 r0 *1 0,0
Xsg13cmos5l_decap_8_2706 VPWR VGND sg13cmos5l_decap_8
* cell instance sg13cmos5l_decap_8_2707 r0 *1 0,0
Xsg13cmos5l_decap_8_2707 VPWR VGND sg13cmos5l_decap_8
* cell instance sg13cmos5l_decap_8_2708 r0 *1 0,0
Xsg13cmos5l_decap_8_2708 VPWR VGND sg13cmos5l_decap_8
* cell instance sg13cmos5l_decap_8_2709 r0 *1 0,0
Xsg13cmos5l_decap_8_2709 VPWR VGND sg13cmos5l_decap_8
* cell instance sg13cmos5l_decap_8_2710 r0 *1 0,0
Xsg13cmos5l_decap_8_2710 VPWR VGND sg13cmos5l_decap_8
* cell instance sg13cmos5l_decap_8_2711 r0 *1 0,0
Xsg13cmos5l_decap_8_2711 VPWR VGND sg13cmos5l_decap_8
* cell instance sg13cmos5l_decap_8_2712 r0 *1 0,0
Xsg13cmos5l_decap_8_2712 VPWR VGND sg13cmos5l_decap_8
* cell instance sg13cmos5l_decap_8_2713 r0 *1 0,0
Xsg13cmos5l_decap_8_2713 VPWR VGND sg13cmos5l_decap_8
* cell instance sg13cmos5l_decap_8_2714 r0 *1 0,0
Xsg13cmos5l_decap_8_2714 VPWR VGND sg13cmos5l_decap_8
* cell instance sg13cmos5l_decap_8_2715 r0 *1 0,0
Xsg13cmos5l_decap_8_2715 VPWR VGND sg13cmos5l_decap_8
* cell instance sg13cmos5l_decap_8_2716 r0 *1 0,0
Xsg13cmos5l_decap_8_2716 VPWR VGND sg13cmos5l_decap_8
* cell instance sg13cmos5l_decap_8_2717 r0 *1 0,0
Xsg13cmos5l_decap_8_2717 VPWR VGND sg13cmos5l_decap_8
* cell instance sg13cmos5l_decap_8_2718 r0 *1 0,0
Xsg13cmos5l_decap_8_2718 VPWR VGND sg13cmos5l_decap_8
* cell instance sg13cmos5l_decap_8_2719 r0 *1 0,0
Xsg13cmos5l_decap_8_2719 VPWR VGND sg13cmos5l_decap_8
* cell instance sg13cmos5l_decap_8_2720 r0 *1 0,0
Xsg13cmos5l_decap_8_2720 VPWR VGND sg13cmos5l_decap_8
* cell instance sg13cmos5l_decap_8_2721 r0 *1 0,0
Xsg13cmos5l_decap_8_2721 VPWR VGND sg13cmos5l_decap_8
* cell instance sg13cmos5l_decap_8_2722 r0 *1 0,0
Xsg13cmos5l_decap_8_2722 VPWR VGND sg13cmos5l_decap_8
* cell instance sg13cmos5l_decap_8_2723 r0 *1 0,0
Xsg13cmos5l_decap_8_2723 VPWR VGND sg13cmos5l_decap_8
* cell instance sg13cmos5l_decap_8_2724 r0 *1 0,0
Xsg13cmos5l_decap_8_2724 VPWR VGND sg13cmos5l_decap_8
* cell instance sg13cmos5l_decap_8_2725 r0 *1 0,0
Xsg13cmos5l_decap_8_2725 VPWR VGND sg13cmos5l_decap_8
* cell instance sg13cmos5l_decap_8_2726 r0 *1 0,0
Xsg13cmos5l_decap_8_2726 VPWR VGND sg13cmos5l_decap_8
* cell instance sg13cmos5l_decap_8_2727 r0 *1 0,0
Xsg13cmos5l_decap_8_2727 VPWR VGND sg13cmos5l_decap_8
* cell instance sg13cmos5l_decap_8_2728 r0 *1 0,0
Xsg13cmos5l_decap_8_2728 VPWR VGND sg13cmos5l_decap_8
* cell instance sg13cmos5l_decap_8_2729 r0 *1 0,0
Xsg13cmos5l_decap_8_2729 VPWR VGND sg13cmos5l_decap_8
* cell instance sg13cmos5l_decap_8_2730 r0 *1 0,0
Xsg13cmos5l_decap_8_2730 VPWR VGND sg13cmos5l_decap_8
* cell instance sg13cmos5l_decap_8_2731 r0 *1 0,0
Xsg13cmos5l_decap_8_2731 VPWR VGND sg13cmos5l_decap_8
* cell instance sg13cmos5l_decap_8_2732 r0 *1 0,0
Xsg13cmos5l_decap_8_2732 VPWR VGND sg13cmos5l_decap_8
* cell instance sg13cmos5l_decap_8_2733 r0 *1 0,0
Xsg13cmos5l_decap_8_2733 VPWR VGND sg13cmos5l_decap_8
* cell instance sg13cmos5l_decap_8_2734 r0 *1 0,0
Xsg13cmos5l_decap_8_2734 VPWR VGND sg13cmos5l_decap_8
* cell instance sg13cmos5l_decap_8_2735 r0 *1 0,0
Xsg13cmos5l_decap_8_2735 VPWR VGND sg13cmos5l_decap_8
* cell instance sg13cmos5l_decap_8_2736 r0 *1 0,0
Xsg13cmos5l_decap_8_2736 VPWR VGND sg13cmos5l_decap_8
* cell instance sg13cmos5l_decap_8_2737 r0 *1 0,0
Xsg13cmos5l_decap_8_2737 VPWR VGND sg13cmos5l_decap_8
* cell instance sg13cmos5l_decap_8_2738 r0 *1 0,0
Xsg13cmos5l_decap_8_2738 VPWR VGND sg13cmos5l_decap_8
* cell instance sg13cmos5l_decap_8_2739 r0 *1 0,0
Xsg13cmos5l_decap_8_2739 VPWR VGND sg13cmos5l_decap_8
* cell instance sg13cmos5l_decap_8_2740 r0 *1 0,0
Xsg13cmos5l_decap_8_2740 VPWR VGND sg13cmos5l_decap_8
* cell instance sg13cmos5l_decap_8_2741 r0 *1 0,0
Xsg13cmos5l_decap_8_2741 VPWR VGND sg13cmos5l_decap_8
* cell instance sg13cmos5l_decap_8_2742 r0 *1 0,0
Xsg13cmos5l_decap_8_2742 VPWR VGND sg13cmos5l_decap_8
* cell instance sg13cmos5l_decap_8_2743 r0 *1 0,0
Xsg13cmos5l_decap_8_2743 VPWR VGND sg13cmos5l_decap_8
* cell instance sg13cmos5l_decap_8_2744 r0 *1 0,0
Xsg13cmos5l_decap_8_2744 VPWR VGND sg13cmos5l_decap_8
* cell instance sg13cmos5l_decap_8_2745 r0 *1 0,0
Xsg13cmos5l_decap_8_2745 VPWR VGND sg13cmos5l_decap_8
* cell instance sg13cmos5l_decap_8_2746 r0 *1 0,0
Xsg13cmos5l_decap_8_2746 VPWR VGND sg13cmos5l_decap_8
* cell instance sg13cmos5l_decap_8_2747 r0 *1 0,0
Xsg13cmos5l_decap_8_2747 VPWR VGND sg13cmos5l_decap_8
* cell instance sg13cmos5l_decap_8_2748 r0 *1 0,0
Xsg13cmos5l_decap_8_2748 VPWR VGND sg13cmos5l_decap_8
* cell instance sg13cmos5l_decap_8_2749 r0 *1 0,0
Xsg13cmos5l_decap_8_2749 VPWR VGND sg13cmos5l_decap_8
* cell instance sg13cmos5l_decap_8_2750 r0 *1 0,0
Xsg13cmos5l_decap_8_2750 VPWR VGND sg13cmos5l_decap_8
* cell instance sg13cmos5l_decap_8_2751 r0 *1 0,0
Xsg13cmos5l_decap_8_2751 VPWR VGND sg13cmos5l_decap_8
* cell instance sg13cmos5l_decap_8_2752 r0 *1 0,0
Xsg13cmos5l_decap_8_2752 VPWR VGND sg13cmos5l_decap_8
* cell instance sg13cmos5l_decap_8_2753 r0 *1 0,0
Xsg13cmos5l_decap_8_2753 VPWR VGND sg13cmos5l_decap_8
* cell instance sg13cmos5l_decap_8_2754 r0 *1 0,0
Xsg13cmos5l_decap_8_2754 VPWR VGND sg13cmos5l_decap_8
* cell instance sg13cmos5l_decap_8_2755 r0 *1 0,0
Xsg13cmos5l_decap_8_2755 VPWR VGND sg13cmos5l_decap_8
* cell instance sg13cmos5l_decap_8_2756 r0 *1 0,0
Xsg13cmos5l_decap_8_2756 VPWR VGND sg13cmos5l_decap_8
* cell instance sg13cmos5l_decap_8_2757 r0 *1 0,0
Xsg13cmos5l_decap_8_2757 VPWR VGND sg13cmos5l_decap_8
* cell instance sg13cmos5l_decap_8_2758 r0 *1 0,0
Xsg13cmos5l_decap_8_2758 VPWR VGND sg13cmos5l_decap_8
* cell instance sg13cmos5l_decap_8_2759 r0 *1 0,0
Xsg13cmos5l_decap_8_2759 VPWR VGND sg13cmos5l_decap_8
* cell instance sg13cmos5l_decap_8_2760 r0 *1 0,0
Xsg13cmos5l_decap_8_2760 VPWR VGND sg13cmos5l_decap_8
* cell instance sg13cmos5l_decap_8_2761 r0 *1 0,0
Xsg13cmos5l_decap_8_2761 VPWR VGND sg13cmos5l_decap_8
* cell instance sg13cmos5l_decap_8_2762 r0 *1 0,0
Xsg13cmos5l_decap_8_2762 VPWR VGND sg13cmos5l_decap_8
* cell instance sg13cmos5l_decap_8_2763 r0 *1 0,0
Xsg13cmos5l_decap_8_2763 VPWR VGND sg13cmos5l_decap_8
* cell instance sg13cmos5l_decap_8_2764 r0 *1 0,0
Xsg13cmos5l_decap_8_2764 VPWR VGND sg13cmos5l_decap_8
* cell instance sg13cmos5l_decap_8_2765 r0 *1 0,0
Xsg13cmos5l_decap_8_2765 VPWR VGND sg13cmos5l_decap_8
* cell instance sg13cmos5l_decap_8_2766 r0 *1 0,0
Xsg13cmos5l_decap_8_2766 VPWR VGND sg13cmos5l_decap_8
* cell instance sg13cmos5l_decap_8_2767 r0 *1 0,0
Xsg13cmos5l_decap_8_2767 VPWR VGND sg13cmos5l_decap_8
* cell instance sg13cmos5l_decap_8_2768 r0 *1 0,0
Xsg13cmos5l_decap_8_2768 VPWR VGND sg13cmos5l_decap_8
* cell instance sg13cmos5l_decap_8_2769 r0 *1 0,0
Xsg13cmos5l_decap_8_2769 VPWR VGND sg13cmos5l_decap_8
* cell instance sg13cmos5l_decap_8_2770 r0 *1 0,0
Xsg13cmos5l_decap_8_2770 VPWR VGND sg13cmos5l_decap_8
* cell instance sg13cmos5l_decap_8_2771 r0 *1 0,0
Xsg13cmos5l_decap_8_2771 VPWR VGND sg13cmos5l_decap_8
* cell instance sg13cmos5l_decap_8_2772 r0 *1 0,0
Xsg13cmos5l_decap_8_2772 VPWR VGND sg13cmos5l_decap_8
* cell instance sg13cmos5l_decap_8_2773 r0 *1 0,0
Xsg13cmos5l_decap_8_2773 VPWR VGND sg13cmos5l_decap_8
* cell instance sg13cmos5l_decap_8_2774 r0 *1 0,0
Xsg13cmos5l_decap_8_2774 VPWR VGND sg13cmos5l_decap_8
* cell instance sg13cmos5l_decap_8_2775 r0 *1 0,0
Xsg13cmos5l_decap_8_2775 VPWR VGND sg13cmos5l_decap_8
* cell instance sg13cmos5l_decap_8_2776 r0 *1 0,0
Xsg13cmos5l_decap_8_2776 VPWR VGND sg13cmos5l_decap_8
* cell instance sg13cmos5l_decap_8_2777 r0 *1 0,0
Xsg13cmos5l_decap_8_2777 VPWR VGND sg13cmos5l_decap_8
* cell instance sg13cmos5l_decap_8_2778 r0 *1 0,0
Xsg13cmos5l_decap_8_2778 VPWR VGND sg13cmos5l_decap_8
* cell instance sg13cmos5l_decap_8_2779 r0 *1 0,0
Xsg13cmos5l_decap_8_2779 VPWR VGND sg13cmos5l_decap_8
* cell instance sg13cmos5l_decap_8_2780 r0 *1 0,0
Xsg13cmos5l_decap_8_2780 VPWR VGND sg13cmos5l_decap_8
* cell instance sg13cmos5l_decap_8_2781 r0 *1 0,0
Xsg13cmos5l_decap_8_2781 VPWR VGND sg13cmos5l_decap_8
* cell instance sg13cmos5l_decap_8_2782 r0 *1 0,0
Xsg13cmos5l_decap_8_2782 VPWR VGND sg13cmos5l_decap_8
* cell instance sg13cmos5l_decap_8_2783 r0 *1 0,0
Xsg13cmos5l_decap_8_2783 VPWR VGND sg13cmos5l_decap_8
* cell instance sg13cmos5l_decap_8_2784 r0 *1 0,0
Xsg13cmos5l_decap_8_2784 VPWR VGND sg13cmos5l_decap_8
* cell instance sg13cmos5l_decap_8_2785 r0 *1 0,0
Xsg13cmos5l_decap_8_2785 VPWR VGND sg13cmos5l_decap_8
* cell instance sg13cmos5l_decap_8_2786 r0 *1 0,0
Xsg13cmos5l_decap_8_2786 VPWR VGND sg13cmos5l_decap_8
* cell instance sg13cmos5l_decap_8_2787 r0 *1 0,0
Xsg13cmos5l_decap_8_2787 VPWR VGND sg13cmos5l_decap_8
* cell instance sg13cmos5l_decap_8_2788 r0 *1 0,0
Xsg13cmos5l_decap_8_2788 VPWR VGND sg13cmos5l_decap_8
* cell instance sg13cmos5l_decap_8_2789 r0 *1 0,0
Xsg13cmos5l_decap_8_2789 VPWR VGND sg13cmos5l_decap_8
* cell instance sg13cmos5l_decap_8_2790 r0 *1 0,0
Xsg13cmos5l_decap_8_2790 VPWR VGND sg13cmos5l_decap_8
* cell instance sg13cmos5l_decap_8_2791 r0 *1 0,0
Xsg13cmos5l_decap_8_2791 VPWR VGND sg13cmos5l_decap_8
* cell instance sg13cmos5l_decap_8_2792 r0 *1 0,0
Xsg13cmos5l_decap_8_2792 VPWR VGND sg13cmos5l_decap_8
* cell instance sg13cmos5l_decap_8_2793 r0 *1 0,0
Xsg13cmos5l_decap_8_2793 VPWR VGND sg13cmos5l_decap_8
* cell instance sg13cmos5l_decap_8_2794 r0 *1 0,0
Xsg13cmos5l_decap_8_2794 VPWR VGND sg13cmos5l_decap_8
* cell instance sg13cmos5l_decap_8_2795 r0 *1 0,0
Xsg13cmos5l_decap_8_2795 VPWR VGND sg13cmos5l_decap_8
* cell instance sg13cmos5l_decap_8_2796 r0 *1 0,0
Xsg13cmos5l_decap_8_2796 VPWR VGND sg13cmos5l_decap_8
* cell instance sg13cmos5l_decap_8_2797 r0 *1 0,0
Xsg13cmos5l_decap_8_2797 VPWR VGND sg13cmos5l_decap_8
* cell instance sg13cmos5l_decap_8_2798 r0 *1 0,0
Xsg13cmos5l_decap_8_2798 VPWR VGND sg13cmos5l_decap_8
* cell instance sg13cmos5l_decap_8_2799 r0 *1 0,0
Xsg13cmos5l_decap_8_2799 VPWR VGND sg13cmos5l_decap_8
* cell instance sg13cmos5l_decap_8_2800 r0 *1 0,0
Xsg13cmos5l_decap_8_2800 VPWR VGND sg13cmos5l_decap_8
* cell instance sg13cmos5l_decap_8_2801 r0 *1 0,0
Xsg13cmos5l_decap_8_2801 VPWR VGND sg13cmos5l_decap_8
* cell instance sg13cmos5l_decap_8_2802 r0 *1 0,0
Xsg13cmos5l_decap_8_2802 VPWR VGND sg13cmos5l_decap_8
* cell instance sg13cmos5l_decap_8_2803 r0 *1 0,0
Xsg13cmos5l_decap_8_2803 VPWR VGND sg13cmos5l_decap_8
* cell instance sg13cmos5l_decap_8_2804 r0 *1 0,0
Xsg13cmos5l_decap_8_2804 VPWR VGND sg13cmos5l_decap_8
* cell instance sg13cmos5l_decap_8_2805 r0 *1 0,0
Xsg13cmos5l_decap_8_2805 VPWR VGND sg13cmos5l_decap_8
* cell instance sg13cmos5l_decap_8_2806 r0 *1 0,0
Xsg13cmos5l_decap_8_2806 VPWR VGND sg13cmos5l_decap_8
* cell instance sg13cmos5l_decap_8_2807 r0 *1 0,0
Xsg13cmos5l_decap_8_2807 VPWR VGND sg13cmos5l_decap_8
* cell instance sg13cmos5l_decap_8_2808 r0 *1 0,0
Xsg13cmos5l_decap_8_2808 VPWR VGND sg13cmos5l_decap_8
* cell instance sg13cmos5l_decap_8_2809 r0 *1 0,0
Xsg13cmos5l_decap_8_2809 VPWR VGND sg13cmos5l_decap_8
* cell instance sg13cmos5l_decap_8_2810 r0 *1 0,0
Xsg13cmos5l_decap_8_2810 VPWR VGND sg13cmos5l_decap_8
* cell instance sg13cmos5l_decap_8_2811 r0 *1 0,0
Xsg13cmos5l_decap_8_2811 VPWR VGND sg13cmos5l_decap_8
* cell instance sg13cmos5l_decap_8_2812 r0 *1 0,0
Xsg13cmos5l_decap_8_2812 VPWR VGND sg13cmos5l_decap_8
* cell instance sg13cmos5l_decap_8_2813 r0 *1 0,0
Xsg13cmos5l_decap_8_2813 VPWR VGND sg13cmos5l_decap_8
* cell instance sg13cmos5l_decap_8_2814 r0 *1 0,0
Xsg13cmos5l_decap_8_2814 VPWR VGND sg13cmos5l_decap_8
* cell instance sg13cmos5l_decap_8_2815 r0 *1 0,0
Xsg13cmos5l_decap_8_2815 VPWR VGND sg13cmos5l_decap_8
* cell instance sg13cmos5l_decap_8_2816 r0 *1 0,0
Xsg13cmos5l_decap_8_2816 VPWR VGND sg13cmos5l_decap_8
* cell instance sg13cmos5l_decap_8_2817 r0 *1 0,0
Xsg13cmos5l_decap_8_2817 VPWR VGND sg13cmos5l_decap_8
* cell instance sg13cmos5l_decap_8_2818 r0 *1 0,0
Xsg13cmos5l_decap_8_2818 VPWR VGND sg13cmos5l_decap_8
* cell instance sg13cmos5l_decap_8_2819 r0 *1 0,0
Xsg13cmos5l_decap_8_2819 VPWR VGND sg13cmos5l_decap_8
* cell instance sg13cmos5l_decap_8_2820 r0 *1 0,0
Xsg13cmos5l_decap_8_2820 VPWR VGND sg13cmos5l_decap_8
* cell instance sg13cmos5l_decap_8_2821 r0 *1 0,0
Xsg13cmos5l_decap_8_2821 VPWR VGND sg13cmos5l_decap_8
* cell instance sg13cmos5l_decap_8_2822 r0 *1 0,0
Xsg13cmos5l_decap_8_2822 VPWR VGND sg13cmos5l_decap_8
* cell instance sg13cmos5l_decap_8_2823 r0 *1 0,0
Xsg13cmos5l_decap_8_2823 VPWR VGND sg13cmos5l_decap_8
* cell instance sg13cmos5l_decap_8_2824 r0 *1 0,0
Xsg13cmos5l_decap_8_2824 VPWR VGND sg13cmos5l_decap_8
* cell instance sg13cmos5l_decap_8_2825 r0 *1 0,0
Xsg13cmos5l_decap_8_2825 VPWR VGND sg13cmos5l_decap_8
* cell instance sg13cmos5l_decap_8_2826 r0 *1 0,0
Xsg13cmos5l_decap_8_2826 VPWR VGND sg13cmos5l_decap_8
* cell instance sg13cmos5l_decap_8_2827 r0 *1 0,0
Xsg13cmos5l_decap_8_2827 VPWR VGND sg13cmos5l_decap_8
* cell instance sg13cmos5l_decap_8_2828 r0 *1 0,0
Xsg13cmos5l_decap_8_2828 VPWR VGND sg13cmos5l_decap_8
* cell instance sg13cmos5l_decap_8_2829 r0 *1 0,0
Xsg13cmos5l_decap_8_2829 VPWR VGND sg13cmos5l_decap_8
* cell instance sg13cmos5l_decap_8_2830 r0 *1 0,0
Xsg13cmos5l_decap_8_2830 VPWR VGND sg13cmos5l_decap_8
* cell instance sg13cmos5l_decap_8_2831 r0 *1 0,0
Xsg13cmos5l_decap_8_2831 VPWR VGND sg13cmos5l_decap_8
* cell instance sg13cmos5l_decap_8_2832 r0 *1 0,0
Xsg13cmos5l_decap_8_2832 VPWR VGND sg13cmos5l_decap_8
* cell instance sg13cmos5l_decap_8_2833 r0 *1 0,0
Xsg13cmos5l_decap_8_2833 VPWR VGND sg13cmos5l_decap_8
* cell instance sg13cmos5l_decap_8_2834 r0 *1 0,0
Xsg13cmos5l_decap_8_2834 VPWR VGND sg13cmos5l_decap_8
* cell instance sg13cmos5l_decap_8_2835 r0 *1 0,0
Xsg13cmos5l_decap_8_2835 VPWR VGND sg13cmos5l_decap_8
* cell instance sg13cmos5l_decap_8_2836 r0 *1 0,0
Xsg13cmos5l_decap_8_2836 VPWR VGND sg13cmos5l_decap_8
* cell instance sg13cmos5l_decap_8_2837 r0 *1 0,0
Xsg13cmos5l_decap_8_2837 VPWR VGND sg13cmos5l_decap_8
* cell instance sg13cmos5l_decap_8_2838 r0 *1 0,0
Xsg13cmos5l_decap_8_2838 VPWR VGND sg13cmos5l_decap_8
* cell instance sg13cmos5l_decap_8_2839 r0 *1 0,0
Xsg13cmos5l_decap_8_2839 VPWR VGND sg13cmos5l_decap_8
* cell instance sg13cmos5l_decap_8_2840 r0 *1 0,0
Xsg13cmos5l_decap_8_2840 VPWR VGND sg13cmos5l_decap_8
* cell instance sg13cmos5l_decap_8_2841 r0 *1 0,0
Xsg13cmos5l_decap_8_2841 VPWR VGND sg13cmos5l_decap_8
* cell instance sg13cmos5l_decap_8_2842 r0 *1 0,0
Xsg13cmos5l_decap_8_2842 VPWR VGND sg13cmos5l_decap_8
* cell instance sg13cmos5l_decap_8_2843 r0 *1 0,0
Xsg13cmos5l_decap_8_2843 VPWR VGND sg13cmos5l_decap_8
* cell instance sg13cmos5l_decap_8_2844 r0 *1 0,0
Xsg13cmos5l_decap_8_2844 VPWR VGND sg13cmos5l_decap_8
* cell instance sg13cmos5l_decap_8_2845 r0 *1 0,0
Xsg13cmos5l_decap_8_2845 VPWR VGND sg13cmos5l_decap_8
* cell instance sg13cmos5l_decap_8_2846 r0 *1 0,0
Xsg13cmos5l_decap_8_2846 VPWR VGND sg13cmos5l_decap_8
* cell instance sg13cmos5l_decap_8_2847 r0 *1 0,0
Xsg13cmos5l_decap_8_2847 VPWR VGND sg13cmos5l_decap_8
* cell instance sg13cmos5l_decap_8_2848 r0 *1 0,0
Xsg13cmos5l_decap_8_2848 VPWR VGND sg13cmos5l_decap_8
* cell instance sg13cmos5l_decap_8_2849 r0 *1 0,0
Xsg13cmos5l_decap_8_2849 VPWR VGND sg13cmos5l_decap_8
* cell instance sg13cmos5l_decap_8_2850 r0 *1 0,0
Xsg13cmos5l_decap_8_2850 VPWR VGND sg13cmos5l_decap_8
* cell instance sg13cmos5l_decap_8_2851 r0 *1 0,0
Xsg13cmos5l_decap_8_2851 VPWR VGND sg13cmos5l_decap_8
* cell instance sg13cmos5l_decap_8_2852 r0 *1 0,0
Xsg13cmos5l_decap_8_2852 VPWR VGND sg13cmos5l_decap_8
* cell instance sg13cmos5l_decap_8_2853 r0 *1 0,0
Xsg13cmos5l_decap_8_2853 VPWR VGND sg13cmos5l_decap_8
* cell instance sg13cmos5l_decap_8_2854 r0 *1 0,0
Xsg13cmos5l_decap_8_2854 VPWR VGND sg13cmos5l_decap_8
* cell instance sg13cmos5l_decap_8_2855 r0 *1 0,0
Xsg13cmos5l_decap_8_2855 VPWR VGND sg13cmos5l_decap_8
* cell instance sg13cmos5l_decap_8_2856 r0 *1 0,0
Xsg13cmos5l_decap_8_2856 VPWR VGND sg13cmos5l_decap_8
* cell instance sg13cmos5l_decap_8_2857 r0 *1 0,0
Xsg13cmos5l_decap_8_2857 VPWR VGND sg13cmos5l_decap_8
* cell instance sg13cmos5l_decap_8_2858 r0 *1 0,0
Xsg13cmos5l_decap_8_2858 VPWR VGND sg13cmos5l_decap_8
* cell instance sg13cmos5l_decap_8_2859 r0 *1 0,0
Xsg13cmos5l_decap_8_2859 VPWR VGND sg13cmos5l_decap_8
* cell instance sg13cmos5l_decap_8_2860 r0 *1 0,0
Xsg13cmos5l_decap_8_2860 VPWR VGND sg13cmos5l_decap_8
* cell instance sg13cmos5l_decap_8_2861 r0 *1 0,0
Xsg13cmos5l_decap_8_2861 VPWR VGND sg13cmos5l_decap_8
* cell instance sg13cmos5l_decap_8_2862 r0 *1 0,0
Xsg13cmos5l_decap_8_2862 VPWR VGND sg13cmos5l_decap_8
* cell instance sg13cmos5l_decap_8_2863 r0 *1 0,0
Xsg13cmos5l_decap_8_2863 VPWR VGND sg13cmos5l_decap_8
* cell instance sg13cmos5l_decap_8_2864 r0 *1 0,0
Xsg13cmos5l_decap_8_2864 VPWR VGND sg13cmos5l_decap_8
* cell instance sg13cmos5l_decap_8_2865 r0 *1 0,0
Xsg13cmos5l_decap_8_2865 VPWR VGND sg13cmos5l_decap_8
* cell instance sg13cmos5l_decap_8_2866 r0 *1 0,0
Xsg13cmos5l_decap_8_2866 VPWR VGND sg13cmos5l_decap_8
* cell instance sg13cmos5l_decap_8_2867 r0 *1 0,0
Xsg13cmos5l_decap_8_2867 VPWR VGND sg13cmos5l_decap_8
* cell instance sg13cmos5l_decap_8_2868 r0 *1 0,0
Xsg13cmos5l_decap_8_2868 VPWR VGND sg13cmos5l_decap_8
* cell instance sg13cmos5l_decap_8_2869 r0 *1 0,0
Xsg13cmos5l_decap_8_2869 VPWR VGND sg13cmos5l_decap_8
* cell instance sg13cmos5l_decap_8_2870 r0 *1 0,0
Xsg13cmos5l_decap_8_2870 VPWR VGND sg13cmos5l_decap_8
* cell instance sg13cmos5l_decap_8_2871 r0 *1 0,0
Xsg13cmos5l_decap_8_2871 VPWR VGND sg13cmos5l_decap_8
* cell instance sg13cmos5l_decap_8_2872 r0 *1 0,0
Xsg13cmos5l_decap_8_2872 VPWR VGND sg13cmos5l_decap_8
* cell instance sg13cmos5l_decap_8_2873 r0 *1 0,0
Xsg13cmos5l_decap_8_2873 VPWR VGND sg13cmos5l_decap_8
* cell instance sg13cmos5l_decap_8_2874 r0 *1 0,0
Xsg13cmos5l_decap_8_2874 VPWR VGND sg13cmos5l_decap_8
* cell instance sg13cmos5l_decap_8_2875 r0 *1 0,0
Xsg13cmos5l_decap_8_2875 VPWR VGND sg13cmos5l_decap_8
* cell instance sg13cmos5l_decap_8_2876 r0 *1 0,0
Xsg13cmos5l_decap_8_2876 VPWR VGND sg13cmos5l_decap_8
* cell instance sg13cmos5l_decap_8_2877 r0 *1 0,0
Xsg13cmos5l_decap_8_2877 VPWR VGND sg13cmos5l_decap_8
* cell instance sg13cmos5l_decap_8_2878 r0 *1 0,0
Xsg13cmos5l_decap_8_2878 VPWR VGND sg13cmos5l_decap_8
* cell instance sg13cmos5l_decap_8_2879 r0 *1 0,0
Xsg13cmos5l_decap_8_2879 VPWR VGND sg13cmos5l_decap_8
* cell instance sg13cmos5l_decap_8_2880 r0 *1 0,0
Xsg13cmos5l_decap_8_2880 VPWR VGND sg13cmos5l_decap_8
* cell instance sg13cmos5l_decap_8_2881 r0 *1 0,0
Xsg13cmos5l_decap_8_2881 VPWR VGND sg13cmos5l_decap_8
* cell instance sg13cmos5l_decap_8_2882 r0 *1 0,0
Xsg13cmos5l_decap_8_2882 VPWR VGND sg13cmos5l_decap_8
* cell instance sg13cmos5l_decap_8_2883 r0 *1 0,0
Xsg13cmos5l_decap_8_2883 VPWR VGND sg13cmos5l_decap_8
* cell instance sg13cmos5l_decap_8_2884 r0 *1 0,0
Xsg13cmos5l_decap_8_2884 VPWR VGND sg13cmos5l_decap_8
* cell instance sg13cmos5l_decap_8_2885 r0 *1 0,0
Xsg13cmos5l_decap_8_2885 VPWR VGND sg13cmos5l_decap_8
* cell instance sg13cmos5l_decap_8_2886 r0 *1 0,0
Xsg13cmos5l_decap_8_2886 VPWR VGND sg13cmos5l_decap_8
* cell instance sg13cmos5l_decap_8_2887 r0 *1 0,0
Xsg13cmos5l_decap_8_2887 VPWR VGND sg13cmos5l_decap_8
* cell instance sg13cmos5l_decap_8_2888 r0 *1 0,0
Xsg13cmos5l_decap_8_2888 VPWR VGND sg13cmos5l_decap_8
* cell instance sg13cmos5l_decap_8_2889 r0 *1 0,0
Xsg13cmos5l_decap_8_2889 VPWR VGND sg13cmos5l_decap_8
* cell instance sg13cmos5l_decap_8_2890 r0 *1 0,0
Xsg13cmos5l_decap_8_2890 VPWR VGND sg13cmos5l_decap_8
* cell instance sg13cmos5l_decap_8_2891 r0 *1 0,0
Xsg13cmos5l_decap_8_2891 VPWR VGND sg13cmos5l_decap_8
* cell instance sg13cmos5l_decap_8_2892 r0 *1 0,0
Xsg13cmos5l_decap_8_2892 VPWR VGND sg13cmos5l_decap_8
* cell instance sg13cmos5l_decap_8_2893 r0 *1 0,0
Xsg13cmos5l_decap_8_2893 VPWR VGND sg13cmos5l_decap_8
* cell instance sg13cmos5l_decap_8_2894 r0 *1 0,0
Xsg13cmos5l_decap_8_2894 VPWR VGND sg13cmos5l_decap_8
* cell instance sg13cmos5l_decap_8_2895 r0 *1 0,0
Xsg13cmos5l_decap_8_2895 VPWR VGND sg13cmos5l_decap_8
* cell instance sg13cmos5l_decap_8_2896 r0 *1 0,0
Xsg13cmos5l_decap_8_2896 VPWR VGND sg13cmos5l_decap_8
* cell instance sg13cmos5l_decap_8_2897 r0 *1 0,0
Xsg13cmos5l_decap_8_2897 VPWR VGND sg13cmos5l_decap_8
* cell instance sg13cmos5l_decap_8_2898 r0 *1 0,0
Xsg13cmos5l_decap_8_2898 VPWR VGND sg13cmos5l_decap_8
* cell instance sg13cmos5l_decap_8_2899 r0 *1 0,0
Xsg13cmos5l_decap_8_2899 VPWR VGND sg13cmos5l_decap_8
* cell instance sg13cmos5l_decap_8_2900 r0 *1 0,0
Xsg13cmos5l_decap_8_2900 VPWR VGND sg13cmos5l_decap_8
* cell instance sg13cmos5l_decap_8_2901 r0 *1 0,0
Xsg13cmos5l_decap_8_2901 VPWR VGND sg13cmos5l_decap_8
* cell instance sg13cmos5l_decap_8_2902 r0 *1 0,0
Xsg13cmos5l_decap_8_2902 VPWR VGND sg13cmos5l_decap_8
* cell instance sg13cmos5l_decap_8_2903 r0 *1 0,0
Xsg13cmos5l_decap_8_2903 VPWR VGND sg13cmos5l_decap_8
* cell instance sg13cmos5l_decap_8_2904 r0 *1 0,0
Xsg13cmos5l_decap_8_2904 VPWR VGND sg13cmos5l_decap_8
* cell instance sg13cmos5l_decap_8_2905 r0 *1 0,0
Xsg13cmos5l_decap_8_2905 VPWR VGND sg13cmos5l_decap_8
* cell instance sg13cmos5l_decap_8_2906 r0 *1 0,0
Xsg13cmos5l_decap_8_2906 VPWR VGND sg13cmos5l_decap_8
* cell instance sg13cmos5l_decap_8_2907 r0 *1 0,0
Xsg13cmos5l_decap_8_2907 VPWR VGND sg13cmos5l_decap_8
* cell instance sg13cmos5l_decap_8_2908 r0 *1 0,0
Xsg13cmos5l_decap_8_2908 VPWR VGND sg13cmos5l_decap_8
* cell instance sg13cmos5l_decap_8_2909 r0 *1 0,0
Xsg13cmos5l_decap_8_2909 VPWR VGND sg13cmos5l_decap_8
* cell instance sg13cmos5l_decap_8_2910 r0 *1 0,0
Xsg13cmos5l_decap_8_2910 VPWR VGND sg13cmos5l_decap_8
* cell instance sg13cmos5l_decap_8_2911 r0 *1 0,0
Xsg13cmos5l_decap_8_2911 VPWR VGND sg13cmos5l_decap_8
* cell instance sg13cmos5l_decap_8_2912 r0 *1 0,0
Xsg13cmos5l_decap_8_2912 VPWR VGND sg13cmos5l_decap_8
* cell instance sg13cmos5l_decap_8_2913 r0 *1 0,0
Xsg13cmos5l_decap_8_2913 VPWR VGND sg13cmos5l_decap_8
* cell instance sg13cmos5l_decap_8_2914 r0 *1 0,0
Xsg13cmos5l_decap_8_2914 VPWR VGND sg13cmos5l_decap_8
* cell instance sg13cmos5l_decap_8_2915 r0 *1 0,0
Xsg13cmos5l_decap_8_2915 VPWR VGND sg13cmos5l_decap_8
* cell instance sg13cmos5l_decap_8_2916 r0 *1 0,0
Xsg13cmos5l_decap_8_2916 VPWR VGND sg13cmos5l_decap_8
* cell instance sg13cmos5l_decap_8_2917 r0 *1 0,0
Xsg13cmos5l_decap_8_2917 VPWR VGND sg13cmos5l_decap_8
* cell instance sg13cmos5l_decap_8_2918 r0 *1 0,0
Xsg13cmos5l_decap_8_2918 VPWR VGND sg13cmos5l_decap_8
* cell instance sg13cmos5l_decap_8_2919 r0 *1 0,0
Xsg13cmos5l_decap_8_2919 VPWR VGND sg13cmos5l_decap_8
* cell instance sg13cmos5l_decap_8_2920 r0 *1 0,0
Xsg13cmos5l_decap_8_2920 VPWR VGND sg13cmos5l_decap_8
* cell instance sg13cmos5l_decap_8_2921 r0 *1 0,0
Xsg13cmos5l_decap_8_2921 VPWR VGND sg13cmos5l_decap_8
* cell instance sg13cmos5l_decap_8_2922 r0 *1 0,0
Xsg13cmos5l_decap_8_2922 VPWR VGND sg13cmos5l_decap_8
* cell instance sg13cmos5l_decap_8_2923 r0 *1 0,0
Xsg13cmos5l_decap_8_2923 VPWR VGND sg13cmos5l_decap_8
* cell instance sg13cmos5l_decap_8_2924 r0 *1 0,0
Xsg13cmos5l_decap_8_2924 VPWR VGND sg13cmos5l_decap_8
* cell instance sg13cmos5l_decap_8_2925 r0 *1 0,0
Xsg13cmos5l_decap_8_2925 VPWR VGND sg13cmos5l_decap_8
* cell instance sg13cmos5l_decap_8_2926 r0 *1 0,0
Xsg13cmos5l_decap_8_2926 VPWR VGND sg13cmos5l_decap_8
* cell instance sg13cmos5l_decap_8_2927 r0 *1 0,0
Xsg13cmos5l_decap_8_2927 VPWR VGND sg13cmos5l_decap_8
* cell instance sg13cmos5l_decap_8_2928 r0 *1 0,0
Xsg13cmos5l_decap_8_2928 VPWR VGND sg13cmos5l_decap_8
* cell instance sg13cmos5l_decap_8_2929 r0 *1 0,0
Xsg13cmos5l_decap_8_2929 VPWR VGND sg13cmos5l_decap_8
* cell instance sg13cmos5l_decap_8_2930 r0 *1 0,0
Xsg13cmos5l_decap_8_2930 VPWR VGND sg13cmos5l_decap_8
* cell instance sg13cmos5l_decap_8_2931 r0 *1 0,0
Xsg13cmos5l_decap_8_2931 VPWR VGND sg13cmos5l_decap_8
* cell instance sg13cmos5l_decap_8_2932 r0 *1 0,0
Xsg13cmos5l_decap_8_2932 VPWR VGND sg13cmos5l_decap_8
* cell instance sg13cmos5l_decap_8_2933 r0 *1 0,0
Xsg13cmos5l_decap_8_2933 VPWR VGND sg13cmos5l_decap_8
* cell instance sg13cmos5l_decap_8_2934 r0 *1 0,0
Xsg13cmos5l_decap_8_2934 VPWR VGND sg13cmos5l_decap_8
* cell instance sg13cmos5l_decap_8_2935 r0 *1 0,0
Xsg13cmos5l_decap_8_2935 VPWR VGND sg13cmos5l_decap_8
* cell instance sg13cmos5l_decap_8_2936 r0 *1 0,0
Xsg13cmos5l_decap_8_2936 VPWR VGND sg13cmos5l_decap_8
* cell instance sg13cmos5l_decap_8_2937 r0 *1 0,0
Xsg13cmos5l_decap_8_2937 VPWR VGND sg13cmos5l_decap_8
* cell instance sg13cmos5l_decap_8_2938 r0 *1 0,0
Xsg13cmos5l_decap_8_2938 VPWR VGND sg13cmos5l_decap_8
* cell instance sg13cmos5l_decap_8_2939 r0 *1 0,0
Xsg13cmos5l_decap_8_2939 VPWR VGND sg13cmos5l_decap_8
* cell instance sg13cmos5l_decap_8_2940 r0 *1 0,0
Xsg13cmos5l_decap_8_2940 VPWR VGND sg13cmos5l_decap_8
* cell instance sg13cmos5l_decap_8_2941 r0 *1 0,0
Xsg13cmos5l_decap_8_2941 VPWR VGND sg13cmos5l_decap_8
* cell instance sg13cmos5l_decap_8_2942 r0 *1 0,0
Xsg13cmos5l_decap_8_2942 VPWR VGND sg13cmos5l_decap_8
* cell instance sg13cmos5l_decap_8_2943 r0 *1 0,0
Xsg13cmos5l_decap_8_2943 VPWR VGND sg13cmos5l_decap_8
* cell instance sg13cmos5l_decap_8_2944 r0 *1 0,0
Xsg13cmos5l_decap_8_2944 VPWR VGND sg13cmos5l_decap_8
* cell instance sg13cmos5l_decap_8_2945 r0 *1 0,0
Xsg13cmos5l_decap_8_2945 VPWR VGND sg13cmos5l_decap_8
* cell instance sg13cmos5l_decap_8_2946 r0 *1 0,0
Xsg13cmos5l_decap_8_2946 VPWR VGND sg13cmos5l_decap_8
* cell instance sg13cmos5l_decap_8_2947 r0 *1 0,0
Xsg13cmos5l_decap_8_2947 VPWR VGND sg13cmos5l_decap_8
* cell instance sg13cmos5l_decap_8_2948 r0 *1 0,0
Xsg13cmos5l_decap_8_2948 VPWR VGND sg13cmos5l_decap_8
* cell instance sg13cmos5l_decap_8_2949 r0 *1 0,0
Xsg13cmos5l_decap_8_2949 VPWR VGND sg13cmos5l_decap_8
* cell instance sg13cmos5l_decap_8_2950 r0 *1 0,0
Xsg13cmos5l_decap_8_2950 VPWR VGND sg13cmos5l_decap_8
* cell instance sg13cmos5l_decap_8_2951 r0 *1 0,0
Xsg13cmos5l_decap_8_2951 VPWR VGND sg13cmos5l_decap_8
* cell instance sg13cmos5l_decap_8_2952 r0 *1 0,0
Xsg13cmos5l_decap_8_2952 VPWR VGND sg13cmos5l_decap_8
* cell instance sg13cmos5l_decap_8_2953 r0 *1 0,0
Xsg13cmos5l_decap_8_2953 VPWR VGND sg13cmos5l_decap_8
* cell instance sg13cmos5l_decap_8_2954 r0 *1 0,0
Xsg13cmos5l_decap_8_2954 VPWR VGND sg13cmos5l_decap_8
* cell instance sg13cmos5l_decap_8_2955 r0 *1 0,0
Xsg13cmos5l_decap_8_2955 VPWR VGND sg13cmos5l_decap_8
* cell instance sg13cmos5l_decap_8_2956 r0 *1 0,0
Xsg13cmos5l_decap_8_2956 VPWR VGND sg13cmos5l_decap_8
* cell instance sg13cmos5l_decap_8_2957 r0 *1 0,0
Xsg13cmos5l_decap_8_2957 VPWR VGND sg13cmos5l_decap_8
* cell instance sg13cmos5l_decap_8_2958 r0 *1 0,0
Xsg13cmos5l_decap_8_2958 VPWR VGND sg13cmos5l_decap_8
* cell instance sg13cmos5l_decap_8_2959 r0 *1 0,0
Xsg13cmos5l_decap_8_2959 VPWR VGND sg13cmos5l_decap_8
* cell instance sg13cmos5l_decap_8_2960 r0 *1 0,0
Xsg13cmos5l_decap_8_2960 VPWR VGND sg13cmos5l_decap_8
* cell instance sg13cmos5l_decap_8_2961 r0 *1 0,0
Xsg13cmos5l_decap_8_2961 VPWR VGND sg13cmos5l_decap_8
* cell instance sg13cmos5l_decap_8_2962 r0 *1 0,0
Xsg13cmos5l_decap_8_2962 VPWR VGND sg13cmos5l_decap_8
* cell instance sg13cmos5l_decap_8_2963 r0 *1 0,0
Xsg13cmos5l_decap_8_2963 VPWR VGND sg13cmos5l_decap_8
* cell instance sg13cmos5l_decap_8_2964 r0 *1 0,0
Xsg13cmos5l_decap_8_2964 VPWR VGND sg13cmos5l_decap_8
* cell instance sg13cmos5l_decap_8_2965 r0 *1 0,0
Xsg13cmos5l_decap_8_2965 VPWR VGND sg13cmos5l_decap_8
* cell instance sg13cmos5l_decap_8_2966 r0 *1 0,0
Xsg13cmos5l_decap_8_2966 VPWR VGND sg13cmos5l_decap_8
* cell instance sg13cmos5l_decap_8_2967 r0 *1 0,0
Xsg13cmos5l_decap_8_2967 VPWR VGND sg13cmos5l_decap_8
* cell instance sg13cmos5l_decap_8_2968 r0 *1 0,0
Xsg13cmos5l_decap_8_2968 VPWR VGND sg13cmos5l_decap_8
* cell instance sg13cmos5l_decap_8_2969 r0 *1 0,0
Xsg13cmos5l_decap_8_2969 VPWR VGND sg13cmos5l_decap_8
* cell instance sg13cmos5l_decap_8_2970 r0 *1 0,0
Xsg13cmos5l_decap_8_2970 VPWR VGND sg13cmos5l_decap_8
* cell instance sg13cmos5l_decap_8_2971 r0 *1 0,0
Xsg13cmos5l_decap_8_2971 VPWR VGND sg13cmos5l_decap_8
* cell instance sg13cmos5l_decap_8_2972 r0 *1 0,0
Xsg13cmos5l_decap_8_2972 VPWR VGND sg13cmos5l_decap_8
* cell instance sg13cmos5l_decap_8_2973 r0 *1 0,0
Xsg13cmos5l_decap_8_2973 VPWR VGND sg13cmos5l_decap_8
* cell instance sg13cmos5l_decap_8_2974 r0 *1 0,0
Xsg13cmos5l_decap_8_2974 VPWR VGND sg13cmos5l_decap_8
* cell instance sg13cmos5l_decap_8_2975 r0 *1 0,0
Xsg13cmos5l_decap_8_2975 VPWR VGND sg13cmos5l_decap_8
* cell instance sg13cmos5l_decap_8_2976 r0 *1 0,0
Xsg13cmos5l_decap_8_2976 VPWR VGND sg13cmos5l_decap_8
* cell instance sg13cmos5l_decap_8_2977 r0 *1 0,0
Xsg13cmos5l_decap_8_2977 VPWR VGND sg13cmos5l_decap_8
* cell instance sg13cmos5l_decap_8_2978 r0 *1 0,0
Xsg13cmos5l_decap_8_2978 VPWR VGND sg13cmos5l_decap_8
* cell instance sg13cmos5l_decap_8_2979 r0 *1 0,0
Xsg13cmos5l_decap_8_2979 VPWR VGND sg13cmos5l_decap_8
* cell instance sg13cmos5l_decap_8_2980 r0 *1 0,0
Xsg13cmos5l_decap_8_2980 VPWR VGND sg13cmos5l_decap_8
* cell instance sg13cmos5l_decap_8_2981 r0 *1 0,0
Xsg13cmos5l_decap_8_2981 VPWR VGND sg13cmos5l_decap_8
* cell instance sg13cmos5l_decap_8_2982 r0 *1 0,0
Xsg13cmos5l_decap_8_2982 VPWR VGND sg13cmos5l_decap_8
* cell instance sg13cmos5l_decap_8_2983 r0 *1 0,0
Xsg13cmos5l_decap_8_2983 VPWR VGND sg13cmos5l_decap_8
* cell instance sg13cmos5l_decap_8_2984 r0 *1 0,0
Xsg13cmos5l_decap_8_2984 VPWR VGND sg13cmos5l_decap_8
* cell instance sg13cmos5l_decap_8_2985 r0 *1 0,0
Xsg13cmos5l_decap_8_2985 VPWR VGND sg13cmos5l_decap_8
* cell instance sg13cmos5l_decap_8_2986 r0 *1 0,0
Xsg13cmos5l_decap_8_2986 VPWR VGND sg13cmos5l_decap_8
* cell instance sg13cmos5l_decap_8_2987 r0 *1 0,0
Xsg13cmos5l_decap_8_2987 VPWR VGND sg13cmos5l_decap_8
* cell instance sg13cmos5l_decap_8_2988 r0 *1 0,0
Xsg13cmos5l_decap_8_2988 VPWR VGND sg13cmos5l_decap_8
* cell instance sg13cmos5l_decap_8_2989 r0 *1 0,0
Xsg13cmos5l_decap_8_2989 VPWR VGND sg13cmos5l_decap_8
* cell instance sg13cmos5l_decap_8_2990 r0 *1 0,0
Xsg13cmos5l_decap_8_2990 VPWR VGND sg13cmos5l_decap_8
* cell instance sg13cmos5l_decap_8_2991 r0 *1 0,0
Xsg13cmos5l_decap_8_2991 VPWR VGND sg13cmos5l_decap_8
* cell instance sg13cmos5l_decap_8_2992 r0 *1 0,0
Xsg13cmos5l_decap_8_2992 VPWR VGND sg13cmos5l_decap_8
* cell instance sg13cmos5l_decap_8_2993 r0 *1 0,0
Xsg13cmos5l_decap_8_2993 VPWR VGND sg13cmos5l_decap_8
* cell instance sg13cmos5l_decap_8_2994 r0 *1 0,0
Xsg13cmos5l_decap_8_2994 VPWR VGND sg13cmos5l_decap_8
* cell instance sg13cmos5l_decap_8_2995 r0 *1 0,0
Xsg13cmos5l_decap_8_2995 VPWR VGND sg13cmos5l_decap_8
* cell instance sg13cmos5l_decap_8_2996 r0 *1 0,0
Xsg13cmos5l_decap_8_2996 VPWR VGND sg13cmos5l_decap_8
* cell instance sg13cmos5l_decap_8_2997 r0 *1 0,0
Xsg13cmos5l_decap_8_2997 VPWR VGND sg13cmos5l_decap_8
* cell instance sg13cmos5l_decap_8_2998 r0 *1 0,0
Xsg13cmos5l_decap_8_2998 VPWR VGND sg13cmos5l_decap_8
* cell instance sg13cmos5l_decap_8_2999 r0 *1 0,0
Xsg13cmos5l_decap_8_2999 VPWR VGND sg13cmos5l_decap_8
* cell instance sg13cmos5l_decap_8_3000 r0 *1 0,0
Xsg13cmos5l_decap_8_3000 VPWR VGND sg13cmos5l_decap_8
* cell instance sg13cmos5l_decap_8_3001 r0 *1 0,0
Xsg13cmos5l_decap_8_3001 VPWR VGND sg13cmos5l_decap_8
* cell instance sg13cmos5l_decap_8_3002 r0 *1 0,0
Xsg13cmos5l_decap_8_3002 VPWR VGND sg13cmos5l_decap_8
* cell instance sg13cmos5l_decap_8_3003 r0 *1 0,0
Xsg13cmos5l_decap_8_3003 VPWR VGND sg13cmos5l_decap_8
* cell instance sg13cmos5l_decap_8_3004 r0 *1 0,0
Xsg13cmos5l_decap_8_3004 VPWR VGND sg13cmos5l_decap_8
* cell instance sg13cmos5l_decap_8_3005 r0 *1 0,0
Xsg13cmos5l_decap_8_3005 VPWR VGND sg13cmos5l_decap_8
* cell instance sg13cmos5l_decap_8_3006 r0 *1 0,0
Xsg13cmos5l_decap_8_3006 VPWR VGND sg13cmos5l_decap_8
* cell instance sg13cmos5l_decap_8_3007 r0 *1 0,0
Xsg13cmos5l_decap_8_3007 VPWR VGND sg13cmos5l_decap_8
* cell instance sg13cmos5l_decap_8_3008 r0 *1 0,0
Xsg13cmos5l_decap_8_3008 VPWR VGND sg13cmos5l_decap_8
* cell instance sg13cmos5l_decap_8_3009 r0 *1 0,0
Xsg13cmos5l_decap_8_3009 VPWR VGND sg13cmos5l_decap_8
* cell instance sg13cmos5l_decap_8_3010 r0 *1 0,0
Xsg13cmos5l_decap_8_3010 VPWR VGND sg13cmos5l_decap_8
* cell instance sg13cmos5l_decap_8_3011 r0 *1 0,0
Xsg13cmos5l_decap_8_3011 VPWR VGND sg13cmos5l_decap_8
* cell instance sg13cmos5l_decap_8_3012 r0 *1 0,0
Xsg13cmos5l_decap_8_3012 VPWR VGND sg13cmos5l_decap_8
* cell instance sg13cmos5l_decap_8_3013 r0 *1 0,0
Xsg13cmos5l_decap_8_3013 VPWR VGND sg13cmos5l_decap_8
* cell instance sg13cmos5l_decap_8_3014 r0 *1 0,0
Xsg13cmos5l_decap_8_3014 VPWR VGND sg13cmos5l_decap_8
* cell instance sg13cmos5l_decap_8_3015 r0 *1 0,0
Xsg13cmos5l_decap_8_3015 VPWR VGND sg13cmos5l_decap_8
* cell instance sg13cmos5l_decap_8_3016 r0 *1 0,0
Xsg13cmos5l_decap_8_3016 VPWR VGND sg13cmos5l_decap_8
* cell instance sg13cmos5l_decap_8_3017 r0 *1 0,0
Xsg13cmos5l_decap_8_3017 VPWR VGND sg13cmos5l_decap_8
* cell instance sg13cmos5l_decap_8_3018 r0 *1 0,0
Xsg13cmos5l_decap_8_3018 VPWR VGND sg13cmos5l_decap_8
* cell instance sg13cmos5l_decap_8_3019 r0 *1 0,0
Xsg13cmos5l_decap_8_3019 VPWR VGND sg13cmos5l_decap_8
* cell instance sg13cmos5l_decap_8_3020 r0 *1 0,0
Xsg13cmos5l_decap_8_3020 VPWR VGND sg13cmos5l_decap_8
* cell instance sg13cmos5l_decap_8_3021 r0 *1 0,0
Xsg13cmos5l_decap_8_3021 VPWR VGND sg13cmos5l_decap_8
* cell instance sg13cmos5l_decap_8_3022 r0 *1 0,0
Xsg13cmos5l_decap_8_3022 VPWR VGND sg13cmos5l_decap_8
* cell instance sg13cmos5l_decap_8_3023 r0 *1 0,0
Xsg13cmos5l_decap_8_3023 VPWR VGND sg13cmos5l_decap_8
* cell instance sg13cmos5l_decap_8_3024 r0 *1 0,0
Xsg13cmos5l_decap_8_3024 VPWR VGND sg13cmos5l_decap_8
* cell instance sg13cmos5l_decap_8_3025 r0 *1 0,0
Xsg13cmos5l_decap_8_3025 VPWR VGND sg13cmos5l_decap_8
* cell instance sg13cmos5l_decap_8_3026 r0 *1 0,0
Xsg13cmos5l_decap_8_3026 VPWR VGND sg13cmos5l_decap_8
* cell instance sg13cmos5l_decap_8_3027 r0 *1 0,0
Xsg13cmos5l_decap_8_3027 VPWR VGND sg13cmos5l_decap_8
* cell instance sg13cmos5l_decap_8_3028 r0 *1 0,0
Xsg13cmos5l_decap_8_3028 VPWR VGND sg13cmos5l_decap_8
* cell instance sg13cmos5l_decap_8_3029 r0 *1 0,0
Xsg13cmos5l_decap_8_3029 VPWR VGND sg13cmos5l_decap_8
* cell instance sg13cmos5l_decap_8_3030 r0 *1 0,0
Xsg13cmos5l_decap_8_3030 VPWR VGND sg13cmos5l_decap_8
* cell instance sg13cmos5l_decap_8_3031 r0 *1 0,0
Xsg13cmos5l_decap_8_3031 VPWR VGND sg13cmos5l_decap_8
* cell instance sg13cmos5l_decap_8_3032 r0 *1 0,0
Xsg13cmos5l_decap_8_3032 VPWR VGND sg13cmos5l_decap_8
* cell instance sg13cmos5l_decap_8_3033 r0 *1 0,0
Xsg13cmos5l_decap_8_3033 VPWR VGND sg13cmos5l_decap_8
* cell instance sg13cmos5l_decap_8_3034 r0 *1 0,0
Xsg13cmos5l_decap_8_3034 VPWR VGND sg13cmos5l_decap_8
* cell instance sg13cmos5l_decap_8_3035 r0 *1 0,0
Xsg13cmos5l_decap_8_3035 VPWR VGND sg13cmos5l_decap_8
* cell instance sg13cmos5l_decap_8_3036 r0 *1 0,0
Xsg13cmos5l_decap_8_3036 VPWR VGND sg13cmos5l_decap_8
* cell instance sg13cmos5l_decap_8_3037 r0 *1 0,0
Xsg13cmos5l_decap_8_3037 VPWR VGND sg13cmos5l_decap_8
* cell instance sg13cmos5l_decap_8_3038 r0 *1 0,0
Xsg13cmos5l_decap_8_3038 VPWR VGND sg13cmos5l_decap_8
* cell instance sg13cmos5l_decap_8_3039 r0 *1 0,0
Xsg13cmos5l_decap_8_3039 VPWR VGND sg13cmos5l_decap_8
* cell instance sg13cmos5l_decap_8_3040 r0 *1 0,0
Xsg13cmos5l_decap_8_3040 VPWR VGND sg13cmos5l_decap_8
* cell instance sg13cmos5l_decap_8_3041 r0 *1 0,0
Xsg13cmos5l_decap_8_3041 VPWR VGND sg13cmos5l_decap_8
* cell instance sg13cmos5l_decap_8_3042 r0 *1 0,0
Xsg13cmos5l_decap_8_3042 VPWR VGND sg13cmos5l_decap_8
* cell instance sg13cmos5l_decap_8_3043 r0 *1 0,0
Xsg13cmos5l_decap_8_3043 VPWR VGND sg13cmos5l_decap_8
* cell instance sg13cmos5l_decap_8_3044 r0 *1 0,0
Xsg13cmos5l_decap_8_3044 VPWR VGND sg13cmos5l_decap_8
* cell instance sg13cmos5l_decap_8_3045 r0 *1 0,0
Xsg13cmos5l_decap_8_3045 VPWR VGND sg13cmos5l_decap_8
* cell instance sg13cmos5l_decap_8_3046 r0 *1 0,0
Xsg13cmos5l_decap_8_3046 VPWR VGND sg13cmos5l_decap_8
* cell instance sg13cmos5l_decap_8_3047 r0 *1 0,0
Xsg13cmos5l_decap_8_3047 VPWR VGND sg13cmos5l_decap_8
* cell instance sg13cmos5l_decap_8_3048 r0 *1 0,0
Xsg13cmos5l_decap_8_3048 VPWR VGND sg13cmos5l_decap_8
* cell instance sg13cmos5l_decap_8_3049 r0 *1 0,0
Xsg13cmos5l_decap_8_3049 VPWR VGND sg13cmos5l_decap_8
* cell instance sg13cmos5l_decap_8_3050 r0 *1 0,0
Xsg13cmos5l_decap_8_3050 VPWR VGND sg13cmos5l_decap_8
* cell instance sg13cmos5l_decap_8_3051 r0 *1 0,0
Xsg13cmos5l_decap_8_3051 VPWR VGND sg13cmos5l_decap_8
* cell instance sg13cmos5l_decap_8_3052 r0 *1 0,0
Xsg13cmos5l_decap_8_3052 VPWR VGND sg13cmos5l_decap_8
* cell instance sg13cmos5l_decap_8_3053 r0 *1 0,0
Xsg13cmos5l_decap_8_3053 VPWR VGND sg13cmos5l_decap_8
* cell instance sg13cmos5l_decap_8_3054 r0 *1 0,0
Xsg13cmos5l_decap_8_3054 VPWR VGND sg13cmos5l_decap_8
* cell instance sg13cmos5l_decap_8_3055 r0 *1 0,0
Xsg13cmos5l_decap_8_3055 VPWR VGND sg13cmos5l_decap_8
* cell instance sg13cmos5l_decap_8_3056 r0 *1 0,0
Xsg13cmos5l_decap_8_3056 VPWR VGND sg13cmos5l_decap_8
* cell instance sg13cmos5l_decap_8_3057 r0 *1 0,0
Xsg13cmos5l_decap_8_3057 VPWR VGND sg13cmos5l_decap_8
* cell instance sg13cmos5l_decap_8_3058 r0 *1 0,0
Xsg13cmos5l_decap_8_3058 VPWR VGND sg13cmos5l_decap_8
* cell instance sg13cmos5l_decap_8_3059 r0 *1 0,0
Xsg13cmos5l_decap_8_3059 VPWR VGND sg13cmos5l_decap_8
* cell instance sg13cmos5l_decap_8_3060 r0 *1 0,0
Xsg13cmos5l_decap_8_3060 VPWR VGND sg13cmos5l_decap_8
* cell instance sg13cmos5l_decap_8_3061 r0 *1 0,0
Xsg13cmos5l_decap_8_3061 VPWR VGND sg13cmos5l_decap_8
* cell instance sg13cmos5l_decap_8_3062 r0 *1 0,0
Xsg13cmos5l_decap_8_3062 VPWR VGND sg13cmos5l_decap_8
* cell instance sg13cmos5l_decap_8_3063 r0 *1 0,0
Xsg13cmos5l_decap_8_3063 VPWR VGND sg13cmos5l_decap_8
* cell instance sg13cmos5l_decap_8_3064 r0 *1 0,0
Xsg13cmos5l_decap_8_3064 VPWR VGND sg13cmos5l_decap_8
* cell instance sg13cmos5l_decap_8_3065 r0 *1 0,0
Xsg13cmos5l_decap_8_3065 VPWR VGND sg13cmos5l_decap_8
* cell instance sg13cmos5l_decap_8_3066 r0 *1 0,0
Xsg13cmos5l_decap_8_3066 VPWR VGND sg13cmos5l_decap_8
* cell instance sg13cmos5l_decap_8_3067 r0 *1 0,0
Xsg13cmos5l_decap_8_3067 VPWR VGND sg13cmos5l_decap_8
* cell instance sg13cmos5l_decap_8_3068 r0 *1 0,0
Xsg13cmos5l_decap_8_3068 VPWR VGND sg13cmos5l_decap_8
* cell instance sg13cmos5l_decap_8_3069 r0 *1 0,0
Xsg13cmos5l_decap_8_3069 VPWR VGND sg13cmos5l_decap_8
* cell instance sg13cmos5l_decap_8_3070 r0 *1 0,0
Xsg13cmos5l_decap_8_3070 VPWR VGND sg13cmos5l_decap_8
* cell instance sg13cmos5l_decap_8_3071 r0 *1 0,0
Xsg13cmos5l_decap_8_3071 VPWR VGND sg13cmos5l_decap_8
* cell instance sg13cmos5l_decap_8_3072 r0 *1 0,0
Xsg13cmos5l_decap_8_3072 VPWR VGND sg13cmos5l_decap_8
* cell instance sg13cmos5l_decap_8_3073 r0 *1 0,0
Xsg13cmos5l_decap_8_3073 VPWR VGND sg13cmos5l_decap_8
* cell instance sg13cmos5l_decap_8_3074 r0 *1 0,0
Xsg13cmos5l_decap_8_3074 VPWR VGND sg13cmos5l_decap_8
* cell instance sg13cmos5l_decap_8_3075 r0 *1 0,0
Xsg13cmos5l_decap_8_3075 VPWR VGND sg13cmos5l_decap_8
* cell instance sg13cmos5l_decap_8_3076 r0 *1 0,0
Xsg13cmos5l_decap_8_3076 VPWR VGND sg13cmos5l_decap_8
* cell instance sg13cmos5l_decap_8_3077 r0 *1 0,0
Xsg13cmos5l_decap_8_3077 VPWR VGND sg13cmos5l_decap_8
* cell instance sg13cmos5l_decap_8_3078 r0 *1 0,0
Xsg13cmos5l_decap_8_3078 VPWR VGND sg13cmos5l_decap_8
* cell instance sg13cmos5l_decap_8_3079 r0 *1 0,0
Xsg13cmos5l_decap_8_3079 VPWR VGND sg13cmos5l_decap_8
* cell instance sg13cmos5l_decap_8_3080 r0 *1 0,0
Xsg13cmos5l_decap_8_3080 VPWR VGND sg13cmos5l_decap_8
* cell instance sg13cmos5l_decap_8_3081 r0 *1 0,0
Xsg13cmos5l_decap_8_3081 VPWR VGND sg13cmos5l_decap_8
* cell instance sg13cmos5l_decap_8_3082 r0 *1 0,0
Xsg13cmos5l_decap_8_3082 VPWR VGND sg13cmos5l_decap_8
* cell instance sg13cmos5l_decap_8_3083 r0 *1 0,0
Xsg13cmos5l_decap_8_3083 VPWR VGND sg13cmos5l_decap_8
* cell instance sg13cmos5l_decap_8_3084 r0 *1 0,0
Xsg13cmos5l_decap_8_3084 VPWR VGND sg13cmos5l_decap_8
* cell instance sg13cmos5l_decap_8_3085 r0 *1 0,0
Xsg13cmos5l_decap_8_3085 VPWR VGND sg13cmos5l_decap_8
* cell instance sg13cmos5l_decap_8_3086 r0 *1 0,0
Xsg13cmos5l_decap_8_3086 VPWR VGND sg13cmos5l_decap_8
* cell instance sg13cmos5l_decap_8_3087 r0 *1 0,0
Xsg13cmos5l_decap_8_3087 VPWR VGND sg13cmos5l_decap_8
* cell instance sg13cmos5l_decap_8_3088 r0 *1 0,0
Xsg13cmos5l_decap_8_3088 VPWR VGND sg13cmos5l_decap_8
* cell instance sg13cmos5l_decap_8_3089 r0 *1 0,0
Xsg13cmos5l_decap_8_3089 VPWR VGND sg13cmos5l_decap_8
* cell instance sg13cmos5l_decap_8_3090 r0 *1 0,0
Xsg13cmos5l_decap_8_3090 VPWR VGND sg13cmos5l_decap_8
* cell instance sg13cmos5l_decap_8_3091 r0 *1 0,0
Xsg13cmos5l_decap_8_3091 VPWR VGND sg13cmos5l_decap_8
* cell instance sg13cmos5l_decap_8_3092 r0 *1 0,0
Xsg13cmos5l_decap_8_3092 VPWR VGND sg13cmos5l_decap_8
* cell instance sg13cmos5l_decap_8_3093 r0 *1 0,0
Xsg13cmos5l_decap_8_3093 VPWR VGND sg13cmos5l_decap_8
* cell instance sg13cmos5l_decap_8_3094 r0 *1 0,0
Xsg13cmos5l_decap_8_3094 VPWR VGND sg13cmos5l_decap_8
* cell instance sg13cmos5l_decap_8_3095 r0 *1 0,0
Xsg13cmos5l_decap_8_3095 VPWR VGND sg13cmos5l_decap_8
* cell instance sg13cmos5l_decap_8_3096 r0 *1 0,0
Xsg13cmos5l_decap_8_3096 VPWR VGND sg13cmos5l_decap_8
* cell instance sg13cmos5l_decap_8_3097 r0 *1 0,0
Xsg13cmos5l_decap_8_3097 VPWR VGND sg13cmos5l_decap_8
* cell instance sg13cmos5l_decap_8_3098 r0 *1 0,0
Xsg13cmos5l_decap_8_3098 VPWR VGND sg13cmos5l_decap_8
* cell instance sg13cmos5l_decap_8_3099 r0 *1 0,0
Xsg13cmos5l_decap_8_3099 VPWR VGND sg13cmos5l_decap_8
* cell instance sg13cmos5l_decap_8_3100 r0 *1 0,0
Xsg13cmos5l_decap_8_3100 VPWR VGND sg13cmos5l_decap_8
* cell instance sg13cmos5l_decap_8_3101 r0 *1 0,0
Xsg13cmos5l_decap_8_3101 VPWR VGND sg13cmos5l_decap_8
* cell instance sg13cmos5l_decap_8_3102 r0 *1 0,0
Xsg13cmos5l_decap_8_3102 VPWR VGND sg13cmos5l_decap_8
* cell instance sg13cmos5l_decap_8_3103 r0 *1 0,0
Xsg13cmos5l_decap_8_3103 VPWR VGND sg13cmos5l_decap_8
* cell instance sg13cmos5l_decap_8_3104 r0 *1 0,0
Xsg13cmos5l_decap_8_3104 VPWR VGND sg13cmos5l_decap_8
* cell instance sg13cmos5l_decap_8_3105 r0 *1 0,0
Xsg13cmos5l_decap_8_3105 VPWR VGND sg13cmos5l_decap_8
* cell instance sg13cmos5l_decap_8_3106 r0 *1 0,0
Xsg13cmos5l_decap_8_3106 VPWR VGND sg13cmos5l_decap_8
* cell instance sg13cmos5l_decap_8_3107 r0 *1 0,0
Xsg13cmos5l_decap_8_3107 VPWR VGND sg13cmos5l_decap_8
* cell instance sg13cmos5l_decap_8_3108 r0 *1 0,0
Xsg13cmos5l_decap_8_3108 VPWR VGND sg13cmos5l_decap_8
* cell instance sg13cmos5l_decap_8_3109 r0 *1 0,0
Xsg13cmos5l_decap_8_3109 VPWR VGND sg13cmos5l_decap_8
* cell instance sg13cmos5l_decap_8_3110 r0 *1 0,0
Xsg13cmos5l_decap_8_3110 VPWR VGND sg13cmos5l_decap_8
* cell instance sg13cmos5l_decap_8_3111 r0 *1 0,0
Xsg13cmos5l_decap_8_3111 VPWR VGND sg13cmos5l_decap_8
* cell instance sg13cmos5l_decap_8_3112 r0 *1 0,0
Xsg13cmos5l_decap_8_3112 VPWR VGND sg13cmos5l_decap_8
* cell instance sg13cmos5l_decap_8_3113 r0 *1 0,0
Xsg13cmos5l_decap_8_3113 VPWR VGND sg13cmos5l_decap_8
* cell instance sg13cmos5l_decap_8_3114 r0 *1 0,0
Xsg13cmos5l_decap_8_3114 VPWR VGND sg13cmos5l_decap_8
* cell instance sg13cmos5l_decap_8_3115 r0 *1 0,0
Xsg13cmos5l_decap_8_3115 VPWR VGND sg13cmos5l_decap_8
* cell instance sg13cmos5l_decap_8_3116 r0 *1 0,0
Xsg13cmos5l_decap_8_3116 VPWR VGND sg13cmos5l_decap_8
* cell instance sg13cmos5l_decap_8_3117 r0 *1 0,0
Xsg13cmos5l_decap_8_3117 VPWR VGND sg13cmos5l_decap_8
* cell instance sg13cmos5l_decap_8_3118 r0 *1 0,0
Xsg13cmos5l_decap_8_3118 VPWR VGND sg13cmos5l_decap_8
* cell instance sg13cmos5l_decap_8_3119 r0 *1 0,0
Xsg13cmos5l_decap_8_3119 VPWR VGND sg13cmos5l_decap_8
* cell instance sg13cmos5l_decap_8_3120 r0 *1 0,0
Xsg13cmos5l_decap_8_3120 VPWR VGND sg13cmos5l_decap_8
* cell instance sg13cmos5l_decap_8_3121 r0 *1 0,0
Xsg13cmos5l_decap_8_3121 VPWR VGND sg13cmos5l_decap_8
* cell instance sg13cmos5l_decap_8_3122 r0 *1 0,0
Xsg13cmos5l_decap_8_3122 VPWR VGND sg13cmos5l_decap_8
* cell instance sg13cmos5l_decap_8_3123 r0 *1 0,0
Xsg13cmos5l_decap_8_3123 VPWR VGND sg13cmos5l_decap_8
* cell instance sg13cmos5l_decap_8_3124 r0 *1 0,0
Xsg13cmos5l_decap_8_3124 VPWR VGND sg13cmos5l_decap_8
* cell instance sg13cmos5l_decap_8_3125 r0 *1 0,0
Xsg13cmos5l_decap_8_3125 VPWR VGND sg13cmos5l_decap_8
* cell instance sg13cmos5l_decap_8_3126 r0 *1 0,0
Xsg13cmos5l_decap_8_3126 VPWR VGND sg13cmos5l_decap_8
* cell instance sg13cmos5l_decap_8_3127 r0 *1 0,0
Xsg13cmos5l_decap_8_3127 VPWR VGND sg13cmos5l_decap_8
* cell instance sg13cmos5l_decap_8_3128 r0 *1 0,0
Xsg13cmos5l_decap_8_3128 VPWR VGND sg13cmos5l_decap_8
* cell instance sg13cmos5l_decap_8_3129 r0 *1 0,0
Xsg13cmos5l_decap_8_3129 VPWR VGND sg13cmos5l_decap_8
* cell instance sg13cmos5l_decap_8_3130 r0 *1 0,0
Xsg13cmos5l_decap_8_3130 VPWR VGND sg13cmos5l_decap_8
* cell instance sg13cmos5l_decap_8_3131 r0 *1 0,0
Xsg13cmos5l_decap_8_3131 VPWR VGND sg13cmos5l_decap_8
* cell instance sg13cmos5l_decap_8_3132 r0 *1 0,0
Xsg13cmos5l_decap_8_3132 VPWR VGND sg13cmos5l_decap_8
* cell instance sg13cmos5l_decap_8_3133 r0 *1 0,0
Xsg13cmos5l_decap_8_3133 VPWR VGND sg13cmos5l_decap_8
* cell instance sg13cmos5l_decap_8_3134 r0 *1 0,0
Xsg13cmos5l_decap_8_3134 VPWR VGND sg13cmos5l_decap_8
* cell instance sg13cmos5l_decap_8_3135 r0 *1 0,0
Xsg13cmos5l_decap_8_3135 VPWR VGND sg13cmos5l_decap_8
* cell instance sg13cmos5l_decap_8_3136 r0 *1 0,0
Xsg13cmos5l_decap_8_3136 VPWR VGND sg13cmos5l_decap_8
* cell instance sg13cmos5l_decap_8_3137 r0 *1 0,0
Xsg13cmos5l_decap_8_3137 VPWR VGND sg13cmos5l_decap_8
* cell instance sg13cmos5l_decap_8_3138 r0 *1 0,0
Xsg13cmos5l_decap_8_3138 VPWR VGND sg13cmos5l_decap_8
* cell instance sg13cmos5l_decap_8_3139 r0 *1 0,0
Xsg13cmos5l_decap_8_3139 VPWR VGND sg13cmos5l_decap_8
* cell instance sg13cmos5l_decap_8_3140 r0 *1 0,0
Xsg13cmos5l_decap_8_3140 VPWR VGND sg13cmos5l_decap_8
* cell instance sg13cmos5l_decap_8_3141 r0 *1 0,0
Xsg13cmos5l_decap_8_3141 VPWR VGND sg13cmos5l_decap_8
* cell instance sg13cmos5l_decap_8_3142 r0 *1 0,0
Xsg13cmos5l_decap_8_3142 VPWR VGND sg13cmos5l_decap_8
* cell instance sg13cmos5l_decap_8_3143 r0 *1 0,0
Xsg13cmos5l_decap_8_3143 VPWR VGND sg13cmos5l_decap_8
* cell instance sg13cmos5l_decap_8_3144 r0 *1 0,0
Xsg13cmos5l_decap_8_3144 VPWR VGND sg13cmos5l_decap_8
* cell instance sg13cmos5l_decap_8_3145 r0 *1 0,0
Xsg13cmos5l_decap_8_3145 VPWR VGND sg13cmos5l_decap_8
* cell instance sg13cmos5l_decap_8_3146 r0 *1 0,0
Xsg13cmos5l_decap_8_3146 VPWR VGND sg13cmos5l_decap_8
* cell instance sg13cmos5l_decap_8_3147 r0 *1 0,0
Xsg13cmos5l_decap_8_3147 VPWR VGND sg13cmos5l_decap_8
* cell instance sg13cmos5l_decap_8_3148 r0 *1 0,0
Xsg13cmos5l_decap_8_3148 VPWR VGND sg13cmos5l_decap_8
* cell instance sg13cmos5l_decap_8_3149 r0 *1 0,0
Xsg13cmos5l_decap_8_3149 VPWR VGND sg13cmos5l_decap_8
* cell instance sg13cmos5l_decap_8_3150 r0 *1 0,0
Xsg13cmos5l_decap_8_3150 VPWR VGND sg13cmos5l_decap_8
* cell instance sg13cmos5l_decap_8_3151 r0 *1 0,0
Xsg13cmos5l_decap_8_3151 VPWR VGND sg13cmos5l_decap_8
* cell instance sg13cmos5l_decap_8_3152 r0 *1 0,0
Xsg13cmos5l_decap_8_3152 VPWR VGND sg13cmos5l_decap_8
* cell instance sg13cmos5l_decap_8_3153 r0 *1 0,0
Xsg13cmos5l_decap_8_3153 VPWR VGND sg13cmos5l_decap_8
* cell instance sg13cmos5l_decap_8_3154 r0 *1 0,0
Xsg13cmos5l_decap_8_3154 VPWR VGND sg13cmos5l_decap_8
* cell instance sg13cmos5l_decap_8_3155 r0 *1 0,0
Xsg13cmos5l_decap_8_3155 VPWR VGND sg13cmos5l_decap_8
* cell instance sg13cmos5l_decap_8_3156 r0 *1 0,0
Xsg13cmos5l_decap_8_3156 VPWR VGND sg13cmos5l_decap_8
* cell instance sg13cmos5l_decap_8_3157 r0 *1 0,0
Xsg13cmos5l_decap_8_3157 VPWR VGND sg13cmos5l_decap_8
* cell instance sg13cmos5l_decap_8_3158 r0 *1 0,0
Xsg13cmos5l_decap_8_3158 VPWR VGND sg13cmos5l_decap_8
* cell instance sg13cmos5l_decap_8_3159 r0 *1 0,0
Xsg13cmos5l_decap_8_3159 VPWR VGND sg13cmos5l_decap_8
* cell instance sg13cmos5l_decap_8_3160 r0 *1 0,0
Xsg13cmos5l_decap_8_3160 VPWR VGND sg13cmos5l_decap_8
* cell instance sg13cmos5l_decap_8_3161 r0 *1 0,0
Xsg13cmos5l_decap_8_3161 VPWR VGND sg13cmos5l_decap_8
* cell instance sg13cmos5l_decap_8_3162 r0 *1 0,0
Xsg13cmos5l_decap_8_3162 VPWR VGND sg13cmos5l_decap_8
* cell instance sg13cmos5l_decap_8_3163 r0 *1 0,0
Xsg13cmos5l_decap_8_3163 VPWR VGND sg13cmos5l_decap_8
* cell instance sg13cmos5l_decap_8_3164 r0 *1 0,0
Xsg13cmos5l_decap_8_3164 VPWR VGND sg13cmos5l_decap_8
* cell instance sg13cmos5l_decap_8_3165 r0 *1 0,0
Xsg13cmos5l_decap_8_3165 VPWR VGND sg13cmos5l_decap_8
* cell instance sg13cmos5l_decap_8_3166 r0 *1 0,0
Xsg13cmos5l_decap_8_3166 VPWR VGND sg13cmos5l_decap_8
* cell instance sg13cmos5l_decap_8_3167 r0 *1 0,0
Xsg13cmos5l_decap_8_3167 VPWR VGND sg13cmos5l_decap_8
* cell instance sg13cmos5l_decap_8_3168 r0 *1 0,0
Xsg13cmos5l_decap_8_3168 VPWR VGND sg13cmos5l_decap_8
* cell instance sg13cmos5l_decap_8_3169 r0 *1 0,0
Xsg13cmos5l_decap_8_3169 VPWR VGND sg13cmos5l_decap_8
* cell instance sg13cmos5l_decap_8_3170 r0 *1 0,0
Xsg13cmos5l_decap_8_3170 VPWR VGND sg13cmos5l_decap_8
* cell instance sg13cmos5l_decap_8_3171 r0 *1 0,0
Xsg13cmos5l_decap_8_3171 VPWR VGND sg13cmos5l_decap_8
* cell instance sg13cmos5l_decap_8_3172 r0 *1 0,0
Xsg13cmos5l_decap_8_3172 VPWR VGND sg13cmos5l_decap_8
* cell instance sg13cmos5l_decap_8_3173 r0 *1 0,0
Xsg13cmos5l_decap_8_3173 VPWR VGND sg13cmos5l_decap_8
* cell instance sg13cmos5l_decap_8_3174 r0 *1 0,0
Xsg13cmos5l_decap_8_3174 VPWR VGND sg13cmos5l_decap_8
* cell instance sg13cmos5l_decap_8_3175 r0 *1 0,0
Xsg13cmos5l_decap_8_3175 VPWR VGND sg13cmos5l_decap_8
* cell instance sg13cmos5l_decap_8_3176 r0 *1 0,0
Xsg13cmos5l_decap_8_3176 VPWR VGND sg13cmos5l_decap_8
* cell instance sg13cmos5l_decap_8_3177 r0 *1 0,0
Xsg13cmos5l_decap_8_3177 VPWR VGND sg13cmos5l_decap_8
* cell instance sg13cmos5l_decap_8_3178 r0 *1 0,0
Xsg13cmos5l_decap_8_3178 VPWR VGND sg13cmos5l_decap_8
* cell instance sg13cmos5l_decap_8_3179 r0 *1 0,0
Xsg13cmos5l_decap_8_3179 VPWR VGND sg13cmos5l_decap_8
* cell instance sg13cmos5l_decap_8_3180 r0 *1 0,0
Xsg13cmos5l_decap_8_3180 VPWR VGND sg13cmos5l_decap_8
* cell instance sg13cmos5l_decap_8_3181 r0 *1 0,0
Xsg13cmos5l_decap_8_3181 VPWR VGND sg13cmos5l_decap_8
* cell instance sg13cmos5l_decap_8_3182 r0 *1 0,0
Xsg13cmos5l_decap_8_3182 VPWR VGND sg13cmos5l_decap_8
* cell instance sg13cmos5l_decap_8_3183 r0 *1 0,0
Xsg13cmos5l_decap_8_3183 VPWR VGND sg13cmos5l_decap_8
* cell instance sg13cmos5l_decap_8_3184 r0 *1 0,0
Xsg13cmos5l_decap_8_3184 VPWR VGND sg13cmos5l_decap_8
* cell instance sg13cmos5l_decap_8_3185 r0 *1 0,0
Xsg13cmos5l_decap_8_3185 VPWR VGND sg13cmos5l_decap_8
* cell instance sg13cmos5l_decap_8_3186 r0 *1 0,0
Xsg13cmos5l_decap_8_3186 VPWR VGND sg13cmos5l_decap_8
* cell instance sg13cmos5l_decap_8_3187 r0 *1 0,0
Xsg13cmos5l_decap_8_3187 VPWR VGND sg13cmos5l_decap_8
* cell instance sg13cmos5l_decap_8_3188 r0 *1 0,0
Xsg13cmos5l_decap_8_3188 VPWR VGND sg13cmos5l_decap_8
* cell instance sg13cmos5l_decap_8_3189 r0 *1 0,0
Xsg13cmos5l_decap_8_3189 VPWR VGND sg13cmos5l_decap_8
* cell instance sg13cmos5l_decap_8_3190 r0 *1 0,0
Xsg13cmos5l_decap_8_3190 VPWR VGND sg13cmos5l_decap_8
* cell instance sg13cmos5l_decap_8_3191 r0 *1 0,0
Xsg13cmos5l_decap_8_3191 VPWR VGND sg13cmos5l_decap_8
* cell instance sg13cmos5l_decap_8_3192 r0 *1 0,0
Xsg13cmos5l_decap_8_3192 VPWR VGND sg13cmos5l_decap_8
* cell instance sg13cmos5l_decap_8_3193 r0 *1 0,0
Xsg13cmos5l_decap_8_3193 VPWR VGND sg13cmos5l_decap_8
* cell instance sg13cmos5l_decap_8_3194 r0 *1 0,0
Xsg13cmos5l_decap_8_3194 VPWR VGND sg13cmos5l_decap_8
* cell instance sg13cmos5l_decap_8_3195 r0 *1 0,0
Xsg13cmos5l_decap_8_3195 VPWR VGND sg13cmos5l_decap_8
* cell instance sg13cmos5l_decap_8_3196 r0 *1 0,0
Xsg13cmos5l_decap_8_3196 VPWR VGND sg13cmos5l_decap_8
* cell instance sg13cmos5l_decap_8_3197 r0 *1 0,0
Xsg13cmos5l_decap_8_3197 VPWR VGND sg13cmos5l_decap_8
* cell instance sg13cmos5l_decap_8_3198 r0 *1 0,0
Xsg13cmos5l_decap_8_3198 VPWR VGND sg13cmos5l_decap_8
* cell instance sg13cmos5l_decap_8_3199 r0 *1 0,0
Xsg13cmos5l_decap_8_3199 VPWR VGND sg13cmos5l_decap_8
* cell instance sg13cmos5l_decap_8_3200 r0 *1 0,0
Xsg13cmos5l_decap_8_3200 VPWR VGND sg13cmos5l_decap_8
* cell instance sg13cmos5l_decap_8_3201 r0 *1 0,0
Xsg13cmos5l_decap_8_3201 VPWR VGND sg13cmos5l_decap_8
* cell instance sg13cmos5l_decap_8_3202 r0 *1 0,0
Xsg13cmos5l_decap_8_3202 VPWR VGND sg13cmos5l_decap_8
* cell instance sg13cmos5l_decap_8_3203 r0 *1 0,0
Xsg13cmos5l_decap_8_3203 VPWR VGND sg13cmos5l_decap_8
* cell instance sg13cmos5l_decap_8_3204 r0 *1 0,0
Xsg13cmos5l_decap_8_3204 VPWR VGND sg13cmos5l_decap_8
* cell instance sg13cmos5l_decap_8_3205 r0 *1 0,0
Xsg13cmos5l_decap_8_3205 VPWR VGND sg13cmos5l_decap_8
* cell instance sg13cmos5l_decap_8_3206 r0 *1 0,0
Xsg13cmos5l_decap_8_3206 VPWR VGND sg13cmos5l_decap_8
* cell instance sg13cmos5l_decap_8_3207 r0 *1 0,0
Xsg13cmos5l_decap_8_3207 VPWR VGND sg13cmos5l_decap_8
* cell instance sg13cmos5l_decap_8_3208 r0 *1 0,0
Xsg13cmos5l_decap_8_3208 VPWR VGND sg13cmos5l_decap_8
* cell instance sg13cmos5l_decap_8_3209 r0 *1 0,0
Xsg13cmos5l_decap_8_3209 VPWR VGND sg13cmos5l_decap_8
* cell instance sg13cmos5l_decap_8_3210 r0 *1 0,0
Xsg13cmos5l_decap_8_3210 VPWR VGND sg13cmos5l_decap_8
* cell instance sg13cmos5l_decap_8_3211 r0 *1 0,0
Xsg13cmos5l_decap_8_3211 VPWR VGND sg13cmos5l_decap_8
* cell instance sg13cmos5l_decap_8_3212 r0 *1 0,0
Xsg13cmos5l_decap_8_3212 VPWR VGND sg13cmos5l_decap_8
* cell instance sg13cmos5l_decap_8_3213 r0 *1 0,0
Xsg13cmos5l_decap_8_3213 VPWR VGND sg13cmos5l_decap_8
* cell instance sg13cmos5l_decap_8_3214 r0 *1 0,0
Xsg13cmos5l_decap_8_3214 VPWR VGND sg13cmos5l_decap_8
* cell instance sg13cmos5l_decap_8_3215 r0 *1 0,0
Xsg13cmos5l_decap_8_3215 VPWR VGND sg13cmos5l_decap_8
* cell instance sg13cmos5l_decap_8_3216 r0 *1 0,0
Xsg13cmos5l_decap_8_3216 VPWR VGND sg13cmos5l_decap_8
* cell instance sg13cmos5l_decap_8_3217 r0 *1 0,0
Xsg13cmos5l_decap_8_3217 VPWR VGND sg13cmos5l_decap_8
* cell instance sg13cmos5l_decap_8_3218 r0 *1 0,0
Xsg13cmos5l_decap_8_3218 VPWR VGND sg13cmos5l_decap_8
* cell instance sg13cmos5l_decap_8_3219 r0 *1 0,0
Xsg13cmos5l_decap_8_3219 VPWR VGND sg13cmos5l_decap_8
* cell instance sg13cmos5l_decap_8_3220 r0 *1 0,0
Xsg13cmos5l_decap_8_3220 VPWR VGND sg13cmos5l_decap_8
* cell instance sg13cmos5l_decap_8_3221 r0 *1 0,0
Xsg13cmos5l_decap_8_3221 VPWR VGND sg13cmos5l_decap_8
* cell instance sg13cmos5l_decap_8_3222 r0 *1 0,0
Xsg13cmos5l_decap_8_3222 VPWR VGND sg13cmos5l_decap_8
* cell instance sg13cmos5l_decap_8_3223 r0 *1 0,0
Xsg13cmos5l_decap_8_3223 VPWR VGND sg13cmos5l_decap_8
* cell instance sg13cmos5l_decap_8_3224 r0 *1 0,0
Xsg13cmos5l_decap_8_3224 VPWR VGND sg13cmos5l_decap_8
* cell instance sg13cmos5l_decap_8_3225 r0 *1 0,0
Xsg13cmos5l_decap_8_3225 VPWR VGND sg13cmos5l_decap_8
* cell instance sg13cmos5l_decap_8_3226 r0 *1 0,0
Xsg13cmos5l_decap_8_3226 VPWR VGND sg13cmos5l_decap_8
* cell instance sg13cmos5l_decap_8_3227 r0 *1 0,0
Xsg13cmos5l_decap_8_3227 VPWR VGND sg13cmos5l_decap_8
* cell instance sg13cmos5l_decap_8_3228 r0 *1 0,0
Xsg13cmos5l_decap_8_3228 VPWR VGND sg13cmos5l_decap_8
* cell instance sg13cmos5l_decap_8_3229 r0 *1 0,0
Xsg13cmos5l_decap_8_3229 VPWR VGND sg13cmos5l_decap_8
* cell instance sg13cmos5l_decap_8_3230 r0 *1 0,0
Xsg13cmos5l_decap_8_3230 VPWR VGND sg13cmos5l_decap_8
* cell instance sg13cmos5l_decap_8_3231 r0 *1 0,0
Xsg13cmos5l_decap_8_3231 VPWR VGND sg13cmos5l_decap_8
* cell instance sg13cmos5l_decap_8_3232 r0 *1 0,0
Xsg13cmos5l_decap_8_3232 VPWR VGND sg13cmos5l_decap_8
* cell instance sg13cmos5l_decap_8_3233 r0 *1 0,0
Xsg13cmos5l_decap_8_3233 VPWR VGND sg13cmos5l_decap_8
* cell instance sg13cmos5l_decap_8_3234 r0 *1 0,0
Xsg13cmos5l_decap_8_3234 VPWR VGND sg13cmos5l_decap_8
* cell instance sg13cmos5l_decap_8_3235 r0 *1 0,0
Xsg13cmos5l_decap_8_3235 VPWR VGND sg13cmos5l_decap_8
* cell instance sg13cmos5l_decap_8_3236 r0 *1 0,0
Xsg13cmos5l_decap_8_3236 VPWR VGND sg13cmos5l_decap_8
* cell instance sg13cmos5l_decap_8_3237 r0 *1 0,0
Xsg13cmos5l_decap_8_3237 VPWR VGND sg13cmos5l_decap_8
* cell instance sg13cmos5l_decap_8_3238 r0 *1 0,0
Xsg13cmos5l_decap_8_3238 VPWR VGND sg13cmos5l_decap_8
* cell instance sg13cmos5l_decap_8_3239 r0 *1 0,0
Xsg13cmos5l_decap_8_3239 VPWR VGND sg13cmos5l_decap_8
* cell instance sg13cmos5l_decap_8_3240 r0 *1 0,0
Xsg13cmos5l_decap_8_3240 VPWR VGND sg13cmos5l_decap_8
* cell instance sg13cmos5l_decap_8_3241 r0 *1 0,0
Xsg13cmos5l_decap_8_3241 VPWR VGND sg13cmos5l_decap_8
* cell instance sg13cmos5l_decap_8_3242 r0 *1 0,0
Xsg13cmos5l_decap_8_3242 VPWR VGND sg13cmos5l_decap_8
* cell instance sg13cmos5l_decap_8_3243 r0 *1 0,0
Xsg13cmos5l_decap_8_3243 VPWR VGND sg13cmos5l_decap_8
* cell instance sg13cmos5l_decap_8_3244 r0 *1 0,0
Xsg13cmos5l_decap_8_3244 VPWR VGND sg13cmos5l_decap_8
* cell instance sg13cmos5l_decap_8_3245 r0 *1 0,0
Xsg13cmos5l_decap_8_3245 VPWR VGND sg13cmos5l_decap_8
* cell instance sg13cmos5l_decap_8_3246 r0 *1 0,0
Xsg13cmos5l_decap_8_3246 VPWR VGND sg13cmos5l_decap_8
* cell instance sg13cmos5l_decap_8_3247 r0 *1 0,0
Xsg13cmos5l_decap_8_3247 VPWR VGND sg13cmos5l_decap_8
* cell instance sg13cmos5l_decap_8_3248 r0 *1 0,0
Xsg13cmos5l_decap_8_3248 VPWR VGND sg13cmos5l_decap_8
* cell instance sg13cmos5l_decap_8_3249 r0 *1 0,0
Xsg13cmos5l_decap_8_3249 VPWR VGND sg13cmos5l_decap_8
* cell instance sg13cmos5l_decap_8_3250 r0 *1 0,0
Xsg13cmos5l_decap_8_3250 VPWR VGND sg13cmos5l_decap_8
* cell instance sg13cmos5l_decap_8_3251 r0 *1 0,0
Xsg13cmos5l_decap_8_3251 VPWR VGND sg13cmos5l_decap_8
* cell instance sg13cmos5l_decap_8_3252 r0 *1 0,0
Xsg13cmos5l_decap_8_3252 VPWR VGND sg13cmos5l_decap_8
* cell instance sg13cmos5l_decap_8_3253 r0 *1 0,0
Xsg13cmos5l_decap_8_3253 VPWR VGND sg13cmos5l_decap_8
* cell instance sg13cmos5l_decap_8_3254 r0 *1 0,0
Xsg13cmos5l_decap_8_3254 VPWR VGND sg13cmos5l_decap_8
* cell instance sg13cmos5l_decap_8_3255 r0 *1 0,0
Xsg13cmos5l_decap_8_3255 VPWR VGND sg13cmos5l_decap_8
* cell instance sg13cmos5l_decap_8_3256 r0 *1 0,0
Xsg13cmos5l_decap_8_3256 VPWR VGND sg13cmos5l_decap_8
* cell instance sg13cmos5l_decap_8_3257 r0 *1 0,0
Xsg13cmos5l_decap_8_3257 VPWR VGND sg13cmos5l_decap_8
* cell instance sg13cmos5l_decap_8_3258 r0 *1 0,0
Xsg13cmos5l_decap_8_3258 VPWR VGND sg13cmos5l_decap_8
* cell instance sg13cmos5l_decap_8_3259 r0 *1 0,0
Xsg13cmos5l_decap_8_3259 VPWR VGND sg13cmos5l_decap_8
* cell instance sg13cmos5l_decap_8_3260 r0 *1 0,0
Xsg13cmos5l_decap_8_3260 VPWR VGND sg13cmos5l_decap_8
* cell instance sg13cmos5l_decap_8_3261 r0 *1 0,0
Xsg13cmos5l_decap_8_3261 VPWR VGND sg13cmos5l_decap_8
* cell instance sg13cmos5l_decap_8_3262 r0 *1 0,0
Xsg13cmos5l_decap_8_3262 VPWR VGND sg13cmos5l_decap_8
* cell instance sg13cmos5l_decap_8_3263 r0 *1 0,0
Xsg13cmos5l_decap_8_3263 VPWR VGND sg13cmos5l_decap_8
* cell instance sg13cmos5l_decap_8_3264 r0 *1 0,0
Xsg13cmos5l_decap_8_3264 VPWR VGND sg13cmos5l_decap_8
* cell instance sg13cmos5l_decap_8_3265 r0 *1 0,0
Xsg13cmos5l_decap_8_3265 VPWR VGND sg13cmos5l_decap_8
* cell instance sg13cmos5l_decap_8_3266 r0 *1 0,0
Xsg13cmos5l_decap_8_3266 VPWR VGND sg13cmos5l_decap_8
* cell instance sg13cmos5l_decap_8_3267 r0 *1 0,0
Xsg13cmos5l_decap_8_3267 VPWR VGND sg13cmos5l_decap_8
* cell instance sg13cmos5l_decap_8_3268 r0 *1 0,0
Xsg13cmos5l_decap_8_3268 VPWR VGND sg13cmos5l_decap_8
* cell instance sg13cmos5l_decap_8_3269 r0 *1 0,0
Xsg13cmos5l_decap_8_3269 VPWR VGND sg13cmos5l_decap_8
* cell instance sg13cmos5l_decap_8_3270 r0 *1 0,0
Xsg13cmos5l_decap_8_3270 VPWR VGND sg13cmos5l_decap_8
* cell instance sg13cmos5l_decap_8_3271 r0 *1 0,0
Xsg13cmos5l_decap_8_3271 VPWR VGND sg13cmos5l_decap_8
* cell instance sg13cmos5l_decap_8_3272 r0 *1 0,0
Xsg13cmos5l_decap_8_3272 VPWR VGND sg13cmos5l_decap_8
* cell instance sg13cmos5l_decap_8_3273 r0 *1 0,0
Xsg13cmos5l_decap_8_3273 VPWR VGND sg13cmos5l_decap_8
* cell instance sg13cmos5l_decap_8_3274 r0 *1 0,0
Xsg13cmos5l_decap_8_3274 VPWR VGND sg13cmos5l_decap_8
* cell instance sg13cmos5l_decap_8_3275 r0 *1 0,0
Xsg13cmos5l_decap_8_3275 VPWR VGND sg13cmos5l_decap_8
* cell instance sg13cmos5l_decap_8_3276 r0 *1 0,0
Xsg13cmos5l_decap_8_3276 VPWR VGND sg13cmos5l_decap_8
* cell instance sg13cmos5l_decap_8_3277 r0 *1 0,0
Xsg13cmos5l_decap_8_3277 VPWR VGND sg13cmos5l_decap_8
* cell instance sg13cmos5l_decap_8_3278 r0 *1 0,0
Xsg13cmos5l_decap_8_3278 VPWR VGND sg13cmos5l_decap_8
* cell instance sg13cmos5l_decap_8_3279 r0 *1 0,0
Xsg13cmos5l_decap_8_3279 VPWR VGND sg13cmos5l_decap_8
* cell instance sg13cmos5l_decap_8_3280 r0 *1 0,0
Xsg13cmos5l_decap_8_3280 VPWR VGND sg13cmos5l_decap_8
* cell instance sg13cmos5l_decap_8_3281 r0 *1 0,0
Xsg13cmos5l_decap_8_3281 VPWR VGND sg13cmos5l_decap_8
* cell instance sg13cmos5l_decap_8_3282 r0 *1 0,0
Xsg13cmos5l_decap_8_3282 VPWR VGND sg13cmos5l_decap_8
* cell instance sg13cmos5l_decap_8_3283 r0 *1 0,0
Xsg13cmos5l_decap_8_3283 VPWR VGND sg13cmos5l_decap_8
* cell instance sg13cmos5l_decap_8_3284 r0 *1 0,0
Xsg13cmos5l_decap_8_3284 VPWR VGND sg13cmos5l_decap_8
* cell instance sg13cmos5l_decap_8_3285 r0 *1 0,0
Xsg13cmos5l_decap_8_3285 VPWR VGND sg13cmos5l_decap_8
* cell instance sg13cmos5l_decap_8_3286 r0 *1 0,0
Xsg13cmos5l_decap_8_3286 VPWR VGND sg13cmos5l_decap_8
* cell instance sg13cmos5l_decap_8_3287 r0 *1 0,0
Xsg13cmos5l_decap_8_3287 VPWR VGND sg13cmos5l_decap_8
* cell instance sg13cmos5l_decap_8_3288 r0 *1 0,0
Xsg13cmos5l_decap_8_3288 VPWR VGND sg13cmos5l_decap_8
* cell instance sg13cmos5l_decap_8_3289 r0 *1 0,0
Xsg13cmos5l_decap_8_3289 VPWR VGND sg13cmos5l_decap_8
* cell instance sg13cmos5l_decap_8_3290 r0 *1 0,0
Xsg13cmos5l_decap_8_3290 VPWR VGND sg13cmos5l_decap_8
* cell instance sg13cmos5l_decap_8_3291 r0 *1 0,0
Xsg13cmos5l_decap_8_3291 VPWR VGND sg13cmos5l_decap_8
* cell instance sg13cmos5l_decap_8_3292 r0 *1 0,0
Xsg13cmos5l_decap_8_3292 VPWR VGND sg13cmos5l_decap_8
* cell instance sg13cmos5l_decap_8_3293 r0 *1 0,0
Xsg13cmos5l_decap_8_3293 VPWR VGND sg13cmos5l_decap_8
* cell instance sg13cmos5l_decap_8_3294 r0 *1 0,0
Xsg13cmos5l_decap_8_3294 VPWR VGND sg13cmos5l_decap_8
* cell instance sg13cmos5l_decap_8_3295 r0 *1 0,0
Xsg13cmos5l_decap_8_3295 VPWR VGND sg13cmos5l_decap_8
* cell instance sg13cmos5l_decap_8_3296 r0 *1 0,0
Xsg13cmos5l_decap_8_3296 VPWR VGND sg13cmos5l_decap_8
* cell instance sg13cmos5l_decap_8_3297 r0 *1 0,0
Xsg13cmos5l_decap_8_3297 VPWR VGND sg13cmos5l_decap_8
* cell instance sg13cmos5l_decap_8_3298 r0 *1 0,0
Xsg13cmos5l_decap_8_3298 VPWR VGND sg13cmos5l_decap_8
* cell instance sg13cmos5l_decap_8_3299 r0 *1 0,0
Xsg13cmos5l_decap_8_3299 VPWR VGND sg13cmos5l_decap_8
* cell instance sg13cmos5l_decap_8_3300 r0 *1 0,0
Xsg13cmos5l_decap_8_3300 VPWR VGND sg13cmos5l_decap_8
* cell instance sg13cmos5l_decap_8_3301 r0 *1 0,0
Xsg13cmos5l_decap_8_3301 VPWR VGND sg13cmos5l_decap_8
* cell instance sg13cmos5l_decap_8_3302 r0 *1 0,0
Xsg13cmos5l_decap_8_3302 VPWR VGND sg13cmos5l_decap_8
* cell instance sg13cmos5l_decap_8_3303 r0 *1 0,0
Xsg13cmos5l_decap_8_3303 VPWR VGND sg13cmos5l_decap_8
* cell instance sg13cmos5l_decap_8_3304 r0 *1 0,0
Xsg13cmos5l_decap_8_3304 VPWR VGND sg13cmos5l_decap_8
* cell instance sg13cmos5l_decap_8_3305 r0 *1 0,0
Xsg13cmos5l_decap_8_3305 VPWR VGND sg13cmos5l_decap_8
* cell instance sg13cmos5l_decap_8_3306 r0 *1 0,0
Xsg13cmos5l_decap_8_3306 VPWR VGND sg13cmos5l_decap_8
* cell instance sg13cmos5l_decap_8_3307 r0 *1 0,0
Xsg13cmos5l_decap_8_3307 VPWR VGND sg13cmos5l_decap_8
* cell instance sg13cmos5l_decap_8_3308 r0 *1 0,0
Xsg13cmos5l_decap_8_3308 VPWR VGND sg13cmos5l_decap_8
* cell instance sg13cmos5l_decap_8_3309 r0 *1 0,0
Xsg13cmos5l_decap_8_3309 VPWR VGND sg13cmos5l_decap_8
* cell instance sg13cmos5l_decap_8_3310 r0 *1 0,0
Xsg13cmos5l_decap_8_3310 VPWR VGND sg13cmos5l_decap_8
* cell instance sg13cmos5l_decap_8_3311 r0 *1 0,0
Xsg13cmos5l_decap_8_3311 VPWR VGND sg13cmos5l_decap_8
* cell instance sg13cmos5l_decap_8_3312 r0 *1 0,0
Xsg13cmos5l_decap_8_3312 VPWR VGND sg13cmos5l_decap_8
* cell instance sg13cmos5l_decap_8_3313 r0 *1 0,0
Xsg13cmos5l_decap_8_3313 VPWR VGND sg13cmos5l_decap_8
* cell instance sg13cmos5l_decap_8_3314 r0 *1 0,0
Xsg13cmos5l_decap_8_3314 VPWR VGND sg13cmos5l_decap_8
* cell instance sg13cmos5l_decap_8_3315 r0 *1 0,0
Xsg13cmos5l_decap_8_3315 VPWR VGND sg13cmos5l_decap_8
* cell instance sg13cmos5l_decap_8_3316 r0 *1 0,0
Xsg13cmos5l_decap_8_3316 VPWR VGND sg13cmos5l_decap_8
* cell instance sg13cmos5l_decap_8_3317 r0 *1 0,0
Xsg13cmos5l_decap_8_3317 VPWR VGND sg13cmos5l_decap_8
* cell instance sg13cmos5l_decap_8_3318 r0 *1 0,0
Xsg13cmos5l_decap_8_3318 VPWR VGND sg13cmos5l_decap_8
* cell instance sg13cmos5l_decap_8_3319 r0 *1 0,0
Xsg13cmos5l_decap_8_3319 VPWR VGND sg13cmos5l_decap_8
* cell instance sg13cmos5l_decap_8_3320 r0 *1 0,0
Xsg13cmos5l_decap_8_3320 VPWR VGND sg13cmos5l_decap_8
* cell instance sg13cmos5l_decap_8_3321 r0 *1 0,0
Xsg13cmos5l_decap_8_3321 VPWR VGND sg13cmos5l_decap_8
* cell instance sg13cmos5l_decap_8_3322 r0 *1 0,0
Xsg13cmos5l_decap_8_3322 VPWR VGND sg13cmos5l_decap_8
* cell instance sg13cmos5l_decap_8_3323 r0 *1 0,0
Xsg13cmos5l_decap_8_3323 VPWR VGND sg13cmos5l_decap_8
* cell instance sg13cmos5l_decap_8_3324 r0 *1 0,0
Xsg13cmos5l_decap_8_3324 VPWR VGND sg13cmos5l_decap_8
* cell instance sg13cmos5l_decap_8_3325 r0 *1 0,0
Xsg13cmos5l_decap_8_3325 VPWR VGND sg13cmos5l_decap_8
* cell instance sg13cmos5l_decap_8_3326 r0 *1 0,0
Xsg13cmos5l_decap_8_3326 VPWR VGND sg13cmos5l_decap_8
* cell instance sg13cmos5l_decap_8_3327 r0 *1 0,0
Xsg13cmos5l_decap_8_3327 VPWR VGND sg13cmos5l_decap_8
* cell instance sg13cmos5l_decap_8_3328 r0 *1 0,0
Xsg13cmos5l_decap_8_3328 VPWR VGND sg13cmos5l_decap_8
* cell instance sg13cmos5l_decap_8_3329 r0 *1 0,0
Xsg13cmos5l_decap_8_3329 VPWR VGND sg13cmos5l_decap_8
* cell instance sg13cmos5l_decap_8_3330 r0 *1 0,0
Xsg13cmos5l_decap_8_3330 VPWR VGND sg13cmos5l_decap_8
* cell instance sg13cmos5l_decap_8_3331 r0 *1 0,0
Xsg13cmos5l_decap_8_3331 VPWR VGND sg13cmos5l_decap_8
* cell instance sg13cmos5l_decap_8_3332 r0 *1 0,0
Xsg13cmos5l_decap_8_3332 VPWR VGND sg13cmos5l_decap_8
* cell instance sg13cmos5l_decap_8_3333 r0 *1 0,0
Xsg13cmos5l_decap_8_3333 VPWR VGND sg13cmos5l_decap_8
* cell instance sg13cmos5l_decap_8_3334 r0 *1 0,0
Xsg13cmos5l_decap_8_3334 VPWR VGND sg13cmos5l_decap_8
* cell instance sg13cmos5l_decap_8_3335 r0 *1 0,0
Xsg13cmos5l_decap_8_3335 VPWR VGND sg13cmos5l_decap_8
* cell instance sg13cmos5l_decap_8_3336 r0 *1 0,0
Xsg13cmos5l_decap_8_3336 VPWR VGND sg13cmos5l_decap_8
* cell instance sg13cmos5l_decap_8_3337 r0 *1 0,0
Xsg13cmos5l_decap_8_3337 VPWR VGND sg13cmos5l_decap_8
* cell instance sg13cmos5l_decap_8_3338 r0 *1 0,0
Xsg13cmos5l_decap_8_3338 VPWR VGND sg13cmos5l_decap_8
* cell instance sg13cmos5l_decap_8_3339 r0 *1 0,0
Xsg13cmos5l_decap_8_3339 VPWR VGND sg13cmos5l_decap_8
* cell instance sg13cmos5l_decap_8_3340 r0 *1 0,0
Xsg13cmos5l_decap_8_3340 VPWR VGND sg13cmos5l_decap_8
* cell instance sg13cmos5l_decap_8_3341 r0 *1 0,0
Xsg13cmos5l_decap_8_3341 VPWR VGND sg13cmos5l_decap_8
* cell instance sg13cmos5l_decap_8_3342 r0 *1 0,0
Xsg13cmos5l_decap_8_3342 VPWR VGND sg13cmos5l_decap_8
* cell instance sg13cmos5l_decap_8_3343 r0 *1 0,0
Xsg13cmos5l_decap_8_3343 VPWR VGND sg13cmos5l_decap_8
* cell instance sg13cmos5l_decap_8_3344 r0 *1 0,0
Xsg13cmos5l_decap_8_3344 VPWR VGND sg13cmos5l_decap_8
* cell instance sg13cmos5l_decap_8_3345 r0 *1 0,0
Xsg13cmos5l_decap_8_3345 VPWR VGND sg13cmos5l_decap_8
* cell instance sg13cmos5l_decap_8_3346 r0 *1 0,0
Xsg13cmos5l_decap_8_3346 VPWR VGND sg13cmos5l_decap_8
* cell instance sg13cmos5l_decap_8_3347 r0 *1 0,0
Xsg13cmos5l_decap_8_3347 VPWR VGND sg13cmos5l_decap_8
* cell instance sg13cmos5l_decap_8_3348 r0 *1 0,0
Xsg13cmos5l_decap_8_3348 VPWR VGND sg13cmos5l_decap_8
* cell instance sg13cmos5l_decap_8_3349 r0 *1 0,0
Xsg13cmos5l_decap_8_3349 VPWR VGND sg13cmos5l_decap_8
* cell instance sg13cmos5l_decap_8_3350 r0 *1 0,0
Xsg13cmos5l_decap_8_3350 VPWR VGND sg13cmos5l_decap_8
* cell instance sg13cmos5l_decap_8_3351 r0 *1 0,0
Xsg13cmos5l_decap_8_3351 VPWR VGND sg13cmos5l_decap_8
* cell instance sg13cmos5l_decap_8_3352 r0 *1 0,0
Xsg13cmos5l_decap_8_3352 VPWR VGND sg13cmos5l_decap_8
* cell instance sg13cmos5l_decap_8_3353 r0 *1 0,0
Xsg13cmos5l_decap_8_3353 VPWR VGND sg13cmos5l_decap_8
* cell instance sg13cmos5l_decap_8_3354 r0 *1 0,0
Xsg13cmos5l_decap_8_3354 VPWR VGND sg13cmos5l_decap_8
* cell instance sg13cmos5l_decap_8_3355 r0 *1 0,0
Xsg13cmos5l_decap_8_3355 VPWR VGND sg13cmos5l_decap_8
* cell instance sg13cmos5l_decap_8_3356 r0 *1 0,0
Xsg13cmos5l_decap_8_3356 VPWR VGND sg13cmos5l_decap_8
* cell instance sg13cmos5l_decap_8_3357 r0 *1 0,0
Xsg13cmos5l_decap_8_3357 VPWR VGND sg13cmos5l_decap_8
* cell instance sg13cmos5l_decap_8_3358 r0 *1 0,0
Xsg13cmos5l_decap_8_3358 VPWR VGND sg13cmos5l_decap_8
* cell instance sg13cmos5l_decap_8_3359 r0 *1 0,0
Xsg13cmos5l_decap_8_3359 VPWR VGND sg13cmos5l_decap_8
* cell instance sg13cmos5l_decap_8_3360 r0 *1 0,0
Xsg13cmos5l_decap_8_3360 VPWR VGND sg13cmos5l_decap_8
* cell instance sg13cmos5l_decap_8_3361 r0 *1 0,0
Xsg13cmos5l_decap_8_3361 VPWR VGND sg13cmos5l_decap_8
* cell instance sg13cmos5l_decap_8_3362 r0 *1 0,0
Xsg13cmos5l_decap_8_3362 VPWR VGND sg13cmos5l_decap_8
* cell instance sg13cmos5l_decap_8_3363 r0 *1 0,0
Xsg13cmos5l_decap_8_3363 VPWR VGND sg13cmos5l_decap_8
* cell instance sg13cmos5l_decap_8_3364 r0 *1 0,0
Xsg13cmos5l_decap_8_3364 VPWR VGND sg13cmos5l_decap_8
* cell instance sg13cmos5l_decap_8_3365 r0 *1 0,0
Xsg13cmos5l_decap_8_3365 VPWR VGND sg13cmos5l_decap_8
* cell instance sg13cmos5l_decap_8_3366 r0 *1 0,0
Xsg13cmos5l_decap_8_3366 VPWR VGND sg13cmos5l_decap_8
* cell instance sg13cmos5l_decap_8_3367 r0 *1 0,0
Xsg13cmos5l_decap_8_3367 VPWR VGND sg13cmos5l_decap_8
* cell instance sg13cmos5l_decap_8_3368 r0 *1 0,0
Xsg13cmos5l_decap_8_3368 VPWR VGND sg13cmos5l_decap_8
* cell instance sg13cmos5l_decap_8_3369 r0 *1 0,0
Xsg13cmos5l_decap_8_3369 VPWR VGND sg13cmos5l_decap_8
* cell instance sg13cmos5l_decap_8_3370 r0 *1 0,0
Xsg13cmos5l_decap_8_3370 VPWR VGND sg13cmos5l_decap_8
* cell instance sg13cmos5l_decap_8_3371 r0 *1 0,0
Xsg13cmos5l_decap_8_3371 VPWR VGND sg13cmos5l_decap_8
* cell instance sg13cmos5l_decap_8_3372 r0 *1 0,0
Xsg13cmos5l_decap_8_3372 VPWR VGND sg13cmos5l_decap_8
* cell instance sg13cmos5l_decap_8_3373 r0 *1 0,0
Xsg13cmos5l_decap_8_3373 VPWR VGND sg13cmos5l_decap_8
* cell instance sg13cmos5l_decap_8_3374 r0 *1 0,0
Xsg13cmos5l_decap_8_3374 VPWR VGND sg13cmos5l_decap_8
* cell instance sg13cmos5l_decap_8_3375 r0 *1 0,0
Xsg13cmos5l_decap_8_3375 VPWR VGND sg13cmos5l_decap_8
* cell instance sg13cmos5l_decap_8_3376 r0 *1 0,0
Xsg13cmos5l_decap_8_3376 VPWR VGND sg13cmos5l_decap_8
* cell instance sg13cmos5l_decap_8_3377 r0 *1 0,0
Xsg13cmos5l_decap_8_3377 VPWR VGND sg13cmos5l_decap_8
* cell instance sg13cmos5l_decap_8_3378 r0 *1 0,0
Xsg13cmos5l_decap_8_3378 VPWR VGND sg13cmos5l_decap_8
* cell instance sg13cmos5l_decap_8_3379 r0 *1 0,0
Xsg13cmos5l_decap_8_3379 VPWR VGND sg13cmos5l_decap_8
* cell instance sg13cmos5l_decap_8_3380 r0 *1 0,0
Xsg13cmos5l_decap_8_3380 VPWR VGND sg13cmos5l_decap_8
* cell instance sg13cmos5l_decap_8_3381 r0 *1 0,0
Xsg13cmos5l_decap_8_3381 VPWR VGND sg13cmos5l_decap_8
* cell instance sg13cmos5l_decap_8_3382 r0 *1 0,0
Xsg13cmos5l_decap_8_3382 VPWR VGND sg13cmos5l_decap_8
* cell instance sg13cmos5l_decap_8_3383 r0 *1 0,0
Xsg13cmos5l_decap_8_3383 VPWR VGND sg13cmos5l_decap_8
* cell instance sg13cmos5l_decap_8_3384 r0 *1 0,0
Xsg13cmos5l_decap_8_3384 VPWR VGND sg13cmos5l_decap_8
* cell instance sg13cmos5l_decap_8_3385 r0 *1 0,0
Xsg13cmos5l_decap_8_3385 VPWR VGND sg13cmos5l_decap_8
* cell instance sg13cmos5l_decap_8_3386 r0 *1 0,0
Xsg13cmos5l_decap_8_3386 VPWR VGND sg13cmos5l_decap_8
* cell instance sg13cmos5l_decap_8_3387 r0 *1 0,0
Xsg13cmos5l_decap_8_3387 VPWR VGND sg13cmos5l_decap_8
* cell instance sg13cmos5l_decap_8_3388 r0 *1 0,0
Xsg13cmos5l_decap_8_3388 VPWR VGND sg13cmos5l_decap_8
* cell instance sg13cmos5l_decap_8_3389 r0 *1 0,0
Xsg13cmos5l_decap_8_3389 VPWR VGND sg13cmos5l_decap_8
* cell instance sg13cmos5l_decap_8_3390 r0 *1 0,0
Xsg13cmos5l_decap_8_3390 VPWR VGND sg13cmos5l_decap_8
* cell instance sg13cmos5l_decap_8_3391 r0 *1 0,0
Xsg13cmos5l_decap_8_3391 VPWR VGND sg13cmos5l_decap_8
* cell instance sg13cmos5l_decap_8_3392 r0 *1 0,0
Xsg13cmos5l_decap_8_3392 VPWR VGND sg13cmos5l_decap_8
* cell instance sg13cmos5l_decap_8_3393 r0 *1 0,0
Xsg13cmos5l_decap_8_3393 VPWR VGND sg13cmos5l_decap_8
* cell instance sg13cmos5l_decap_8_3394 r0 *1 0,0
Xsg13cmos5l_decap_8_3394 VPWR VGND sg13cmos5l_decap_8
* cell instance sg13cmos5l_decap_8_3395 r0 *1 0,0
Xsg13cmos5l_decap_8_3395 VPWR VGND sg13cmos5l_decap_8
* cell instance sg13cmos5l_decap_8_3396 r0 *1 0,0
Xsg13cmos5l_decap_8_3396 VPWR VGND sg13cmos5l_decap_8
* cell instance sg13cmos5l_decap_8_3397 r0 *1 0,0
Xsg13cmos5l_decap_8_3397 VPWR VGND sg13cmos5l_decap_8
* cell instance sg13cmos5l_decap_8_3398 r0 *1 0,0
Xsg13cmos5l_decap_8_3398 VPWR VGND sg13cmos5l_decap_8
* cell instance sg13cmos5l_decap_8_3399 r0 *1 0,0
Xsg13cmos5l_decap_8_3399 VPWR VGND sg13cmos5l_decap_8
* cell instance sg13cmos5l_decap_8_3400 r0 *1 0,0
Xsg13cmos5l_decap_8_3400 VPWR VGND sg13cmos5l_decap_8
* cell instance sg13cmos5l_decap_8_3401 r0 *1 0,0
Xsg13cmos5l_decap_8_3401 VPWR VGND sg13cmos5l_decap_8
* cell instance sg13cmos5l_decap_8_3402 r0 *1 0,0
Xsg13cmos5l_decap_8_3402 VPWR VGND sg13cmos5l_decap_8
* cell instance sg13cmos5l_decap_8_3403 r0 *1 0,0
Xsg13cmos5l_decap_8_3403 VPWR VGND sg13cmos5l_decap_8
* cell instance sg13cmos5l_decap_8_3404 r0 *1 0,0
Xsg13cmos5l_decap_8_3404 VPWR VGND sg13cmos5l_decap_8
* cell instance sg13cmos5l_decap_8_3405 r0 *1 0,0
Xsg13cmos5l_decap_8_3405 VPWR VGND sg13cmos5l_decap_8
* cell instance sg13cmos5l_decap_8_3406 r0 *1 0,0
Xsg13cmos5l_decap_8_3406 VPWR VGND sg13cmos5l_decap_8
* cell instance sg13cmos5l_decap_8_3407 r0 *1 0,0
Xsg13cmos5l_decap_8_3407 VPWR VGND sg13cmos5l_decap_8
* cell instance sg13cmos5l_decap_8_3408 r0 *1 0,0
Xsg13cmos5l_decap_8_3408 VPWR VGND sg13cmos5l_decap_8
* cell instance sg13cmos5l_decap_8_3409 r0 *1 0,0
Xsg13cmos5l_decap_8_3409 VPWR VGND sg13cmos5l_decap_8
* cell instance sg13cmos5l_decap_8_3410 r0 *1 0,0
Xsg13cmos5l_decap_8_3410 VPWR VGND sg13cmos5l_decap_8
* cell instance sg13cmos5l_decap_8_3411 r0 *1 0,0
Xsg13cmos5l_decap_8_3411 VPWR VGND sg13cmos5l_decap_8
* cell instance sg13cmos5l_decap_8_3412 r0 *1 0,0
Xsg13cmos5l_decap_8_3412 VPWR VGND sg13cmos5l_decap_8
* cell instance sg13cmos5l_decap_8_3413 r0 *1 0,0
Xsg13cmos5l_decap_8_3413 VPWR VGND sg13cmos5l_decap_8
* cell instance sg13cmos5l_decap_8_3414 r0 *1 0,0
Xsg13cmos5l_decap_8_3414 VPWR VGND sg13cmos5l_decap_8
* cell instance sg13cmos5l_decap_8_3415 r0 *1 0,0
Xsg13cmos5l_decap_8_3415 VPWR VGND sg13cmos5l_decap_8
* cell instance sg13cmos5l_decap_8_3416 r0 *1 0,0
Xsg13cmos5l_decap_8_3416 VPWR VGND sg13cmos5l_decap_8
* cell instance sg13cmos5l_decap_8_3417 r0 *1 0,0
Xsg13cmos5l_decap_8_3417 VPWR VGND sg13cmos5l_decap_8
* cell instance sg13cmos5l_decap_8_3418 r0 *1 0,0
Xsg13cmos5l_decap_8_3418 VPWR VGND sg13cmos5l_decap_8
* cell instance sg13cmos5l_decap_8_3419 r0 *1 0,0
Xsg13cmos5l_decap_8_3419 VPWR VGND sg13cmos5l_decap_8
* cell instance sg13cmos5l_decap_8_3420 r0 *1 0,0
Xsg13cmos5l_decap_8_3420 VPWR VGND sg13cmos5l_decap_8
* cell instance sg13cmos5l_decap_8_3421 r0 *1 0,0
Xsg13cmos5l_decap_8_3421 VPWR VGND sg13cmos5l_decap_8
* cell instance sg13cmos5l_decap_8_3422 r0 *1 0,0
Xsg13cmos5l_decap_8_3422 VPWR VGND sg13cmos5l_decap_8
* cell instance sg13cmos5l_decap_8_3423 r0 *1 0,0
Xsg13cmos5l_decap_8_3423 VPWR VGND sg13cmos5l_decap_8
* cell instance sg13cmos5l_decap_8_3424 r0 *1 0,0
Xsg13cmos5l_decap_8_3424 VPWR VGND sg13cmos5l_decap_8
* cell instance sg13cmos5l_decap_8_3425 r0 *1 0,0
Xsg13cmos5l_decap_8_3425 VPWR VGND sg13cmos5l_decap_8
* cell instance sg13cmos5l_decap_8_3426 r0 *1 0,0
Xsg13cmos5l_decap_8_3426 VPWR VGND sg13cmos5l_decap_8
* cell instance sg13cmos5l_decap_8_3427 r0 *1 0,0
Xsg13cmos5l_decap_8_3427 VPWR VGND sg13cmos5l_decap_8
* cell instance sg13cmos5l_decap_8_3428 r0 *1 0,0
Xsg13cmos5l_decap_8_3428 VPWR VGND sg13cmos5l_decap_8
* cell instance sg13cmos5l_decap_8_3429 r0 *1 0,0
Xsg13cmos5l_decap_8_3429 VPWR VGND sg13cmos5l_decap_8
* cell instance sg13cmos5l_decap_8_3430 r0 *1 0,0
Xsg13cmos5l_decap_8_3430 VPWR VGND sg13cmos5l_decap_8
* cell instance sg13cmos5l_decap_8_3431 r0 *1 0,0
Xsg13cmos5l_decap_8_3431 VPWR VGND sg13cmos5l_decap_8
* cell instance sg13cmos5l_decap_8_3432 r0 *1 0,0
Xsg13cmos5l_decap_8_3432 VPWR VGND sg13cmos5l_decap_8
* cell instance sg13cmos5l_decap_8_3433 r0 *1 0,0
Xsg13cmos5l_decap_8_3433 VPWR VGND sg13cmos5l_decap_8
* cell instance sg13cmos5l_decap_8_3434 r0 *1 0,0
Xsg13cmos5l_decap_8_3434 VPWR VGND sg13cmos5l_decap_8
* cell instance sg13cmos5l_decap_8_3435 r0 *1 0,0
Xsg13cmos5l_decap_8_3435 VPWR VGND sg13cmos5l_decap_8
* cell instance sg13cmos5l_decap_8_3436 r0 *1 0,0
Xsg13cmos5l_decap_8_3436 VPWR VGND sg13cmos5l_decap_8
* cell instance sg13cmos5l_decap_8_3437 r0 *1 0,0
Xsg13cmos5l_decap_8_3437 VPWR VGND sg13cmos5l_decap_8
* cell instance sg13cmos5l_decap_8_3438 r0 *1 0,0
Xsg13cmos5l_decap_8_3438 VPWR VGND sg13cmos5l_decap_8
* cell instance sg13cmos5l_decap_8_3439 r0 *1 0,0
Xsg13cmos5l_decap_8_3439 VPWR VGND sg13cmos5l_decap_8
* cell instance sg13cmos5l_decap_8_3440 r0 *1 0,0
Xsg13cmos5l_decap_8_3440 VPWR VGND sg13cmos5l_decap_8
* cell instance sg13cmos5l_decap_8_3441 r0 *1 0,0
Xsg13cmos5l_decap_8_3441 VPWR VGND sg13cmos5l_decap_8
* cell instance sg13cmos5l_decap_8_3442 r0 *1 0,0
Xsg13cmos5l_decap_8_3442 VPWR VGND sg13cmos5l_decap_8
* cell instance sg13cmos5l_decap_8_3443 r0 *1 0,0
Xsg13cmos5l_decap_8_3443 VPWR VGND sg13cmos5l_decap_8
* cell instance sg13cmos5l_decap_8_3444 r0 *1 0,0
Xsg13cmos5l_decap_8_3444 VPWR VGND sg13cmos5l_decap_8
* cell instance sg13cmos5l_decap_8_3445 r0 *1 0,0
Xsg13cmos5l_decap_8_3445 VPWR VGND sg13cmos5l_decap_8
* cell instance sg13cmos5l_decap_8_3446 r0 *1 0,0
Xsg13cmos5l_decap_8_3446 VPWR VGND sg13cmos5l_decap_8
* cell instance sg13cmos5l_decap_8_3447 r0 *1 0,0
Xsg13cmos5l_decap_8_3447 VPWR VGND sg13cmos5l_decap_8
* cell instance sg13cmos5l_decap_8_3448 r0 *1 0,0
Xsg13cmos5l_decap_8_3448 VPWR VGND sg13cmos5l_decap_8
* cell instance sg13cmos5l_decap_8_3449 r0 *1 0,0
Xsg13cmos5l_decap_8_3449 VPWR VGND sg13cmos5l_decap_8
* cell instance sg13cmos5l_decap_8_3450 r0 *1 0,0
Xsg13cmos5l_decap_8_3450 VPWR VGND sg13cmos5l_decap_8
* cell instance sg13cmos5l_decap_8_3451 r0 *1 0,0
Xsg13cmos5l_decap_8_3451 VPWR VGND sg13cmos5l_decap_8
* cell instance sg13cmos5l_decap_8_3452 r0 *1 0,0
Xsg13cmos5l_decap_8_3452 VPWR VGND sg13cmos5l_decap_8
* cell instance sg13cmos5l_decap_8_3453 r0 *1 0,0
Xsg13cmos5l_decap_8_3453 VPWR VGND sg13cmos5l_decap_8
* cell instance sg13cmos5l_decap_8_3454 r0 *1 0,0
Xsg13cmos5l_decap_8_3454 VPWR VGND sg13cmos5l_decap_8
* cell instance sg13cmos5l_decap_8_3455 r0 *1 0,0
Xsg13cmos5l_decap_8_3455 VPWR VGND sg13cmos5l_decap_8
* cell instance sg13cmos5l_decap_8_3456 r0 *1 0,0
Xsg13cmos5l_decap_8_3456 VPWR VGND sg13cmos5l_decap_8
* cell instance sg13cmos5l_decap_8_3457 r0 *1 0,0
Xsg13cmos5l_decap_8_3457 VPWR VGND sg13cmos5l_decap_8
* cell instance sg13cmos5l_decap_8_3458 r0 *1 0,0
Xsg13cmos5l_decap_8_3458 VPWR VGND sg13cmos5l_decap_8
* cell instance sg13cmos5l_decap_8_3459 r0 *1 0,0
Xsg13cmos5l_decap_8_3459 VPWR VGND sg13cmos5l_decap_8
* cell instance sg13cmos5l_decap_8_3460 r0 *1 0,0
Xsg13cmos5l_decap_8_3460 VPWR VGND sg13cmos5l_decap_8
* cell instance sg13cmos5l_decap_8_3461 r0 *1 0,0
Xsg13cmos5l_decap_8_3461 VPWR VGND sg13cmos5l_decap_8
* cell instance sg13cmos5l_decap_8_3462 r0 *1 0,0
Xsg13cmos5l_decap_8_3462 VPWR VGND sg13cmos5l_decap_8
* cell instance sg13cmos5l_decap_8_3463 r0 *1 0,0
Xsg13cmos5l_decap_8_3463 VPWR VGND sg13cmos5l_decap_8
* cell instance sg13cmos5l_decap_8_3464 r0 *1 0,0
Xsg13cmos5l_decap_8_3464 VPWR VGND sg13cmos5l_decap_8
* cell instance sg13cmos5l_decap_8_3465 r0 *1 0,0
Xsg13cmos5l_decap_8_3465 VPWR VGND sg13cmos5l_decap_8
* cell instance sg13cmos5l_decap_8_3466 r0 *1 0,0
Xsg13cmos5l_decap_8_3466 VPWR VGND sg13cmos5l_decap_8
* cell instance sg13cmos5l_decap_8_3467 r0 *1 0,0
Xsg13cmos5l_decap_8_3467 VPWR VGND sg13cmos5l_decap_8
* cell instance sg13cmos5l_decap_8_3468 r0 *1 0,0
Xsg13cmos5l_decap_8_3468 VPWR VGND sg13cmos5l_decap_8
* cell instance sg13cmos5l_decap_8_3469 r0 *1 0,0
Xsg13cmos5l_decap_8_3469 VPWR VGND sg13cmos5l_decap_8
* cell instance sg13cmos5l_decap_8_3470 r0 *1 0,0
Xsg13cmos5l_decap_8_3470 VPWR VGND sg13cmos5l_decap_8
* cell instance sg13cmos5l_decap_8_3471 r0 *1 0,0
Xsg13cmos5l_decap_8_3471 VPWR VGND sg13cmos5l_decap_8
* cell instance sg13cmos5l_decap_8_3472 r0 *1 0,0
Xsg13cmos5l_decap_8_3472 VPWR VGND sg13cmos5l_decap_8
* cell instance sg13cmos5l_decap_8_3473 r0 *1 0,0
Xsg13cmos5l_decap_8_3473 VPWR VGND sg13cmos5l_decap_8
* cell instance sg13cmos5l_decap_8_3474 r0 *1 0,0
Xsg13cmos5l_decap_8_3474 VPWR VGND sg13cmos5l_decap_8
* cell instance sg13cmos5l_decap_8_3475 r0 *1 0,0
Xsg13cmos5l_decap_8_3475 VPWR VGND sg13cmos5l_decap_8
* cell instance sg13cmos5l_decap_8_3476 r0 *1 0,0
Xsg13cmos5l_decap_8_3476 VPWR VGND sg13cmos5l_decap_8
* cell instance sg13cmos5l_decap_8_3477 r0 *1 0,0
Xsg13cmos5l_decap_8_3477 VPWR VGND sg13cmos5l_decap_8
* cell instance sg13cmos5l_decap_8_3478 r0 *1 0,0
Xsg13cmos5l_decap_8_3478 VPWR VGND sg13cmos5l_decap_8
* cell instance sg13cmos5l_decap_8_3479 r0 *1 0,0
Xsg13cmos5l_decap_8_3479 VPWR VGND sg13cmos5l_decap_8
* cell instance sg13cmos5l_decap_8_3480 r0 *1 0,0
Xsg13cmos5l_decap_8_3480 VPWR VGND sg13cmos5l_decap_8
* cell instance sg13cmos5l_decap_8_3481 r0 *1 0,0
Xsg13cmos5l_decap_8_3481 VPWR VGND sg13cmos5l_decap_8
* cell instance sg13cmos5l_decap_8_3482 r0 *1 0,0
Xsg13cmos5l_decap_8_3482 VPWR VGND sg13cmos5l_decap_8
* cell instance sg13cmos5l_decap_8_3483 r0 *1 0,0
Xsg13cmos5l_decap_8_3483 VPWR VGND sg13cmos5l_decap_8
* cell instance sg13cmos5l_decap_8_3484 r0 *1 0,0
Xsg13cmos5l_decap_8_3484 VPWR VGND sg13cmos5l_decap_8
* cell instance sg13cmos5l_decap_8_3485 r0 *1 0,0
Xsg13cmos5l_decap_8_3485 VPWR VGND sg13cmos5l_decap_8
* cell instance sg13cmos5l_decap_8_3486 r0 *1 0,0
Xsg13cmos5l_decap_8_3486 VPWR VGND sg13cmos5l_decap_8
* cell instance sg13cmos5l_decap_8_3487 r0 *1 0,0
Xsg13cmos5l_decap_8_3487 VPWR VGND sg13cmos5l_decap_8
* cell instance sg13cmos5l_decap_8_3488 r0 *1 0,0
Xsg13cmos5l_decap_8_3488 VPWR VGND sg13cmos5l_decap_8
* cell instance sg13cmos5l_decap_8_3489 r0 *1 0,0
Xsg13cmos5l_decap_8_3489 VPWR VGND sg13cmos5l_decap_8
* cell instance sg13cmos5l_decap_8_3490 r0 *1 0,0
Xsg13cmos5l_decap_8_3490 VPWR VGND sg13cmos5l_decap_8
* cell instance sg13cmos5l_decap_8_3491 r0 *1 0,0
Xsg13cmos5l_decap_8_3491 VPWR VGND sg13cmos5l_decap_8
* cell instance sg13cmos5l_decap_8_3492 r0 *1 0,0
Xsg13cmos5l_decap_8_3492 VPWR VGND sg13cmos5l_decap_8
* cell instance sg13cmos5l_decap_8_3493 r0 *1 0,0
Xsg13cmos5l_decap_8_3493 VPWR VGND sg13cmos5l_decap_8
* cell instance sg13cmos5l_decap_8_3494 r0 *1 0,0
Xsg13cmos5l_decap_8_3494 VPWR VGND sg13cmos5l_decap_8
* cell instance sg13cmos5l_decap_8_3495 r0 *1 0,0
Xsg13cmos5l_decap_8_3495 VPWR VGND sg13cmos5l_decap_8
* cell instance sg13cmos5l_decap_8_3496 r0 *1 0,0
Xsg13cmos5l_decap_8_3496 VPWR VGND sg13cmos5l_decap_8
* cell instance sg13cmos5l_decap_8_3497 r0 *1 0,0
Xsg13cmos5l_decap_8_3497 VPWR VGND sg13cmos5l_decap_8
* cell instance sg13cmos5l_decap_8_3498 r0 *1 0,0
Xsg13cmos5l_decap_8_3498 VPWR VGND sg13cmos5l_decap_8
* cell instance sg13cmos5l_decap_8_3499 r0 *1 0,0
Xsg13cmos5l_decap_8_3499 VPWR VGND sg13cmos5l_decap_8
* cell instance sg13cmos5l_decap_8_3500 r0 *1 0,0
Xsg13cmos5l_decap_8_3500 VPWR VGND sg13cmos5l_decap_8
* cell instance sg13cmos5l_decap_8_3501 r0 *1 0,0
Xsg13cmos5l_decap_8_3501 VPWR VGND sg13cmos5l_decap_8
* cell instance sg13cmos5l_decap_8_3502 r0 *1 0,0
Xsg13cmos5l_decap_8_3502 VPWR VGND sg13cmos5l_decap_8
* cell instance sg13cmos5l_decap_8_3503 r0 *1 0,0
Xsg13cmos5l_decap_8_3503 VPWR VGND sg13cmos5l_decap_8
* cell instance sg13cmos5l_decap_8_3504 r0 *1 0,0
Xsg13cmos5l_decap_8_3504 VPWR VGND sg13cmos5l_decap_8
* cell instance sg13cmos5l_decap_8_3505 r0 *1 0,0
Xsg13cmos5l_decap_8_3505 VPWR VGND sg13cmos5l_decap_8
* cell instance sg13cmos5l_decap_8_3506 r0 *1 0,0
Xsg13cmos5l_decap_8_3506 VPWR VGND sg13cmos5l_decap_8
* cell instance sg13cmos5l_decap_8_3507 r0 *1 0,0
Xsg13cmos5l_decap_8_3507 VPWR VGND sg13cmos5l_decap_8
* cell instance sg13cmos5l_decap_8_3508 r0 *1 0,0
Xsg13cmos5l_decap_8_3508 VPWR VGND sg13cmos5l_decap_8
* cell instance sg13cmos5l_decap_8_3509 r0 *1 0,0
Xsg13cmos5l_decap_8_3509 VPWR VGND sg13cmos5l_decap_8
* cell instance sg13cmos5l_decap_8_3510 r0 *1 0,0
Xsg13cmos5l_decap_8_3510 VPWR VGND sg13cmos5l_decap_8
* cell instance sg13cmos5l_decap_8_3511 r0 *1 0,0
Xsg13cmos5l_decap_8_3511 VPWR VGND sg13cmos5l_decap_8
* cell instance sg13cmos5l_decap_8_3512 r0 *1 0,0
Xsg13cmos5l_decap_8_3512 VPWR VGND sg13cmos5l_decap_8
* cell instance sg13cmos5l_decap_8_3513 r0 *1 0,0
Xsg13cmos5l_decap_8_3513 VPWR VGND sg13cmos5l_decap_8
* cell instance sg13cmos5l_decap_8_3514 r0 *1 0,0
Xsg13cmos5l_decap_8_3514 VPWR VGND sg13cmos5l_decap_8
* cell instance sg13cmos5l_decap_8_3515 r0 *1 0,0
Xsg13cmos5l_decap_8_3515 VPWR VGND sg13cmos5l_decap_8
* cell instance sg13cmos5l_decap_8_3516 r0 *1 0,0
Xsg13cmos5l_decap_8_3516 VPWR VGND sg13cmos5l_decap_8
* cell instance sg13cmos5l_decap_8_3517 r0 *1 0,0
Xsg13cmos5l_decap_8_3517 VPWR VGND sg13cmos5l_decap_8
* cell instance sg13cmos5l_decap_8_3518 r0 *1 0,0
Xsg13cmos5l_decap_8_3518 VPWR VGND sg13cmos5l_decap_8
* cell instance sg13cmos5l_decap_8_3519 r0 *1 0,0
Xsg13cmos5l_decap_8_3519 VPWR VGND sg13cmos5l_decap_8
* cell instance sg13cmos5l_decap_8_3520 r0 *1 0,0
Xsg13cmos5l_decap_8_3520 VPWR VGND sg13cmos5l_decap_8
* cell instance sg13cmos5l_decap_8_3521 r0 *1 0,0
Xsg13cmos5l_decap_8_3521 VPWR VGND sg13cmos5l_decap_8
* cell instance sg13cmos5l_decap_8_3522 r0 *1 0,0
Xsg13cmos5l_decap_8_3522 VPWR VGND sg13cmos5l_decap_8
* cell instance sg13cmos5l_decap_8_3523 r0 *1 0,0
Xsg13cmos5l_decap_8_3523 VPWR VGND sg13cmos5l_decap_8
* cell instance sg13cmos5l_decap_8_3524 r0 *1 0,0
Xsg13cmos5l_decap_8_3524 VPWR VGND sg13cmos5l_decap_8
* cell instance sg13cmos5l_decap_8_3525 r0 *1 0,0
Xsg13cmos5l_decap_8_3525 VPWR VGND sg13cmos5l_decap_8
* cell instance sg13cmos5l_decap_8_3526 r0 *1 0,0
Xsg13cmos5l_decap_8_3526 VPWR VGND sg13cmos5l_decap_8
* cell instance sg13cmos5l_decap_8_3527 r0 *1 0,0
Xsg13cmos5l_decap_8_3527 VPWR VGND sg13cmos5l_decap_8
* cell instance sg13cmos5l_decap_8_3528 r0 *1 0,0
Xsg13cmos5l_decap_8_3528 VPWR VGND sg13cmos5l_decap_8
* cell instance sg13cmos5l_decap_8_3529 r0 *1 0,0
Xsg13cmos5l_decap_8_3529 VPWR VGND sg13cmos5l_decap_8
* cell instance sg13cmos5l_decap_8_3530 r0 *1 0,0
Xsg13cmos5l_decap_8_3530 VPWR VGND sg13cmos5l_decap_8
* cell instance sg13cmos5l_decap_8_3531 r0 *1 0,0
Xsg13cmos5l_decap_8_3531 VPWR VGND sg13cmos5l_decap_8
* cell instance sg13cmos5l_decap_8_3532 r0 *1 0,0
Xsg13cmos5l_decap_8_3532 VPWR VGND sg13cmos5l_decap_8
* cell instance sg13cmos5l_decap_8_3533 r0 *1 0,0
Xsg13cmos5l_decap_8_3533 VPWR VGND sg13cmos5l_decap_8
* cell instance sg13cmos5l_decap_8_3534 r0 *1 0,0
Xsg13cmos5l_decap_8_3534 VPWR VGND sg13cmos5l_decap_8
* cell instance sg13cmos5l_decap_8_3535 r0 *1 0,0
Xsg13cmos5l_decap_8_3535 VPWR VGND sg13cmos5l_decap_8
* cell instance sg13cmos5l_decap_8_3536 r0 *1 0,0
Xsg13cmos5l_decap_8_3536 VPWR VGND sg13cmos5l_decap_8
* cell instance sg13cmos5l_decap_8_3537 r0 *1 0,0
Xsg13cmos5l_decap_8_3537 VPWR VGND sg13cmos5l_decap_8
* cell instance sg13cmos5l_decap_8_3538 r0 *1 0,0
Xsg13cmos5l_decap_8_3538 VPWR VGND sg13cmos5l_decap_8
* cell instance sg13cmos5l_decap_8_3539 r0 *1 0,0
Xsg13cmos5l_decap_8_3539 VPWR VGND sg13cmos5l_decap_8
* cell instance sg13cmos5l_decap_8_3540 r0 *1 0,0
Xsg13cmos5l_decap_8_3540 VPWR VGND sg13cmos5l_decap_8
* cell instance sg13cmos5l_decap_8_3541 r0 *1 0,0
Xsg13cmos5l_decap_8_3541 VPWR VGND sg13cmos5l_decap_8
* cell instance sg13cmos5l_decap_8_3542 r0 *1 0,0
Xsg13cmos5l_decap_8_3542 VPWR VGND sg13cmos5l_decap_8
* cell instance sg13cmos5l_decap_8_3543 r0 *1 0,0
Xsg13cmos5l_decap_8_3543 VPWR VGND sg13cmos5l_decap_8
* cell instance sg13cmos5l_decap_8_3544 r0 *1 0,0
Xsg13cmos5l_decap_8_3544 VPWR VGND sg13cmos5l_decap_8
* cell instance sg13cmos5l_decap_8_3545 r0 *1 0,0
Xsg13cmos5l_decap_8_3545 VPWR VGND sg13cmos5l_decap_8
* cell instance sg13cmos5l_decap_8_3546 r0 *1 0,0
Xsg13cmos5l_decap_8_3546 VPWR VGND sg13cmos5l_decap_8
* cell instance sg13cmos5l_decap_8_3547 r0 *1 0,0
Xsg13cmos5l_decap_8_3547 VPWR VGND sg13cmos5l_decap_8
* cell instance sg13cmos5l_decap_8_3548 r0 *1 0,0
Xsg13cmos5l_decap_8_3548 VPWR VGND sg13cmos5l_decap_8
* cell instance sg13cmos5l_decap_8_3549 r0 *1 0,0
Xsg13cmos5l_decap_8_3549 VPWR VGND sg13cmos5l_decap_8
* cell instance sg13cmos5l_decap_8_3550 r0 *1 0,0
Xsg13cmos5l_decap_8_3550 VPWR VGND sg13cmos5l_decap_8
* cell instance sg13cmos5l_decap_8_3551 r0 *1 0,0
Xsg13cmos5l_decap_8_3551 VPWR VGND sg13cmos5l_decap_8
* cell instance sg13cmos5l_decap_8_3552 r0 *1 0,0
Xsg13cmos5l_decap_8_3552 VPWR VGND sg13cmos5l_decap_8
* cell instance sg13cmos5l_decap_8_3553 r0 *1 0,0
Xsg13cmos5l_decap_8_3553 VPWR VGND sg13cmos5l_decap_8
* cell instance sg13cmos5l_decap_8_3554 r0 *1 0,0
Xsg13cmos5l_decap_8_3554 VPWR VGND sg13cmos5l_decap_8
* cell instance sg13cmos5l_decap_8_3555 r0 *1 0,0
Xsg13cmos5l_decap_8_3555 VPWR VGND sg13cmos5l_decap_8
* cell instance sg13cmos5l_decap_8_3556 r0 *1 0,0
Xsg13cmos5l_decap_8_3556 VPWR VGND sg13cmos5l_decap_8
* cell instance sg13cmos5l_decap_8_3557 r0 *1 0,0
Xsg13cmos5l_decap_8_3557 VPWR VGND sg13cmos5l_decap_8
* cell instance sg13cmos5l_decap_8_3558 r0 *1 0,0
Xsg13cmos5l_decap_8_3558 VPWR VGND sg13cmos5l_decap_8
* cell instance sg13cmos5l_decap_8_3559 r0 *1 0,0
Xsg13cmos5l_decap_8_3559 VPWR VGND sg13cmos5l_decap_8
* cell instance sg13cmos5l_decap_8_3560 r0 *1 0,0
Xsg13cmos5l_decap_8_3560 VPWR VGND sg13cmos5l_decap_8
* cell instance sg13cmos5l_decap_8_3561 r0 *1 0,0
Xsg13cmos5l_decap_8_3561 VPWR VGND sg13cmos5l_decap_8
* cell instance sg13cmos5l_decap_8_3562 r0 *1 0,0
Xsg13cmos5l_decap_8_3562 VPWR VGND sg13cmos5l_decap_8
* cell instance sg13cmos5l_decap_8_3563 r0 *1 0,0
Xsg13cmos5l_decap_8_3563 VPWR VGND sg13cmos5l_decap_8
* cell instance sg13cmos5l_decap_8_3564 r0 *1 0,0
Xsg13cmos5l_decap_8_3564 VPWR VGND sg13cmos5l_decap_8
* cell instance sg13cmos5l_decap_8_3565 r0 *1 0,0
Xsg13cmos5l_decap_8_3565 VPWR VGND sg13cmos5l_decap_8
* cell instance sg13cmos5l_decap_8_3566 r0 *1 0,0
Xsg13cmos5l_decap_8_3566 VPWR VGND sg13cmos5l_decap_8
* cell instance sg13cmos5l_decap_8_3567 r0 *1 0,0
Xsg13cmos5l_decap_8_3567 VPWR VGND sg13cmos5l_decap_8
* cell instance sg13cmos5l_decap_8_3568 r0 *1 0,0
Xsg13cmos5l_decap_8_3568 VPWR VGND sg13cmos5l_decap_8
* cell instance sg13cmos5l_decap_8_3569 r0 *1 0,0
Xsg13cmos5l_decap_8_3569 VPWR VGND sg13cmos5l_decap_8
* cell instance sg13cmos5l_decap_8_3570 r0 *1 0,0
Xsg13cmos5l_decap_8_3570 VPWR VGND sg13cmos5l_decap_8
* cell instance sg13cmos5l_decap_8_3571 r0 *1 0,0
Xsg13cmos5l_decap_8_3571 VPWR VGND sg13cmos5l_decap_8
* cell instance sg13cmos5l_decap_8_3572 r0 *1 0,0
Xsg13cmos5l_decap_8_3572 VPWR VGND sg13cmos5l_decap_8
* cell instance sg13cmos5l_decap_8_3573 r0 *1 0,0
Xsg13cmos5l_decap_8_3573 VPWR VGND sg13cmos5l_decap_8
* cell instance sg13cmos5l_decap_8_3574 r0 *1 0,0
Xsg13cmos5l_decap_8_3574 VPWR VGND sg13cmos5l_decap_8
* cell instance sg13cmos5l_decap_8_3575 r0 *1 0,0
Xsg13cmos5l_decap_8_3575 VPWR VGND sg13cmos5l_decap_8
* cell instance sg13cmos5l_decap_8_3576 r0 *1 0,0
Xsg13cmos5l_decap_8_3576 VPWR VGND sg13cmos5l_decap_8
* cell instance sg13cmos5l_decap_8_3577 r0 *1 0,0
Xsg13cmos5l_decap_8_3577 VPWR VGND sg13cmos5l_decap_8
* cell instance sg13cmos5l_decap_8_3578 r0 *1 0,0
Xsg13cmos5l_decap_8_3578 VPWR VGND sg13cmos5l_decap_8
* cell instance sg13cmos5l_decap_8_3579 r0 *1 0,0
Xsg13cmos5l_decap_8_3579 VPWR VGND sg13cmos5l_decap_8
* cell instance sg13cmos5l_decap_8_3580 r0 *1 0,0
Xsg13cmos5l_decap_8_3580 VPWR VGND sg13cmos5l_decap_8
* cell instance sg13cmos5l_decap_8_3581 r0 *1 0,0
Xsg13cmos5l_decap_8_3581 VPWR VGND sg13cmos5l_decap_8
* cell instance sg13cmos5l_decap_8_3582 r0 *1 0,0
Xsg13cmos5l_decap_8_3582 VPWR VGND sg13cmos5l_decap_8
* cell instance sg13cmos5l_decap_8_3583 r0 *1 0,0
Xsg13cmos5l_decap_8_3583 VPWR VGND sg13cmos5l_decap_8
* cell instance sg13cmos5l_decap_8_3584 r0 *1 0,0
Xsg13cmos5l_decap_8_3584 VPWR VGND sg13cmos5l_decap_8
* cell instance sg13cmos5l_decap_8_3585 r0 *1 0,0
Xsg13cmos5l_decap_8_3585 VPWR VGND sg13cmos5l_decap_8
* cell instance sg13cmos5l_decap_8_3586 r0 *1 0,0
Xsg13cmos5l_decap_8_3586 VPWR VGND sg13cmos5l_decap_8
* cell instance sg13cmos5l_decap_8_3587 r0 *1 0,0
Xsg13cmos5l_decap_8_3587 VPWR VGND sg13cmos5l_decap_8
* cell instance sg13cmos5l_decap_8_3588 r0 *1 0,0
Xsg13cmos5l_decap_8_3588 VPWR VGND sg13cmos5l_decap_8
* cell instance sg13cmos5l_decap_8_3589 r0 *1 0,0
Xsg13cmos5l_decap_8_3589 VPWR VGND sg13cmos5l_decap_8
* cell instance sg13cmos5l_decap_8_3590 r0 *1 0,0
Xsg13cmos5l_decap_8_3590 VPWR VGND sg13cmos5l_decap_8
* cell instance sg13cmos5l_decap_8_3591 r0 *1 0,0
Xsg13cmos5l_decap_8_3591 VPWR VGND sg13cmos5l_decap_8
* cell instance sg13cmos5l_decap_8_3592 r0 *1 0,0
Xsg13cmos5l_decap_8_3592 VPWR VGND sg13cmos5l_decap_8
* cell instance sg13cmos5l_decap_8_3593 r0 *1 0,0
Xsg13cmos5l_decap_8_3593 VPWR VGND sg13cmos5l_decap_8
* cell instance sg13cmos5l_decap_8_3594 r0 *1 0,0
Xsg13cmos5l_decap_8_3594 VPWR VGND sg13cmos5l_decap_8
* cell instance sg13cmos5l_decap_8_3595 r0 *1 0,0
Xsg13cmos5l_decap_8_3595 VPWR VGND sg13cmos5l_decap_8
* cell instance sg13cmos5l_decap_8_3596 r0 *1 0,0
Xsg13cmos5l_decap_8_3596 VPWR VGND sg13cmos5l_decap_8
* cell instance sg13cmos5l_decap_8_3597 r0 *1 0,0
Xsg13cmos5l_decap_8_3597 VPWR VGND sg13cmos5l_decap_8
* cell instance sg13cmos5l_decap_8_3598 r0 *1 0,0
Xsg13cmos5l_decap_8_3598 VPWR VGND sg13cmos5l_decap_8
* cell instance sg13cmos5l_decap_8_3599 r0 *1 0,0
Xsg13cmos5l_decap_8_3599 VPWR VGND sg13cmos5l_decap_8
* cell instance sg13cmos5l_decap_8_3600 r0 *1 0,0
Xsg13cmos5l_decap_8_3600 VPWR VGND sg13cmos5l_decap_8
* cell instance sg13cmos5l_decap_8_3601 r0 *1 0,0
Xsg13cmos5l_decap_8_3601 VPWR VGND sg13cmos5l_decap_8
* cell instance sg13cmos5l_decap_8_3602 r0 *1 0,0
Xsg13cmos5l_decap_8_3602 VPWR VGND sg13cmos5l_decap_8
* cell instance sg13cmos5l_decap_8_3603 r0 *1 0,0
Xsg13cmos5l_decap_8_3603 VPWR VGND sg13cmos5l_decap_8
* cell instance sg13cmos5l_decap_8_3604 r0 *1 0,0
Xsg13cmos5l_decap_8_3604 VPWR VGND sg13cmos5l_decap_8
* cell instance sg13cmos5l_decap_8_3605 r0 *1 0,0
Xsg13cmos5l_decap_8_3605 VPWR VGND sg13cmos5l_decap_8
* cell instance sg13cmos5l_decap_8_3606 r0 *1 0,0
Xsg13cmos5l_decap_8_3606 VPWR VGND sg13cmos5l_decap_8
* cell instance sg13cmos5l_decap_8_3607 r0 *1 0,0
Xsg13cmos5l_decap_8_3607 VPWR VGND sg13cmos5l_decap_8
* cell instance sg13cmos5l_decap_8_3608 r0 *1 0,0
Xsg13cmos5l_decap_8_3608 VPWR VGND sg13cmos5l_decap_8
* cell instance sg13cmos5l_decap_8_3609 r0 *1 0,0
Xsg13cmos5l_decap_8_3609 VPWR VGND sg13cmos5l_decap_8
* cell instance sg13cmos5l_decap_8_3610 r0 *1 0,0
Xsg13cmos5l_decap_8_3610 VPWR VGND sg13cmos5l_decap_8
* cell instance sg13cmos5l_decap_8_3611 r0 *1 0,0
Xsg13cmos5l_decap_8_3611 VPWR VGND sg13cmos5l_decap_8
* cell instance sg13cmos5l_decap_8_3612 r0 *1 0,0
Xsg13cmos5l_decap_8_3612 VPWR VGND sg13cmos5l_decap_8
* cell instance sg13cmos5l_decap_8_3613 r0 *1 0,0
Xsg13cmos5l_decap_8_3613 VPWR VGND sg13cmos5l_decap_8
* cell instance sg13cmos5l_decap_8_3614 r0 *1 0,0
Xsg13cmos5l_decap_8_3614 VPWR VGND sg13cmos5l_decap_8
* cell instance sg13cmos5l_decap_8_3615 r0 *1 0,0
Xsg13cmos5l_decap_8_3615 VPWR VGND sg13cmos5l_decap_8
* cell instance sg13cmos5l_decap_8_3616 r0 *1 0,0
Xsg13cmos5l_decap_8_3616 VPWR VGND sg13cmos5l_decap_8
* cell instance sg13cmos5l_decap_8_3617 r0 *1 0,0
Xsg13cmos5l_decap_8_3617 VPWR VGND sg13cmos5l_decap_8
* cell instance sg13cmos5l_decap_8_3618 r0 *1 0,0
Xsg13cmos5l_decap_8_3618 VPWR VGND sg13cmos5l_decap_8
* cell instance sg13cmos5l_decap_8_3619 r0 *1 0,0
Xsg13cmos5l_decap_8_3619 VPWR VGND sg13cmos5l_decap_8
* cell instance sg13cmos5l_decap_8_3620 r0 *1 0,0
Xsg13cmos5l_decap_8_3620 VPWR VGND sg13cmos5l_decap_8
* cell instance sg13cmos5l_decap_8_3621 r0 *1 0,0
Xsg13cmos5l_decap_8_3621 VPWR VGND sg13cmos5l_decap_8
* cell instance sg13cmos5l_decap_8_3622 r0 *1 0,0
Xsg13cmos5l_decap_8_3622 VPWR VGND sg13cmos5l_decap_8
* cell instance sg13cmos5l_decap_8_3623 r0 *1 0,0
Xsg13cmos5l_decap_8_3623 VPWR VGND sg13cmos5l_decap_8
* cell instance sg13cmos5l_decap_8_3624 r0 *1 0,0
Xsg13cmos5l_decap_8_3624 VPWR VGND sg13cmos5l_decap_8
* cell instance sg13cmos5l_decap_8_3625 r0 *1 0,0
Xsg13cmos5l_decap_8_3625 VPWR VGND sg13cmos5l_decap_8
* cell instance sg13cmos5l_decap_8_3626 r0 *1 0,0
Xsg13cmos5l_decap_8_3626 VPWR VGND sg13cmos5l_decap_8
* cell instance sg13cmos5l_decap_8_3627 r0 *1 0,0
Xsg13cmos5l_decap_8_3627 VPWR VGND sg13cmos5l_decap_8
* cell instance sg13cmos5l_decap_8_3628 r0 *1 0,0
Xsg13cmos5l_decap_8_3628 VPWR VGND sg13cmos5l_decap_8
* cell instance sg13cmos5l_decap_8_3629 r0 *1 0,0
Xsg13cmos5l_decap_8_3629 VPWR VGND sg13cmos5l_decap_8
* cell instance sg13cmos5l_decap_8_3630 r0 *1 0,0
Xsg13cmos5l_decap_8_3630 VPWR VGND sg13cmos5l_decap_8
* cell instance sg13cmos5l_decap_8_3631 r0 *1 0,0
Xsg13cmos5l_decap_8_3631 VPWR VGND sg13cmos5l_decap_8
* cell instance sg13cmos5l_decap_8_3632 r0 *1 0,0
Xsg13cmos5l_decap_8_3632 VPWR VGND sg13cmos5l_decap_8
* cell instance sg13cmos5l_decap_8_3633 r0 *1 0,0
Xsg13cmos5l_decap_8_3633 VPWR VGND sg13cmos5l_decap_8
* cell instance sg13cmos5l_decap_8_3634 r0 *1 0,0
Xsg13cmos5l_decap_8_3634 VPWR VGND sg13cmos5l_decap_8
* cell instance sg13cmos5l_decap_8_3635 r0 *1 0,0
Xsg13cmos5l_decap_8_3635 VPWR VGND sg13cmos5l_decap_8
* cell instance sg13cmos5l_decap_8_3636 r0 *1 0,0
Xsg13cmos5l_decap_8_3636 VPWR VGND sg13cmos5l_decap_8
* cell instance sg13cmos5l_decap_8_3637 r0 *1 0,0
Xsg13cmos5l_decap_8_3637 VPWR VGND sg13cmos5l_decap_8
* cell instance sg13cmos5l_decap_8_3638 r0 *1 0,0
Xsg13cmos5l_decap_8_3638 VPWR VGND sg13cmos5l_decap_8
* cell instance sg13cmos5l_decap_8_3639 r0 *1 0,0
Xsg13cmos5l_decap_8_3639 VPWR VGND sg13cmos5l_decap_8
* cell instance sg13cmos5l_decap_8_3640 r0 *1 0,0
Xsg13cmos5l_decap_8_3640 VPWR VGND sg13cmos5l_decap_8
* cell instance sg13cmos5l_decap_8_3641 r0 *1 0,0
Xsg13cmos5l_decap_8_3641 VPWR VGND sg13cmos5l_decap_8
* cell instance sg13cmos5l_decap_8_3642 r0 *1 0,0
Xsg13cmos5l_decap_8_3642 VPWR VGND sg13cmos5l_decap_8
* cell instance sg13cmos5l_decap_8_3643 r0 *1 0,0
Xsg13cmos5l_decap_8_3643 VPWR VGND sg13cmos5l_decap_8
* cell instance sg13cmos5l_decap_8_3644 r0 *1 0,0
Xsg13cmos5l_decap_8_3644 VPWR VGND sg13cmos5l_decap_8
* cell instance sg13cmos5l_decap_8_3645 r0 *1 0,0
Xsg13cmos5l_decap_8_3645 VPWR VGND sg13cmos5l_decap_8
* cell instance sg13cmos5l_decap_8_3646 r0 *1 0,0
Xsg13cmos5l_decap_8_3646 VPWR VGND sg13cmos5l_decap_8
* cell instance sg13cmos5l_decap_8_3647 r0 *1 0,0
Xsg13cmos5l_decap_8_3647 VPWR VGND sg13cmos5l_decap_8
* cell instance sg13cmos5l_decap_8_3648 r0 *1 0,0
Xsg13cmos5l_decap_8_3648 VPWR VGND sg13cmos5l_decap_8
* cell instance sg13cmos5l_decap_8_3649 r0 *1 0,0
Xsg13cmos5l_decap_8_3649 VPWR VGND sg13cmos5l_decap_8
* cell instance sg13cmos5l_decap_8_3650 r0 *1 0,0
Xsg13cmos5l_decap_8_3650 VPWR VGND sg13cmos5l_decap_8
* cell instance sg13cmos5l_decap_8_3651 r0 *1 0,0
Xsg13cmos5l_decap_8_3651 VPWR VGND sg13cmos5l_decap_8
* cell instance sg13cmos5l_decap_8_3652 r0 *1 0,0
Xsg13cmos5l_decap_8_3652 VPWR VGND sg13cmos5l_decap_8
* cell instance sg13cmos5l_decap_8_3653 r0 *1 0,0
Xsg13cmos5l_decap_8_3653 VPWR VGND sg13cmos5l_decap_8
* cell instance sg13cmos5l_decap_8_3654 r0 *1 0,0
Xsg13cmos5l_decap_8_3654 VPWR VGND sg13cmos5l_decap_8
* cell instance sg13cmos5l_decap_8_3655 r0 *1 0,0
Xsg13cmos5l_decap_8_3655 VPWR VGND sg13cmos5l_decap_8
* cell instance sg13cmos5l_decap_8_3656 r0 *1 0,0
Xsg13cmos5l_decap_8_3656 VPWR VGND sg13cmos5l_decap_8
* cell instance sg13cmos5l_decap_8_3657 r0 *1 0,0
Xsg13cmos5l_decap_8_3657 VPWR VGND sg13cmos5l_decap_8
* cell instance sg13cmos5l_decap_8_3658 r0 *1 0,0
Xsg13cmos5l_decap_8_3658 VPWR VGND sg13cmos5l_decap_8
* cell instance sg13cmos5l_decap_8_3659 r0 *1 0,0
Xsg13cmos5l_decap_8_3659 VPWR VGND sg13cmos5l_decap_8
* cell instance sg13cmos5l_decap_8_3660 r0 *1 0,0
Xsg13cmos5l_decap_8_3660 VPWR VGND sg13cmos5l_decap_8
* cell instance sg13cmos5l_decap_8_3661 r0 *1 0,0
Xsg13cmos5l_decap_8_3661 VPWR VGND sg13cmos5l_decap_8
* cell instance sg13cmos5l_decap_8_3662 r0 *1 0,0
Xsg13cmos5l_decap_8_3662 VPWR VGND sg13cmos5l_decap_8
* cell instance sg13cmos5l_decap_8_3663 r0 *1 0,0
Xsg13cmos5l_decap_8_3663 VPWR VGND sg13cmos5l_decap_8
* cell instance sg13cmos5l_decap_8_3664 r0 *1 0,0
Xsg13cmos5l_decap_8_3664 VPWR VGND sg13cmos5l_decap_8
* cell instance sg13cmos5l_decap_8_3665 r0 *1 0,0
Xsg13cmos5l_decap_8_3665 VPWR VGND sg13cmos5l_decap_8
* cell instance sg13cmos5l_decap_8_3666 r0 *1 0,0
Xsg13cmos5l_decap_8_3666 VPWR VGND sg13cmos5l_decap_8
* cell instance sg13cmos5l_decap_8_3667 r0 *1 0,0
Xsg13cmos5l_decap_8_3667 VPWR VGND sg13cmos5l_decap_8
* cell instance sg13cmos5l_decap_8_3668 r0 *1 0,0
Xsg13cmos5l_decap_8_3668 VPWR VGND sg13cmos5l_decap_8
* cell instance sg13cmos5l_decap_8_3669 r0 *1 0,0
Xsg13cmos5l_decap_8_3669 VPWR VGND sg13cmos5l_decap_8
* cell instance sg13cmos5l_decap_8_3670 r0 *1 0,0
Xsg13cmos5l_decap_8_3670 VPWR VGND sg13cmos5l_decap_8
* cell instance sg13cmos5l_decap_8_3671 r0 *1 0,0
Xsg13cmos5l_decap_8_3671 VPWR VGND sg13cmos5l_decap_8
* cell instance sg13cmos5l_decap_8_3672 r0 *1 0,0
Xsg13cmos5l_decap_8_3672 VPWR VGND sg13cmos5l_decap_8
* cell instance sg13cmos5l_decap_8_3673 r0 *1 0,0
Xsg13cmos5l_decap_8_3673 VPWR VGND sg13cmos5l_decap_8
* cell instance sg13cmos5l_decap_8_3674 r0 *1 0,0
Xsg13cmos5l_decap_8_3674 VPWR VGND sg13cmos5l_decap_8
* cell instance sg13cmos5l_decap_8_3675 r0 *1 0,0
Xsg13cmos5l_decap_8_3675 VPWR VGND sg13cmos5l_decap_8
* cell instance sg13cmos5l_decap_8_3676 r0 *1 0,0
Xsg13cmos5l_decap_8_3676 VPWR VGND sg13cmos5l_decap_8
* cell instance sg13cmos5l_decap_8_3677 r0 *1 0,0
Xsg13cmos5l_decap_8_3677 VPWR VGND sg13cmos5l_decap_8
* cell instance sg13cmos5l_decap_8_3678 r0 *1 0,0
Xsg13cmos5l_decap_8_3678 VPWR VGND sg13cmos5l_decap_8
* cell instance sg13cmos5l_decap_8_3679 r0 *1 0,0
Xsg13cmos5l_decap_8_3679 VPWR VGND sg13cmos5l_decap_8
* cell instance sg13cmos5l_decap_8_3680 r0 *1 0,0
Xsg13cmos5l_decap_8_3680 VPWR VGND sg13cmos5l_decap_8
* cell instance sg13cmos5l_decap_8_3681 r0 *1 0,0
Xsg13cmos5l_decap_8_3681 VPWR VGND sg13cmos5l_decap_8
* cell instance sg13cmos5l_decap_8_3682 r0 *1 0,0
Xsg13cmos5l_decap_8_3682 VPWR VGND sg13cmos5l_decap_8
* cell instance sg13cmos5l_decap_8_3683 r0 *1 0,0
Xsg13cmos5l_decap_8_3683 VPWR VGND sg13cmos5l_decap_8
* cell instance sg13cmos5l_decap_8_3684 r0 *1 0,0
Xsg13cmos5l_decap_8_3684 VPWR VGND sg13cmos5l_decap_8
* cell instance sg13cmos5l_decap_8_3685 r0 *1 0,0
Xsg13cmos5l_decap_8_3685 VPWR VGND sg13cmos5l_decap_8
* cell instance sg13cmos5l_decap_8_3686 r0 *1 0,0
Xsg13cmos5l_decap_8_3686 VPWR VGND sg13cmos5l_decap_8
* cell instance sg13cmos5l_decap_8_3687 r0 *1 0,0
Xsg13cmos5l_decap_8_3687 VPWR VGND sg13cmos5l_decap_8
* cell instance sg13cmos5l_decap_8_3688 r0 *1 0,0
Xsg13cmos5l_decap_8_3688 VPWR VGND sg13cmos5l_decap_8
* cell instance sg13cmos5l_decap_8_3689 r0 *1 0,0
Xsg13cmos5l_decap_8_3689 VPWR VGND sg13cmos5l_decap_8
* cell instance sg13cmos5l_decap_8_3690 r0 *1 0,0
Xsg13cmos5l_decap_8_3690 VPWR VGND sg13cmos5l_decap_8
* cell instance sg13cmos5l_decap_8_3691 r0 *1 0,0
Xsg13cmos5l_decap_8_3691 VPWR VGND sg13cmos5l_decap_8
* cell instance sg13cmos5l_decap_8_3692 r0 *1 0,0
Xsg13cmos5l_decap_8_3692 VPWR VGND sg13cmos5l_decap_8
* cell instance sg13cmos5l_decap_8_3693 r0 *1 0,0
Xsg13cmos5l_decap_8_3693 VPWR VGND sg13cmos5l_decap_8
* cell instance sg13cmos5l_decap_8_3694 r0 *1 0,0
Xsg13cmos5l_decap_8_3694 VPWR VGND sg13cmos5l_decap_8
* cell instance sg13cmos5l_decap_8_3695 r0 *1 0,0
Xsg13cmos5l_decap_8_3695 VPWR VGND sg13cmos5l_decap_8
* cell instance sg13cmos5l_decap_8_3696 r0 *1 0,0
Xsg13cmos5l_decap_8_3696 VPWR VGND sg13cmos5l_decap_8
* cell instance sg13cmos5l_decap_8_3697 r0 *1 0,0
Xsg13cmos5l_decap_8_3697 VPWR VGND sg13cmos5l_decap_8
* cell instance sg13cmos5l_decap_8_3698 r0 *1 0,0
Xsg13cmos5l_decap_8_3698 VPWR VGND sg13cmos5l_decap_8
* cell instance sg13cmos5l_decap_8_3699 r0 *1 0,0
Xsg13cmos5l_decap_8_3699 VPWR VGND sg13cmos5l_decap_8
* cell instance sg13cmos5l_decap_8_3700 r0 *1 0,0
Xsg13cmos5l_decap_8_3700 VPWR VGND sg13cmos5l_decap_8
* cell instance sg13cmos5l_decap_8_3701 r0 *1 0,0
Xsg13cmos5l_decap_8_3701 VPWR VGND sg13cmos5l_decap_8
* cell instance sg13cmos5l_decap_8_3702 r0 *1 0,0
Xsg13cmos5l_decap_8_3702 VPWR VGND sg13cmos5l_decap_8
* cell instance sg13cmos5l_decap_8_3703 r0 *1 0,0
Xsg13cmos5l_decap_8_3703 VPWR VGND sg13cmos5l_decap_8
* cell instance sg13cmos5l_decap_8_3704 r0 *1 0,0
Xsg13cmos5l_decap_8_3704 VPWR VGND sg13cmos5l_decap_8
* cell instance sg13cmos5l_decap_8_3705 r0 *1 0,0
Xsg13cmos5l_decap_8_3705 VPWR VGND sg13cmos5l_decap_8
* cell instance sg13cmos5l_decap_8_3706 r0 *1 0,0
Xsg13cmos5l_decap_8_3706 VPWR VGND sg13cmos5l_decap_8
* cell instance sg13cmos5l_decap_8_3707 r0 *1 0,0
Xsg13cmos5l_decap_8_3707 VPWR VGND sg13cmos5l_decap_8
* cell instance sg13cmos5l_decap_8_3708 r0 *1 0,0
Xsg13cmos5l_decap_8_3708 VPWR VGND sg13cmos5l_decap_8
* cell instance sg13cmos5l_decap_8_3709 r0 *1 0,0
Xsg13cmos5l_decap_8_3709 VPWR VGND sg13cmos5l_decap_8
* cell instance sg13cmos5l_decap_8_3710 r0 *1 0,0
Xsg13cmos5l_decap_8_3710 VPWR VGND sg13cmos5l_decap_8
* cell instance sg13cmos5l_decap_8_3711 r0 *1 0,0
Xsg13cmos5l_decap_8_3711 VPWR VGND sg13cmos5l_decap_8
* cell instance sg13cmos5l_decap_8_3712 r0 *1 0,0
Xsg13cmos5l_decap_8_3712 VPWR VGND sg13cmos5l_decap_8
* cell instance sg13cmos5l_decap_8_3713 r0 *1 0,0
Xsg13cmos5l_decap_8_3713 VPWR VGND sg13cmos5l_decap_8
* cell instance sg13cmos5l_decap_8_3714 r0 *1 0,0
Xsg13cmos5l_decap_8_3714 VPWR VGND sg13cmos5l_decap_8
* cell instance sg13cmos5l_decap_8_3715 r0 *1 0,0
Xsg13cmos5l_decap_8_3715 VPWR VGND sg13cmos5l_decap_8
* cell instance sg13cmos5l_decap_8_3716 r0 *1 0,0
Xsg13cmos5l_decap_8_3716 VPWR VGND sg13cmos5l_decap_8
* cell instance sg13cmos5l_decap_8_3717 r0 *1 0,0
Xsg13cmos5l_decap_8_3717 VPWR VGND sg13cmos5l_decap_8
* cell instance sg13cmos5l_decap_8_3718 r0 *1 0,0
Xsg13cmos5l_decap_8_3718 VPWR VGND sg13cmos5l_decap_8
* cell instance sg13cmos5l_decap_8_3719 r0 *1 0,0
Xsg13cmos5l_decap_8_3719 VPWR VGND sg13cmos5l_decap_8
* cell instance sg13cmos5l_decap_8_3720 r0 *1 0,0
Xsg13cmos5l_decap_8_3720 VPWR VGND sg13cmos5l_decap_8
* cell instance sg13cmos5l_decap_8_3721 r0 *1 0,0
Xsg13cmos5l_decap_8_3721 VPWR VGND sg13cmos5l_decap_8
* cell instance sg13cmos5l_decap_8_3722 r0 *1 0,0
Xsg13cmos5l_decap_8_3722 VPWR VGND sg13cmos5l_decap_8
* cell instance sg13cmos5l_decap_8_3723 r0 *1 0,0
Xsg13cmos5l_decap_8_3723 VPWR VGND sg13cmos5l_decap_8
* cell instance sg13cmos5l_decap_8_3724 r0 *1 0,0
Xsg13cmos5l_decap_8_3724 VPWR VGND sg13cmos5l_decap_8
* cell instance sg13cmos5l_decap_8_3725 r0 *1 0,0
Xsg13cmos5l_decap_8_3725 VPWR VGND sg13cmos5l_decap_8
* cell instance sg13cmos5l_decap_8_3726 r0 *1 0,0
Xsg13cmos5l_decap_8_3726 VPWR VGND sg13cmos5l_decap_8
* cell instance sg13cmos5l_decap_8_3727 r0 *1 0,0
Xsg13cmos5l_decap_8_3727 VPWR VGND sg13cmos5l_decap_8
* cell instance sg13cmos5l_decap_8_3728 r0 *1 0,0
Xsg13cmos5l_decap_8_3728 VPWR VGND sg13cmos5l_decap_8
* cell instance sg13cmos5l_decap_8_3729 r0 *1 0,0
Xsg13cmos5l_decap_8_3729 VPWR VGND sg13cmos5l_decap_8
* cell instance sg13cmos5l_decap_8_3730 r0 *1 0,0
Xsg13cmos5l_decap_8_3730 VPWR VGND sg13cmos5l_decap_8
* cell instance sg13cmos5l_decap_8_3731 r0 *1 0,0
Xsg13cmos5l_decap_8_3731 VPWR VGND sg13cmos5l_decap_8
* cell instance sg13cmos5l_decap_8_3732 r0 *1 0,0
Xsg13cmos5l_decap_8_3732 VPWR VGND sg13cmos5l_decap_8
* cell instance sg13cmos5l_decap_8_3733 r0 *1 0,0
Xsg13cmos5l_decap_8_3733 VPWR VGND sg13cmos5l_decap_8
* cell instance sg13cmos5l_decap_8_3734 r0 *1 0,0
Xsg13cmos5l_decap_8_3734 VPWR VGND sg13cmos5l_decap_8
* cell instance sg13cmos5l_decap_8_3735 r0 *1 0,0
Xsg13cmos5l_decap_8_3735 VPWR VGND sg13cmos5l_decap_8
* cell instance sg13cmos5l_decap_8_3736 r0 *1 0,0
Xsg13cmos5l_decap_8_3736 VPWR VGND sg13cmos5l_decap_8
* cell instance sg13cmos5l_decap_8_3737 r0 *1 0,0
Xsg13cmos5l_decap_8_3737 VPWR VGND sg13cmos5l_decap_8
* cell instance sg13cmos5l_decap_8_3738 r0 *1 0,0
Xsg13cmos5l_decap_8_3738 VPWR VGND sg13cmos5l_decap_8
* cell instance sg13cmos5l_decap_8_3739 r0 *1 0,0
Xsg13cmos5l_decap_8_3739 VPWR VGND sg13cmos5l_decap_8
* cell instance sg13cmos5l_decap_8_3740 r0 *1 0,0
Xsg13cmos5l_decap_8_3740 VPWR VGND sg13cmos5l_decap_8
* cell instance sg13cmos5l_decap_8_3741 r0 *1 0,0
Xsg13cmos5l_decap_8_3741 VPWR VGND sg13cmos5l_decap_8
* cell instance sg13cmos5l_decap_8_3742 r0 *1 0,0
Xsg13cmos5l_decap_8_3742 VPWR VGND sg13cmos5l_decap_8
* cell instance sg13cmos5l_decap_8_3743 r0 *1 0,0
Xsg13cmos5l_decap_8_3743 VPWR VGND sg13cmos5l_decap_8
* cell instance sg13cmos5l_decap_8_3744 r0 *1 0,0
Xsg13cmos5l_decap_8_3744 VPWR VGND sg13cmos5l_decap_8
* cell instance sg13cmos5l_decap_8_3745 r0 *1 0,0
Xsg13cmos5l_decap_8_3745 VPWR VGND sg13cmos5l_decap_8
* cell instance sg13cmos5l_decap_8_3746 r0 *1 0,0
Xsg13cmos5l_decap_8_3746 VPWR VGND sg13cmos5l_decap_8
* cell instance sg13cmos5l_decap_8_3747 r0 *1 0,0
Xsg13cmos5l_decap_8_3747 VPWR VGND sg13cmos5l_decap_8
* cell instance sg13cmos5l_decap_8_3748 r0 *1 0,0
Xsg13cmos5l_decap_8_3748 VPWR VGND sg13cmos5l_decap_8
* cell instance sg13cmos5l_decap_8_3749 r0 *1 0,0
Xsg13cmos5l_decap_8_3749 VPWR VGND sg13cmos5l_decap_8
* cell instance sg13cmos5l_decap_8_3750 r0 *1 0,0
Xsg13cmos5l_decap_8_3750 VPWR VGND sg13cmos5l_decap_8
* cell instance sg13cmos5l_decap_8_3751 r0 *1 0,0
Xsg13cmos5l_decap_8_3751 VPWR VGND sg13cmos5l_decap_8
* cell instance sg13cmos5l_decap_8_3752 r0 *1 0,0
Xsg13cmos5l_decap_8_3752 VPWR VGND sg13cmos5l_decap_8
* cell instance sg13cmos5l_decap_8_3753 r0 *1 0,0
Xsg13cmos5l_decap_8_3753 VPWR VGND sg13cmos5l_decap_8
* cell instance sg13cmos5l_decap_8_3754 r0 *1 0,0
Xsg13cmos5l_decap_8_3754 VPWR VGND sg13cmos5l_decap_8
* cell instance sg13cmos5l_decap_8_3755 r0 *1 0,0
Xsg13cmos5l_decap_8_3755 VPWR VGND sg13cmos5l_decap_8
* cell instance sg13cmos5l_decap_8_3756 r0 *1 0,0
Xsg13cmos5l_decap_8_3756 VPWR VGND sg13cmos5l_decap_8
* cell instance sg13cmos5l_decap_8_3757 r0 *1 0,0
Xsg13cmos5l_decap_8_3757 VPWR VGND sg13cmos5l_decap_8
* cell instance sg13cmos5l_decap_8_3758 r0 *1 0,0
Xsg13cmos5l_decap_8_3758 VPWR VGND sg13cmos5l_decap_8
* cell instance sg13cmos5l_decap_8_3759 r0 *1 0,0
Xsg13cmos5l_decap_8_3759 VPWR VGND sg13cmos5l_decap_8
* cell instance sg13cmos5l_decap_8_3760 r0 *1 0,0
Xsg13cmos5l_decap_8_3760 VPWR VGND sg13cmos5l_decap_8
* cell instance sg13cmos5l_decap_8_3761 r0 *1 0,0
Xsg13cmos5l_decap_8_3761 VPWR VGND sg13cmos5l_decap_8
* cell instance sg13cmos5l_decap_8_3762 r0 *1 0,0
Xsg13cmos5l_decap_8_3762 VPWR VGND sg13cmos5l_decap_8
* cell instance sg13cmos5l_decap_8_3763 r0 *1 0,0
Xsg13cmos5l_decap_8_3763 VPWR VGND sg13cmos5l_decap_8
* cell instance sg13cmos5l_decap_8_3764 r0 *1 0,0
Xsg13cmos5l_decap_8_3764 VPWR VGND sg13cmos5l_decap_8
* cell instance sg13cmos5l_decap_8_3765 r0 *1 0,0
Xsg13cmos5l_decap_8_3765 VPWR VGND sg13cmos5l_decap_8
* cell instance sg13cmos5l_decap_8_3766 r0 *1 0,0
Xsg13cmos5l_decap_8_3766 VPWR VGND sg13cmos5l_decap_8
* cell instance sg13cmos5l_decap_8_3767 r0 *1 0,0
Xsg13cmos5l_decap_8_3767 VPWR VGND sg13cmos5l_decap_8
* cell instance sg13cmos5l_decap_8_3768 r0 *1 0,0
Xsg13cmos5l_decap_8_3768 VPWR VGND sg13cmos5l_decap_8
* cell instance sg13cmos5l_decap_8_3769 r0 *1 0,0
Xsg13cmos5l_decap_8_3769 VPWR VGND sg13cmos5l_decap_8
* cell instance sg13cmos5l_decap_8_3770 r0 *1 0,0
Xsg13cmos5l_decap_8_3770 VPWR VGND sg13cmos5l_decap_8
* cell instance sg13cmos5l_decap_8_3771 r0 *1 0,0
Xsg13cmos5l_decap_8_3771 VPWR VGND sg13cmos5l_decap_8
* cell instance sg13cmos5l_decap_8_3772 r0 *1 0,0
Xsg13cmos5l_decap_8_3772 VPWR VGND sg13cmos5l_decap_8
* cell instance sg13cmos5l_decap_8_3773 r0 *1 0,0
Xsg13cmos5l_decap_8_3773 VPWR VGND sg13cmos5l_decap_8
* cell instance sg13cmos5l_decap_8_3774 r0 *1 0,0
Xsg13cmos5l_decap_8_3774 VPWR VGND sg13cmos5l_decap_8
* cell instance sg13cmos5l_decap_8_3775 r0 *1 0,0
Xsg13cmos5l_decap_8_3775 VPWR VGND sg13cmos5l_decap_8
* cell instance sg13cmos5l_decap_8_3776 r0 *1 0,0
Xsg13cmos5l_decap_8_3776 VPWR VGND sg13cmos5l_decap_8
* cell instance sg13cmos5l_decap_8_3777 r0 *1 0,0
Xsg13cmos5l_decap_8_3777 VPWR VGND sg13cmos5l_decap_8
* cell instance sg13cmos5l_decap_8_3778 r0 *1 0,0
Xsg13cmos5l_decap_8_3778 VPWR VGND sg13cmos5l_decap_8
* cell instance sg13cmos5l_decap_8_3779 r0 *1 0,0
Xsg13cmos5l_decap_8_3779 VPWR VGND sg13cmos5l_decap_8
* cell instance sg13cmos5l_decap_8_3780 r0 *1 0,0
Xsg13cmos5l_decap_8_3780 VPWR VGND sg13cmos5l_decap_8
* cell instance sg13cmos5l_decap_8_3781 r0 *1 0,0
Xsg13cmos5l_decap_8_3781 VPWR VGND sg13cmos5l_decap_8
* cell instance sg13cmos5l_decap_8_3782 r0 *1 0,0
Xsg13cmos5l_decap_8_3782 VPWR VGND sg13cmos5l_decap_8
* cell instance sg13cmos5l_decap_8_3783 r0 *1 0,0
Xsg13cmos5l_decap_8_3783 VPWR VGND sg13cmos5l_decap_8
* cell instance sg13cmos5l_decap_8_3784 r0 *1 0,0
Xsg13cmos5l_decap_8_3784 VPWR VGND sg13cmos5l_decap_8
* cell instance sg13cmos5l_decap_8_3785 r0 *1 0,0
Xsg13cmos5l_decap_8_3785 VPWR VGND sg13cmos5l_decap_8
* cell instance sg13cmos5l_decap_8_3786 r0 *1 0,0
Xsg13cmos5l_decap_8_3786 VPWR VGND sg13cmos5l_decap_8
* cell instance sg13cmos5l_decap_8_3787 r0 *1 0,0
Xsg13cmos5l_decap_8_3787 VPWR VGND sg13cmos5l_decap_8
* cell instance sg13cmos5l_decap_8_3788 r0 *1 0,0
Xsg13cmos5l_decap_8_3788 VPWR VGND sg13cmos5l_decap_8
* cell instance sg13cmos5l_decap_8_3789 r0 *1 0,0
Xsg13cmos5l_decap_8_3789 VPWR VGND sg13cmos5l_decap_8
* cell instance sg13cmos5l_decap_8_3790 r0 *1 0,0
Xsg13cmos5l_decap_8_3790 VPWR VGND sg13cmos5l_decap_8
* cell instance sg13cmos5l_decap_8_3791 r0 *1 0,0
Xsg13cmos5l_decap_8_3791 VPWR VGND sg13cmos5l_decap_8
* cell instance sg13cmos5l_decap_8_3792 r0 *1 0,0
Xsg13cmos5l_decap_8_3792 VPWR VGND sg13cmos5l_decap_8
* cell instance sg13cmos5l_decap_8_3793 r0 *1 0,0
Xsg13cmos5l_decap_8_3793 VPWR VGND sg13cmos5l_decap_8
* cell instance sg13cmos5l_decap_8_3794 r0 *1 0,0
Xsg13cmos5l_decap_8_3794 VPWR VGND sg13cmos5l_decap_8
* cell instance sg13cmos5l_decap_8_3795 r0 *1 0,0
Xsg13cmos5l_decap_8_3795 VPWR VGND sg13cmos5l_decap_8
* cell instance sg13cmos5l_decap_8_3796 r0 *1 0,0
Xsg13cmos5l_decap_8_3796 VPWR VGND sg13cmos5l_decap_8
* cell instance sg13cmos5l_decap_8_3797 r0 *1 0,0
Xsg13cmos5l_decap_8_3797 VPWR VGND sg13cmos5l_decap_8
* cell instance sg13cmos5l_decap_8_3798 r0 *1 0,0
Xsg13cmos5l_decap_8_3798 VPWR VGND sg13cmos5l_decap_8
* cell instance sg13cmos5l_decap_8_3799 r0 *1 0,0
Xsg13cmos5l_decap_8_3799 VPWR VGND sg13cmos5l_decap_8
* cell instance sg13cmos5l_decap_8_3800 r0 *1 0,0
Xsg13cmos5l_decap_8_3800 VPWR VGND sg13cmos5l_decap_8
* cell instance sg13cmos5l_decap_8_3801 r0 *1 0,0
Xsg13cmos5l_decap_8_3801 VPWR VGND sg13cmos5l_decap_8
* cell instance sg13cmos5l_decap_8_3802 r0 *1 0,0
Xsg13cmos5l_decap_8_3802 VPWR VGND sg13cmos5l_decap_8
* cell instance sg13cmos5l_decap_8_3803 r0 *1 0,0
Xsg13cmos5l_decap_8_3803 VPWR VGND sg13cmos5l_decap_8
* cell instance sg13cmos5l_decap_8_3804 r0 *1 0,0
Xsg13cmos5l_decap_8_3804 VPWR VGND sg13cmos5l_decap_8
* cell instance sg13cmos5l_decap_8_3805 r0 *1 0,0
Xsg13cmos5l_decap_8_3805 VPWR VGND sg13cmos5l_decap_8
* cell instance sg13cmos5l_decap_8_3806 r0 *1 0,0
Xsg13cmos5l_decap_8_3806 VPWR VGND sg13cmos5l_decap_8
* cell instance sg13cmos5l_decap_8_3807 r0 *1 0,0
Xsg13cmos5l_decap_8_3807 VPWR VGND sg13cmos5l_decap_8
* cell instance sg13cmos5l_decap_8_3808 r0 *1 0,0
Xsg13cmos5l_decap_8_3808 VPWR VGND sg13cmos5l_decap_8
* cell instance sg13cmos5l_decap_8_3809 r0 *1 0,0
Xsg13cmos5l_decap_8_3809 VPWR VGND sg13cmos5l_decap_8
* cell instance sg13cmos5l_decap_8_3810 r0 *1 0,0
Xsg13cmos5l_decap_8_3810 VPWR VGND sg13cmos5l_decap_8
* cell instance sg13cmos5l_decap_8_3811 r0 *1 0,0
Xsg13cmos5l_decap_8_3811 VPWR VGND sg13cmos5l_decap_8
* cell instance sg13cmos5l_decap_8_3812 r0 *1 0,0
Xsg13cmos5l_decap_8_3812 VPWR VGND sg13cmos5l_decap_8
* cell instance sg13cmos5l_decap_8_3813 r0 *1 0,0
Xsg13cmos5l_decap_8_3813 VPWR VGND sg13cmos5l_decap_8
* cell instance sg13cmos5l_decap_8_3814 r0 *1 0,0
Xsg13cmos5l_decap_8_3814 VPWR VGND sg13cmos5l_decap_8
* cell instance sg13cmos5l_decap_8_3815 r0 *1 0,0
Xsg13cmos5l_decap_8_3815 VPWR VGND sg13cmos5l_decap_8
* cell instance sg13cmos5l_decap_8_3816 r0 *1 0,0
Xsg13cmos5l_decap_8_3816 VPWR VGND sg13cmos5l_decap_8
* cell instance sg13cmos5l_decap_8_3817 r0 *1 0,0
Xsg13cmos5l_decap_8_3817 VPWR VGND sg13cmos5l_decap_8
* cell instance sg13cmos5l_decap_8_3818 r0 *1 0,0
Xsg13cmos5l_decap_8_3818 VPWR VGND sg13cmos5l_decap_8
* cell instance sg13cmos5l_decap_8_3819 r0 *1 0,0
Xsg13cmos5l_decap_8_3819 VPWR VGND sg13cmos5l_decap_8
* cell instance sg13cmos5l_decap_8_3820 r0 *1 0,0
Xsg13cmos5l_decap_8_3820 VPWR VGND sg13cmos5l_decap_8
* cell instance sg13cmos5l_decap_8_3821 r0 *1 0,0
Xsg13cmos5l_decap_8_3821 VPWR VGND sg13cmos5l_decap_8
* cell instance sg13cmos5l_decap_8_3822 r0 *1 0,0
Xsg13cmos5l_decap_8_3822 VPWR VGND sg13cmos5l_decap_8
* cell instance sg13cmos5l_decap_8_3823 r0 *1 0,0
Xsg13cmos5l_decap_8_3823 VPWR VGND sg13cmos5l_decap_8
* cell instance sg13cmos5l_decap_8_3824 r0 *1 0,0
Xsg13cmos5l_decap_8_3824 VPWR VGND sg13cmos5l_decap_8
* cell instance sg13cmos5l_decap_8_3825 r0 *1 0,0
Xsg13cmos5l_decap_8_3825 VPWR VGND sg13cmos5l_decap_8
* cell instance sg13cmos5l_decap_8_3826 r0 *1 0,0
Xsg13cmos5l_decap_8_3826 VPWR VGND sg13cmos5l_decap_8
* cell instance sg13cmos5l_decap_8_3827 r0 *1 0,0
Xsg13cmos5l_decap_8_3827 VPWR VGND sg13cmos5l_decap_8
* cell instance sg13cmos5l_decap_8_3828 r0 *1 0,0
Xsg13cmos5l_decap_8_3828 VPWR VGND sg13cmos5l_decap_8
* cell instance sg13cmos5l_decap_8_3829 r0 *1 0,0
Xsg13cmos5l_decap_8_3829 VPWR VGND sg13cmos5l_decap_8
* cell instance sg13cmos5l_decap_8_3830 r0 *1 0,0
Xsg13cmos5l_decap_8_3830 VPWR VGND sg13cmos5l_decap_8
* cell instance sg13cmos5l_decap_8_3831 r0 *1 0,0
Xsg13cmos5l_decap_8_3831 VPWR VGND sg13cmos5l_decap_8
* cell instance sg13cmos5l_decap_8_3832 r0 *1 0,0
Xsg13cmos5l_decap_8_3832 VPWR VGND sg13cmos5l_decap_8
* cell instance sg13cmos5l_decap_8_3833 r0 *1 0,0
Xsg13cmos5l_decap_8_3833 VPWR VGND sg13cmos5l_decap_8
* cell instance sg13cmos5l_decap_8_3834 r0 *1 0,0
Xsg13cmos5l_decap_8_3834 VPWR VGND sg13cmos5l_decap_8
* cell instance sg13cmos5l_decap_8_3835 r0 *1 0,0
Xsg13cmos5l_decap_8_3835 VPWR VGND sg13cmos5l_decap_8
* cell instance sg13cmos5l_decap_8_3836 r0 *1 0,0
Xsg13cmos5l_decap_8_3836 VPWR VGND sg13cmos5l_decap_8
* cell instance sg13cmos5l_decap_8_3837 r0 *1 0,0
Xsg13cmos5l_decap_8_3837 VPWR VGND sg13cmos5l_decap_8
* cell instance sg13cmos5l_decap_8_3838 r0 *1 0,0
Xsg13cmos5l_decap_8_3838 VPWR VGND sg13cmos5l_decap_8
* cell instance sg13cmos5l_decap_8_3839 r0 *1 0,0
Xsg13cmos5l_decap_8_3839 VPWR VGND sg13cmos5l_decap_8
* cell instance sg13cmos5l_decap_8_3840 r0 *1 0,0
Xsg13cmos5l_decap_8_3840 VPWR VGND sg13cmos5l_decap_8
* cell instance sg13cmos5l_decap_8_3841 r0 *1 0,0
Xsg13cmos5l_decap_8_3841 VPWR VGND sg13cmos5l_decap_8
* cell instance sg13cmos5l_decap_8_3842 r0 *1 0,0
Xsg13cmos5l_decap_8_3842 VPWR VGND sg13cmos5l_decap_8
* cell instance sg13cmos5l_decap_8_3843 r0 *1 0,0
Xsg13cmos5l_decap_8_3843 VPWR VGND sg13cmos5l_decap_8
* cell instance sg13cmos5l_decap_8_3844 r0 *1 0,0
Xsg13cmos5l_decap_8_3844 VPWR VGND sg13cmos5l_decap_8
* cell instance sg13cmos5l_decap_8_3845 r0 *1 0,0
Xsg13cmos5l_decap_8_3845 VPWR VGND sg13cmos5l_decap_8
* cell instance sg13cmos5l_decap_8_3846 r0 *1 0,0
Xsg13cmos5l_decap_8_3846 VPWR VGND sg13cmos5l_decap_8
* cell instance sg13cmos5l_decap_8_3847 r0 *1 0,0
Xsg13cmos5l_decap_8_3847 VPWR VGND sg13cmos5l_decap_8
* cell instance sg13cmos5l_decap_8_3848 r0 *1 0,0
Xsg13cmos5l_decap_8_3848 VPWR VGND sg13cmos5l_decap_8
* cell instance sg13cmos5l_decap_8_3849 r0 *1 0,0
Xsg13cmos5l_decap_8_3849 VPWR VGND sg13cmos5l_decap_8
* cell instance sg13cmos5l_decap_8_3850 r0 *1 0,0
Xsg13cmos5l_decap_8_3850 VPWR VGND sg13cmos5l_decap_8
* cell instance sg13cmos5l_decap_8_3851 r0 *1 0,0
Xsg13cmos5l_decap_8_3851 VPWR VGND sg13cmos5l_decap_8
* cell instance sg13cmos5l_decap_8_3852 r0 *1 0,0
Xsg13cmos5l_decap_8_3852 VPWR VGND sg13cmos5l_decap_8
* cell instance sg13cmos5l_decap_8_3853 r0 *1 0,0
Xsg13cmos5l_decap_8_3853 VPWR VGND sg13cmos5l_decap_8
* cell instance sg13cmos5l_decap_8_3854 r0 *1 0,0
Xsg13cmos5l_decap_8_3854 VPWR VGND sg13cmos5l_decap_8
* cell instance sg13cmos5l_decap_8_3855 r0 *1 0,0
Xsg13cmos5l_decap_8_3855 VPWR VGND sg13cmos5l_decap_8
* cell instance sg13cmos5l_decap_8_3856 r0 *1 0,0
Xsg13cmos5l_decap_8_3856 VPWR VGND sg13cmos5l_decap_8
* cell instance sg13cmos5l_decap_8_3857 r0 *1 0,0
Xsg13cmos5l_decap_8_3857 VPWR VGND sg13cmos5l_decap_8
* cell instance sg13cmos5l_decap_8_3858 r0 *1 0,0
Xsg13cmos5l_decap_8_3858 VPWR VGND sg13cmos5l_decap_8
* cell instance sg13cmos5l_decap_8_3859 r0 *1 0,0
Xsg13cmos5l_decap_8_3859 VPWR VGND sg13cmos5l_decap_8
* cell instance sg13cmos5l_decap_8_3860 r0 *1 0,0
Xsg13cmos5l_decap_8_3860 VPWR VGND sg13cmos5l_decap_8
* cell instance sg13cmos5l_decap_8_3861 r0 *1 0,0
Xsg13cmos5l_decap_8_3861 VPWR VGND sg13cmos5l_decap_8
* cell instance sg13cmos5l_decap_8_3862 r0 *1 0,0
Xsg13cmos5l_decap_8_3862 VPWR VGND sg13cmos5l_decap_8
* cell instance sg13cmos5l_decap_8_3863 r0 *1 0,0
Xsg13cmos5l_decap_8_3863 VPWR VGND sg13cmos5l_decap_8
* cell instance sg13cmos5l_decap_8_3864 r0 *1 0,0
Xsg13cmos5l_decap_8_3864 VPWR VGND sg13cmos5l_decap_8
* cell instance sg13cmos5l_decap_8_3865 r0 *1 0,0
Xsg13cmos5l_decap_8_3865 VPWR VGND sg13cmos5l_decap_8
* cell instance sg13cmos5l_decap_8_3866 r0 *1 0,0
Xsg13cmos5l_decap_8_3866 VPWR VGND sg13cmos5l_decap_8
* cell instance sg13cmos5l_decap_8_3867 r0 *1 0,0
Xsg13cmos5l_decap_8_3867 VPWR VGND sg13cmos5l_decap_8
* cell instance sg13cmos5l_decap_8_3868 r0 *1 0,0
Xsg13cmos5l_decap_8_3868 VPWR VGND sg13cmos5l_decap_8
* cell instance sg13cmos5l_decap_8_3869 r0 *1 0,0
Xsg13cmos5l_decap_8_3869 VPWR VGND sg13cmos5l_decap_8
* cell instance sg13cmos5l_decap_8_3870 r0 *1 0,0
Xsg13cmos5l_decap_8_3870 VPWR VGND sg13cmos5l_decap_8
* cell instance sg13cmos5l_decap_8_3871 r0 *1 0,0
Xsg13cmos5l_decap_8_3871 VPWR VGND sg13cmos5l_decap_8
* cell instance sg13cmos5l_decap_8_3872 r0 *1 0,0
Xsg13cmos5l_decap_8_3872 VPWR VGND sg13cmos5l_decap_8
* cell instance sg13cmos5l_decap_8_3873 r0 *1 0,0
Xsg13cmos5l_decap_8_3873 VPWR VGND sg13cmos5l_decap_8
* cell instance sg13cmos5l_decap_8_3874 r0 *1 0,0
Xsg13cmos5l_decap_8_3874 VPWR VGND sg13cmos5l_decap_8
* cell instance sg13cmos5l_decap_8_3875 r0 *1 0,0
Xsg13cmos5l_decap_8_3875 VPWR VGND sg13cmos5l_decap_8
* cell instance sg13cmos5l_decap_8_3876 r0 *1 0,0
Xsg13cmos5l_decap_8_3876 VPWR VGND sg13cmos5l_decap_8
* cell instance sg13cmos5l_decap_8_3877 r0 *1 0,0
Xsg13cmos5l_decap_8_3877 VPWR VGND sg13cmos5l_decap_8
* cell instance sg13cmos5l_decap_8_3878 r0 *1 0,0
Xsg13cmos5l_decap_8_3878 VPWR VGND sg13cmos5l_decap_8
* cell instance sg13cmos5l_decap_8_3879 r0 *1 0,0
Xsg13cmos5l_decap_8_3879 VPWR VGND sg13cmos5l_decap_8
* cell instance sg13cmos5l_decap_8_3880 r0 *1 0,0
Xsg13cmos5l_decap_8_3880 VPWR VGND sg13cmos5l_decap_8
* cell instance sg13cmos5l_decap_8_3881 r0 *1 0,0
Xsg13cmos5l_decap_8_3881 VPWR VGND sg13cmos5l_decap_8
* cell instance sg13cmos5l_decap_8_3882 r0 *1 0,0
Xsg13cmos5l_decap_8_3882 VPWR VGND sg13cmos5l_decap_8
* cell instance sg13cmos5l_decap_8_3883 r0 *1 0,0
Xsg13cmos5l_decap_8_3883 VPWR VGND sg13cmos5l_decap_8
* cell instance sg13cmos5l_decap_8_3884 r0 *1 0,0
Xsg13cmos5l_decap_8_3884 VPWR VGND sg13cmos5l_decap_8
* cell instance sg13cmos5l_decap_8_3885 r0 *1 0,0
Xsg13cmos5l_decap_8_3885 VPWR VGND sg13cmos5l_decap_8
* cell instance sg13cmos5l_decap_8_3886 r0 *1 0,0
Xsg13cmos5l_decap_8_3886 VPWR VGND sg13cmos5l_decap_8
* cell instance sg13cmos5l_decap_8_3887 r0 *1 0,0
Xsg13cmos5l_decap_8_3887 VPWR VGND sg13cmos5l_decap_8
* cell instance sg13cmos5l_decap_8_3888 r0 *1 0,0
Xsg13cmos5l_decap_8_3888 VPWR VGND sg13cmos5l_decap_8
* cell instance sg13cmos5l_decap_8_3889 r0 *1 0,0
Xsg13cmos5l_decap_8_3889 VPWR VGND sg13cmos5l_decap_8
* cell instance sg13cmos5l_decap_8_3890 r0 *1 0,0
Xsg13cmos5l_decap_8_3890 VPWR VGND sg13cmos5l_decap_8
* cell instance sg13cmos5l_decap_8_3891 r0 *1 0,0
Xsg13cmos5l_decap_8_3891 VPWR VGND sg13cmos5l_decap_8
* cell instance sg13cmos5l_decap_8_3892 r0 *1 0,0
Xsg13cmos5l_decap_8_3892 VPWR VGND sg13cmos5l_decap_8
* cell instance sg13cmos5l_decap_8_3893 r0 *1 0,0
Xsg13cmos5l_decap_8_3893 VPWR VGND sg13cmos5l_decap_8
* cell instance sg13cmos5l_decap_8_3894 r0 *1 0,0
Xsg13cmos5l_decap_8_3894 VPWR VGND sg13cmos5l_decap_8
* cell instance sg13cmos5l_decap_8_3895 r0 *1 0,0
Xsg13cmos5l_decap_8_3895 VPWR VGND sg13cmos5l_decap_8
* cell instance sg13cmos5l_decap_8_3896 r0 *1 0,0
Xsg13cmos5l_decap_8_3896 VPWR VGND sg13cmos5l_decap_8
* cell instance sg13cmos5l_decap_8_3897 r0 *1 0,0
Xsg13cmos5l_decap_8_3897 VPWR VGND sg13cmos5l_decap_8
* cell instance sg13cmos5l_decap_8_3898 r0 *1 0,0
Xsg13cmos5l_decap_8_3898 VPWR VGND sg13cmos5l_decap_8
* cell instance sg13cmos5l_decap_8_3899 r0 *1 0,0
Xsg13cmos5l_decap_8_3899 VPWR VGND sg13cmos5l_decap_8
* cell instance sg13cmos5l_decap_8_3900 r0 *1 0,0
Xsg13cmos5l_decap_8_3900 VPWR VGND sg13cmos5l_decap_8
* cell instance sg13cmos5l_decap_8_3901 r0 *1 0,0
Xsg13cmos5l_decap_8_3901 VPWR VGND sg13cmos5l_decap_8
* cell instance sg13cmos5l_decap_8_3902 r0 *1 0,0
Xsg13cmos5l_decap_8_3902 VPWR VGND sg13cmos5l_decap_8
* cell instance sg13cmos5l_decap_8_3903 r0 *1 0,0
Xsg13cmos5l_decap_8_3903 VPWR VGND sg13cmos5l_decap_8
* cell instance sg13cmos5l_decap_8_3904 r0 *1 0,0
Xsg13cmos5l_decap_8_3904 VPWR VGND sg13cmos5l_decap_8
* cell instance sg13cmos5l_decap_8_3905 r0 *1 0,0
Xsg13cmos5l_decap_8_3905 VPWR VGND sg13cmos5l_decap_8
* cell instance sg13cmos5l_decap_8_3906 r0 *1 0,0
Xsg13cmos5l_decap_8_3906 VPWR VGND sg13cmos5l_decap_8
* cell instance sg13cmos5l_decap_8_3907 r0 *1 0,0
Xsg13cmos5l_decap_8_3907 VPWR VGND sg13cmos5l_decap_8
* cell instance sg13cmos5l_decap_8_3908 r0 *1 0,0
Xsg13cmos5l_decap_8_3908 VPWR VGND sg13cmos5l_decap_8
* cell instance sg13cmos5l_decap_8_3909 r0 *1 0,0
Xsg13cmos5l_decap_8_3909 VPWR VGND sg13cmos5l_decap_8
* cell instance sg13cmos5l_decap_8_3910 r0 *1 0,0
Xsg13cmos5l_decap_8_3910 VPWR VGND sg13cmos5l_decap_8
* cell instance sg13cmos5l_decap_8_3911 r0 *1 0,0
Xsg13cmos5l_decap_8_3911 VPWR VGND sg13cmos5l_decap_8
* cell instance sg13cmos5l_decap_8_3912 r0 *1 0,0
Xsg13cmos5l_decap_8_3912 VPWR VGND sg13cmos5l_decap_8
* cell instance sg13cmos5l_decap_8_3913 r0 *1 0,0
Xsg13cmos5l_decap_8_3913 VPWR VGND sg13cmos5l_decap_8
* cell instance sg13cmos5l_decap_8_3914 r0 *1 0,0
Xsg13cmos5l_decap_8_3914 VPWR VGND sg13cmos5l_decap_8
* cell instance sg13cmos5l_decap_8_3915 r0 *1 0,0
Xsg13cmos5l_decap_8_3915 VPWR VGND sg13cmos5l_decap_8
* cell instance sg13cmos5l_decap_8_3916 r0 *1 0,0
Xsg13cmos5l_decap_8_3916 VPWR VGND sg13cmos5l_decap_8
* cell instance sg13cmos5l_decap_8_3917 r0 *1 0,0
Xsg13cmos5l_decap_8_3917 VPWR VGND sg13cmos5l_decap_8
* cell instance sg13cmos5l_decap_8_3918 r0 *1 0,0
Xsg13cmos5l_decap_8_3918 VPWR VGND sg13cmos5l_decap_8
* cell instance sg13cmos5l_decap_8_3919 r0 *1 0,0
Xsg13cmos5l_decap_8_3919 VPWR VGND sg13cmos5l_decap_8
* cell instance sg13cmos5l_decap_8_3920 r0 *1 0,0
Xsg13cmos5l_decap_8_3920 VPWR VGND sg13cmos5l_decap_8
* cell instance sg13cmos5l_decap_8_3921 r0 *1 0,0
Xsg13cmos5l_decap_8_3921 VPWR VGND sg13cmos5l_decap_8
* cell instance sg13cmos5l_decap_8_3922 r0 *1 0,0
Xsg13cmos5l_decap_8_3922 VPWR VGND sg13cmos5l_decap_8
* cell instance sg13cmos5l_decap_8_3923 r0 *1 0,0
Xsg13cmos5l_decap_8_3923 VPWR VGND sg13cmos5l_decap_8
* cell instance sg13cmos5l_decap_8_3924 r0 *1 0,0
Xsg13cmos5l_decap_8_3924 VPWR VGND sg13cmos5l_decap_8
* cell instance sg13cmos5l_decap_8_3925 r0 *1 0,0
Xsg13cmos5l_decap_8_3925 VPWR VGND sg13cmos5l_decap_8
* cell instance sg13cmos5l_decap_8_3926 r0 *1 0,0
Xsg13cmos5l_decap_8_3926 VPWR VGND sg13cmos5l_decap_8
* cell instance sg13cmos5l_decap_8_3927 r0 *1 0,0
Xsg13cmos5l_decap_8_3927 VPWR VGND sg13cmos5l_decap_8
* cell instance sg13cmos5l_decap_8_3928 r0 *1 0,0
Xsg13cmos5l_decap_8_3928 VPWR VGND sg13cmos5l_decap_8
* cell instance sg13cmos5l_decap_8_3929 r0 *1 0,0
Xsg13cmos5l_decap_8_3929 VPWR VGND sg13cmos5l_decap_8
* cell instance sg13cmos5l_decap_8_3930 r0 *1 0,0
Xsg13cmos5l_decap_8_3930 VPWR VGND sg13cmos5l_decap_8
* cell instance sg13cmos5l_decap_8_3931 r0 *1 0,0
Xsg13cmos5l_decap_8_3931 VPWR VGND sg13cmos5l_decap_8
* cell instance sg13cmos5l_decap_8_3932 r0 *1 0,0
Xsg13cmos5l_decap_8_3932 VPWR VGND sg13cmos5l_decap_8
* cell instance sg13cmos5l_decap_8_3933 r0 *1 0,0
Xsg13cmos5l_decap_8_3933 VPWR VGND sg13cmos5l_decap_8
* cell instance sg13cmos5l_decap_8_3934 r0 *1 0,0
Xsg13cmos5l_decap_8_3934 VPWR VGND sg13cmos5l_decap_8
* cell instance sg13cmos5l_decap_8_3935 r0 *1 0,0
Xsg13cmos5l_decap_8_3935 VPWR VGND sg13cmos5l_decap_8
* cell instance sg13cmos5l_decap_8_3936 r0 *1 0,0
Xsg13cmos5l_decap_8_3936 VPWR VGND sg13cmos5l_decap_8
* cell instance sg13cmos5l_decap_8_3937 r0 *1 0,0
Xsg13cmos5l_decap_8_3937 VPWR VGND sg13cmos5l_decap_8
* cell instance sg13cmos5l_decap_8_3938 r0 *1 0,0
Xsg13cmos5l_decap_8_3938 VPWR VGND sg13cmos5l_decap_8
* cell instance sg13cmos5l_decap_8_3939 r0 *1 0,0
Xsg13cmos5l_decap_8_3939 VPWR VGND sg13cmos5l_decap_8
* cell instance sg13cmos5l_decap_8_3940 r0 *1 0,0
Xsg13cmos5l_decap_8_3940 VPWR VGND sg13cmos5l_decap_8
* cell instance sg13cmos5l_decap_8_3941 r0 *1 0,0
Xsg13cmos5l_decap_8_3941 VPWR VGND sg13cmos5l_decap_8
* cell instance sg13cmos5l_decap_8_3942 r0 *1 0,0
Xsg13cmos5l_decap_8_3942 VPWR VGND sg13cmos5l_decap_8
* cell instance sg13cmos5l_decap_8_3943 r0 *1 0,0
Xsg13cmos5l_decap_8_3943 VPWR VGND sg13cmos5l_decap_8
* cell instance sg13cmos5l_decap_8_3944 r0 *1 0,0
Xsg13cmos5l_decap_8_3944 VPWR VGND sg13cmos5l_decap_8
* cell instance sg13cmos5l_decap_8_3945 r0 *1 0,0
Xsg13cmos5l_decap_8_3945 VPWR VGND sg13cmos5l_decap_8
* cell instance sg13cmos5l_decap_8_3946 r0 *1 0,0
Xsg13cmos5l_decap_8_3946 VPWR VGND sg13cmos5l_decap_8
* cell instance sg13cmos5l_decap_8_3947 r0 *1 0,0
Xsg13cmos5l_decap_8_3947 VPWR VGND sg13cmos5l_decap_8
* cell instance sg13cmos5l_decap_8_3948 r0 *1 0,0
Xsg13cmos5l_decap_8_3948 VPWR VGND sg13cmos5l_decap_8
* cell instance sg13cmos5l_decap_8_3949 r0 *1 0,0
Xsg13cmos5l_decap_8_3949 VPWR VGND sg13cmos5l_decap_8
* cell instance sg13cmos5l_decap_8_3950 r0 *1 0,0
Xsg13cmos5l_decap_8_3950 VPWR VGND sg13cmos5l_decap_8
* cell instance sg13cmos5l_decap_8_3951 r0 *1 0,0
Xsg13cmos5l_decap_8_3951 VPWR VGND sg13cmos5l_decap_8
* cell instance sg13cmos5l_decap_8_3952 r0 *1 0,0
Xsg13cmos5l_decap_8_3952 VPWR VGND sg13cmos5l_decap_8
* cell instance sg13cmos5l_decap_8_3953 r0 *1 0,0
Xsg13cmos5l_decap_8_3953 VPWR VGND sg13cmos5l_decap_8
* cell instance sg13cmos5l_decap_8_3954 r0 *1 0,0
Xsg13cmos5l_decap_8_3954 VPWR VGND sg13cmos5l_decap_8
* cell instance sg13cmos5l_decap_8_3955 r0 *1 0,0
Xsg13cmos5l_decap_8_3955 VPWR VGND sg13cmos5l_decap_8
* cell instance sg13cmos5l_decap_8_3956 r0 *1 0,0
Xsg13cmos5l_decap_8_3956 VPWR VGND sg13cmos5l_decap_8
* cell instance sg13cmos5l_decap_8_3957 r0 *1 0,0
Xsg13cmos5l_decap_8_3957 VPWR VGND sg13cmos5l_decap_8
* cell instance sg13cmos5l_decap_8_3958 r0 *1 0,0
Xsg13cmos5l_decap_8_3958 VPWR VGND sg13cmos5l_decap_8
* cell instance sg13cmos5l_decap_8_3959 r0 *1 0,0
Xsg13cmos5l_decap_8_3959 VPWR VGND sg13cmos5l_decap_8
* cell instance sg13cmos5l_decap_8_3960 r0 *1 0,0
Xsg13cmos5l_decap_8_3960 VPWR VGND sg13cmos5l_decap_8
* cell instance sg13cmos5l_decap_8_3961 r0 *1 0,0
Xsg13cmos5l_decap_8_3961 VPWR VGND sg13cmos5l_decap_8
* cell instance sg13cmos5l_decap_8_3962 r0 *1 0,0
Xsg13cmos5l_decap_8_3962 VPWR VGND sg13cmos5l_decap_8
* cell instance sg13cmos5l_decap_8_3963 r0 *1 0,0
Xsg13cmos5l_decap_8_3963 VPWR VGND sg13cmos5l_decap_8
* cell instance sg13cmos5l_decap_8_3964 r0 *1 0,0
Xsg13cmos5l_decap_8_3964 VPWR VGND sg13cmos5l_decap_8
* cell instance sg13cmos5l_decap_8_3965 r0 *1 0,0
Xsg13cmos5l_decap_8_3965 VPWR VGND sg13cmos5l_decap_8
* cell instance sg13cmos5l_decap_8_3966 r0 *1 0,0
Xsg13cmos5l_decap_8_3966 VPWR VGND sg13cmos5l_decap_8
* cell instance sg13cmos5l_decap_8_3967 r0 *1 0,0
Xsg13cmos5l_decap_8_3967 VPWR VGND sg13cmos5l_decap_8
* cell instance sg13cmos5l_decap_8_3968 r0 *1 0,0
Xsg13cmos5l_decap_8_3968 VPWR VGND sg13cmos5l_decap_8
* cell instance sg13cmos5l_decap_8_3969 r0 *1 0,0
Xsg13cmos5l_decap_8_3969 VPWR VGND sg13cmos5l_decap_8
* cell instance sg13cmos5l_decap_8_3970 r0 *1 0,0
Xsg13cmos5l_decap_8_3970 VPWR VGND sg13cmos5l_decap_8
* cell instance sg13cmos5l_decap_8_3971 r0 *1 0,0
Xsg13cmos5l_decap_8_3971 VPWR VGND sg13cmos5l_decap_8
* cell instance sg13cmos5l_decap_8_3972 r0 *1 0,0
Xsg13cmos5l_decap_8_3972 VPWR VGND sg13cmos5l_decap_8
* cell instance sg13cmos5l_decap_8_3973 r0 *1 0,0
Xsg13cmos5l_decap_8_3973 VPWR VGND sg13cmos5l_decap_8
* cell instance sg13cmos5l_decap_8_3974 r0 *1 0,0
Xsg13cmos5l_decap_8_3974 VPWR VGND sg13cmos5l_decap_8
* cell instance sg13cmos5l_decap_8_3975 r0 *1 0,0
Xsg13cmos5l_decap_8_3975 VPWR VGND sg13cmos5l_decap_8
* cell instance sg13cmos5l_decap_8_3976 r0 *1 0,0
Xsg13cmos5l_decap_8_3976 VPWR VGND sg13cmos5l_decap_8
* cell instance sg13cmos5l_decap_8_3977 r0 *1 0,0
Xsg13cmos5l_decap_8_3977 VPWR VGND sg13cmos5l_decap_8
* cell instance sg13cmos5l_decap_8_3978 r0 *1 0,0
Xsg13cmos5l_decap_8_3978 VPWR VGND sg13cmos5l_decap_8
* cell instance sg13cmos5l_decap_8_3979 r0 *1 0,0
Xsg13cmos5l_decap_8_3979 VPWR VGND sg13cmos5l_decap_8
* cell instance sg13cmos5l_decap_8_3980 r0 *1 0,0
Xsg13cmos5l_decap_8_3980 VPWR VGND sg13cmos5l_decap_8
* cell instance sg13cmos5l_decap_8_3981 r0 *1 0,0
Xsg13cmos5l_decap_8_3981 VPWR VGND sg13cmos5l_decap_8
* cell instance sg13cmos5l_decap_8_3982 r0 *1 0,0
Xsg13cmos5l_decap_8_3982 VPWR VGND sg13cmos5l_decap_8
* cell instance sg13cmos5l_decap_8_3983 r0 *1 0,0
Xsg13cmos5l_decap_8_3983 VPWR VGND sg13cmos5l_decap_8
* cell instance sg13cmos5l_decap_8_3984 r0 *1 0,0
Xsg13cmos5l_decap_8_3984 VPWR VGND sg13cmos5l_decap_8
* cell instance sg13cmos5l_decap_8_3985 r0 *1 0,0
Xsg13cmos5l_decap_8_3985 VPWR VGND sg13cmos5l_decap_8
* cell instance sg13cmos5l_decap_8_3986 r0 *1 0,0
Xsg13cmos5l_decap_8_3986 VPWR VGND sg13cmos5l_decap_8
* cell instance sg13cmos5l_decap_8_3987 r0 *1 0,0
Xsg13cmos5l_decap_8_3987 VPWR VGND sg13cmos5l_decap_8
* cell instance sg13cmos5l_decap_8_3988 r0 *1 0,0
Xsg13cmos5l_decap_8_3988 VPWR VGND sg13cmos5l_decap_8
* cell instance sg13cmos5l_decap_8_3989 r0 *1 0,0
Xsg13cmos5l_decap_8_3989 VPWR VGND sg13cmos5l_decap_8
* cell instance sg13cmos5l_decap_8_3990 r0 *1 0,0
Xsg13cmos5l_decap_8_3990 VPWR VGND sg13cmos5l_decap_8
* cell instance sg13cmos5l_decap_8_3991 r0 *1 0,0
Xsg13cmos5l_decap_8_3991 VPWR VGND sg13cmos5l_decap_8
* cell instance sg13cmos5l_decap_8_3992 r0 *1 0,0
Xsg13cmos5l_decap_8_3992 VPWR VGND sg13cmos5l_decap_8
* cell instance sg13cmos5l_decap_8_3993 r0 *1 0,0
Xsg13cmos5l_decap_8_3993 VPWR VGND sg13cmos5l_decap_8
* cell instance sg13cmos5l_decap_8_3994 r0 *1 0,0
Xsg13cmos5l_decap_8_3994 VPWR VGND sg13cmos5l_decap_8
* cell instance sg13cmos5l_decap_8_3995 r0 *1 0,0
Xsg13cmos5l_decap_8_3995 VPWR VGND sg13cmos5l_decap_8
* cell instance sg13cmos5l_decap_8_3996 r0 *1 0,0
Xsg13cmos5l_decap_8_3996 VPWR VGND sg13cmos5l_decap_8
* cell instance sg13cmos5l_decap_8_3997 r0 *1 0,0
Xsg13cmos5l_decap_8_3997 VPWR VGND sg13cmos5l_decap_8
* cell instance sg13cmos5l_decap_8_3998 r0 *1 0,0
Xsg13cmos5l_decap_8_3998 VPWR VGND sg13cmos5l_decap_8
* cell instance sg13cmos5l_decap_8_3999 r0 *1 0,0
Xsg13cmos5l_decap_8_3999 VPWR VGND sg13cmos5l_decap_8
* cell instance sg13cmos5l_decap_8_4000 r0 *1 0,0
Xsg13cmos5l_decap_8_4000 VPWR VGND sg13cmos5l_decap_8
* cell instance sg13cmos5l_decap_8_4001 r0 *1 0,0
Xsg13cmos5l_decap_8_4001 VPWR VGND sg13cmos5l_decap_8
* cell instance sg13cmos5l_decap_8_4002 r0 *1 0,0
Xsg13cmos5l_decap_8_4002 VPWR VGND sg13cmos5l_decap_8
* cell instance sg13cmos5l_decap_8_4003 r0 *1 0,0
Xsg13cmos5l_decap_8_4003 VPWR VGND sg13cmos5l_decap_8
* cell instance sg13cmos5l_decap_8_4004 r0 *1 0,0
Xsg13cmos5l_decap_8_4004 VPWR VGND sg13cmos5l_decap_8
* cell instance sg13cmos5l_decap_8_4005 r0 *1 0,0
Xsg13cmos5l_decap_8_4005 VPWR VGND sg13cmos5l_decap_8
* cell instance sg13cmos5l_decap_8_4006 r0 *1 0,0
Xsg13cmos5l_decap_8_4006 VPWR VGND sg13cmos5l_decap_8
* cell instance sg13cmos5l_decap_8_4007 r0 *1 0,0
Xsg13cmos5l_decap_8_4007 VPWR VGND sg13cmos5l_decap_8
* cell instance sg13cmos5l_decap_8_4008 r0 *1 0,0
Xsg13cmos5l_decap_8_4008 VPWR VGND sg13cmos5l_decap_8
* cell instance sg13cmos5l_decap_8_4009 r0 *1 0,0
Xsg13cmos5l_decap_8_4009 VPWR VGND sg13cmos5l_decap_8
* cell instance sg13cmos5l_decap_8_4010 r0 *1 0,0
Xsg13cmos5l_decap_8_4010 VPWR VGND sg13cmos5l_decap_8
* cell instance sg13cmos5l_decap_8_4011 r0 *1 0,0
Xsg13cmos5l_decap_8_4011 VPWR VGND sg13cmos5l_decap_8
* cell instance sg13cmos5l_decap_8_4012 r0 *1 0,0
Xsg13cmos5l_decap_8_4012 VPWR VGND sg13cmos5l_decap_8
* cell instance sg13cmos5l_decap_8_4013 r0 *1 0,0
Xsg13cmos5l_decap_8_4013 VPWR VGND sg13cmos5l_decap_8
* cell instance sg13cmos5l_decap_8_4014 r0 *1 0,0
Xsg13cmos5l_decap_8_4014 VPWR VGND sg13cmos5l_decap_8
* cell instance sg13cmos5l_decap_8_4015 r0 *1 0,0
Xsg13cmos5l_decap_8_4015 VPWR VGND sg13cmos5l_decap_8
* cell instance sg13cmos5l_decap_8_4016 r0 *1 0,0
Xsg13cmos5l_decap_8_4016 VPWR VGND sg13cmos5l_decap_8
* cell instance sg13cmos5l_decap_8_4017 r0 *1 0,0
Xsg13cmos5l_decap_8_4017 VPWR VGND sg13cmos5l_decap_8
* cell instance sg13cmos5l_decap_8_4018 r0 *1 0,0
Xsg13cmos5l_decap_8_4018 VPWR VGND sg13cmos5l_decap_8
* cell instance sg13cmos5l_decap_8_4019 r0 *1 0,0
Xsg13cmos5l_decap_8_4019 VPWR VGND sg13cmos5l_decap_8
* cell instance sg13cmos5l_decap_8_4020 r0 *1 0,0
Xsg13cmos5l_decap_8_4020 VPWR VGND sg13cmos5l_decap_8
* cell instance sg13cmos5l_decap_8_4021 r0 *1 0,0
Xsg13cmos5l_decap_8_4021 VPWR VGND sg13cmos5l_decap_8
* cell instance sg13cmos5l_decap_8_4022 r0 *1 0,0
Xsg13cmos5l_decap_8_4022 VPWR VGND sg13cmos5l_decap_8
* cell instance sg13cmos5l_decap_8_4023 r0 *1 0,0
Xsg13cmos5l_decap_8_4023 VPWR VGND sg13cmos5l_decap_8
* cell instance sg13cmos5l_decap_8_4024 r0 *1 0,0
Xsg13cmos5l_decap_8_4024 VPWR VGND sg13cmos5l_decap_8
* cell instance sg13cmos5l_decap_8_4025 r0 *1 0,0
Xsg13cmos5l_decap_8_4025 VPWR VGND sg13cmos5l_decap_8
* cell instance sg13cmos5l_decap_8_4026 r0 *1 0,0
Xsg13cmos5l_decap_8_4026 VPWR VGND sg13cmos5l_decap_8
* cell instance sg13cmos5l_decap_8_4027 r0 *1 0,0
Xsg13cmos5l_decap_8_4027 VPWR VGND sg13cmos5l_decap_8
* cell instance sg13cmos5l_decap_8_4028 r0 *1 0,0
Xsg13cmos5l_decap_8_4028 VPWR VGND sg13cmos5l_decap_8
* cell instance sg13cmos5l_decap_8_4029 r0 *1 0,0
Xsg13cmos5l_decap_8_4029 VPWR VGND sg13cmos5l_decap_8
* cell instance sg13cmos5l_decap_8_4030 r0 *1 0,0
Xsg13cmos5l_decap_8_4030 VPWR VGND sg13cmos5l_decap_8
* cell instance sg13cmos5l_decap_8_4031 r0 *1 0,0
Xsg13cmos5l_decap_8_4031 VPWR VGND sg13cmos5l_decap_8
* cell instance sg13cmos5l_decap_8_4032 r0 *1 0,0
Xsg13cmos5l_decap_8_4032 VPWR VGND sg13cmos5l_decap_8
* cell instance sg13cmos5l_decap_8_4033 r0 *1 0,0
Xsg13cmos5l_decap_8_4033 VPWR VGND sg13cmos5l_decap_8
* cell instance sg13cmos5l_decap_8_4034 r0 *1 0,0
Xsg13cmos5l_decap_8_4034 VPWR VGND sg13cmos5l_decap_8
* cell instance sg13cmos5l_decap_8_4035 r0 *1 0,0
Xsg13cmos5l_decap_8_4035 VPWR VGND sg13cmos5l_decap_8
* cell instance sg13cmos5l_decap_8_4036 r0 *1 0,0
Xsg13cmos5l_decap_8_4036 VPWR VGND sg13cmos5l_decap_8
* cell instance sg13cmos5l_decap_8_4037 r0 *1 0,0
Xsg13cmos5l_decap_8_4037 VPWR VGND sg13cmos5l_decap_8
* cell instance sg13cmos5l_decap_8_4038 r0 *1 0,0
Xsg13cmos5l_decap_8_4038 VPWR VGND sg13cmos5l_decap_8
* cell instance sg13cmos5l_decap_8_4039 r0 *1 0,0
Xsg13cmos5l_decap_8_4039 VPWR VGND sg13cmos5l_decap_8
* cell instance sg13cmos5l_decap_8_4040 r0 *1 0,0
Xsg13cmos5l_decap_8_4040 VPWR VGND sg13cmos5l_decap_8
* cell instance sg13cmos5l_decap_8_4041 r0 *1 0,0
Xsg13cmos5l_decap_8_4041 VPWR VGND sg13cmos5l_decap_8
* cell instance sg13cmos5l_decap_8_4042 r0 *1 0,0
Xsg13cmos5l_decap_8_4042 VPWR VGND sg13cmos5l_decap_8
* cell instance sg13cmos5l_decap_8_4043 r0 *1 0,0
Xsg13cmos5l_decap_8_4043 VPWR VGND sg13cmos5l_decap_8
* cell instance sg13cmos5l_decap_8_4044 r0 *1 0,0
Xsg13cmos5l_decap_8_4044 VPWR VGND sg13cmos5l_decap_8
* cell instance sg13cmos5l_decap_8_4045 r0 *1 0,0
Xsg13cmos5l_decap_8_4045 VPWR VGND sg13cmos5l_decap_8
* cell instance sg13cmos5l_decap_8_4046 r0 *1 0,0
Xsg13cmos5l_decap_8_4046 VPWR VGND sg13cmos5l_decap_8
* cell instance sg13cmos5l_decap_8_4047 r0 *1 0,0
Xsg13cmos5l_decap_8_4047 VPWR VGND sg13cmos5l_decap_8
* cell instance sg13cmos5l_decap_8_4048 r0 *1 0,0
Xsg13cmos5l_decap_8_4048 VPWR VGND sg13cmos5l_decap_8
* cell instance sg13cmos5l_decap_8_4049 r0 *1 0,0
Xsg13cmos5l_decap_8_4049 VPWR VGND sg13cmos5l_decap_8
* cell instance sg13cmos5l_decap_8_4050 r0 *1 0,0
Xsg13cmos5l_decap_8_4050 VPWR VGND sg13cmos5l_decap_8
* cell instance sg13cmos5l_decap_8_4051 r0 *1 0,0
Xsg13cmos5l_decap_8_4051 VPWR VGND sg13cmos5l_decap_8
* cell instance sg13cmos5l_decap_8_4052 r0 *1 0,0
Xsg13cmos5l_decap_8_4052 VPWR VGND sg13cmos5l_decap_8
* cell instance sg13cmos5l_decap_8_4053 r0 *1 0,0
Xsg13cmos5l_decap_8_4053 VPWR VGND sg13cmos5l_decap_8
* cell instance sg13cmos5l_decap_8_4054 r0 *1 0,0
Xsg13cmos5l_decap_8_4054 VPWR VGND sg13cmos5l_decap_8
* cell instance sg13cmos5l_decap_8_4055 r0 *1 0,0
Xsg13cmos5l_decap_8_4055 VPWR VGND sg13cmos5l_decap_8
* cell instance sg13cmos5l_decap_8_4056 r0 *1 0,0
Xsg13cmos5l_decap_8_4056 VPWR VGND sg13cmos5l_decap_8
* cell instance sg13cmos5l_decap_8_4057 r0 *1 0,0
Xsg13cmos5l_decap_8_4057 VPWR VGND sg13cmos5l_decap_8
* cell instance sg13cmos5l_decap_8_4058 r0 *1 0,0
Xsg13cmos5l_decap_8_4058 VPWR VGND sg13cmos5l_decap_8
* cell instance sg13cmos5l_decap_8_4059 r0 *1 0,0
Xsg13cmos5l_decap_8_4059 VPWR VGND sg13cmos5l_decap_8
* cell instance sg13cmos5l_decap_8_4060 r0 *1 0,0
Xsg13cmos5l_decap_8_4060 VPWR VGND sg13cmos5l_decap_8
* cell instance sg13cmos5l_decap_8_4061 r0 *1 0,0
Xsg13cmos5l_decap_8_4061 VPWR VGND sg13cmos5l_decap_8
* cell instance sg13cmos5l_decap_8_4062 r0 *1 0,0
Xsg13cmos5l_decap_8_4062 VPWR VGND sg13cmos5l_decap_8
* cell instance sg13cmos5l_decap_8_4063 r0 *1 0,0
Xsg13cmos5l_decap_8_4063 VPWR VGND sg13cmos5l_decap_8
* cell instance sg13cmos5l_decap_8_4064 r0 *1 0,0
Xsg13cmos5l_decap_8_4064 VPWR VGND sg13cmos5l_decap_8
* cell instance sg13cmos5l_decap_8_4065 r0 *1 0,0
Xsg13cmos5l_decap_8_4065 VPWR VGND sg13cmos5l_decap_8
* cell instance sg13cmos5l_decap_8_4066 r0 *1 0,0
Xsg13cmos5l_decap_8_4066 VPWR VGND sg13cmos5l_decap_8
* cell instance sg13cmos5l_decap_8_4067 r0 *1 0,0
Xsg13cmos5l_decap_8_4067 VPWR VGND sg13cmos5l_decap_8
* cell instance sg13cmos5l_decap_8_4068 r0 *1 0,0
Xsg13cmos5l_decap_8_4068 VPWR VGND sg13cmos5l_decap_8
* cell instance sg13cmos5l_decap_8_4069 r0 *1 0,0
Xsg13cmos5l_decap_8_4069 VPWR VGND sg13cmos5l_decap_8
* cell instance sg13cmos5l_decap_8_4070 r0 *1 0,0
Xsg13cmos5l_decap_8_4070 VPWR VGND sg13cmos5l_decap_8
* cell instance sg13cmos5l_decap_8_4071 r0 *1 0,0
Xsg13cmos5l_decap_8_4071 VPWR VGND sg13cmos5l_decap_8
* cell instance sg13cmos5l_decap_8_4072 r0 *1 0,0
Xsg13cmos5l_decap_8_4072 VPWR VGND sg13cmos5l_decap_8
* cell instance sg13cmos5l_decap_8_4073 r0 *1 0,0
Xsg13cmos5l_decap_8_4073 VPWR VGND sg13cmos5l_decap_8
* cell instance sg13cmos5l_decap_8_4074 r0 *1 0,0
Xsg13cmos5l_decap_8_4074 VPWR VGND sg13cmos5l_decap_8
* cell instance sg13cmos5l_decap_8_4075 r0 *1 0,0
Xsg13cmos5l_decap_8_4075 VPWR VGND sg13cmos5l_decap_8
* cell instance sg13cmos5l_decap_8_4076 r0 *1 0,0
Xsg13cmos5l_decap_8_4076 VPWR VGND sg13cmos5l_decap_8
* cell instance sg13cmos5l_decap_8_4077 r0 *1 0,0
Xsg13cmos5l_decap_8_4077 VPWR VGND sg13cmos5l_decap_8
* cell instance sg13cmos5l_decap_8_4078 r0 *1 0,0
Xsg13cmos5l_decap_8_4078 VPWR VGND sg13cmos5l_decap_8
* cell instance sg13cmos5l_decap_8_4079 r0 *1 0,0
Xsg13cmos5l_decap_8_4079 VPWR VGND sg13cmos5l_decap_8
* cell instance sg13cmos5l_decap_8_4080 r0 *1 0,0
Xsg13cmos5l_decap_8_4080 VPWR VGND sg13cmos5l_decap_8
* cell instance sg13cmos5l_decap_8_4081 r0 *1 0,0
Xsg13cmos5l_decap_8_4081 VPWR VGND sg13cmos5l_decap_8
* cell instance sg13cmos5l_decap_8_4082 r0 *1 0,0
Xsg13cmos5l_decap_8_4082 VPWR VGND sg13cmos5l_decap_8
* cell instance sg13cmos5l_decap_8_4083 r0 *1 0,0
Xsg13cmos5l_decap_8_4083 VPWR VGND sg13cmos5l_decap_8
* cell instance sg13cmos5l_decap_8_4084 r0 *1 0,0
Xsg13cmos5l_decap_8_4084 VPWR VGND sg13cmos5l_decap_8
* cell instance sg13cmos5l_decap_8_4085 r0 *1 0,0
Xsg13cmos5l_decap_8_4085 VPWR VGND sg13cmos5l_decap_8
* cell instance sg13cmos5l_decap_8_4086 r0 *1 0,0
Xsg13cmos5l_decap_8_4086 VPWR VGND sg13cmos5l_decap_8
* cell instance sg13cmos5l_decap_8_4087 r0 *1 0,0
Xsg13cmos5l_decap_8_4087 VPWR VGND sg13cmos5l_decap_8
* cell instance sg13cmos5l_decap_8_4088 r0 *1 0,0
Xsg13cmos5l_decap_8_4088 VPWR VGND sg13cmos5l_decap_8
* cell instance sg13cmos5l_decap_8_4089 r0 *1 0,0
Xsg13cmos5l_decap_8_4089 VPWR VGND sg13cmos5l_decap_8
* cell instance sg13cmos5l_decap_8_4090 r0 *1 0,0
Xsg13cmos5l_decap_8_4090 VPWR VGND sg13cmos5l_decap_8
* cell instance sg13cmos5l_decap_8_4091 r0 *1 0,0
Xsg13cmos5l_decap_8_4091 VPWR VGND sg13cmos5l_decap_8
* cell instance sg13cmos5l_decap_8_4092 r0 *1 0,0
Xsg13cmos5l_decap_8_4092 VPWR VGND sg13cmos5l_decap_8
* cell instance sg13cmos5l_decap_8_4093 r0 *1 0,0
Xsg13cmos5l_decap_8_4093 VPWR VGND sg13cmos5l_decap_8
* cell instance sg13cmos5l_decap_8_4094 r0 *1 0,0
Xsg13cmos5l_decap_8_4094 VPWR VGND sg13cmos5l_decap_8
* cell instance sg13cmos5l_decap_8_4095 r0 *1 0,0
Xsg13cmos5l_decap_8_4095 VPWR VGND sg13cmos5l_decap_8
* cell instance sg13cmos5l_decap_8_4096 r0 *1 0,0
Xsg13cmos5l_decap_8_4096 VPWR VGND sg13cmos5l_decap_8
* cell instance sg13cmos5l_decap_8_4097 r0 *1 0,0
Xsg13cmos5l_decap_8_4097 VPWR VGND sg13cmos5l_decap_8
* cell instance sg13cmos5l_decap_8_4098 r0 *1 0,0
Xsg13cmos5l_decap_8_4098 VPWR VGND sg13cmos5l_decap_8
* cell instance sg13cmos5l_decap_8_4099 r0 *1 0,0
Xsg13cmos5l_decap_8_4099 VPWR VGND sg13cmos5l_decap_8
* cell instance sg13cmos5l_decap_8_4100 r0 *1 0,0
Xsg13cmos5l_decap_8_4100 VPWR VGND sg13cmos5l_decap_8
* cell instance sg13cmos5l_decap_8_4101 r0 *1 0,0
Xsg13cmos5l_decap_8_4101 VPWR VGND sg13cmos5l_decap_8
* cell instance sg13cmos5l_decap_8_4102 r0 *1 0,0
Xsg13cmos5l_decap_8_4102 VPWR VGND sg13cmos5l_decap_8
* cell instance sg13cmos5l_decap_8_4103 r0 *1 0,0
Xsg13cmos5l_decap_8_4103 VPWR VGND sg13cmos5l_decap_8
* cell instance sg13cmos5l_decap_8_4104 r0 *1 0,0
Xsg13cmos5l_decap_8_4104 VPWR VGND sg13cmos5l_decap_8
* cell instance sg13cmos5l_decap_8_4105 r0 *1 0,0
Xsg13cmos5l_decap_8_4105 VPWR VGND sg13cmos5l_decap_8
* cell instance sg13cmos5l_decap_8_4106 r0 *1 0,0
Xsg13cmos5l_decap_8_4106 VPWR VGND sg13cmos5l_decap_8
* cell instance sg13cmos5l_decap_8_4107 r0 *1 0,0
Xsg13cmos5l_decap_8_4107 VPWR VGND sg13cmos5l_decap_8
* cell instance sg13cmos5l_decap_8_4108 r0 *1 0,0
Xsg13cmos5l_decap_8_4108 VPWR VGND sg13cmos5l_decap_8
* cell instance sg13cmos5l_decap_8_4109 r0 *1 0,0
Xsg13cmos5l_decap_8_4109 VPWR VGND sg13cmos5l_decap_8
* cell instance sg13cmos5l_decap_8_4110 r0 *1 0,0
Xsg13cmos5l_decap_8_4110 VPWR VGND sg13cmos5l_decap_8
* cell instance sg13cmos5l_decap_8_4111 r0 *1 0,0
Xsg13cmos5l_decap_8_4111 VPWR VGND sg13cmos5l_decap_8
* cell instance sg13cmos5l_decap_8_4112 r0 *1 0,0
Xsg13cmos5l_decap_8_4112 VPWR VGND sg13cmos5l_decap_8
* cell instance sg13cmos5l_decap_8_4113 r0 *1 0,0
Xsg13cmos5l_decap_8_4113 VPWR VGND sg13cmos5l_decap_8
* cell instance sg13cmos5l_decap_8_4114 r0 *1 0,0
Xsg13cmos5l_decap_8_4114 VPWR VGND sg13cmos5l_decap_8
* cell instance sg13cmos5l_decap_8_4115 r0 *1 0,0
Xsg13cmos5l_decap_8_4115 VPWR VGND sg13cmos5l_decap_8
* cell instance sg13cmos5l_decap_8_4116 r0 *1 0,0
Xsg13cmos5l_decap_8_4116 VPWR VGND sg13cmos5l_decap_8
* cell instance sg13cmos5l_decap_8_4117 r0 *1 0,0
Xsg13cmos5l_decap_8_4117 VPWR VGND sg13cmos5l_decap_8
* cell instance sg13cmos5l_decap_8_4118 r0 *1 0,0
Xsg13cmos5l_decap_8_4118 VPWR VGND sg13cmos5l_decap_8
* cell instance sg13cmos5l_decap_8_4119 r0 *1 0,0
Xsg13cmos5l_decap_8_4119 VPWR VGND sg13cmos5l_decap_8
* cell instance sg13cmos5l_decap_8_4120 r0 *1 0,0
Xsg13cmos5l_decap_8_4120 VPWR VGND sg13cmos5l_decap_8
* cell instance sg13cmos5l_decap_8_4121 r0 *1 0,0
Xsg13cmos5l_decap_8_4121 VPWR VGND sg13cmos5l_decap_8
* cell instance sg13cmos5l_decap_8_4122 r0 *1 0,0
Xsg13cmos5l_decap_8_4122 VPWR VGND sg13cmos5l_decap_8
* cell instance sg13cmos5l_decap_8_4123 r0 *1 0,0
Xsg13cmos5l_decap_8_4123 VPWR VGND sg13cmos5l_decap_8
* cell instance sg13cmos5l_decap_8_4124 r0 *1 0,0
Xsg13cmos5l_decap_8_4124 VPWR VGND sg13cmos5l_decap_8
* cell instance sg13cmos5l_decap_8_4125 r0 *1 0,0
Xsg13cmos5l_decap_8_4125 VPWR VGND sg13cmos5l_decap_8
* cell instance sg13cmos5l_decap_8_4126 r0 *1 0,0
Xsg13cmos5l_decap_8_4126 VPWR VGND sg13cmos5l_decap_8
* cell instance sg13cmos5l_decap_8_4127 r0 *1 0,0
Xsg13cmos5l_decap_8_4127 VPWR VGND sg13cmos5l_decap_8
* cell instance sg13cmos5l_decap_8_4128 r0 *1 0,0
Xsg13cmos5l_decap_8_4128 VPWR VGND sg13cmos5l_decap_8
* cell instance sg13cmos5l_decap_8_4129 r0 *1 0,0
Xsg13cmos5l_decap_8_4129 VPWR VGND sg13cmos5l_decap_8
* cell instance sg13cmos5l_decap_8_4130 r0 *1 0,0
Xsg13cmos5l_decap_8_4130 VPWR VGND sg13cmos5l_decap_8
* cell instance sg13cmos5l_decap_8_4131 r0 *1 0,0
Xsg13cmos5l_decap_8_4131 VPWR VGND sg13cmos5l_decap_8
* cell instance sg13cmos5l_decap_8_4132 r0 *1 0,0
Xsg13cmos5l_decap_8_4132 VPWR VGND sg13cmos5l_decap_8
* cell instance sg13cmos5l_decap_8_4133 r0 *1 0,0
Xsg13cmos5l_decap_8_4133 VPWR VGND sg13cmos5l_decap_8
* cell instance sg13cmos5l_decap_8_4134 r0 *1 0,0
Xsg13cmos5l_decap_8_4134 VPWR VGND sg13cmos5l_decap_8
* cell instance sg13cmos5l_decap_8_4135 r0 *1 0,0
Xsg13cmos5l_decap_8_4135 VPWR VGND sg13cmos5l_decap_8
* cell instance sg13cmos5l_decap_8_4136 r0 *1 0,0
Xsg13cmos5l_decap_8_4136 VPWR VGND sg13cmos5l_decap_8
* cell instance sg13cmos5l_decap_8_4137 r0 *1 0,0
Xsg13cmos5l_decap_8_4137 VPWR VGND sg13cmos5l_decap_8
* cell instance sg13cmos5l_decap_8_4138 r0 *1 0,0
Xsg13cmos5l_decap_8_4138 VPWR VGND sg13cmos5l_decap_8
* cell instance sg13cmos5l_decap_8_4139 r0 *1 0,0
Xsg13cmos5l_decap_8_4139 VPWR VGND sg13cmos5l_decap_8
* cell instance sg13cmos5l_decap_8_4140 r0 *1 0,0
Xsg13cmos5l_decap_8_4140 VPWR VGND sg13cmos5l_decap_8
* cell instance sg13cmos5l_decap_8_4141 r0 *1 0,0
Xsg13cmos5l_decap_8_4141 VPWR VGND sg13cmos5l_decap_8
* cell instance sg13cmos5l_decap_8_4142 r0 *1 0,0
Xsg13cmos5l_decap_8_4142 VPWR VGND sg13cmos5l_decap_8
* cell instance sg13cmos5l_decap_8_4143 r0 *1 0,0
Xsg13cmos5l_decap_8_4143 VPWR VGND sg13cmos5l_decap_8
* cell instance sg13cmos5l_decap_8_4144 r0 *1 0,0
Xsg13cmos5l_decap_8_4144 VPWR VGND sg13cmos5l_decap_8
* cell instance sg13cmos5l_decap_8_4145 r0 *1 0,0
Xsg13cmos5l_decap_8_4145 VPWR VGND sg13cmos5l_decap_8
* cell instance sg13cmos5l_decap_8_4146 r0 *1 0,0
Xsg13cmos5l_decap_8_4146 VPWR VGND sg13cmos5l_decap_8
* cell instance sg13cmos5l_decap_8_4147 r0 *1 0,0
Xsg13cmos5l_decap_8_4147 VPWR VGND sg13cmos5l_decap_8
* cell instance sg13cmos5l_decap_8_4148 r0 *1 0,0
Xsg13cmos5l_decap_8_4148 VPWR VGND sg13cmos5l_decap_8
* cell instance sg13cmos5l_decap_8_4149 r0 *1 0,0
Xsg13cmos5l_decap_8_4149 VPWR VGND sg13cmos5l_decap_8
* cell instance sg13cmos5l_decap_8_4150 r0 *1 0,0
Xsg13cmos5l_decap_8_4150 VPWR VGND sg13cmos5l_decap_8
* cell instance sg13cmos5l_decap_8_4151 r0 *1 0,0
Xsg13cmos5l_decap_8_4151 VPWR VGND sg13cmos5l_decap_8
* cell instance sg13cmos5l_decap_8_4152 r0 *1 0,0
Xsg13cmos5l_decap_8_4152 VPWR VGND sg13cmos5l_decap_8
* cell instance sg13cmos5l_decap_8_4153 r0 *1 0,0
Xsg13cmos5l_decap_8_4153 VPWR VGND sg13cmos5l_decap_8
* cell instance sg13cmos5l_decap_8_4154 r0 *1 0,0
Xsg13cmos5l_decap_8_4154 VPWR VGND sg13cmos5l_decap_8
* cell instance sg13cmos5l_decap_8_4155 r0 *1 0,0
Xsg13cmos5l_decap_8_4155 VPWR VGND sg13cmos5l_decap_8
* cell instance sg13cmos5l_decap_8_4156 r0 *1 0,0
Xsg13cmos5l_decap_8_4156 VPWR VGND sg13cmos5l_decap_8
* cell instance sg13cmos5l_decap_8_4157 r0 *1 0,0
Xsg13cmos5l_decap_8_4157 VPWR VGND sg13cmos5l_decap_8
* cell instance sg13cmos5l_decap_8_4158 r0 *1 0,0
Xsg13cmos5l_decap_8_4158 VPWR VGND sg13cmos5l_decap_8
* cell instance sg13cmos5l_decap_8_4159 r0 *1 0,0
Xsg13cmos5l_decap_8_4159 VPWR VGND sg13cmos5l_decap_8
* cell instance sg13cmos5l_decap_8_4160 r0 *1 0,0
Xsg13cmos5l_decap_8_4160 VPWR VGND sg13cmos5l_decap_8
* cell instance sg13cmos5l_decap_8_4161 r0 *1 0,0
Xsg13cmos5l_decap_8_4161 VPWR VGND sg13cmos5l_decap_8
* cell instance sg13cmos5l_decap_8_4162 r0 *1 0,0
Xsg13cmos5l_decap_8_4162 VPWR VGND sg13cmos5l_decap_8
* cell instance sg13cmos5l_decap_8_4163 r0 *1 0,0
Xsg13cmos5l_decap_8_4163 VPWR VGND sg13cmos5l_decap_8
* cell instance sg13cmos5l_decap_8_4164 r0 *1 0,0
Xsg13cmos5l_decap_8_4164 VPWR VGND sg13cmos5l_decap_8
* cell instance sg13cmos5l_decap_8_4165 r0 *1 0,0
Xsg13cmos5l_decap_8_4165 VPWR VGND sg13cmos5l_decap_8
* cell instance sg13cmos5l_decap_8_4166 r0 *1 0,0
Xsg13cmos5l_decap_8_4166 VPWR VGND sg13cmos5l_decap_8
* cell instance sg13cmos5l_decap_8_4167 r0 *1 0,0
Xsg13cmos5l_decap_8_4167 VPWR VGND sg13cmos5l_decap_8
* cell instance sg13cmos5l_decap_8_4168 r0 *1 0,0
Xsg13cmos5l_decap_8_4168 VPWR VGND sg13cmos5l_decap_8
* cell instance sg13cmos5l_decap_8_4169 r0 *1 0,0
Xsg13cmos5l_decap_8_4169 VPWR VGND sg13cmos5l_decap_8
* cell instance sg13cmos5l_decap_8_4170 r0 *1 0,0
Xsg13cmos5l_decap_8_4170 VPWR VGND sg13cmos5l_decap_8
* cell instance sg13cmos5l_decap_8_4171 r0 *1 0,0
Xsg13cmos5l_decap_8_4171 VPWR VGND sg13cmos5l_decap_8
* cell instance sg13cmos5l_decap_8_4172 r0 *1 0,0
Xsg13cmos5l_decap_8_4172 VPWR VGND sg13cmos5l_decap_8
* cell instance sg13cmos5l_decap_8_4173 r0 *1 0,0
Xsg13cmos5l_decap_8_4173 VPWR VGND sg13cmos5l_decap_8
* cell instance sg13cmos5l_decap_8_4174 r0 *1 0,0
Xsg13cmos5l_decap_8_4174 VPWR VGND sg13cmos5l_decap_8
* cell instance sg13cmos5l_decap_8_4175 r0 *1 0,0
Xsg13cmos5l_decap_8_4175 VPWR VGND sg13cmos5l_decap_8
* cell instance sg13cmos5l_decap_8_4176 r0 *1 0,0
Xsg13cmos5l_decap_8_4176 VPWR VGND sg13cmos5l_decap_8
* cell instance sg13cmos5l_decap_8_4177 r0 *1 0,0
Xsg13cmos5l_decap_8_4177 VPWR VGND sg13cmos5l_decap_8
* cell instance sg13cmos5l_decap_8_4178 r0 *1 0,0
Xsg13cmos5l_decap_8_4178 VPWR VGND sg13cmos5l_decap_8
* cell instance sg13cmos5l_decap_8_4179 r0 *1 0,0
Xsg13cmos5l_decap_8_4179 VPWR VGND sg13cmos5l_decap_8
* cell instance sg13cmos5l_decap_8_4180 r0 *1 0,0
Xsg13cmos5l_decap_8_4180 VPWR VGND sg13cmos5l_decap_8
* cell instance sg13cmos5l_decap_8_4181 r0 *1 0,0
Xsg13cmos5l_decap_8_4181 VPWR VGND sg13cmos5l_decap_8
* cell instance sg13cmos5l_decap_8_4182 r0 *1 0,0
Xsg13cmos5l_decap_8_4182 VPWR VGND sg13cmos5l_decap_8
* cell instance sg13cmos5l_decap_8_4183 r0 *1 0,0
Xsg13cmos5l_decap_8_4183 VPWR VGND sg13cmos5l_decap_8
* cell instance sg13cmos5l_decap_8_4184 r0 *1 0,0
Xsg13cmos5l_decap_8_4184 VPWR VGND sg13cmos5l_decap_8
* cell instance sg13cmos5l_decap_8_4185 r0 *1 0,0
Xsg13cmos5l_decap_8_4185 VPWR VGND sg13cmos5l_decap_8
* cell instance sg13cmos5l_decap_8_4186 r0 *1 0,0
Xsg13cmos5l_decap_8_4186 VPWR VGND sg13cmos5l_decap_8
* cell instance sg13cmos5l_decap_8_4187 r0 *1 0,0
Xsg13cmos5l_decap_8_4187 VPWR VGND sg13cmos5l_decap_8
* cell instance sg13cmos5l_decap_8_4188 r0 *1 0,0
Xsg13cmos5l_decap_8_4188 VPWR VGND sg13cmos5l_decap_8
* cell instance sg13cmos5l_decap_8_4189 r0 *1 0,0
Xsg13cmos5l_decap_8_4189 VPWR VGND sg13cmos5l_decap_8
* cell instance sg13cmos5l_decap_8_4190 r0 *1 0,0
Xsg13cmos5l_decap_8_4190 VPWR VGND sg13cmos5l_decap_8
* cell instance sg13cmos5l_decap_8_4191 r0 *1 0,0
Xsg13cmos5l_decap_8_4191 VPWR VGND sg13cmos5l_decap_8
* cell instance sg13cmos5l_decap_8_4192 r0 *1 0,0
Xsg13cmos5l_decap_8_4192 VPWR VGND sg13cmos5l_decap_8
* cell instance sg13cmos5l_decap_8_4193 r0 *1 0,0
Xsg13cmos5l_decap_8_4193 VPWR VGND sg13cmos5l_decap_8
* cell instance sg13cmos5l_decap_8_4194 r0 *1 0,0
Xsg13cmos5l_decap_8_4194 VPWR VGND sg13cmos5l_decap_8
* cell instance sg13cmos5l_decap_8_4195 r0 *1 0,0
Xsg13cmos5l_decap_8_4195 VPWR VGND sg13cmos5l_decap_8
* cell instance sg13cmos5l_decap_8_4196 r0 *1 0,0
Xsg13cmos5l_decap_8_4196 VPWR VGND sg13cmos5l_decap_8
* cell instance sg13cmos5l_decap_8_4197 r0 *1 0,0
Xsg13cmos5l_decap_8_4197 VPWR VGND sg13cmos5l_decap_8
* cell instance sg13cmos5l_decap_8_4198 r0 *1 0,0
Xsg13cmos5l_decap_8_4198 VPWR VGND sg13cmos5l_decap_8
* cell instance sg13cmos5l_decap_8_4199 r0 *1 0,0
Xsg13cmos5l_decap_8_4199 VPWR VGND sg13cmos5l_decap_8
* cell instance sg13cmos5l_decap_8_4200 r0 *1 0,0
Xsg13cmos5l_decap_8_4200 VPWR VGND sg13cmos5l_decap_8
* cell instance sg13cmos5l_decap_8_4201 r0 *1 0,0
Xsg13cmos5l_decap_8_4201 VPWR VGND sg13cmos5l_decap_8
* cell instance sg13cmos5l_decap_8_4202 r0 *1 0,0
Xsg13cmos5l_decap_8_4202 VPWR VGND sg13cmos5l_decap_8
* cell instance sg13cmos5l_decap_8_4203 r0 *1 0,0
Xsg13cmos5l_decap_8_4203 VPWR VGND sg13cmos5l_decap_8
* cell instance sg13cmos5l_decap_8_4204 r0 *1 0,0
Xsg13cmos5l_decap_8_4204 VPWR VGND sg13cmos5l_decap_8
* cell instance sg13cmos5l_decap_8_4205 r0 *1 0,0
Xsg13cmos5l_decap_8_4205 VPWR VGND sg13cmos5l_decap_8
* cell instance sg13cmos5l_decap_8_4206 r0 *1 0,0
Xsg13cmos5l_decap_8_4206 VPWR VGND sg13cmos5l_decap_8
* cell instance sg13cmos5l_decap_8_4207 r0 *1 0,0
Xsg13cmos5l_decap_8_4207 VPWR VGND sg13cmos5l_decap_8
* cell instance sg13cmos5l_decap_8_4208 r0 *1 0,0
Xsg13cmos5l_decap_8_4208 VPWR VGND sg13cmos5l_decap_8
* cell instance sg13cmos5l_decap_8_4209 r0 *1 0,0
Xsg13cmos5l_decap_8_4209 VPWR VGND sg13cmos5l_decap_8
* cell instance sg13cmos5l_decap_8_4210 r0 *1 0,0
Xsg13cmos5l_decap_8_4210 VPWR VGND sg13cmos5l_decap_8
* cell instance sg13cmos5l_decap_8_4211 r0 *1 0,0
Xsg13cmos5l_decap_8_4211 VPWR VGND sg13cmos5l_decap_8
* cell instance sg13cmos5l_decap_8_4212 r0 *1 0,0
Xsg13cmos5l_decap_8_4212 VPWR VGND sg13cmos5l_decap_8
* cell instance sg13cmos5l_decap_8_4213 r0 *1 0,0
Xsg13cmos5l_decap_8_4213 VPWR VGND sg13cmos5l_decap_8
* cell instance sg13cmos5l_decap_8_4214 r0 *1 0,0
Xsg13cmos5l_decap_8_4214 VPWR VGND sg13cmos5l_decap_8
* cell instance sg13cmos5l_decap_8_4215 r0 *1 0,0
Xsg13cmos5l_decap_8_4215 VPWR VGND sg13cmos5l_decap_8
* cell instance sg13cmos5l_decap_8_4216 r0 *1 0,0
Xsg13cmos5l_decap_8_4216 VPWR VGND sg13cmos5l_decap_8
* cell instance sg13cmos5l_decap_8_4217 r0 *1 0,0
Xsg13cmos5l_decap_8_4217 VPWR VGND sg13cmos5l_decap_8
* cell instance sg13cmos5l_decap_8_4218 r0 *1 0,0
Xsg13cmos5l_decap_8_4218 VPWR VGND sg13cmos5l_decap_8
* cell instance sg13cmos5l_decap_8_4219 r0 *1 0,0
Xsg13cmos5l_decap_8_4219 VPWR VGND sg13cmos5l_decap_8
* cell instance sg13cmos5l_decap_8_4220 r0 *1 0,0
Xsg13cmos5l_decap_8_4220 VPWR VGND sg13cmos5l_decap_8
* cell instance sg13cmos5l_decap_8_4221 r0 *1 0,0
Xsg13cmos5l_decap_8_4221 VPWR VGND sg13cmos5l_decap_8
* cell instance sg13cmos5l_decap_8_4222 r0 *1 0,0
Xsg13cmos5l_decap_8_4222 VPWR VGND sg13cmos5l_decap_8
* cell instance sg13cmos5l_decap_8_4223 r0 *1 0,0
Xsg13cmos5l_decap_8_4223 VPWR VGND sg13cmos5l_decap_8
* cell instance sg13cmos5l_decap_8_4224 r0 *1 0,0
Xsg13cmos5l_decap_8_4224 VPWR VGND sg13cmos5l_decap_8
* cell instance sg13cmos5l_decap_8_4225 r0 *1 0,0
Xsg13cmos5l_decap_8_4225 VPWR VGND sg13cmos5l_decap_8
* cell instance sg13cmos5l_decap_8_4226 r0 *1 0,0
Xsg13cmos5l_decap_8_4226 VPWR VGND sg13cmos5l_decap_8
* cell instance sg13cmos5l_decap_8_4227 r0 *1 0,0
Xsg13cmos5l_decap_8_4227 VPWR VGND sg13cmos5l_decap_8
* cell instance sg13cmos5l_decap_8_4228 r0 *1 0,0
Xsg13cmos5l_decap_8_4228 VPWR VGND sg13cmos5l_decap_8
* cell instance sg13cmos5l_decap_8_4229 r0 *1 0,0
Xsg13cmos5l_decap_8_4229 VPWR VGND sg13cmos5l_decap_8
* cell instance sg13cmos5l_decap_8_4230 r0 *1 0,0
Xsg13cmos5l_decap_8_4230 VPWR VGND sg13cmos5l_decap_8
* cell instance sg13cmos5l_decap_8_4231 r0 *1 0,0
Xsg13cmos5l_decap_8_4231 VPWR VGND sg13cmos5l_decap_8
* cell instance sg13cmos5l_decap_8_4232 r0 *1 0,0
Xsg13cmos5l_decap_8_4232 VPWR VGND sg13cmos5l_decap_8
* cell instance sg13cmos5l_decap_8_4233 r0 *1 0,0
Xsg13cmos5l_decap_8_4233 VPWR VGND sg13cmos5l_decap_8
* cell instance sg13cmos5l_decap_8_4234 r0 *1 0,0
Xsg13cmos5l_decap_8_4234 VPWR VGND sg13cmos5l_decap_8
* cell instance sg13cmos5l_decap_8_4235 r0 *1 0,0
Xsg13cmos5l_decap_8_4235 VPWR VGND sg13cmos5l_decap_8
* cell instance sg13cmos5l_decap_8_4236 r0 *1 0,0
Xsg13cmos5l_decap_8_4236 VPWR VGND sg13cmos5l_decap_8
* cell instance sg13cmos5l_decap_8_4237 r0 *1 0,0
Xsg13cmos5l_decap_8_4237 VPWR VGND sg13cmos5l_decap_8
* cell instance sg13cmos5l_decap_8_4238 r0 *1 0,0
Xsg13cmos5l_decap_8_4238 VPWR VGND sg13cmos5l_decap_8
* cell instance sg13cmos5l_decap_8_4239 r0 *1 0,0
Xsg13cmos5l_decap_8_4239 VPWR VGND sg13cmos5l_decap_8
* cell instance sg13cmos5l_decap_8_4240 r0 *1 0,0
Xsg13cmos5l_decap_8_4240 VPWR VGND sg13cmos5l_decap_8
* cell instance sg13cmos5l_decap_8_4241 r0 *1 0,0
Xsg13cmos5l_decap_8_4241 VPWR VGND sg13cmos5l_decap_8
* cell instance sg13cmos5l_decap_8_4242 r0 *1 0,0
Xsg13cmos5l_decap_8_4242 VPWR VGND sg13cmos5l_decap_8
* cell instance sg13cmos5l_decap_8_4243 r0 *1 0,0
Xsg13cmos5l_decap_8_4243 VPWR VGND sg13cmos5l_decap_8
* cell instance sg13cmos5l_decap_8_4244 r0 *1 0,0
Xsg13cmos5l_decap_8_4244 VPWR VGND sg13cmos5l_decap_8
* cell instance sg13cmos5l_decap_8_4245 r0 *1 0,0
Xsg13cmos5l_decap_8_4245 VPWR VGND sg13cmos5l_decap_8
* cell instance sg13cmos5l_decap_8_4246 r0 *1 0,0
Xsg13cmos5l_decap_8_4246 VPWR VGND sg13cmos5l_decap_8
* cell instance sg13cmos5l_decap_8_4247 r0 *1 0,0
Xsg13cmos5l_decap_8_4247 VPWR VGND sg13cmos5l_decap_8
* cell instance sg13cmos5l_decap_8_4248 r0 *1 0,0
Xsg13cmos5l_decap_8_4248 VPWR VGND sg13cmos5l_decap_8
* cell instance sg13cmos5l_decap_8_4249 r0 *1 0,0
Xsg13cmos5l_decap_8_4249 VPWR VGND sg13cmos5l_decap_8
* cell instance sg13cmos5l_decap_8_4250 r0 *1 0,0
Xsg13cmos5l_decap_8_4250 VPWR VGND sg13cmos5l_decap_8
* cell instance sg13cmos5l_decap_8_4251 r0 *1 0,0
Xsg13cmos5l_decap_8_4251 VPWR VGND sg13cmos5l_decap_8
* cell instance sg13cmos5l_decap_8_4252 r0 *1 0,0
Xsg13cmos5l_decap_8_4252 VPWR VGND sg13cmos5l_decap_8
* cell instance sg13cmos5l_decap_8_4253 r0 *1 0,0
Xsg13cmos5l_decap_8_4253 VPWR VGND sg13cmos5l_decap_8
* cell instance sg13cmos5l_decap_8_4254 r0 *1 0,0
Xsg13cmos5l_decap_8_4254 VPWR VGND sg13cmos5l_decap_8
* cell instance sg13cmos5l_decap_8_4255 r0 *1 0,0
Xsg13cmos5l_decap_8_4255 VPWR VGND sg13cmos5l_decap_8
* cell instance sg13cmos5l_decap_8_4256 r0 *1 0,0
Xsg13cmos5l_decap_8_4256 VPWR VGND sg13cmos5l_decap_8
* cell instance sg13cmos5l_decap_8_4257 r0 *1 0,0
Xsg13cmos5l_decap_8_4257 VPWR VGND sg13cmos5l_decap_8
* cell instance sg13cmos5l_decap_8_4258 r0 *1 0,0
Xsg13cmos5l_decap_8_4258 VPWR VGND sg13cmos5l_decap_8
* cell instance sg13cmos5l_decap_8_4259 r0 *1 0,0
Xsg13cmos5l_decap_8_4259 VPWR VGND sg13cmos5l_decap_8
* cell instance sg13cmos5l_decap_8_4260 r0 *1 0,0
Xsg13cmos5l_decap_8_4260 VPWR VGND sg13cmos5l_decap_8
* cell instance sg13cmos5l_decap_8_4261 r0 *1 0,0
Xsg13cmos5l_decap_8_4261 VPWR VGND sg13cmos5l_decap_8
* cell instance sg13cmos5l_decap_8_4262 r0 *1 0,0
Xsg13cmos5l_decap_8_4262 VPWR VGND sg13cmos5l_decap_8
* cell instance sg13cmos5l_decap_8_4263 r0 *1 0,0
Xsg13cmos5l_decap_8_4263 VPWR VGND sg13cmos5l_decap_8
* cell instance sg13cmos5l_decap_8_4264 r0 *1 0,0
Xsg13cmos5l_decap_8_4264 VPWR VGND sg13cmos5l_decap_8
* cell instance sg13cmos5l_decap_8_4265 r0 *1 0,0
Xsg13cmos5l_decap_8_4265 VPWR VGND sg13cmos5l_decap_8
* cell instance sg13cmos5l_decap_8_4266 r0 *1 0,0
Xsg13cmos5l_decap_8_4266 VPWR VGND sg13cmos5l_decap_8
* cell instance sg13cmos5l_decap_8_4267 r0 *1 0,0
Xsg13cmos5l_decap_8_4267 VPWR VGND sg13cmos5l_decap_8
* cell instance sg13cmos5l_decap_8_4268 r0 *1 0,0
Xsg13cmos5l_decap_8_4268 VPWR VGND sg13cmos5l_decap_8
* cell instance sg13cmos5l_decap_8_4269 r0 *1 0,0
Xsg13cmos5l_decap_8_4269 VPWR VGND sg13cmos5l_decap_8
* cell instance sg13cmos5l_decap_8_4270 r0 *1 0,0
Xsg13cmos5l_decap_8_4270 VPWR VGND sg13cmos5l_decap_8
* cell instance sg13cmos5l_decap_8_4271 r0 *1 0,0
Xsg13cmos5l_decap_8_4271 VPWR VGND sg13cmos5l_decap_8
* cell instance sg13cmos5l_decap_8_4272 r0 *1 0,0
Xsg13cmos5l_decap_8_4272 VPWR VGND sg13cmos5l_decap_8
* cell instance sg13cmos5l_decap_8_4273 r0 *1 0,0
Xsg13cmos5l_decap_8_4273 VPWR VGND sg13cmos5l_decap_8
* cell instance sg13cmos5l_decap_8_4274 r0 *1 0,0
Xsg13cmos5l_decap_8_4274 VPWR VGND sg13cmos5l_decap_8
* cell instance sg13cmos5l_decap_8_4275 r0 *1 0,0
Xsg13cmos5l_decap_8_4275 VPWR VGND sg13cmos5l_decap_8
* cell instance sg13cmos5l_decap_8_4276 r0 *1 0,0
Xsg13cmos5l_decap_8_4276 VPWR VGND sg13cmos5l_decap_8
* cell instance sg13cmos5l_decap_8_4277 r0 *1 0,0
Xsg13cmos5l_decap_8_4277 VPWR VGND sg13cmos5l_decap_8
* cell instance sg13cmos5l_decap_8_4278 r0 *1 0,0
Xsg13cmos5l_decap_8_4278 VPWR VGND sg13cmos5l_decap_8
* cell instance sg13cmos5l_decap_8_4279 r0 *1 0,0
Xsg13cmos5l_decap_8_4279 VPWR VGND sg13cmos5l_decap_8
* cell instance sg13cmos5l_decap_8_4280 r0 *1 0,0
Xsg13cmos5l_decap_8_4280 VPWR VGND sg13cmos5l_decap_8
* cell instance sg13cmos5l_decap_8_4281 r0 *1 0,0
Xsg13cmos5l_decap_8_4281 VPWR VGND sg13cmos5l_decap_8
* cell instance sg13cmos5l_decap_8_4282 r0 *1 0,0
Xsg13cmos5l_decap_8_4282 VPWR VGND sg13cmos5l_decap_8
* cell instance sg13cmos5l_decap_8_4283 r0 *1 0,0
Xsg13cmos5l_decap_8_4283 VPWR VGND sg13cmos5l_decap_8
* cell instance sg13cmos5l_decap_8_4284 r0 *1 0,0
Xsg13cmos5l_decap_8_4284 VPWR VGND sg13cmos5l_decap_8
* cell instance sg13cmos5l_decap_8_4285 r0 *1 0,0
Xsg13cmos5l_decap_8_4285 VPWR VGND sg13cmos5l_decap_8
* cell instance sg13cmos5l_decap_8_4286 r0 *1 0,0
Xsg13cmos5l_decap_8_4286 VPWR VGND sg13cmos5l_decap_8
* cell instance sg13cmos5l_decap_8_4287 r0 *1 0,0
Xsg13cmos5l_decap_8_4287 VPWR VGND sg13cmos5l_decap_8
* cell instance sg13cmos5l_decap_8_4288 r0 *1 0,0
Xsg13cmos5l_decap_8_4288 VPWR VGND sg13cmos5l_decap_8
* cell instance sg13cmos5l_decap_8_4289 r0 *1 0,0
Xsg13cmos5l_decap_8_4289 VPWR VGND sg13cmos5l_decap_8
* cell instance sg13cmos5l_decap_8_4290 r0 *1 0,0
Xsg13cmos5l_decap_8_4290 VPWR VGND sg13cmos5l_decap_8
* cell instance sg13cmos5l_decap_8_4291 r0 *1 0,0
Xsg13cmos5l_decap_8_4291 VPWR VGND sg13cmos5l_decap_8
* cell instance sg13cmos5l_decap_8_4292 r0 *1 0,0
Xsg13cmos5l_decap_8_4292 VPWR VGND sg13cmos5l_decap_8
* cell instance sg13cmos5l_decap_8_4293 r0 *1 0,0
Xsg13cmos5l_decap_8_4293 VPWR VGND sg13cmos5l_decap_8
* cell instance sg13cmos5l_decap_8_4294 r0 *1 0,0
Xsg13cmos5l_decap_8_4294 VPWR VGND sg13cmos5l_decap_8
* cell instance sg13cmos5l_decap_8_4295 r0 *1 0,0
Xsg13cmos5l_decap_8_4295 VPWR VGND sg13cmos5l_decap_8
* cell instance sg13cmos5l_decap_8_4296 r0 *1 0,0
Xsg13cmos5l_decap_8_4296 VPWR VGND sg13cmos5l_decap_8
* cell instance sg13cmos5l_decap_8_4297 r0 *1 0,0
Xsg13cmos5l_decap_8_4297 VPWR VGND sg13cmos5l_decap_8
* cell instance sg13cmos5l_decap_8_4298 r0 *1 0,0
Xsg13cmos5l_decap_8_4298 VPWR VGND sg13cmos5l_decap_8
* cell instance sg13cmos5l_decap_8_4299 r0 *1 0,0
Xsg13cmos5l_decap_8_4299 VPWR VGND sg13cmos5l_decap_8
* cell instance sg13cmos5l_decap_8_4300 r0 *1 0,0
Xsg13cmos5l_decap_8_4300 VPWR VGND sg13cmos5l_decap_8
* cell instance sg13cmos5l_decap_8_4301 r0 *1 0,0
Xsg13cmos5l_decap_8_4301 VPWR VGND sg13cmos5l_decap_8
* cell instance sg13cmos5l_decap_8_4302 r0 *1 0,0
Xsg13cmos5l_decap_8_4302 VPWR VGND sg13cmos5l_decap_8
* cell instance sg13cmos5l_decap_8_4303 r0 *1 0,0
Xsg13cmos5l_decap_8_4303 VPWR VGND sg13cmos5l_decap_8
* cell instance sg13cmos5l_decap_8_4304 r0 *1 0,0
Xsg13cmos5l_decap_8_4304 VPWR VGND sg13cmos5l_decap_8
* cell instance sg13cmos5l_decap_8_4305 r0 *1 0,0
Xsg13cmos5l_decap_8_4305 VPWR VGND sg13cmos5l_decap_8
* cell instance sg13cmos5l_decap_8_4306 r0 *1 0,0
Xsg13cmos5l_decap_8_4306 VPWR VGND sg13cmos5l_decap_8
* cell instance sg13cmos5l_decap_8_4307 r0 *1 0,0
Xsg13cmos5l_decap_8_4307 VPWR VGND sg13cmos5l_decap_8
* cell instance sg13cmos5l_decap_8_4308 r0 *1 0,0
Xsg13cmos5l_decap_8_4308 VPWR VGND sg13cmos5l_decap_8
* cell instance sg13cmos5l_decap_8_4309 r0 *1 0,0
Xsg13cmos5l_decap_8_4309 VPWR VGND sg13cmos5l_decap_8
* cell instance sg13cmos5l_decap_8_4310 r0 *1 0,0
Xsg13cmos5l_decap_8_4310 VPWR VGND sg13cmos5l_decap_8
* cell instance sg13cmos5l_decap_8_4311 r0 *1 0,0
Xsg13cmos5l_decap_8_4311 VPWR VGND sg13cmos5l_decap_8
* cell instance sg13cmos5l_decap_8_4312 r0 *1 0,0
Xsg13cmos5l_decap_8_4312 VPWR VGND sg13cmos5l_decap_8
* cell instance sg13cmos5l_decap_8_4313 r0 *1 0,0
Xsg13cmos5l_decap_8_4313 VPWR VGND sg13cmos5l_decap_8
* cell instance sg13cmos5l_decap_8_4314 r0 *1 0,0
Xsg13cmos5l_decap_8_4314 VPWR VGND sg13cmos5l_decap_8
* cell instance sg13cmos5l_decap_8_4315 r0 *1 0,0
Xsg13cmos5l_decap_8_4315 VPWR VGND sg13cmos5l_decap_8
* cell instance sg13cmos5l_decap_8_4316 r0 *1 0,0
Xsg13cmos5l_decap_8_4316 VPWR VGND sg13cmos5l_decap_8
* cell instance sg13cmos5l_decap_8_4317 r0 *1 0,0
Xsg13cmos5l_decap_8_4317 VPWR VGND sg13cmos5l_decap_8
* cell instance sg13cmos5l_decap_8_4318 r0 *1 0,0
Xsg13cmos5l_decap_8_4318 VPWR VGND sg13cmos5l_decap_8
* cell instance sg13cmos5l_decap_8_4319 r0 *1 0,0
Xsg13cmos5l_decap_8_4319 VPWR VGND sg13cmos5l_decap_8
* cell instance sg13cmos5l_decap_8_4320 r0 *1 0,0
Xsg13cmos5l_decap_8_4320 VPWR VGND sg13cmos5l_decap_8
* cell instance sg13cmos5l_decap_8_4321 r0 *1 0,0
Xsg13cmos5l_decap_8_4321 VPWR VGND sg13cmos5l_decap_8
* cell instance sg13cmos5l_decap_8_4322 r0 *1 0,0
Xsg13cmos5l_decap_8_4322 VPWR VGND sg13cmos5l_decap_8
* cell instance sg13cmos5l_decap_8_4323 r0 *1 0,0
Xsg13cmos5l_decap_8_4323 VPWR VGND sg13cmos5l_decap_8
* cell instance sg13cmos5l_decap_8_4324 r0 *1 0,0
Xsg13cmos5l_decap_8_4324 VPWR VGND sg13cmos5l_decap_8
* cell instance sg13cmos5l_decap_8_4325 r0 *1 0,0
Xsg13cmos5l_decap_8_4325 VPWR VGND sg13cmos5l_decap_8
* cell instance sg13cmos5l_decap_8_4326 r0 *1 0,0
Xsg13cmos5l_decap_8_4326 VPWR VGND sg13cmos5l_decap_8
* cell instance sg13cmos5l_decap_8_4327 r0 *1 0,0
Xsg13cmos5l_decap_8_4327 VPWR VGND sg13cmos5l_decap_8
* cell instance sg13cmos5l_decap_8_4328 r0 *1 0,0
Xsg13cmos5l_decap_8_4328 VPWR VGND sg13cmos5l_decap_8
* cell instance sg13cmos5l_decap_8_4329 r0 *1 0,0
Xsg13cmos5l_decap_8_4329 VPWR VGND sg13cmos5l_decap_8
* cell instance sg13cmos5l_decap_8_4330 r0 *1 0,0
Xsg13cmos5l_decap_8_4330 VPWR VGND sg13cmos5l_decap_8
* cell instance sg13cmos5l_decap_8_4331 r0 *1 0,0
Xsg13cmos5l_decap_8_4331 VPWR VGND sg13cmos5l_decap_8
* cell instance sg13cmos5l_decap_8_4332 r0 *1 0,0
Xsg13cmos5l_decap_8_4332 VPWR VGND sg13cmos5l_decap_8
* cell instance sg13cmos5l_decap_8_4333 r0 *1 0,0
Xsg13cmos5l_decap_8_4333 VPWR VGND sg13cmos5l_decap_8
* cell instance sg13cmos5l_decap_8_4334 r0 *1 0,0
Xsg13cmos5l_decap_8_4334 VPWR VGND sg13cmos5l_decap_8
* cell instance sg13cmos5l_decap_8_4335 r0 *1 0,0
Xsg13cmos5l_decap_8_4335 VPWR VGND sg13cmos5l_decap_8
* cell instance sg13cmos5l_decap_8_4336 r0 *1 0,0
Xsg13cmos5l_decap_8_4336 VPWR VGND sg13cmos5l_decap_8
* cell instance sg13cmos5l_decap_8_4337 r0 *1 0,0
Xsg13cmos5l_decap_8_4337 VPWR VGND sg13cmos5l_decap_8
* cell instance sg13cmos5l_decap_8_4338 r0 *1 0,0
Xsg13cmos5l_decap_8_4338 VPWR VGND sg13cmos5l_decap_8
* cell instance sg13cmos5l_decap_8_4339 r0 *1 0,0
Xsg13cmos5l_decap_8_4339 VPWR VGND sg13cmos5l_decap_8
* cell instance sg13cmos5l_decap_8_4340 r0 *1 0,0
Xsg13cmos5l_decap_8_4340 VPWR VGND sg13cmos5l_decap_8
* cell instance sg13cmos5l_decap_8_4341 r0 *1 0,0
Xsg13cmos5l_decap_8_4341 VPWR VGND sg13cmos5l_decap_8
* cell instance sg13cmos5l_decap_8_4342 r0 *1 0,0
Xsg13cmos5l_decap_8_4342 VPWR VGND sg13cmos5l_decap_8
* cell instance sg13cmos5l_decap_8_4343 r0 *1 0,0
Xsg13cmos5l_decap_8_4343 VPWR VGND sg13cmos5l_decap_8
* cell instance sg13cmos5l_decap_8_4344 r0 *1 0,0
Xsg13cmos5l_decap_8_4344 VPWR VGND sg13cmos5l_decap_8
* cell instance sg13cmos5l_decap_8_4345 r0 *1 0,0
Xsg13cmos5l_decap_8_4345 VPWR VGND sg13cmos5l_decap_8
* cell instance sg13cmos5l_decap_8_4346 r0 *1 0,0
Xsg13cmos5l_decap_8_4346 VPWR VGND sg13cmos5l_decap_8
* cell instance sg13cmos5l_decap_8_4347 r0 *1 0,0
Xsg13cmos5l_decap_8_4347 VPWR VGND sg13cmos5l_decap_8
* cell instance sg13cmos5l_decap_8_4348 r0 *1 0,0
Xsg13cmos5l_decap_8_4348 VPWR VGND sg13cmos5l_decap_8
* cell instance sg13cmos5l_decap_8_4349 r0 *1 0,0
Xsg13cmos5l_decap_8_4349 VPWR VGND sg13cmos5l_decap_8
* cell instance sg13cmos5l_decap_8_4350 r0 *1 0,0
Xsg13cmos5l_decap_8_4350 VPWR VGND sg13cmos5l_decap_8
* cell instance sg13cmos5l_decap_8_4351 r0 *1 0,0
Xsg13cmos5l_decap_8_4351 VPWR VGND sg13cmos5l_decap_8
* cell instance sg13cmos5l_decap_8_4352 r0 *1 0,0
Xsg13cmos5l_decap_8_4352 VPWR VGND sg13cmos5l_decap_8
* cell instance sg13cmos5l_decap_8_4353 r0 *1 0,0
Xsg13cmos5l_decap_8_4353 VPWR VGND sg13cmos5l_decap_8
* cell instance sg13cmos5l_decap_8_4354 r0 *1 0,0
Xsg13cmos5l_decap_8_4354 VPWR VGND sg13cmos5l_decap_8
* cell instance sg13cmos5l_decap_8_4355 r0 *1 0,0
Xsg13cmos5l_decap_8_4355 VPWR VGND sg13cmos5l_decap_8
* cell instance sg13cmos5l_decap_8_4356 r0 *1 0,0
Xsg13cmos5l_decap_8_4356 VPWR VGND sg13cmos5l_decap_8
* cell instance sg13cmos5l_decap_8_4357 r0 *1 0,0
Xsg13cmos5l_decap_8_4357 VPWR VGND sg13cmos5l_decap_8
* cell instance sg13cmos5l_decap_8_4358 r0 *1 0,0
Xsg13cmos5l_decap_8_4358 VPWR VGND sg13cmos5l_decap_8
* cell instance sg13cmos5l_decap_8_4359 r0 *1 0,0
Xsg13cmos5l_decap_8_4359 VPWR VGND sg13cmos5l_decap_8
* cell instance sg13cmos5l_decap_8_4360 r0 *1 0,0
Xsg13cmos5l_decap_8_4360 VPWR VGND sg13cmos5l_decap_8
* cell instance sg13cmos5l_decap_8_4361 r0 *1 0,0
Xsg13cmos5l_decap_8_4361 VPWR VGND sg13cmos5l_decap_8
* cell instance sg13cmos5l_decap_8_4362 r0 *1 0,0
Xsg13cmos5l_decap_8_4362 VPWR VGND sg13cmos5l_decap_8
* cell instance sg13cmos5l_decap_8_4363 r0 *1 0,0
Xsg13cmos5l_decap_8_4363 VPWR VGND sg13cmos5l_decap_8
* cell instance sg13cmos5l_decap_8_4364 r0 *1 0,0
Xsg13cmos5l_decap_8_4364 VPWR VGND sg13cmos5l_decap_8
* cell instance sg13cmos5l_decap_8_4365 r0 *1 0,0
Xsg13cmos5l_decap_8_4365 VPWR VGND sg13cmos5l_decap_8
* cell instance sg13cmos5l_decap_8_4366 r0 *1 0,0
Xsg13cmos5l_decap_8_4366 VPWR VGND sg13cmos5l_decap_8
* cell instance sg13cmos5l_decap_8_4367 r0 *1 0,0
Xsg13cmos5l_decap_8_4367 VPWR VGND sg13cmos5l_decap_8
* cell instance sg13cmos5l_decap_8_4368 r0 *1 0,0
Xsg13cmos5l_decap_8_4368 VPWR VGND sg13cmos5l_decap_8
* cell instance sg13cmos5l_decap_8_4369 r0 *1 0,0
Xsg13cmos5l_decap_8_4369 VPWR VGND sg13cmos5l_decap_8
* cell instance sg13cmos5l_decap_8_4370 r0 *1 0,0
Xsg13cmos5l_decap_8_4370 VPWR VGND sg13cmos5l_decap_8
* cell instance sg13cmos5l_decap_8_4371 r0 *1 0,0
Xsg13cmos5l_decap_8_4371 VPWR VGND sg13cmos5l_decap_8
* cell instance sg13cmos5l_decap_8_4372 r0 *1 0,0
Xsg13cmos5l_decap_8_4372 VPWR VGND sg13cmos5l_decap_8
* cell instance sg13cmos5l_decap_8_4373 r0 *1 0,0
Xsg13cmos5l_decap_8_4373 VPWR VGND sg13cmos5l_decap_8
* cell instance sg13cmos5l_decap_8_4374 r0 *1 0,0
Xsg13cmos5l_decap_8_4374 VPWR VGND sg13cmos5l_decap_8
* cell instance sg13cmos5l_decap_8_4375 r0 *1 0,0
Xsg13cmos5l_decap_8_4375 VPWR VGND sg13cmos5l_decap_8
* cell instance sg13cmos5l_decap_8_4376 r0 *1 0,0
Xsg13cmos5l_decap_8_4376 VPWR VGND sg13cmos5l_decap_8
* cell instance sg13cmos5l_decap_8_4377 r0 *1 0,0
Xsg13cmos5l_decap_8_4377 VPWR VGND sg13cmos5l_decap_8
* cell instance sg13cmos5l_decap_8_4378 r0 *1 0,0
Xsg13cmos5l_decap_8_4378 VPWR VGND sg13cmos5l_decap_8
* cell instance sg13cmos5l_decap_8_4379 r0 *1 0,0
Xsg13cmos5l_decap_8_4379 VPWR VGND sg13cmos5l_decap_8
* cell instance sg13cmos5l_decap_8_4380 r0 *1 0,0
Xsg13cmos5l_decap_8_4380 VPWR VGND sg13cmos5l_decap_8
* cell instance sg13cmos5l_decap_8_4381 r0 *1 0,0
Xsg13cmos5l_decap_8_4381 VPWR VGND sg13cmos5l_decap_8
* cell instance sg13cmos5l_decap_8_4382 r0 *1 0,0
Xsg13cmos5l_decap_8_4382 VPWR VGND sg13cmos5l_decap_8
* cell instance sg13cmos5l_decap_8_4383 r0 *1 0,0
Xsg13cmos5l_decap_8_4383 VPWR VGND sg13cmos5l_decap_8
* cell instance sg13cmos5l_decap_8_4384 r0 *1 0,0
Xsg13cmos5l_decap_8_4384 VPWR VGND sg13cmos5l_decap_8
* cell instance sg13cmos5l_decap_8_4385 r0 *1 0,0
Xsg13cmos5l_decap_8_4385 VPWR VGND sg13cmos5l_decap_8
* cell instance sg13cmos5l_decap_8_4386 r0 *1 0,0
Xsg13cmos5l_decap_8_4386 VPWR VGND sg13cmos5l_decap_8
* cell instance sg13cmos5l_decap_8_4387 r0 *1 0,0
Xsg13cmos5l_decap_8_4387 VPWR VGND sg13cmos5l_decap_8
* cell instance sg13cmos5l_decap_8_4388 r0 *1 0,0
Xsg13cmos5l_decap_8_4388 VPWR VGND sg13cmos5l_decap_8
* cell instance sg13cmos5l_decap_8_4389 r0 *1 0,0
Xsg13cmos5l_decap_8_4389 VPWR VGND sg13cmos5l_decap_8
* cell instance sg13cmos5l_decap_8_4390 r0 *1 0,0
Xsg13cmos5l_decap_8_4390 VPWR VGND sg13cmos5l_decap_8
* cell instance sg13cmos5l_decap_8_4391 r0 *1 0,0
Xsg13cmos5l_decap_8_4391 VPWR VGND sg13cmos5l_decap_8
* cell instance sg13cmos5l_decap_8_4392 r0 *1 0,0
Xsg13cmos5l_decap_8_4392 VPWR VGND sg13cmos5l_decap_8
* cell instance sg13cmos5l_decap_8_4393 r0 *1 0,0
Xsg13cmos5l_decap_8_4393 VPWR VGND sg13cmos5l_decap_8
* cell instance sg13cmos5l_decap_8_4394 r0 *1 0,0
Xsg13cmos5l_decap_8_4394 VPWR VGND sg13cmos5l_decap_8
* cell instance sg13cmos5l_decap_8_4395 r0 *1 0,0
Xsg13cmos5l_decap_8_4395 VPWR VGND sg13cmos5l_decap_8
* cell instance sg13cmos5l_decap_8_4396 r0 *1 0,0
Xsg13cmos5l_decap_8_4396 VPWR VGND sg13cmos5l_decap_8
* cell instance sg13cmos5l_decap_8_4397 r0 *1 0,0
Xsg13cmos5l_decap_8_4397 VPWR VGND sg13cmos5l_decap_8
* cell instance sg13cmos5l_decap_8_4398 r0 *1 0,0
Xsg13cmos5l_decap_8_4398 VPWR VGND sg13cmos5l_decap_8
* cell instance sg13cmos5l_decap_8_4399 r0 *1 0,0
Xsg13cmos5l_decap_8_4399 VPWR VGND sg13cmos5l_decap_8
* cell instance sg13cmos5l_decap_8_4400 r0 *1 0,0
Xsg13cmos5l_decap_8_4400 VPWR VGND sg13cmos5l_decap_8
* cell instance sg13cmos5l_decap_8_4401 r0 *1 0,0
Xsg13cmos5l_decap_8_4401 VPWR VGND sg13cmos5l_decap_8
* cell instance sg13cmos5l_decap_8_4402 r0 *1 0,0
Xsg13cmos5l_decap_8_4402 VPWR VGND sg13cmos5l_decap_8
* cell instance sg13cmos5l_decap_8_4403 r0 *1 0,0
Xsg13cmos5l_decap_8_4403 VPWR VGND sg13cmos5l_decap_8
* cell instance sg13cmos5l_decap_8_4404 r0 *1 0,0
Xsg13cmos5l_decap_8_4404 VPWR VGND sg13cmos5l_decap_8
* cell instance sg13cmos5l_decap_8_4405 r0 *1 0,0
Xsg13cmos5l_decap_8_4405 VPWR VGND sg13cmos5l_decap_8
* cell instance sg13cmos5l_decap_8_4406 r0 *1 0,0
Xsg13cmos5l_decap_8_4406 VPWR VGND sg13cmos5l_decap_8
* cell instance sg13cmos5l_decap_8_4407 r0 *1 0,0
Xsg13cmos5l_decap_8_4407 VPWR VGND sg13cmos5l_decap_8
* cell instance sg13cmos5l_decap_8_4408 r0 *1 0,0
Xsg13cmos5l_decap_8_4408 VPWR VGND sg13cmos5l_decap_8
* cell instance sg13cmos5l_decap_8_4409 r0 *1 0,0
Xsg13cmos5l_decap_8_4409 VPWR VGND sg13cmos5l_decap_8
* cell instance sg13cmos5l_decap_8_4410 r0 *1 0,0
Xsg13cmos5l_decap_8_4410 VPWR VGND sg13cmos5l_decap_8
* cell instance sg13cmos5l_decap_8_4411 r0 *1 0,0
Xsg13cmos5l_decap_8_4411 VPWR VGND sg13cmos5l_decap_8
* cell instance sg13cmos5l_decap_8_4412 r0 *1 0,0
Xsg13cmos5l_decap_8_4412 VPWR VGND sg13cmos5l_decap_8
* cell instance sg13cmos5l_decap_8_4413 r0 *1 0,0
Xsg13cmos5l_decap_8_4413 VPWR VGND sg13cmos5l_decap_8
* cell instance sg13cmos5l_decap_8_4414 r0 *1 0,0
Xsg13cmos5l_decap_8_4414 VPWR VGND sg13cmos5l_decap_8
* cell instance sg13cmos5l_decap_8_4415 r0 *1 0,0
Xsg13cmos5l_decap_8_4415 VPWR VGND sg13cmos5l_decap_8
* cell instance sg13cmos5l_decap_8_4416 r0 *1 0,0
Xsg13cmos5l_decap_8_4416 VPWR VGND sg13cmos5l_decap_8
* cell instance sg13cmos5l_decap_8_4417 r0 *1 0,0
Xsg13cmos5l_decap_8_4417 VPWR VGND sg13cmos5l_decap_8
* cell instance sg13cmos5l_decap_8_4418 r0 *1 0,0
Xsg13cmos5l_decap_8_4418 VPWR VGND sg13cmos5l_decap_8
* cell instance sg13cmos5l_decap_8_4419 r0 *1 0,0
Xsg13cmos5l_decap_8_4419 VPWR VGND sg13cmos5l_decap_8
* cell instance sg13cmos5l_decap_8_4420 r0 *1 0,0
Xsg13cmos5l_decap_8_4420 VPWR VGND sg13cmos5l_decap_8
* cell instance sg13cmos5l_decap_8_4421 r0 *1 0,0
Xsg13cmos5l_decap_8_4421 VPWR VGND sg13cmos5l_decap_8
* cell instance sg13cmos5l_decap_8_4422 r0 *1 0,0
Xsg13cmos5l_decap_8_4422 VPWR VGND sg13cmos5l_decap_8
* cell instance sg13cmos5l_decap_8_4423 r0 *1 0,0
Xsg13cmos5l_decap_8_4423 VPWR VGND sg13cmos5l_decap_8
* cell instance sg13cmos5l_decap_8_4424 r0 *1 0,0
Xsg13cmos5l_decap_8_4424 VPWR VGND sg13cmos5l_decap_8
* cell instance sg13cmos5l_decap_8_4425 r0 *1 0,0
Xsg13cmos5l_decap_8_4425 VPWR VGND sg13cmos5l_decap_8
* cell instance sg13cmos5l_decap_8_4426 r0 *1 0,0
Xsg13cmos5l_decap_8_4426 VPWR VGND sg13cmos5l_decap_8
* cell instance sg13cmos5l_decap_8_4427 r0 *1 0,0
Xsg13cmos5l_decap_8_4427 VPWR VGND sg13cmos5l_decap_8
* cell instance sg13cmos5l_decap_8_4428 r0 *1 0,0
Xsg13cmos5l_decap_8_4428 VPWR VGND sg13cmos5l_decap_8
* cell instance sg13cmos5l_decap_8_4429 r0 *1 0,0
Xsg13cmos5l_decap_8_4429 VPWR VGND sg13cmos5l_decap_8
* cell instance sg13cmos5l_decap_8_4430 r0 *1 0,0
Xsg13cmos5l_decap_8_4430 VPWR VGND sg13cmos5l_decap_8
* cell instance sg13cmos5l_decap_8_4431 r0 *1 0,0
Xsg13cmos5l_decap_8_4431 VPWR VGND sg13cmos5l_decap_8
* cell instance sg13cmos5l_decap_8_4432 r0 *1 0,0
Xsg13cmos5l_decap_8_4432 VPWR VGND sg13cmos5l_decap_8
* cell instance sg13cmos5l_decap_8_4433 r0 *1 0,0
Xsg13cmos5l_decap_8_4433 VPWR VGND sg13cmos5l_decap_8
* cell instance sg13cmos5l_decap_8_4434 r0 *1 0,0
Xsg13cmos5l_decap_8_4434 VPWR VGND sg13cmos5l_decap_8
* cell instance sg13cmos5l_decap_8_4435 r0 *1 0,0
Xsg13cmos5l_decap_8_4435 VPWR VGND sg13cmos5l_decap_8
* cell instance sg13cmos5l_decap_8_4436 r0 *1 0,0
Xsg13cmos5l_decap_8_4436 VPWR VGND sg13cmos5l_decap_8
* cell instance sg13cmos5l_decap_8_4437 r0 *1 0,0
Xsg13cmos5l_decap_8_4437 VPWR VGND sg13cmos5l_decap_8
* cell instance sg13cmos5l_decap_8_4438 r0 *1 0,0
Xsg13cmos5l_decap_8_4438 VPWR VGND sg13cmos5l_decap_8
* cell instance sg13cmos5l_decap_8_4439 r0 *1 0,0
Xsg13cmos5l_decap_8_4439 VPWR VGND sg13cmos5l_decap_8
* cell instance sg13cmos5l_decap_8_4440 r0 *1 0,0
Xsg13cmos5l_decap_8_4440 VPWR VGND sg13cmos5l_decap_8
* cell instance sg13cmos5l_decap_8_4441 r0 *1 0,0
Xsg13cmos5l_decap_8_4441 VPWR VGND sg13cmos5l_decap_8
* cell instance sg13cmos5l_decap_8_4442 r0 *1 0,0
Xsg13cmos5l_decap_8_4442 VPWR VGND sg13cmos5l_decap_8
* cell instance sg13cmos5l_decap_8_4443 r0 *1 0,0
Xsg13cmos5l_decap_8_4443 VPWR VGND sg13cmos5l_decap_8
* cell instance sg13cmos5l_decap_8_4444 r0 *1 0,0
Xsg13cmos5l_decap_8_4444 VPWR VGND sg13cmos5l_decap_8
* cell instance sg13cmos5l_decap_8_4445 r0 *1 0,0
Xsg13cmos5l_decap_8_4445 VPWR VGND sg13cmos5l_decap_8
* cell instance sg13cmos5l_decap_8_4446 r0 *1 0,0
Xsg13cmos5l_decap_8_4446 VPWR VGND sg13cmos5l_decap_8
* cell instance sg13cmos5l_decap_8_4447 r0 *1 0,0
Xsg13cmos5l_decap_8_4447 VPWR VGND sg13cmos5l_decap_8
* cell instance sg13cmos5l_decap_8_4448 r0 *1 0,0
Xsg13cmos5l_decap_8_4448 VPWR VGND sg13cmos5l_decap_8
* cell instance sg13cmos5l_decap_8_4449 r0 *1 0,0
Xsg13cmos5l_decap_8_4449 VPWR VGND sg13cmos5l_decap_8
* cell instance sg13cmos5l_decap_8_4450 r0 *1 0,0
Xsg13cmos5l_decap_8_4450 VPWR VGND sg13cmos5l_decap_8
* cell instance sg13cmos5l_decap_8_4451 r0 *1 0,0
Xsg13cmos5l_decap_8_4451 VPWR VGND sg13cmos5l_decap_8
* cell instance sg13cmos5l_decap_8_4452 r0 *1 0,0
Xsg13cmos5l_decap_8_4452 VPWR VGND sg13cmos5l_decap_8
* cell instance sg13cmos5l_decap_8_4453 r0 *1 0,0
Xsg13cmos5l_decap_8_4453 VPWR VGND sg13cmos5l_decap_8
* cell instance sg13cmos5l_decap_8_4454 r0 *1 0,0
Xsg13cmos5l_decap_8_4454 VPWR VGND sg13cmos5l_decap_8
* cell instance sg13cmos5l_decap_8_4455 r0 *1 0,0
Xsg13cmos5l_decap_8_4455 VPWR VGND sg13cmos5l_decap_8
* cell instance sg13cmos5l_decap_8_4456 r0 *1 0,0
Xsg13cmos5l_decap_8_4456 VPWR VGND sg13cmos5l_decap_8
* cell instance sg13cmos5l_decap_8_4457 r0 *1 0,0
Xsg13cmos5l_decap_8_4457 VPWR VGND sg13cmos5l_decap_8
* cell instance sg13cmos5l_decap_8_4458 r0 *1 0,0
Xsg13cmos5l_decap_8_4458 VPWR VGND sg13cmos5l_decap_8
* cell instance sg13cmos5l_decap_8_4459 r0 *1 0,0
Xsg13cmos5l_decap_8_4459 VPWR VGND sg13cmos5l_decap_8
* cell instance sg13cmos5l_decap_8_4460 r0 *1 0,0
Xsg13cmos5l_decap_8_4460 VPWR VGND sg13cmos5l_decap_8
* cell instance sg13cmos5l_decap_8_4461 r0 *1 0,0
Xsg13cmos5l_decap_8_4461 VPWR VGND sg13cmos5l_decap_8
* cell instance sg13cmos5l_decap_8_4462 r0 *1 0,0
Xsg13cmos5l_decap_8_4462 VPWR VGND sg13cmos5l_decap_8
* cell instance sg13cmos5l_decap_8_4463 r0 *1 0,0
Xsg13cmos5l_decap_8_4463 VPWR VGND sg13cmos5l_decap_8
* cell instance sg13cmos5l_decap_8_4464 r0 *1 0,0
Xsg13cmos5l_decap_8_4464 VPWR VGND sg13cmos5l_decap_8
* cell instance sg13cmos5l_decap_8_4465 r0 *1 0,0
Xsg13cmos5l_decap_8_4465 VPWR VGND sg13cmos5l_decap_8
* cell instance sg13cmos5l_decap_8_4466 r0 *1 0,0
Xsg13cmos5l_decap_8_4466 VPWR VGND sg13cmos5l_decap_8
* cell instance sg13cmos5l_decap_8_4467 r0 *1 0,0
Xsg13cmos5l_decap_8_4467 VPWR VGND sg13cmos5l_decap_8
* cell instance sg13cmos5l_decap_8_4468 r0 *1 0,0
Xsg13cmos5l_decap_8_4468 VPWR VGND sg13cmos5l_decap_8
* cell instance sg13cmos5l_decap_8_4469 r0 *1 0,0
Xsg13cmos5l_decap_8_4469 VPWR VGND sg13cmos5l_decap_8
* cell instance sg13cmos5l_decap_8_4470 r0 *1 0,0
Xsg13cmos5l_decap_8_4470 VPWR VGND sg13cmos5l_decap_8
* cell instance sg13cmos5l_decap_8_4471 r0 *1 0,0
Xsg13cmos5l_decap_8_4471 VPWR VGND sg13cmos5l_decap_8
* cell instance sg13cmos5l_decap_8_4472 r0 *1 0,0
Xsg13cmos5l_decap_8_4472 VPWR VGND sg13cmos5l_decap_8
* cell instance sg13cmos5l_decap_8_4473 r0 *1 0,0
Xsg13cmos5l_decap_8_4473 VPWR VGND sg13cmos5l_decap_8
* cell instance sg13cmos5l_decap_8_4474 r0 *1 0,0
Xsg13cmos5l_decap_8_4474 VPWR VGND sg13cmos5l_decap_8
* cell instance sg13cmos5l_decap_8_4475 r0 *1 0,0
Xsg13cmos5l_decap_8_4475 VPWR VGND sg13cmos5l_decap_8
* cell instance sg13cmos5l_decap_8_4476 r0 *1 0,0
Xsg13cmos5l_decap_8_4476 VPWR VGND sg13cmos5l_decap_8
* cell instance sg13cmos5l_decap_8_4477 r0 *1 0,0
Xsg13cmos5l_decap_8_4477 VPWR VGND sg13cmos5l_decap_8
* cell instance sg13cmos5l_decap_8_4478 r0 *1 0,0
Xsg13cmos5l_decap_8_4478 VPWR VGND sg13cmos5l_decap_8
* cell instance sg13cmos5l_decap_8_4479 r0 *1 0,0
Xsg13cmos5l_decap_8_4479 VPWR VGND sg13cmos5l_decap_8
* cell instance sg13cmos5l_decap_8_4480 r0 *1 0,0
Xsg13cmos5l_decap_8_4480 VPWR VGND sg13cmos5l_decap_8
* cell instance sg13cmos5l_decap_8_4481 r0 *1 0,0
Xsg13cmos5l_decap_8_4481 VPWR VGND sg13cmos5l_decap_8
* cell instance sg13cmos5l_decap_8_4482 r0 *1 0,0
Xsg13cmos5l_decap_8_4482 VPWR VGND sg13cmos5l_decap_8
* cell instance sg13cmos5l_decap_8_4483 r0 *1 0,0
Xsg13cmos5l_decap_8_4483 VPWR VGND sg13cmos5l_decap_8
* cell instance sg13cmos5l_decap_8_4484 r0 *1 0,0
Xsg13cmos5l_decap_8_4484 VPWR VGND sg13cmos5l_decap_8
* cell instance sg13cmos5l_decap_8_4485 r0 *1 0,0
Xsg13cmos5l_decap_8_4485 VPWR VGND sg13cmos5l_decap_8
* cell instance sg13cmos5l_decap_8_4486 r0 *1 0,0
Xsg13cmos5l_decap_8_4486 VPWR VGND sg13cmos5l_decap_8
* cell instance sg13cmos5l_decap_8_4487 r0 *1 0,0
Xsg13cmos5l_decap_8_4487 VPWR VGND sg13cmos5l_decap_8
* cell instance sg13cmos5l_decap_8_4488 r0 *1 0,0
Xsg13cmos5l_decap_8_4488 VPWR VGND sg13cmos5l_decap_8
* cell instance sg13cmos5l_decap_8_4489 r0 *1 0,0
Xsg13cmos5l_decap_8_4489 VPWR VGND sg13cmos5l_decap_8
* cell instance sg13cmos5l_decap_8_4490 r0 *1 0,0
Xsg13cmos5l_decap_8_4490 VPWR VGND sg13cmos5l_decap_8
* cell instance sg13cmos5l_decap_8_4491 r0 *1 0,0
Xsg13cmos5l_decap_8_4491 VPWR VGND sg13cmos5l_decap_8
* cell instance sg13cmos5l_decap_8_4492 r0 *1 0,0
Xsg13cmos5l_decap_8_4492 VPWR VGND sg13cmos5l_decap_8
* cell instance sg13cmos5l_decap_8_4493 r0 *1 0,0
Xsg13cmos5l_decap_8_4493 VPWR VGND sg13cmos5l_decap_8
* cell instance sg13cmos5l_decap_8_4494 r0 *1 0,0
Xsg13cmos5l_decap_8_4494 VPWR VGND sg13cmos5l_decap_8
* cell instance sg13cmos5l_decap_8_4495 r0 *1 0,0
Xsg13cmos5l_decap_8_4495 VPWR VGND sg13cmos5l_decap_8
* cell instance sg13cmos5l_decap_8_4496 r0 *1 0,0
Xsg13cmos5l_decap_8_4496 VPWR VGND sg13cmos5l_decap_8
* cell instance sg13cmos5l_decap_8_4497 r0 *1 0,0
Xsg13cmos5l_decap_8_4497 VPWR VGND sg13cmos5l_decap_8
* cell instance sg13cmos5l_decap_8_4498 r0 *1 0,0
Xsg13cmos5l_decap_8_4498 VPWR VGND sg13cmos5l_decap_8
* cell instance sg13cmos5l_decap_8_4499 r0 *1 0,0
Xsg13cmos5l_decap_8_4499 VPWR VGND sg13cmos5l_decap_8
* cell instance sg13cmos5l_decap_8_4500 r0 *1 0,0
Xsg13cmos5l_decap_8_4500 VPWR VGND sg13cmos5l_decap_8
* cell instance sg13cmos5l_decap_8_4501 r0 *1 0,0
Xsg13cmos5l_decap_8_4501 VPWR VGND sg13cmos5l_decap_8
* cell instance sg13cmos5l_decap_8_4502 r0 *1 0,0
Xsg13cmos5l_decap_8_4502 VPWR VGND sg13cmos5l_decap_8
* cell instance sg13cmos5l_decap_8_4503 r0 *1 0,0
Xsg13cmos5l_decap_8_4503 VPWR VGND sg13cmos5l_decap_8
* cell instance sg13cmos5l_decap_8_4504 r0 *1 0,0
Xsg13cmos5l_decap_8_4504 VPWR VGND sg13cmos5l_decap_8
* cell instance sg13cmos5l_decap_8_4505 r0 *1 0,0
Xsg13cmos5l_decap_8_4505 VPWR VGND sg13cmos5l_decap_8
* cell instance sg13cmos5l_decap_8_4506 r0 *1 0,0
Xsg13cmos5l_decap_8_4506 VPWR VGND sg13cmos5l_decap_8
* cell instance sg13cmos5l_decap_8_4507 r0 *1 0,0
Xsg13cmos5l_decap_8_4507 VPWR VGND sg13cmos5l_decap_8
* cell instance sg13cmos5l_decap_8_4508 r0 *1 0,0
Xsg13cmos5l_decap_8_4508 VPWR VGND sg13cmos5l_decap_8
* cell instance sg13cmos5l_decap_8_4509 r0 *1 0,0
Xsg13cmos5l_decap_8_4509 VPWR VGND sg13cmos5l_decap_8
* cell instance sg13cmos5l_decap_8_4510 r0 *1 0,0
Xsg13cmos5l_decap_8_4510 VPWR VGND sg13cmos5l_decap_8
* cell instance sg13cmos5l_decap_8_4511 r0 *1 0,0
Xsg13cmos5l_decap_8_4511 VPWR VGND sg13cmos5l_decap_8
* cell instance sg13cmos5l_decap_8_4512 r0 *1 0,0
Xsg13cmos5l_decap_8_4512 VPWR VGND sg13cmos5l_decap_8
* cell instance sg13cmos5l_decap_8_4513 r0 *1 0,0
Xsg13cmos5l_decap_8_4513 VPWR VGND sg13cmos5l_decap_8
* cell instance sg13cmos5l_decap_8_4514 r0 *1 0,0
Xsg13cmos5l_decap_8_4514 VPWR VGND sg13cmos5l_decap_8
* cell instance sg13cmos5l_decap_8_4515 r0 *1 0,0
Xsg13cmos5l_decap_8_4515 VPWR VGND sg13cmos5l_decap_8
* cell instance sg13cmos5l_decap_8_4516 r0 *1 0,0
Xsg13cmos5l_decap_8_4516 VPWR VGND sg13cmos5l_decap_8
* cell instance sg13cmos5l_decap_8_4517 r0 *1 0,0
Xsg13cmos5l_decap_8_4517 VPWR VGND sg13cmos5l_decap_8
* cell instance sg13cmos5l_decap_8_4518 r0 *1 0,0
Xsg13cmos5l_decap_8_4518 VPWR VGND sg13cmos5l_decap_8
* cell instance sg13cmos5l_decap_8_4519 r0 *1 0,0
Xsg13cmos5l_decap_8_4519 VPWR VGND sg13cmos5l_decap_8
* cell instance sg13cmos5l_decap_8_4520 r0 *1 0,0
Xsg13cmos5l_decap_8_4520 VPWR VGND sg13cmos5l_decap_8
* cell instance sg13cmos5l_decap_8_4521 r0 *1 0,0
Xsg13cmos5l_decap_8_4521 VPWR VGND sg13cmos5l_decap_8
* cell instance sg13cmos5l_decap_8_4522 r0 *1 0,0
Xsg13cmos5l_decap_8_4522 VPWR VGND sg13cmos5l_decap_8
* cell instance sg13cmos5l_decap_8_4523 r0 *1 0,0
Xsg13cmos5l_decap_8_4523 VPWR VGND sg13cmos5l_decap_8
* cell instance sg13cmos5l_decap_8_4524 r0 *1 0,0
Xsg13cmos5l_decap_8_4524 VPWR VGND sg13cmos5l_decap_8
* cell instance sg13cmos5l_decap_8_4525 r0 *1 0,0
Xsg13cmos5l_decap_8_4525 VPWR VGND sg13cmos5l_decap_8
* cell instance sg13cmos5l_decap_8_4526 r0 *1 0,0
Xsg13cmos5l_decap_8_4526 VPWR VGND sg13cmos5l_decap_8
* cell instance sg13cmos5l_decap_8_4527 r0 *1 0,0
Xsg13cmos5l_decap_8_4527 VPWR VGND sg13cmos5l_decap_8
* cell instance sg13cmos5l_decap_8_4528 r0 *1 0,0
Xsg13cmos5l_decap_8_4528 VPWR VGND sg13cmos5l_decap_8
* cell instance sg13cmos5l_decap_8_4529 r0 *1 0,0
Xsg13cmos5l_decap_8_4529 VPWR VGND sg13cmos5l_decap_8
* cell instance sg13cmos5l_decap_8_4530 r0 *1 0,0
Xsg13cmos5l_decap_8_4530 VPWR VGND sg13cmos5l_decap_8
* cell instance sg13cmos5l_decap_8_4531 r0 *1 0,0
Xsg13cmos5l_decap_8_4531 VPWR VGND sg13cmos5l_decap_8
* cell instance sg13cmos5l_decap_8_4532 r0 *1 0,0
Xsg13cmos5l_decap_8_4532 VPWR VGND sg13cmos5l_decap_8
* cell instance sg13cmos5l_decap_8_4533 r0 *1 0,0
Xsg13cmos5l_decap_8_4533 VPWR VGND sg13cmos5l_decap_8
* cell instance sg13cmos5l_decap_8_4534 r0 *1 0,0
Xsg13cmos5l_decap_8_4534 VPWR VGND sg13cmos5l_decap_8
* cell instance sg13cmos5l_decap_8_4535 r0 *1 0,0
Xsg13cmos5l_decap_8_4535 VPWR VGND sg13cmos5l_decap_8
* cell instance sg13cmos5l_decap_8_4536 r0 *1 0,0
Xsg13cmos5l_decap_8_4536 VPWR VGND sg13cmos5l_decap_8
* cell instance sg13cmos5l_decap_8_4537 r0 *1 0,0
Xsg13cmos5l_decap_8_4537 VPWR VGND sg13cmos5l_decap_8
* cell instance sg13cmos5l_decap_8_4538 r0 *1 0,0
Xsg13cmos5l_decap_8_4538 VPWR VGND sg13cmos5l_decap_8
* cell instance sg13cmos5l_decap_8_4539 r0 *1 0,0
Xsg13cmos5l_decap_8_4539 VPWR VGND sg13cmos5l_decap_8
* cell instance sg13cmos5l_decap_8_4540 r0 *1 0,0
Xsg13cmos5l_decap_8_4540 VPWR VGND sg13cmos5l_decap_8
* cell instance sg13cmos5l_decap_8_4541 r0 *1 0,0
Xsg13cmos5l_decap_8_4541 VPWR VGND sg13cmos5l_decap_8
* cell instance sg13cmos5l_decap_8_4542 r0 *1 0,0
Xsg13cmos5l_decap_8_4542 VPWR VGND sg13cmos5l_decap_8
* cell instance sg13cmos5l_decap_8_4543 r0 *1 0,0
Xsg13cmos5l_decap_8_4543 VPWR VGND sg13cmos5l_decap_8
* cell instance sg13cmos5l_decap_8_4544 r0 *1 0,0
Xsg13cmos5l_decap_8_4544 VPWR VGND sg13cmos5l_decap_8
* cell instance sg13cmos5l_decap_8_4545 r0 *1 0,0
Xsg13cmos5l_decap_8_4545 VPWR VGND sg13cmos5l_decap_8
* cell instance sg13cmos5l_decap_8_4546 r0 *1 0,0
Xsg13cmos5l_decap_8_4546 VPWR VGND sg13cmos5l_decap_8
* cell instance sg13cmos5l_decap_8_4547 r0 *1 0,0
Xsg13cmos5l_decap_8_4547 VPWR VGND sg13cmos5l_decap_8
* cell instance sg13cmos5l_decap_8_4548 r0 *1 0,0
Xsg13cmos5l_decap_8_4548 VPWR VGND sg13cmos5l_decap_8
* cell instance sg13cmos5l_decap_8_4549 r0 *1 0,0
Xsg13cmos5l_decap_8_4549 VPWR VGND sg13cmos5l_decap_8
* cell instance sg13cmos5l_decap_8_4550 r0 *1 0,0
Xsg13cmos5l_decap_8_4550 VPWR VGND sg13cmos5l_decap_8
* cell instance sg13cmos5l_decap_8_4551 r0 *1 0,0
Xsg13cmos5l_decap_8_4551 VPWR VGND sg13cmos5l_decap_8
* cell instance sg13cmos5l_decap_8_4552 r0 *1 0,0
Xsg13cmos5l_decap_8_4552 VPWR VGND sg13cmos5l_decap_8
* cell instance sg13cmos5l_decap_8_4553 r0 *1 0,0
Xsg13cmos5l_decap_8_4553 VPWR VGND sg13cmos5l_decap_8
* cell instance sg13cmos5l_decap_8_4554 r0 *1 0,0
Xsg13cmos5l_decap_8_4554 VPWR VGND sg13cmos5l_decap_8
* cell instance sg13cmos5l_decap_8_4555 r0 *1 0,0
Xsg13cmos5l_decap_8_4555 VPWR VGND sg13cmos5l_decap_8
* cell instance sg13cmos5l_decap_8_4556 r0 *1 0,0
Xsg13cmos5l_decap_8_4556 VPWR VGND sg13cmos5l_decap_8
* cell instance sg13cmos5l_decap_8_4557 r0 *1 0,0
Xsg13cmos5l_decap_8_4557 VPWR VGND sg13cmos5l_decap_8
* cell instance sg13cmos5l_decap_8_4558 r0 *1 0,0
Xsg13cmos5l_decap_8_4558 VPWR VGND sg13cmos5l_decap_8
* cell instance sg13cmos5l_decap_8_4559 r0 *1 0,0
Xsg13cmos5l_decap_8_4559 VPWR VGND sg13cmos5l_decap_8
* cell instance sg13cmos5l_decap_8_4560 r0 *1 0,0
Xsg13cmos5l_decap_8_4560 VPWR VGND sg13cmos5l_decap_8
* cell instance sg13cmos5l_decap_8_4561 r0 *1 0,0
Xsg13cmos5l_decap_8_4561 VPWR VGND sg13cmos5l_decap_8
* cell instance sg13cmos5l_decap_8_4562 r0 *1 0,0
Xsg13cmos5l_decap_8_4562 VPWR VGND sg13cmos5l_decap_8
* cell instance sg13cmos5l_decap_8_4563 r0 *1 0,0
Xsg13cmos5l_decap_8_4563 VPWR VGND sg13cmos5l_decap_8
* cell instance sg13cmos5l_decap_8_4564 r0 *1 0,0
Xsg13cmos5l_decap_8_4564 VPWR VGND sg13cmos5l_decap_8
* cell instance sg13cmos5l_decap_8_4565 r0 *1 0,0
Xsg13cmos5l_decap_8_4565 VPWR VGND sg13cmos5l_decap_8
* cell instance sg13cmos5l_decap_8_4566 r0 *1 0,0
Xsg13cmos5l_decap_8_4566 VPWR VGND sg13cmos5l_decap_8
* cell instance sg13cmos5l_decap_8_4567 r0 *1 0,0
Xsg13cmos5l_decap_8_4567 VPWR VGND sg13cmos5l_decap_8
* cell instance sg13cmos5l_decap_8_4568 r0 *1 0,0
Xsg13cmos5l_decap_8_4568 VPWR VGND sg13cmos5l_decap_8
* cell instance sg13cmos5l_decap_8_4569 r0 *1 0,0
Xsg13cmos5l_decap_8_4569 VPWR VGND sg13cmos5l_decap_8
* cell instance sg13cmos5l_decap_8_4570 r0 *1 0,0
Xsg13cmos5l_decap_8_4570 VPWR VGND sg13cmos5l_decap_8
* cell instance sg13cmos5l_decap_8_4571 r0 *1 0,0
Xsg13cmos5l_decap_8_4571 VPWR VGND sg13cmos5l_decap_8
* cell instance sg13cmos5l_decap_8_4572 r0 *1 0,0
Xsg13cmos5l_decap_8_4572 VPWR VGND sg13cmos5l_decap_8
* cell instance sg13cmos5l_decap_8_4573 r0 *1 0,0
Xsg13cmos5l_decap_8_4573 VPWR VGND sg13cmos5l_decap_8
* cell instance sg13cmos5l_decap_8_4574 r0 *1 0,0
Xsg13cmos5l_decap_8_4574 VPWR VGND sg13cmos5l_decap_8
* cell instance sg13cmos5l_decap_8_4575 r0 *1 0,0
Xsg13cmos5l_decap_8_4575 VPWR VGND sg13cmos5l_decap_8
* cell instance sg13cmos5l_decap_8_4576 r0 *1 0,0
Xsg13cmos5l_decap_8_4576 VPWR VGND sg13cmos5l_decap_8
* cell instance sg13cmos5l_decap_8_4577 r0 *1 0,0
Xsg13cmos5l_decap_8_4577 VPWR VGND sg13cmos5l_decap_8
* cell instance sg13cmos5l_decap_8_4578 r0 *1 0,0
Xsg13cmos5l_decap_8_4578 VPWR VGND sg13cmos5l_decap_8
* cell instance sg13cmos5l_decap_8_4579 r0 *1 0,0
Xsg13cmos5l_decap_8_4579 VPWR VGND sg13cmos5l_decap_8
* cell instance sg13cmos5l_decap_8_4580 r0 *1 0,0
Xsg13cmos5l_decap_8_4580 VPWR VGND sg13cmos5l_decap_8
* cell instance sg13cmos5l_decap_8_4581 r0 *1 0,0
Xsg13cmos5l_decap_8_4581 VPWR VGND sg13cmos5l_decap_8
* cell instance sg13cmos5l_decap_8_4582 r0 *1 0,0
Xsg13cmos5l_decap_8_4582 VPWR VGND sg13cmos5l_decap_8
* cell instance sg13cmos5l_decap_8_4583 r0 *1 0,0
Xsg13cmos5l_decap_8_4583 VPWR VGND sg13cmos5l_decap_8
* cell instance sg13cmos5l_decap_8_4584 r0 *1 0,0
Xsg13cmos5l_decap_8_4584 VPWR VGND sg13cmos5l_decap_8
* cell instance sg13cmos5l_decap_8_4585 r0 *1 0,0
Xsg13cmos5l_decap_8_4585 VPWR VGND sg13cmos5l_decap_8
* cell instance sg13cmos5l_decap_8_4586 r0 *1 0,0
Xsg13cmos5l_decap_8_4586 VPWR VGND sg13cmos5l_decap_8
* cell instance sg13cmos5l_decap_8_4587 r0 *1 0,0
Xsg13cmos5l_decap_8_4587 VPWR VGND sg13cmos5l_decap_8
* cell instance sg13cmos5l_decap_8_4588 r0 *1 0,0
Xsg13cmos5l_decap_8_4588 VPWR VGND sg13cmos5l_decap_8
* cell instance sg13cmos5l_decap_8_4589 r0 *1 0,0
Xsg13cmos5l_decap_8_4589 VPWR VGND sg13cmos5l_decap_8
* cell instance sg13cmos5l_decap_8_4590 r0 *1 0,0
Xsg13cmos5l_decap_8_4590 VPWR VGND sg13cmos5l_decap_8
* cell instance sg13cmos5l_decap_8_4591 r0 *1 0,0
Xsg13cmos5l_decap_8_4591 VPWR VGND sg13cmos5l_decap_8
* cell instance sg13cmos5l_decap_8_4592 r0 *1 0,0
Xsg13cmos5l_decap_8_4592 VPWR VGND sg13cmos5l_decap_8
* cell instance sg13cmos5l_decap_8_4593 r0 *1 0,0
Xsg13cmos5l_decap_8_4593 VPWR VGND sg13cmos5l_decap_8
* cell instance sg13cmos5l_decap_8_4594 r0 *1 0,0
Xsg13cmos5l_decap_8_4594 VPWR VGND sg13cmos5l_decap_8
* cell instance sg13cmos5l_decap_8_4595 r0 *1 0,0
Xsg13cmos5l_decap_8_4595 VPWR VGND sg13cmos5l_decap_8
* cell instance sg13cmos5l_decap_8_4596 r0 *1 0,0
Xsg13cmos5l_decap_8_4596 VPWR VGND sg13cmos5l_decap_8
* cell instance sg13cmos5l_decap_8_4597 r0 *1 0,0
Xsg13cmos5l_decap_8_4597 VPWR VGND sg13cmos5l_decap_8
* cell instance sg13cmos5l_decap_8_4598 r0 *1 0,0
Xsg13cmos5l_decap_8_4598 VPWR VGND sg13cmos5l_decap_8
* cell instance sg13cmos5l_decap_8_4599 r0 *1 0,0
Xsg13cmos5l_decap_8_4599 VPWR VGND sg13cmos5l_decap_8
* cell instance sg13cmos5l_decap_8_4600 r0 *1 0,0
Xsg13cmos5l_decap_8_4600 VPWR VGND sg13cmos5l_decap_8
* cell instance sg13cmos5l_decap_8_4601 r0 *1 0,0
Xsg13cmos5l_decap_8_4601 VPWR VGND sg13cmos5l_decap_8
* cell instance sg13cmos5l_decap_8_4602 r0 *1 0,0
Xsg13cmos5l_decap_8_4602 VPWR VGND sg13cmos5l_decap_8
* cell instance sg13cmos5l_decap_8_4603 r0 *1 0,0
Xsg13cmos5l_decap_8_4603 VPWR VGND sg13cmos5l_decap_8
* cell instance sg13cmos5l_decap_8_4604 r0 *1 0,0
Xsg13cmos5l_decap_8_4604 VPWR VGND sg13cmos5l_decap_8
* cell instance sg13cmos5l_decap_8_4605 r0 *1 0,0
Xsg13cmos5l_decap_8_4605 VPWR VGND sg13cmos5l_decap_8
* cell instance sg13cmos5l_decap_8_4606 r0 *1 0,0
Xsg13cmos5l_decap_8_4606 VPWR VGND sg13cmos5l_decap_8
* cell instance sg13cmos5l_decap_8_4607 r0 *1 0,0
Xsg13cmos5l_decap_8_4607 VPWR VGND sg13cmos5l_decap_8
* cell instance sg13cmos5l_decap_8_4608 r0 *1 0,0
Xsg13cmos5l_decap_8_4608 VPWR VGND sg13cmos5l_decap_8
* cell instance sg13cmos5l_decap_8_4609 r0 *1 0,0
Xsg13cmos5l_decap_8_4609 VPWR VGND sg13cmos5l_decap_8
* cell instance sg13cmos5l_decap_8_4610 r0 *1 0,0
Xsg13cmos5l_decap_8_4610 VPWR VGND sg13cmos5l_decap_8
* cell instance sg13cmos5l_decap_8_4611 r0 *1 0,0
Xsg13cmos5l_decap_8_4611 VPWR VGND sg13cmos5l_decap_8
* cell instance sg13cmos5l_decap_8_4612 r0 *1 0,0
Xsg13cmos5l_decap_8_4612 VPWR VGND sg13cmos5l_decap_8
* cell instance sg13cmos5l_decap_8_4613 r0 *1 0,0
Xsg13cmos5l_decap_8_4613 VPWR VGND sg13cmos5l_decap_8
* cell instance sg13cmos5l_decap_8_4614 r0 *1 0,0
Xsg13cmos5l_decap_8_4614 VPWR VGND sg13cmos5l_decap_8
* cell instance sg13cmos5l_decap_8_4615 r0 *1 0,0
Xsg13cmos5l_decap_8_4615 VPWR VGND sg13cmos5l_decap_8
* cell instance sg13cmos5l_decap_8_4616 r0 *1 0,0
Xsg13cmos5l_decap_8_4616 VPWR VGND sg13cmos5l_decap_8
* cell instance sg13cmos5l_decap_8_4617 r0 *1 0,0
Xsg13cmos5l_decap_8_4617 VPWR VGND sg13cmos5l_decap_8
* cell instance sg13cmos5l_decap_8_4618 r0 *1 0,0
Xsg13cmos5l_decap_8_4618 VPWR VGND sg13cmos5l_decap_8
* cell instance sg13cmos5l_decap_8_4619 r0 *1 0,0
Xsg13cmos5l_decap_8_4619 VPWR VGND sg13cmos5l_decap_8
* cell instance sg13cmos5l_decap_8_4620 r0 *1 0,0
Xsg13cmos5l_decap_8_4620 VPWR VGND sg13cmos5l_decap_8
* cell instance sg13cmos5l_decap_8_4621 r0 *1 0,0
Xsg13cmos5l_decap_8_4621 VPWR VGND sg13cmos5l_decap_8
* cell instance sg13cmos5l_decap_8_4622 r0 *1 0,0
Xsg13cmos5l_decap_8_4622 VPWR VGND sg13cmos5l_decap_8
* cell instance sg13cmos5l_decap_8_4623 r0 *1 0,0
Xsg13cmos5l_decap_8_4623 VPWR VGND sg13cmos5l_decap_8
* cell instance sg13cmos5l_decap_8_4624 r0 *1 0,0
Xsg13cmos5l_decap_8_4624 VPWR VGND sg13cmos5l_decap_8
* cell instance sg13cmos5l_decap_8_4625 r0 *1 0,0
Xsg13cmos5l_decap_8_4625 VPWR VGND sg13cmos5l_decap_8
* cell instance sg13cmos5l_decap_8_4626 r0 *1 0,0
Xsg13cmos5l_decap_8_4626 VPWR VGND sg13cmos5l_decap_8
* cell instance sg13cmos5l_decap_8_4627 r0 *1 0,0
Xsg13cmos5l_decap_8_4627 VPWR VGND sg13cmos5l_decap_8
* cell instance sg13cmos5l_decap_8_4628 r0 *1 0,0
Xsg13cmos5l_decap_8_4628 VPWR VGND sg13cmos5l_decap_8
* cell instance sg13cmos5l_decap_8_4629 r0 *1 0,0
Xsg13cmos5l_decap_8_4629 VPWR VGND sg13cmos5l_decap_8
* cell instance sg13cmos5l_decap_8_4630 r0 *1 0,0
Xsg13cmos5l_decap_8_4630 VPWR VGND sg13cmos5l_decap_8
* cell instance sg13cmos5l_decap_8_4631 r0 *1 0,0
Xsg13cmos5l_decap_8_4631 VPWR VGND sg13cmos5l_decap_8
* cell instance sg13cmos5l_decap_8_4632 r0 *1 0,0
Xsg13cmos5l_decap_8_4632 VPWR VGND sg13cmos5l_decap_8
* cell instance sg13cmos5l_decap_8_4633 r0 *1 0,0
Xsg13cmos5l_decap_8_4633 VPWR VGND sg13cmos5l_decap_8
* cell instance sg13cmos5l_decap_8_4634 r0 *1 0,0
Xsg13cmos5l_decap_8_4634 VPWR VGND sg13cmos5l_decap_8
* cell instance sg13cmos5l_decap_8_4635 r0 *1 0,0
Xsg13cmos5l_decap_8_4635 VPWR VGND sg13cmos5l_decap_8
* cell instance sg13cmos5l_decap_8_4636 r0 *1 0,0
Xsg13cmos5l_decap_8_4636 VPWR VGND sg13cmos5l_decap_8
* cell instance sg13cmos5l_decap_8_4637 r0 *1 0,0
Xsg13cmos5l_decap_8_4637 VPWR VGND sg13cmos5l_decap_8
* cell instance sg13cmos5l_decap_8_4638 r0 *1 0,0
Xsg13cmos5l_decap_8_4638 VPWR VGND sg13cmos5l_decap_8
* cell instance sg13cmos5l_decap_8_4639 r0 *1 0,0
Xsg13cmos5l_decap_8_4639 VPWR VGND sg13cmos5l_decap_8
* cell instance sg13cmos5l_decap_8_4640 r0 *1 0,0
Xsg13cmos5l_decap_8_4640 VPWR VGND sg13cmos5l_decap_8
* cell instance sg13cmos5l_decap_8_4641 r0 *1 0,0
Xsg13cmos5l_decap_8_4641 VPWR VGND sg13cmos5l_decap_8
* cell instance sg13cmos5l_decap_8_4642 r0 *1 0,0
Xsg13cmos5l_decap_8_4642 VPWR VGND sg13cmos5l_decap_8
* cell instance sg13cmos5l_decap_8_4643 r0 *1 0,0
Xsg13cmos5l_decap_8_4643 VPWR VGND sg13cmos5l_decap_8
* cell instance sg13cmos5l_decap_8_4644 r0 *1 0,0
Xsg13cmos5l_decap_8_4644 VPWR VGND sg13cmos5l_decap_8
* cell instance sg13cmos5l_decap_8_4645 r0 *1 0,0
Xsg13cmos5l_decap_8_4645 VPWR VGND sg13cmos5l_decap_8
* cell instance sg13cmos5l_decap_8_4646 r0 *1 0,0
Xsg13cmos5l_decap_8_4646 VPWR VGND sg13cmos5l_decap_8
* cell instance sg13cmos5l_decap_8_4647 r0 *1 0,0
Xsg13cmos5l_decap_8_4647 VPWR VGND sg13cmos5l_decap_8
* cell instance sg13cmos5l_decap_8_4648 r0 *1 0,0
Xsg13cmos5l_decap_8_4648 VPWR VGND sg13cmos5l_decap_8
* cell instance sg13cmos5l_decap_8_4649 r0 *1 0,0
Xsg13cmos5l_decap_8_4649 VPWR VGND sg13cmos5l_decap_8
* cell instance sg13cmos5l_decap_8_4650 r0 *1 0,0
Xsg13cmos5l_decap_8_4650 VPWR VGND sg13cmos5l_decap_8
* cell instance sg13cmos5l_decap_8_4651 r0 *1 0,0
Xsg13cmos5l_decap_8_4651 VPWR VGND sg13cmos5l_decap_8
* cell instance sg13cmos5l_decap_8_4652 r0 *1 0,0
Xsg13cmos5l_decap_8_4652 VPWR VGND sg13cmos5l_decap_8
* cell instance sg13cmos5l_decap_8_4653 r0 *1 0,0
Xsg13cmos5l_decap_8_4653 VPWR VGND sg13cmos5l_decap_8
* cell instance sg13cmos5l_decap_8_4654 r0 *1 0,0
Xsg13cmos5l_decap_8_4654 VPWR VGND sg13cmos5l_decap_8
* cell instance sg13cmos5l_decap_8_4655 r0 *1 0,0
Xsg13cmos5l_decap_8_4655 VPWR VGND sg13cmos5l_decap_8
* cell instance sg13cmos5l_decap_8_4656 r0 *1 0,0
Xsg13cmos5l_decap_8_4656 VPWR VGND sg13cmos5l_decap_8
* cell instance sg13cmos5l_decap_8_4657 r0 *1 0,0
Xsg13cmos5l_decap_8_4657 VPWR VGND sg13cmos5l_decap_8
* cell instance sg13cmos5l_decap_8_4658 r0 *1 0,0
Xsg13cmos5l_decap_8_4658 VPWR VGND sg13cmos5l_decap_8
* cell instance sg13cmos5l_decap_8_4659 r0 *1 0,0
Xsg13cmos5l_decap_8_4659 VPWR VGND sg13cmos5l_decap_8
* cell instance sg13cmos5l_decap_8_4660 r0 *1 0,0
Xsg13cmos5l_decap_8_4660 VPWR VGND sg13cmos5l_decap_8
* cell instance sg13cmos5l_decap_8_4661 r0 *1 0,0
Xsg13cmos5l_decap_8_4661 VPWR VGND sg13cmos5l_decap_8
* cell instance sg13cmos5l_decap_8_4662 r0 *1 0,0
Xsg13cmos5l_decap_8_4662 VPWR VGND sg13cmos5l_decap_8
* cell instance sg13cmos5l_decap_8_4663 r0 *1 0,0
Xsg13cmos5l_decap_8_4663 VPWR VGND sg13cmos5l_decap_8
* cell instance sg13cmos5l_decap_8_4664 r0 *1 0,0
Xsg13cmos5l_decap_8_4664 VPWR VGND sg13cmos5l_decap_8
* cell instance sg13cmos5l_decap_8_4665 r0 *1 0,0
Xsg13cmos5l_decap_8_4665 VPWR VGND sg13cmos5l_decap_8
* cell instance sg13cmos5l_decap_8_4666 r0 *1 0,0
Xsg13cmos5l_decap_8_4666 VPWR VGND sg13cmos5l_decap_8
* cell instance sg13cmos5l_decap_8_4667 r0 *1 0,0
Xsg13cmos5l_decap_8_4667 VPWR VGND sg13cmos5l_decap_8
* cell instance sg13cmos5l_decap_8_4668 r0 *1 0,0
Xsg13cmos5l_decap_8_4668 VPWR VGND sg13cmos5l_decap_8
* cell instance sg13cmos5l_decap_8_4669 r0 *1 0,0
Xsg13cmos5l_decap_8_4669 VPWR VGND sg13cmos5l_decap_8
* cell instance sg13cmos5l_decap_8_4670 r0 *1 0,0
Xsg13cmos5l_decap_8_4670 VPWR VGND sg13cmos5l_decap_8
* cell instance sg13cmos5l_decap_8_4671 r0 *1 0,0
Xsg13cmos5l_decap_8_4671 VPWR VGND sg13cmos5l_decap_8
* cell instance sg13cmos5l_decap_8_4672 r0 *1 0,0
Xsg13cmos5l_decap_8_4672 VPWR VGND sg13cmos5l_decap_8
* cell instance sg13cmos5l_decap_8_4673 r0 *1 0,0
Xsg13cmos5l_decap_8_4673 VPWR VGND sg13cmos5l_decap_8
* cell instance sg13cmos5l_decap_8_4674 r0 *1 0,0
Xsg13cmos5l_decap_8_4674 VPWR VGND sg13cmos5l_decap_8
* cell instance sg13cmos5l_decap_8_4675 r0 *1 0,0
Xsg13cmos5l_decap_8_4675 VPWR VGND sg13cmos5l_decap_8
* cell instance sg13cmos5l_decap_8_4676 r0 *1 0,0
Xsg13cmos5l_decap_8_4676 VPWR VGND sg13cmos5l_decap_8
* cell instance sg13cmos5l_decap_8_4677 r0 *1 0,0
Xsg13cmos5l_decap_8_4677 VPWR VGND sg13cmos5l_decap_8
* cell instance sg13cmos5l_decap_8_4678 r0 *1 0,0
Xsg13cmos5l_decap_8_4678 VPWR VGND sg13cmos5l_decap_8
* cell instance sg13cmos5l_decap_8_4679 r0 *1 0,0
Xsg13cmos5l_decap_8_4679 VPWR VGND sg13cmos5l_decap_8
* cell instance sg13cmos5l_decap_8_4680 r0 *1 0,0
Xsg13cmos5l_decap_8_4680 VPWR VGND sg13cmos5l_decap_8
* cell instance sg13cmos5l_decap_8_4681 r0 *1 0,0
Xsg13cmos5l_decap_8_4681 VPWR VGND sg13cmos5l_decap_8
* cell instance sg13cmos5l_decap_8_4682 r0 *1 0,0
Xsg13cmos5l_decap_8_4682 VPWR VGND sg13cmos5l_decap_8
* cell instance sg13cmos5l_decap_8_4683 r0 *1 0,0
Xsg13cmos5l_decap_8_4683 VPWR VGND sg13cmos5l_decap_8
* cell instance sg13cmos5l_decap_8_4684 r0 *1 0,0
Xsg13cmos5l_decap_8_4684 VPWR VGND sg13cmos5l_decap_8
* cell instance sg13cmos5l_decap_8_4685 r0 *1 0,0
Xsg13cmos5l_decap_8_4685 VPWR VGND sg13cmos5l_decap_8
* cell instance sg13cmos5l_decap_8_4686 r0 *1 0,0
Xsg13cmos5l_decap_8_4686 VPWR VGND sg13cmos5l_decap_8
* cell instance sg13cmos5l_decap_8_4687 r0 *1 0,0
Xsg13cmos5l_decap_8_4687 VPWR VGND sg13cmos5l_decap_8
* cell instance sg13cmos5l_decap_8_4688 r0 *1 0,0
Xsg13cmos5l_decap_8_4688 VPWR VGND sg13cmos5l_decap_8
* cell instance sg13cmos5l_decap_8_4689 r0 *1 0,0
Xsg13cmos5l_decap_8_4689 VPWR VGND sg13cmos5l_decap_8
* cell instance sg13cmos5l_decap_8_4690 r0 *1 0,0
Xsg13cmos5l_decap_8_4690 VPWR VGND sg13cmos5l_decap_8
* cell instance sg13cmos5l_decap_8_4691 r0 *1 0,0
Xsg13cmos5l_decap_8_4691 VPWR VGND sg13cmos5l_decap_8
* cell instance sg13cmos5l_decap_8_4692 r0 *1 0,0
Xsg13cmos5l_decap_8_4692 VPWR VGND sg13cmos5l_decap_8
* cell instance sg13cmos5l_decap_8_4693 r0 *1 0,0
Xsg13cmos5l_decap_8_4693 VPWR VGND sg13cmos5l_decap_8
* cell instance sg13cmos5l_decap_8_4694 r0 *1 0,0
Xsg13cmos5l_decap_8_4694 VPWR VGND sg13cmos5l_decap_8
* cell instance sg13cmos5l_decap_8_4695 r0 *1 0,0
Xsg13cmos5l_decap_8_4695 VPWR VGND sg13cmos5l_decap_8
* cell instance sg13cmos5l_decap_8_4696 r0 *1 0,0
Xsg13cmos5l_decap_8_4696 VPWR VGND sg13cmos5l_decap_8
* cell instance sg13cmos5l_decap_8_4697 r0 *1 0,0
Xsg13cmos5l_decap_8_4697 VPWR VGND sg13cmos5l_decap_8
* cell instance sg13cmos5l_decap_8_4698 r0 *1 0,0
Xsg13cmos5l_decap_8_4698 VPWR VGND sg13cmos5l_decap_8
* cell instance sg13cmos5l_decap_8_4699 r0 *1 0,0
Xsg13cmos5l_decap_8_4699 VPWR VGND sg13cmos5l_decap_8
* cell instance sg13cmos5l_decap_8_4700 r0 *1 0,0
Xsg13cmos5l_decap_8_4700 VPWR VGND sg13cmos5l_decap_8
* cell instance sg13cmos5l_decap_8_4701 r0 *1 0,0
Xsg13cmos5l_decap_8_4701 VPWR VGND sg13cmos5l_decap_8
* cell instance sg13cmos5l_decap_8_4702 r0 *1 0,0
Xsg13cmos5l_decap_8_4702 VPWR VGND sg13cmos5l_decap_8
* cell instance sg13cmos5l_decap_8_4703 r0 *1 0,0
Xsg13cmos5l_decap_8_4703 VPWR VGND sg13cmos5l_decap_8
* cell instance sg13cmos5l_decap_8_4704 r0 *1 0,0
Xsg13cmos5l_decap_8_4704 VPWR VGND sg13cmos5l_decap_8
* cell instance sg13cmos5l_decap_8_4705 r0 *1 0,0
Xsg13cmos5l_decap_8_4705 VPWR VGND sg13cmos5l_decap_8
* cell instance sg13cmos5l_decap_8_4706 r0 *1 0,0
Xsg13cmos5l_decap_8_4706 VPWR VGND sg13cmos5l_decap_8
* cell instance sg13cmos5l_decap_8_4707 r0 *1 0,0
Xsg13cmos5l_decap_8_4707 VPWR VGND sg13cmos5l_decap_8
* cell instance sg13cmos5l_decap_8_4708 r0 *1 0,0
Xsg13cmos5l_decap_8_4708 VPWR VGND sg13cmos5l_decap_8
* cell instance sg13cmos5l_decap_8_4709 r0 *1 0,0
Xsg13cmos5l_decap_8_4709 VPWR VGND sg13cmos5l_decap_8
* cell instance sg13cmos5l_decap_8_4710 r0 *1 0,0
Xsg13cmos5l_decap_8_4710 VPWR VGND sg13cmos5l_decap_8
* cell instance sg13cmos5l_decap_8_4711 r0 *1 0,0
Xsg13cmos5l_decap_8_4711 VPWR VGND sg13cmos5l_decap_8
* cell instance sg13cmos5l_decap_8_4712 r0 *1 0,0
Xsg13cmos5l_decap_8_4712 VPWR VGND sg13cmos5l_decap_8
* cell instance sg13cmos5l_decap_8_4713 r0 *1 0,0
Xsg13cmos5l_decap_8_4713 VPWR VGND sg13cmos5l_decap_8
* cell instance sg13cmos5l_decap_8_4714 r0 *1 0,0
Xsg13cmos5l_decap_8_4714 VPWR VGND sg13cmos5l_decap_8
* cell instance sg13cmos5l_decap_8_4715 r0 *1 0,0
Xsg13cmos5l_decap_8_4715 VPWR VGND sg13cmos5l_decap_8
* cell instance sg13cmos5l_decap_8_4716 r0 *1 0,0
Xsg13cmos5l_decap_8_4716 VPWR VGND sg13cmos5l_decap_8
* cell instance sg13cmos5l_decap_8_4717 r0 *1 0,0
Xsg13cmos5l_decap_8_4717 VPWR VGND sg13cmos5l_decap_8
* cell instance sg13cmos5l_decap_8_4718 r0 *1 0,0
Xsg13cmos5l_decap_8_4718 VPWR VGND sg13cmos5l_decap_8
* cell instance sg13cmos5l_decap_8_4719 r0 *1 0,0
Xsg13cmos5l_decap_8_4719 VPWR VGND sg13cmos5l_decap_8
* cell instance sg13cmos5l_decap_8_4720 r0 *1 0,0
Xsg13cmos5l_decap_8_4720 VPWR VGND sg13cmos5l_decap_8
* cell instance sg13cmos5l_decap_8_4721 r0 *1 0,0
Xsg13cmos5l_decap_8_4721 VPWR VGND sg13cmos5l_decap_8
* cell instance sg13cmos5l_decap_8_4722 r0 *1 0,0
Xsg13cmos5l_decap_8_4722 VPWR VGND sg13cmos5l_decap_8
* cell instance sg13cmos5l_decap_8_4723 r0 *1 0,0
Xsg13cmos5l_decap_8_4723 VPWR VGND sg13cmos5l_decap_8
* cell instance sg13cmos5l_decap_8_4724 r0 *1 0,0
Xsg13cmos5l_decap_8_4724 VPWR VGND sg13cmos5l_decap_8
* cell instance sg13cmos5l_decap_8_4725 r0 *1 0,0
Xsg13cmos5l_decap_8_4725 VPWR VGND sg13cmos5l_decap_8
* cell instance sg13cmos5l_decap_8_4726 r0 *1 0,0
Xsg13cmos5l_decap_8_4726 VPWR VGND sg13cmos5l_decap_8
* cell instance sg13cmos5l_decap_8_4727 r0 *1 0,0
Xsg13cmos5l_decap_8_4727 VPWR VGND sg13cmos5l_decap_8
* cell instance sg13cmos5l_decap_8_4728 r0 *1 0,0
Xsg13cmos5l_decap_8_4728 VPWR VGND sg13cmos5l_decap_8
* cell instance sg13cmos5l_decap_8_4729 r0 *1 0,0
Xsg13cmos5l_decap_8_4729 VPWR VGND sg13cmos5l_decap_8
* cell instance sg13cmos5l_decap_8_4730 r0 *1 0,0
Xsg13cmos5l_decap_8_4730 VPWR VGND sg13cmos5l_decap_8
* cell instance sg13cmos5l_decap_8_4731 r0 *1 0,0
Xsg13cmos5l_decap_8_4731 VPWR VGND sg13cmos5l_decap_8
* cell instance sg13cmos5l_decap_8_4732 r0 *1 0,0
Xsg13cmos5l_decap_8_4732 VPWR VGND sg13cmos5l_decap_8
* cell instance sg13cmos5l_decap_8_4733 r0 *1 0,0
Xsg13cmos5l_decap_8_4733 VPWR VGND sg13cmos5l_decap_8
* cell instance sg13cmos5l_decap_8_4734 r0 *1 0,0
Xsg13cmos5l_decap_8_4734 VPWR VGND sg13cmos5l_decap_8
* cell instance sg13cmos5l_decap_8_4735 r0 *1 0,0
Xsg13cmos5l_decap_8_4735 VPWR VGND sg13cmos5l_decap_8
* cell instance sg13cmos5l_decap_8_4736 r0 *1 0,0
Xsg13cmos5l_decap_8_4736 VPWR VGND sg13cmos5l_decap_8
* cell instance sg13cmos5l_decap_8_4737 r0 *1 0,0
Xsg13cmos5l_decap_8_4737 VPWR VGND sg13cmos5l_decap_8
* cell instance sg13cmos5l_decap_8_4738 r0 *1 0,0
Xsg13cmos5l_decap_8_4738 VPWR VGND sg13cmos5l_decap_8
* cell instance sg13cmos5l_decap_8_4739 r0 *1 0,0
Xsg13cmos5l_decap_8_4739 VPWR VGND sg13cmos5l_decap_8
* cell instance sg13cmos5l_decap_8_4740 r0 *1 0,0
Xsg13cmos5l_decap_8_4740 VPWR VGND sg13cmos5l_decap_8
* cell instance sg13cmos5l_decap_8_4741 r0 *1 0,0
Xsg13cmos5l_decap_8_4741 VPWR VGND sg13cmos5l_decap_8
* cell instance sg13cmos5l_decap_8_4742 r0 *1 0,0
Xsg13cmos5l_decap_8_4742 VPWR VGND sg13cmos5l_decap_8
* cell instance sg13cmos5l_decap_8_4743 r0 *1 0,0
Xsg13cmos5l_decap_8_4743 VPWR VGND sg13cmos5l_decap_8
* cell instance sg13cmos5l_decap_8_4744 r0 *1 0,0
Xsg13cmos5l_decap_8_4744 VPWR VGND sg13cmos5l_decap_8
* cell instance sg13cmos5l_decap_8_4745 r0 *1 0,0
Xsg13cmos5l_decap_8_4745 VPWR VGND sg13cmos5l_decap_8
* cell instance sg13cmos5l_decap_8_4746 r0 *1 0,0
Xsg13cmos5l_decap_8_4746 VPWR VGND sg13cmos5l_decap_8
* cell instance sg13cmos5l_decap_8_4747 r0 *1 0,0
Xsg13cmos5l_decap_8_4747 VPWR VGND sg13cmos5l_decap_8
* cell instance sg13cmos5l_decap_8_4748 r0 *1 0,0
Xsg13cmos5l_decap_8_4748 VPWR VGND sg13cmos5l_decap_8
* cell instance sg13cmos5l_decap_8_4749 r0 *1 0,0
Xsg13cmos5l_decap_8_4749 VPWR VGND sg13cmos5l_decap_8
* cell instance sg13cmos5l_decap_8_4750 r0 *1 0,0
Xsg13cmos5l_decap_8_4750 VPWR VGND sg13cmos5l_decap_8
* cell instance sg13cmos5l_decap_8_4751 r0 *1 0,0
Xsg13cmos5l_decap_8_4751 VPWR VGND sg13cmos5l_decap_8
* cell instance sg13cmos5l_decap_8_4752 r0 *1 0,0
Xsg13cmos5l_decap_8_4752 VPWR VGND sg13cmos5l_decap_8
* cell instance sg13cmos5l_decap_8_4753 r0 *1 0,0
Xsg13cmos5l_decap_8_4753 VPWR VGND sg13cmos5l_decap_8
* cell instance sg13cmos5l_decap_8_4754 r0 *1 0,0
Xsg13cmos5l_decap_8_4754 VPWR VGND sg13cmos5l_decap_8
* cell instance sg13cmos5l_decap_8_4755 r0 *1 0,0
Xsg13cmos5l_decap_8_4755 VPWR VGND sg13cmos5l_decap_8
* cell instance sg13cmos5l_decap_8_4756 r0 *1 0,0
Xsg13cmos5l_decap_8_4756 VPWR VGND sg13cmos5l_decap_8
* cell instance sg13cmos5l_decap_8_4757 r0 *1 0,0
Xsg13cmos5l_decap_8_4757 VPWR VGND sg13cmos5l_decap_8
* cell instance sg13cmos5l_decap_8_4758 r0 *1 0,0
Xsg13cmos5l_decap_8_4758 VPWR VGND sg13cmos5l_decap_8
* cell instance sg13cmos5l_decap_8_4759 r0 *1 0,0
Xsg13cmos5l_decap_8_4759 VPWR VGND sg13cmos5l_decap_8
* cell instance sg13cmos5l_decap_8_4760 r0 *1 0,0
Xsg13cmos5l_decap_8_4760 VPWR VGND sg13cmos5l_decap_8
* cell instance sg13cmos5l_decap_8_4761 r0 *1 0,0
Xsg13cmos5l_decap_8_4761 VPWR VGND sg13cmos5l_decap_8
* cell instance sg13cmos5l_decap_8_4762 r0 *1 0,0
Xsg13cmos5l_decap_8_4762 VPWR VGND sg13cmos5l_decap_8
* cell instance sg13cmos5l_decap_8_4763 r0 *1 0,0
Xsg13cmos5l_decap_8_4763 VPWR VGND sg13cmos5l_decap_8
* cell instance sg13cmos5l_decap_8_4764 r0 *1 0,0
Xsg13cmos5l_decap_8_4764 VPWR VGND sg13cmos5l_decap_8
* cell instance sg13cmos5l_decap_8_4765 r0 *1 0,0
Xsg13cmos5l_decap_8_4765 VPWR VGND sg13cmos5l_decap_8
* cell instance sg13cmos5l_decap_8_4766 r0 *1 0,0
Xsg13cmos5l_decap_8_4766 VPWR VGND sg13cmos5l_decap_8
* cell instance sg13cmos5l_decap_8_4767 r0 *1 0,0
Xsg13cmos5l_decap_8_4767 VPWR VGND sg13cmos5l_decap_8
* cell instance sg13cmos5l_decap_8_4768 r0 *1 0,0
Xsg13cmos5l_decap_8_4768 VPWR VGND sg13cmos5l_decap_8
* cell instance sg13cmos5l_decap_8_4769 r0 *1 0,0
Xsg13cmos5l_decap_8_4769 VPWR VGND sg13cmos5l_decap_8
* cell instance sg13cmos5l_decap_8_4770 r0 *1 0,0
Xsg13cmos5l_decap_8_4770 VPWR VGND sg13cmos5l_decap_8
* cell instance sg13cmos5l_decap_8_4771 r0 *1 0,0
Xsg13cmos5l_decap_8_4771 VPWR VGND sg13cmos5l_decap_8
* cell instance sg13cmos5l_decap_8_4772 r0 *1 0,0
Xsg13cmos5l_decap_8_4772 VPWR VGND sg13cmos5l_decap_8
* cell instance sg13cmos5l_decap_8_4773 r0 *1 0,0
Xsg13cmos5l_decap_8_4773 VPWR VGND sg13cmos5l_decap_8
* cell instance sg13cmos5l_decap_8_4774 r0 *1 0,0
Xsg13cmos5l_decap_8_4774 VPWR VGND sg13cmos5l_decap_8
* cell instance sg13cmos5l_decap_8_4775 r0 *1 0,0
Xsg13cmos5l_decap_8_4775 VPWR VGND sg13cmos5l_decap_8
* cell instance sg13cmos5l_decap_8_4776 r0 *1 0,0
Xsg13cmos5l_decap_8_4776 VPWR VGND sg13cmos5l_decap_8
* cell instance sg13cmos5l_decap_8_4777 r0 *1 0,0
Xsg13cmos5l_decap_8_4777 VPWR VGND sg13cmos5l_decap_8
* cell instance sg13cmos5l_decap_8_4778 r0 *1 0,0
Xsg13cmos5l_decap_8_4778 VPWR VGND sg13cmos5l_decap_8
* cell instance sg13cmos5l_decap_8_4779 r0 *1 0,0
Xsg13cmos5l_decap_8_4779 VPWR VGND sg13cmos5l_decap_8
* cell instance sg13cmos5l_decap_8_4780 r0 *1 0,0
Xsg13cmos5l_decap_8_4780 VPWR VGND sg13cmos5l_decap_8
* cell instance sg13cmos5l_decap_8_4781 r0 *1 0,0
Xsg13cmos5l_decap_8_4781 VPWR VGND sg13cmos5l_decap_8
* cell instance sg13cmos5l_decap_8_4782 r0 *1 0,0
Xsg13cmos5l_decap_8_4782 VPWR VGND sg13cmos5l_decap_8
* cell instance sg13cmos5l_decap_8_4783 r0 *1 0,0
Xsg13cmos5l_decap_8_4783 VPWR VGND sg13cmos5l_decap_8
* cell instance sg13cmos5l_decap_8_4784 r0 *1 0,0
Xsg13cmos5l_decap_8_4784 VPWR VGND sg13cmos5l_decap_8
* cell instance sg13cmos5l_decap_8_4785 r0 *1 0,0
Xsg13cmos5l_decap_8_4785 VPWR VGND sg13cmos5l_decap_8
* cell instance sg13cmos5l_decap_8_4786 r0 *1 0,0
Xsg13cmos5l_decap_8_4786 VPWR VGND sg13cmos5l_decap_8
* cell instance sg13cmos5l_decap_8_4787 r0 *1 0,0
Xsg13cmos5l_decap_8_4787 VPWR VGND sg13cmos5l_decap_8
* cell instance sg13cmos5l_decap_8_4788 r0 *1 0,0
Xsg13cmos5l_decap_8_4788 VPWR VGND sg13cmos5l_decap_8
* cell instance sg13cmos5l_decap_8_4789 r0 *1 0,0
Xsg13cmos5l_decap_8_4789 VPWR VGND sg13cmos5l_decap_8
* cell instance sg13cmos5l_decap_8_4790 r0 *1 0,0
Xsg13cmos5l_decap_8_4790 VPWR VGND sg13cmos5l_decap_8
* cell instance sg13cmos5l_decap_8_4791 r0 *1 0,0
Xsg13cmos5l_decap_8_4791 VPWR VGND sg13cmos5l_decap_8
* cell instance sg13cmos5l_decap_8_4792 r0 *1 0,0
Xsg13cmos5l_decap_8_4792 VPWR VGND sg13cmos5l_decap_8
* cell instance sg13cmos5l_decap_8_4793 r0 *1 0,0
Xsg13cmos5l_decap_8_4793 VPWR VGND sg13cmos5l_decap_8
* cell instance sg13cmos5l_decap_8_4794 r0 *1 0,0
Xsg13cmos5l_decap_8_4794 VPWR VGND sg13cmos5l_decap_8
* cell instance sg13cmos5l_decap_8_4795 r0 *1 0,0
Xsg13cmos5l_decap_8_4795 VPWR VGND sg13cmos5l_decap_8
* cell instance sg13cmos5l_decap_8_4796 r0 *1 0,0
Xsg13cmos5l_decap_8_4796 VPWR VGND sg13cmos5l_decap_8
* cell instance sg13cmos5l_decap_8_4797 r0 *1 0,0
Xsg13cmos5l_decap_8_4797 VPWR VGND sg13cmos5l_decap_8
* cell instance sg13cmos5l_decap_8_4798 r0 *1 0,0
Xsg13cmos5l_decap_8_4798 VPWR VGND sg13cmos5l_decap_8
* cell instance sg13cmos5l_decap_8_4799 r0 *1 0,0
Xsg13cmos5l_decap_8_4799 VPWR VGND sg13cmos5l_decap_8
* cell instance sg13cmos5l_decap_8_4800 r0 *1 0,0
Xsg13cmos5l_decap_8_4800 VPWR VGND sg13cmos5l_decap_8
* cell instance sg13cmos5l_decap_8_4801 r0 *1 0,0
Xsg13cmos5l_decap_8_4801 VPWR VGND sg13cmos5l_decap_8
* cell instance sg13cmos5l_decap_8_4802 r0 *1 0,0
Xsg13cmos5l_decap_8_4802 VPWR VGND sg13cmos5l_decap_8
* cell instance sg13cmos5l_decap_8_4803 r0 *1 0,0
Xsg13cmos5l_decap_8_4803 VPWR VGND sg13cmos5l_decap_8
* cell instance sg13cmos5l_decap_8_4804 r0 *1 0,0
Xsg13cmos5l_decap_8_4804 VPWR VGND sg13cmos5l_decap_8
* cell instance sg13cmos5l_decap_8_4805 r0 *1 0,0
Xsg13cmos5l_decap_8_4805 VPWR VGND sg13cmos5l_decap_8
* cell instance sg13cmos5l_decap_8_4806 r0 *1 0,0
Xsg13cmos5l_decap_8_4806 VPWR VGND sg13cmos5l_decap_8
* cell instance sg13cmos5l_decap_8_4807 r0 *1 0,0
Xsg13cmos5l_decap_8_4807 VPWR VGND sg13cmos5l_decap_8
* cell instance sg13cmos5l_decap_8_4808 r0 *1 0,0
Xsg13cmos5l_decap_8_4808 VPWR VGND sg13cmos5l_decap_8
* cell instance sg13cmos5l_decap_8_4809 r0 *1 0,0
Xsg13cmos5l_decap_8_4809 VPWR VGND sg13cmos5l_decap_8
* cell instance sg13cmos5l_decap_8_4810 r0 *1 0,0
Xsg13cmos5l_decap_8_4810 VPWR VGND sg13cmos5l_decap_8
* cell instance sg13cmos5l_decap_8_4811 r0 *1 0,0
Xsg13cmos5l_decap_8_4811 VPWR VGND sg13cmos5l_decap_8
* cell instance sg13cmos5l_decap_8_4812 r0 *1 0,0
Xsg13cmos5l_decap_8_4812 VPWR VGND sg13cmos5l_decap_8
* cell instance sg13cmos5l_decap_8_4813 r0 *1 0,0
Xsg13cmos5l_decap_8_4813 VPWR VGND sg13cmos5l_decap_8
* cell instance sg13cmos5l_decap_8_4814 r0 *1 0,0
Xsg13cmos5l_decap_8_4814 VPWR VGND sg13cmos5l_decap_8
* cell instance sg13cmos5l_decap_8_4815 r0 *1 0,0
Xsg13cmos5l_decap_8_4815 VPWR VGND sg13cmos5l_decap_8
* cell instance sg13cmos5l_decap_8_4816 r0 *1 0,0
Xsg13cmos5l_decap_8_4816 VPWR VGND sg13cmos5l_decap_8
* cell instance sg13cmos5l_decap_8_4817 r0 *1 0,0
Xsg13cmos5l_decap_8_4817 VPWR VGND sg13cmos5l_decap_8
* cell instance sg13cmos5l_decap_8_4818 r0 *1 0,0
Xsg13cmos5l_decap_8_4818 VPWR VGND sg13cmos5l_decap_8
* cell instance sg13cmos5l_decap_8_4819 r0 *1 0,0
Xsg13cmos5l_decap_8_4819 VPWR VGND sg13cmos5l_decap_8
* cell instance sg13cmos5l_decap_8_4820 r0 *1 0,0
Xsg13cmos5l_decap_8_4820 VPWR VGND sg13cmos5l_decap_8
* cell instance sg13cmos5l_decap_8_4821 r0 *1 0,0
Xsg13cmos5l_decap_8_4821 VPWR VGND sg13cmos5l_decap_8
* cell instance sg13cmos5l_decap_8_4822 r0 *1 0,0
Xsg13cmos5l_decap_8_4822 VPWR VGND sg13cmos5l_decap_8
* cell instance sg13cmos5l_decap_8_4823 r0 *1 0,0
Xsg13cmos5l_decap_8_4823 VPWR VGND sg13cmos5l_decap_8
* cell instance sg13cmos5l_decap_8_4824 r0 *1 0,0
Xsg13cmos5l_decap_8_4824 VPWR VGND sg13cmos5l_decap_8
* cell instance sg13cmos5l_decap_8_4825 r0 *1 0,0
Xsg13cmos5l_decap_8_4825 VPWR VGND sg13cmos5l_decap_8
* cell instance sg13cmos5l_decap_8_4826 r0 *1 0,0
Xsg13cmos5l_decap_8_4826 VPWR VGND sg13cmos5l_decap_8
* cell instance sg13cmos5l_decap_8_4827 r0 *1 0,0
Xsg13cmos5l_decap_8_4827 VPWR VGND sg13cmos5l_decap_8
* cell instance sg13cmos5l_decap_8_4828 r0 *1 0,0
Xsg13cmos5l_decap_8_4828 VPWR VGND sg13cmos5l_decap_8
* cell instance sg13cmos5l_decap_8_4829 r0 *1 0,0
Xsg13cmos5l_decap_8_4829 VPWR VGND sg13cmos5l_decap_8
* cell instance sg13cmos5l_decap_8_4830 r0 *1 0,0
Xsg13cmos5l_decap_8_4830 VPWR VGND sg13cmos5l_decap_8
* cell instance sg13cmos5l_decap_8_4831 r0 *1 0,0
Xsg13cmos5l_decap_8_4831 VPWR VGND sg13cmos5l_decap_8
* cell instance sg13cmos5l_decap_8_4832 r0 *1 0,0
Xsg13cmos5l_decap_8_4832 VPWR VGND sg13cmos5l_decap_8
* cell instance sg13cmos5l_decap_8_4833 r0 *1 0,0
Xsg13cmos5l_decap_8_4833 VPWR VGND sg13cmos5l_decap_8
* cell instance sg13cmos5l_decap_8_4834 r0 *1 0,0
Xsg13cmos5l_decap_8_4834 VPWR VGND sg13cmos5l_decap_8
* cell instance sg13cmos5l_decap_8_4835 r0 *1 0,0
Xsg13cmos5l_decap_8_4835 VPWR VGND sg13cmos5l_decap_8
* cell instance sg13cmos5l_decap_8_4836 r0 *1 0,0
Xsg13cmos5l_decap_8_4836 VPWR VGND sg13cmos5l_decap_8
* cell instance sg13cmos5l_decap_8_4837 r0 *1 0,0
Xsg13cmos5l_decap_8_4837 VPWR VGND sg13cmos5l_decap_8
* cell instance sg13cmos5l_decap_8_4838 r0 *1 0,0
Xsg13cmos5l_decap_8_4838 VPWR VGND sg13cmos5l_decap_8
* cell instance sg13cmos5l_decap_8_4839 r0 *1 0,0
Xsg13cmos5l_decap_8_4839 VPWR VGND sg13cmos5l_decap_8
* cell instance sg13cmos5l_decap_8_4840 r0 *1 0,0
Xsg13cmos5l_decap_8_4840 VPWR VGND sg13cmos5l_decap_8
* cell instance sg13cmos5l_decap_8_4841 r0 *1 0,0
Xsg13cmos5l_decap_8_4841 VPWR VGND sg13cmos5l_decap_8
* cell instance sg13cmos5l_decap_8_4842 r0 *1 0,0
Xsg13cmos5l_decap_8_4842 VPWR VGND sg13cmos5l_decap_8
* cell instance sg13cmos5l_decap_8_4843 r0 *1 0,0
Xsg13cmos5l_decap_8_4843 VPWR VGND sg13cmos5l_decap_8
* cell instance sg13cmos5l_decap_8_4844 r0 *1 0,0
Xsg13cmos5l_decap_8_4844 VPWR VGND sg13cmos5l_decap_8
* cell instance sg13cmos5l_decap_8_4845 r0 *1 0,0
Xsg13cmos5l_decap_8_4845 VPWR VGND sg13cmos5l_decap_8
* cell instance sg13cmos5l_decap_8_4846 r0 *1 0,0
Xsg13cmos5l_decap_8_4846 VPWR VGND sg13cmos5l_decap_8
* cell instance sg13cmos5l_decap_8_4847 r0 *1 0,0
Xsg13cmos5l_decap_8_4847 VPWR VGND sg13cmos5l_decap_8
* cell instance sg13cmos5l_decap_8_4848 r0 *1 0,0
Xsg13cmos5l_decap_8_4848 VPWR VGND sg13cmos5l_decap_8
* cell instance sg13cmos5l_decap_8_4849 r0 *1 0,0
Xsg13cmos5l_decap_8_4849 VPWR VGND sg13cmos5l_decap_8
* cell instance sg13cmos5l_decap_8_4850 r0 *1 0,0
Xsg13cmos5l_decap_8_4850 VPWR VGND sg13cmos5l_decap_8
* cell instance sg13cmos5l_decap_8_4851 r0 *1 0,0
Xsg13cmos5l_decap_8_4851 VPWR VGND sg13cmos5l_decap_8
* cell instance sg13cmos5l_decap_8_4852 r0 *1 0,0
Xsg13cmos5l_decap_8_4852 VPWR VGND sg13cmos5l_decap_8
* cell instance sg13cmos5l_decap_8_4853 r0 *1 0,0
Xsg13cmos5l_decap_8_4853 VPWR VGND sg13cmos5l_decap_8
* cell instance sg13cmos5l_decap_8_4854 r0 *1 0,0
Xsg13cmos5l_decap_8_4854 VPWR VGND sg13cmos5l_decap_8
* cell instance sg13cmos5l_decap_8_4855 r0 *1 0,0
Xsg13cmos5l_decap_8_4855 VPWR VGND sg13cmos5l_decap_8
* cell instance sg13cmos5l_decap_8_4856 r0 *1 0,0
Xsg13cmos5l_decap_8_4856 VPWR VGND sg13cmos5l_decap_8
* cell instance sg13cmos5l_decap_8_4857 r0 *1 0,0
Xsg13cmos5l_decap_8_4857 VPWR VGND sg13cmos5l_decap_8
* cell instance sg13cmos5l_decap_8_4858 r0 *1 0,0
Xsg13cmos5l_decap_8_4858 VPWR VGND sg13cmos5l_decap_8
* cell instance sg13cmos5l_decap_8_4859 r0 *1 0,0
Xsg13cmos5l_decap_8_4859 VPWR VGND sg13cmos5l_decap_8
* cell instance sg13cmos5l_decap_8_4860 r0 *1 0,0
Xsg13cmos5l_decap_8_4860 VPWR VGND sg13cmos5l_decap_8
* cell instance sg13cmos5l_decap_8_4861 r0 *1 0,0
Xsg13cmos5l_decap_8_4861 VPWR VGND sg13cmos5l_decap_8
* cell instance sg13cmos5l_decap_8_4862 r0 *1 0,0
Xsg13cmos5l_decap_8_4862 VPWR VGND sg13cmos5l_decap_8
* cell instance sg13cmos5l_decap_8_4863 r0 *1 0,0
Xsg13cmos5l_decap_8_4863 VPWR VGND sg13cmos5l_decap_8
* cell instance sg13cmos5l_decap_8_4864 r0 *1 0,0
Xsg13cmos5l_decap_8_4864 VPWR VGND sg13cmos5l_decap_8
* cell instance sg13cmos5l_decap_8_4865 r0 *1 0,0
Xsg13cmos5l_decap_8_4865 VPWR VGND sg13cmos5l_decap_8
* cell instance sg13cmos5l_decap_8_4866 r0 *1 0,0
Xsg13cmos5l_decap_8_4866 VPWR VGND sg13cmos5l_decap_8
* cell instance sg13cmos5l_decap_8_4867 r0 *1 0,0
Xsg13cmos5l_decap_8_4867 VPWR VGND sg13cmos5l_decap_8
* cell instance sg13cmos5l_decap_8_4868 r0 *1 0,0
Xsg13cmos5l_decap_8_4868 VPWR VGND sg13cmos5l_decap_8
* cell instance sg13cmos5l_decap_8_4869 r0 *1 0,0
Xsg13cmos5l_decap_8_4869 VPWR VGND sg13cmos5l_decap_8
* cell instance sg13cmos5l_decap_8_4870 r0 *1 0,0
Xsg13cmos5l_decap_8_4870 VPWR VGND sg13cmos5l_decap_8
* cell instance sg13cmos5l_decap_8_4871 r0 *1 0,0
Xsg13cmos5l_decap_8_4871 VPWR VGND sg13cmos5l_decap_8
* cell instance sg13cmos5l_decap_8_4872 r0 *1 0,0
Xsg13cmos5l_decap_8_4872 VPWR VGND sg13cmos5l_decap_8
* cell instance sg13cmos5l_decap_8_4873 r0 *1 0,0
Xsg13cmos5l_decap_8_4873 VPWR VGND sg13cmos5l_decap_8
* cell instance sg13cmos5l_decap_8_4874 r0 *1 0,0
Xsg13cmos5l_decap_8_4874 VPWR VGND sg13cmos5l_decap_8
* cell instance sg13cmos5l_decap_8_4875 r0 *1 0,0
Xsg13cmos5l_decap_8_4875 VPWR VGND sg13cmos5l_decap_8
* cell instance sg13cmos5l_decap_8_4876 r0 *1 0,0
Xsg13cmos5l_decap_8_4876 VPWR VGND sg13cmos5l_decap_8
* cell instance sg13cmos5l_decap_8_4877 r0 *1 0,0
Xsg13cmos5l_decap_8_4877 VPWR VGND sg13cmos5l_decap_8
* cell instance sg13cmos5l_decap_8_4878 r0 *1 0,0
Xsg13cmos5l_decap_8_4878 VPWR VGND sg13cmos5l_decap_8
* cell instance sg13cmos5l_decap_8_4879 r0 *1 0,0
Xsg13cmos5l_decap_8_4879 VPWR VGND sg13cmos5l_decap_8
* cell instance sg13cmos5l_decap_8_4880 r0 *1 0,0
Xsg13cmos5l_decap_8_4880 VPWR VGND sg13cmos5l_decap_8
* cell instance sg13cmos5l_decap_8_4881 r0 *1 0,0
Xsg13cmos5l_decap_8_4881 VPWR VGND sg13cmos5l_decap_8
* cell instance sg13cmos5l_decap_8_4882 r0 *1 0,0
Xsg13cmos5l_decap_8_4882 VPWR VGND sg13cmos5l_decap_8
* cell instance sg13cmos5l_decap_8_4883 r0 *1 0,0
Xsg13cmos5l_decap_8_4883 VPWR VGND sg13cmos5l_decap_8
* cell instance sg13cmos5l_decap_8_4884 r0 *1 0,0
Xsg13cmos5l_decap_8_4884 VPWR VGND sg13cmos5l_decap_8
* cell instance sg13cmos5l_decap_8_4885 r0 *1 0,0
Xsg13cmos5l_decap_8_4885 VPWR VGND sg13cmos5l_decap_8
* cell instance sg13cmos5l_decap_8_4886 r0 *1 0,0
Xsg13cmos5l_decap_8_4886 VPWR VGND sg13cmos5l_decap_8
* cell instance sg13cmos5l_decap_8_4887 r0 *1 0,0
Xsg13cmos5l_decap_8_4887 VPWR VGND sg13cmos5l_decap_8
* cell instance sg13cmos5l_decap_8_4888 r0 *1 0,0
Xsg13cmos5l_decap_8_4888 VPWR VGND sg13cmos5l_decap_8
* cell instance sg13cmos5l_decap_8_4889 r0 *1 0,0
Xsg13cmos5l_decap_8_4889 VPWR VGND sg13cmos5l_decap_8
* cell instance sg13cmos5l_decap_8_4890 r0 *1 0,0
Xsg13cmos5l_decap_8_4890 VPWR VGND sg13cmos5l_decap_8
* cell instance sg13cmos5l_decap_8_4891 r0 *1 0,0
Xsg13cmos5l_decap_8_4891 VPWR VGND sg13cmos5l_decap_8
* cell instance sg13cmos5l_decap_8_4892 r0 *1 0,0
Xsg13cmos5l_decap_8_4892 VPWR VGND sg13cmos5l_decap_8
* cell instance sg13cmos5l_decap_8_4893 r0 *1 0,0
Xsg13cmos5l_decap_8_4893 VPWR VGND sg13cmos5l_decap_8
* cell instance sg13cmos5l_decap_8_4894 r0 *1 0,0
Xsg13cmos5l_decap_8_4894 VPWR VGND sg13cmos5l_decap_8
* cell instance sg13cmos5l_decap_8_4895 r0 *1 0,0
Xsg13cmos5l_decap_8_4895 VPWR VGND sg13cmos5l_decap_8
* cell instance sg13cmos5l_decap_8_4896 r0 *1 0,0
Xsg13cmos5l_decap_8_4896 VPWR VGND sg13cmos5l_decap_8
* cell instance sg13cmos5l_decap_8_4897 r0 *1 0,0
Xsg13cmos5l_decap_8_4897 VPWR VGND sg13cmos5l_decap_8
* cell instance sg13cmos5l_decap_8_4898 r0 *1 0,0
Xsg13cmos5l_decap_8_4898 VPWR VGND sg13cmos5l_decap_8
* cell instance sg13cmos5l_decap_8_4899 r0 *1 0,0
Xsg13cmos5l_decap_8_4899 VPWR VGND sg13cmos5l_decap_8
* cell instance sg13cmos5l_decap_8_4900 r0 *1 0,0
Xsg13cmos5l_decap_8_4900 VPWR VGND sg13cmos5l_decap_8
* cell instance sg13cmos5l_decap_8_4901 r0 *1 0,0
Xsg13cmos5l_decap_8_4901 VPWR VGND sg13cmos5l_decap_8
* cell instance sg13cmos5l_decap_8_4902 r0 *1 0,0
Xsg13cmos5l_decap_8_4902 VPWR VGND sg13cmos5l_decap_8
* cell instance sg13cmos5l_decap_8_4903 r0 *1 0,0
Xsg13cmos5l_decap_8_4903 VPWR VGND sg13cmos5l_decap_8
* cell instance sg13cmos5l_decap_8_4904 r0 *1 0,0
Xsg13cmos5l_decap_8_4904 VPWR VGND sg13cmos5l_decap_8
* cell instance sg13cmos5l_decap_8_4905 r0 *1 0,0
Xsg13cmos5l_decap_8_4905 VPWR VGND sg13cmos5l_decap_8
* cell instance sg13cmos5l_decap_8_4906 r0 *1 0,0
Xsg13cmos5l_decap_8_4906 VPWR VGND sg13cmos5l_decap_8
* cell instance sg13cmos5l_decap_8_4907 r0 *1 0,0
Xsg13cmos5l_decap_8_4907 VPWR VGND sg13cmos5l_decap_8
* cell instance sg13cmos5l_decap_8_4908 r0 *1 0,0
Xsg13cmos5l_decap_8_4908 VPWR VGND sg13cmos5l_decap_8
* cell instance sg13cmos5l_decap_8_4909 r0 *1 0,0
Xsg13cmos5l_decap_8_4909 VPWR VGND sg13cmos5l_decap_8
* cell instance sg13cmos5l_decap_8_4910 r0 *1 0,0
Xsg13cmos5l_decap_8_4910 VPWR VGND sg13cmos5l_decap_8
* cell instance sg13cmos5l_decap_8_4911 r0 *1 0,0
Xsg13cmos5l_decap_8_4911 VPWR VGND sg13cmos5l_decap_8
* cell instance sg13cmos5l_decap_8_4912 r0 *1 0,0
Xsg13cmos5l_decap_8_4912 VPWR VGND sg13cmos5l_decap_8
* cell instance sg13cmos5l_decap_8_4913 r0 *1 0,0
Xsg13cmos5l_decap_8_4913 VPWR VGND sg13cmos5l_decap_8
* cell instance sg13cmos5l_decap_8_4914 r0 *1 0,0
Xsg13cmos5l_decap_8_4914 VPWR VGND sg13cmos5l_decap_8
* cell instance sg13cmos5l_decap_8_4915 r0 *1 0,0
Xsg13cmos5l_decap_8_4915 VPWR VGND sg13cmos5l_decap_8
* cell instance sg13cmos5l_decap_8_4916 r0 *1 0,0
Xsg13cmos5l_decap_8_4916 VPWR VGND sg13cmos5l_decap_8
* cell instance sg13cmos5l_decap_8_4917 r0 *1 0,0
Xsg13cmos5l_decap_8_4917 VPWR VGND sg13cmos5l_decap_8
* cell instance sg13cmos5l_decap_8_4918 r0 *1 0,0
Xsg13cmos5l_decap_8_4918 VPWR VGND sg13cmos5l_decap_8
* cell instance sg13cmos5l_decap_8_4919 r0 *1 0,0
Xsg13cmos5l_decap_8_4919 VPWR VGND sg13cmos5l_decap_8
* cell instance sg13cmos5l_decap_8_4920 r0 *1 0,0
Xsg13cmos5l_decap_8_4920 VPWR VGND sg13cmos5l_decap_8
* cell instance sg13cmos5l_decap_8_4921 r0 *1 0,0
Xsg13cmos5l_decap_8_4921 VPWR VGND sg13cmos5l_decap_8
* cell instance sg13cmos5l_decap_8_4922 r0 *1 0,0
Xsg13cmos5l_decap_8_4922 VPWR VGND sg13cmos5l_decap_8
* cell instance sg13cmos5l_decap_8_4923 r0 *1 0,0
Xsg13cmos5l_decap_8_4923 VPWR VGND sg13cmos5l_decap_8
* cell instance sg13cmos5l_decap_8_4924 r0 *1 0,0
Xsg13cmos5l_decap_8_4924 VPWR VGND sg13cmos5l_decap_8
* cell instance sg13cmos5l_decap_8_4925 r0 *1 0,0
Xsg13cmos5l_decap_8_4925 VPWR VGND sg13cmos5l_decap_8
* cell instance sg13cmos5l_decap_8_4926 r0 *1 0,0
Xsg13cmos5l_decap_8_4926 VPWR VGND sg13cmos5l_decap_8
* cell instance sg13cmos5l_decap_8_4927 r0 *1 0,0
Xsg13cmos5l_decap_8_4927 VPWR VGND sg13cmos5l_decap_8
* cell instance sg13cmos5l_decap_8_4928 r0 *1 0,0
Xsg13cmos5l_decap_8_4928 VPWR VGND sg13cmos5l_decap_8
* cell instance sg13cmos5l_decap_8_4929 r0 *1 0,0
Xsg13cmos5l_decap_8_4929 VPWR VGND sg13cmos5l_decap_8
* cell instance sg13cmos5l_decap_8_4930 r0 *1 0,0
Xsg13cmos5l_decap_8_4930 VPWR VGND sg13cmos5l_decap_8
* cell instance sg13cmos5l_decap_8_4931 r0 *1 0,0
Xsg13cmos5l_decap_8_4931 VPWR VGND sg13cmos5l_decap_8
* cell instance sg13cmos5l_decap_8_4932 r0 *1 0,0
Xsg13cmos5l_decap_8_4932 VPWR VGND sg13cmos5l_decap_8
* cell instance sg13cmos5l_decap_8_4933 r0 *1 0,0
Xsg13cmos5l_decap_8_4933 VPWR VGND sg13cmos5l_decap_8
* cell instance sg13cmos5l_decap_8_4934 r0 *1 0,0
Xsg13cmos5l_decap_8_4934 VPWR VGND sg13cmos5l_decap_8
* cell instance sg13cmos5l_decap_8_4935 r0 *1 0,0
Xsg13cmos5l_decap_8_4935 VPWR VGND sg13cmos5l_decap_8
* cell instance sg13cmos5l_decap_8_4936 r0 *1 0,0
Xsg13cmos5l_decap_8_4936 VPWR VGND sg13cmos5l_decap_8
* cell instance sg13cmos5l_decap_8_4937 r0 *1 0,0
Xsg13cmos5l_decap_8_4937 VPWR VGND sg13cmos5l_decap_8
* cell instance sg13cmos5l_decap_8_4938 r0 *1 0,0
Xsg13cmos5l_decap_8_4938 VPWR VGND sg13cmos5l_decap_8
* cell instance sg13cmos5l_decap_8_4939 r0 *1 0,0
Xsg13cmos5l_decap_8_4939 VPWR VGND sg13cmos5l_decap_8
* cell instance sg13cmos5l_decap_8_4940 r0 *1 0,0
Xsg13cmos5l_decap_8_4940 VPWR VGND sg13cmos5l_decap_8
* cell instance sg13cmos5l_decap_8_4941 r0 *1 0,0
Xsg13cmos5l_decap_8_4941 VPWR VGND sg13cmos5l_decap_8
* cell instance sg13cmos5l_decap_8_4942 r0 *1 0,0
Xsg13cmos5l_decap_8_4942 VPWR VGND sg13cmos5l_decap_8
* cell instance sg13cmos5l_decap_8_4943 r0 *1 0,0
Xsg13cmos5l_decap_8_4943 VPWR VGND sg13cmos5l_decap_8
* cell instance sg13cmos5l_decap_8_4944 r0 *1 0,0
Xsg13cmos5l_decap_8_4944 VPWR VGND sg13cmos5l_decap_8
* cell instance sg13cmos5l_decap_8_4945 r0 *1 0,0
Xsg13cmos5l_decap_8_4945 VPWR VGND sg13cmos5l_decap_8
* cell instance sg13cmos5l_decap_8_4946 r0 *1 0,0
Xsg13cmos5l_decap_8_4946 VPWR VGND sg13cmos5l_decap_8
* cell instance sg13cmos5l_decap_8_4947 r0 *1 0,0
Xsg13cmos5l_decap_8_4947 VPWR VGND sg13cmos5l_decap_8
* cell instance sg13cmos5l_decap_8_4948 r0 *1 0,0
Xsg13cmos5l_decap_8_4948 VPWR VGND sg13cmos5l_decap_8
* cell instance sg13cmos5l_decap_8_4949 r0 *1 0,0
Xsg13cmos5l_decap_8_4949 VPWR VGND sg13cmos5l_decap_8
* cell instance sg13cmos5l_decap_8_4950 r0 *1 0,0
Xsg13cmos5l_decap_8_4950 VPWR VGND sg13cmos5l_decap_8
* cell instance sg13cmos5l_decap_8_4951 r0 *1 0,0
Xsg13cmos5l_decap_8_4951 VPWR VGND sg13cmos5l_decap_8
* cell instance sg13cmos5l_decap_8_4952 r0 *1 0,0
Xsg13cmos5l_decap_8_4952 VPWR VGND sg13cmos5l_decap_8
* cell instance sg13cmos5l_decap_8_4953 r0 *1 0,0
Xsg13cmos5l_decap_8_4953 VPWR VGND sg13cmos5l_decap_8
* cell instance sg13cmos5l_decap_8_4954 r0 *1 0,0
Xsg13cmos5l_decap_8_4954 VPWR VGND sg13cmos5l_decap_8
* cell instance sg13cmos5l_decap_8_4955 r0 *1 0,0
Xsg13cmos5l_decap_8_4955 VPWR VGND sg13cmos5l_decap_8
* cell instance sg13cmos5l_decap_8_4956 r0 *1 0,0
Xsg13cmos5l_decap_8_4956 VPWR VGND sg13cmos5l_decap_8
* cell instance sg13cmos5l_decap_8_4957 r0 *1 0,0
Xsg13cmos5l_decap_8_4957 VPWR VGND sg13cmos5l_decap_8
* cell instance sg13cmos5l_decap_8_4958 r0 *1 0,0
Xsg13cmos5l_decap_8_4958 VPWR VGND sg13cmos5l_decap_8
* cell instance sg13cmos5l_decap_8_4959 r0 *1 0,0
Xsg13cmos5l_decap_8_4959 VPWR VGND sg13cmos5l_decap_8
* cell instance sg13cmos5l_decap_8_4960 r0 *1 0,0
Xsg13cmos5l_decap_8_4960 VPWR VGND sg13cmos5l_decap_8
* cell instance sg13cmos5l_decap_8_4961 r0 *1 0,0
Xsg13cmos5l_decap_8_4961 VPWR VGND sg13cmos5l_decap_8
* cell instance sg13cmos5l_decap_8_4962 r0 *1 0,0
Xsg13cmos5l_decap_8_4962 VPWR VGND sg13cmos5l_decap_8
* cell instance sg13cmos5l_decap_8_4963 r0 *1 0,0
Xsg13cmos5l_decap_8_4963 VPWR VGND sg13cmos5l_decap_8
* cell instance sg13cmos5l_decap_8_4964 r0 *1 0,0
Xsg13cmos5l_decap_8_4964 VPWR VGND sg13cmos5l_decap_8
* cell instance sg13cmos5l_decap_8_4965 r0 *1 0,0
Xsg13cmos5l_decap_8_4965 VPWR VGND sg13cmos5l_decap_8
* cell instance sg13cmos5l_decap_8_4966 r0 *1 0,0
Xsg13cmos5l_decap_8_4966 VPWR VGND sg13cmos5l_decap_8
* cell instance sg13cmos5l_decap_8_4967 r0 *1 0,0
Xsg13cmos5l_decap_8_4967 VPWR VGND sg13cmos5l_decap_8
* cell instance sg13cmos5l_decap_8_4968 r0 *1 0,0
Xsg13cmos5l_decap_8_4968 VPWR VGND sg13cmos5l_decap_8
* cell instance sg13cmos5l_decap_8_4969 r0 *1 0,0
Xsg13cmos5l_decap_8_4969 VPWR VGND sg13cmos5l_decap_8
* cell instance sg13cmos5l_decap_8_4970 r0 *1 0,0
Xsg13cmos5l_decap_8_4970 VPWR VGND sg13cmos5l_decap_8
* cell instance sg13cmos5l_decap_8_4971 r0 *1 0,0
Xsg13cmos5l_decap_8_4971 VPWR VGND sg13cmos5l_decap_8
* cell instance sg13cmos5l_decap_8_4972 r0 *1 0,0
Xsg13cmos5l_decap_8_4972 VPWR VGND sg13cmos5l_decap_8
* cell instance sg13cmos5l_decap_8_4973 r0 *1 0,0
Xsg13cmos5l_decap_8_4973 VPWR VGND sg13cmos5l_decap_8
* cell instance sg13cmos5l_decap_8_4974 r0 *1 0,0
Xsg13cmos5l_decap_8_4974 VPWR VGND sg13cmos5l_decap_8
* cell instance sg13cmos5l_decap_8_4975 r0 *1 0,0
Xsg13cmos5l_decap_8_4975 VPWR VGND sg13cmos5l_decap_8
* cell instance sg13cmos5l_decap_8_4976 r0 *1 0,0
Xsg13cmos5l_decap_8_4976 VPWR VGND sg13cmos5l_decap_8
* cell instance sg13cmos5l_decap_8_4977 r0 *1 0,0
Xsg13cmos5l_decap_8_4977 VPWR VGND sg13cmos5l_decap_8
* cell instance sg13cmos5l_decap_8_4978 r0 *1 0,0
Xsg13cmos5l_decap_8_4978 VPWR VGND sg13cmos5l_decap_8
* cell instance sg13cmos5l_decap_8_4979 r0 *1 0,0
Xsg13cmos5l_decap_8_4979 VPWR VGND sg13cmos5l_decap_8
* cell instance sg13cmos5l_decap_8_4980 r0 *1 0,0
Xsg13cmos5l_decap_8_4980 VPWR VGND sg13cmos5l_decap_8
* cell instance sg13cmos5l_decap_8_4981 r0 *1 0,0
Xsg13cmos5l_decap_8_4981 VPWR VGND sg13cmos5l_decap_8
* cell instance sg13cmos5l_decap_8_4982 r0 *1 0,0
Xsg13cmos5l_decap_8_4982 VPWR VGND sg13cmos5l_decap_8
* cell instance sg13cmos5l_decap_8_4983 r0 *1 0,0
Xsg13cmos5l_decap_8_4983 VPWR VGND sg13cmos5l_decap_8
* cell instance sg13cmos5l_decap_8_4984 r0 *1 0,0
Xsg13cmos5l_decap_8_4984 VPWR VGND sg13cmos5l_decap_8
* cell instance sg13cmos5l_decap_8_4985 r0 *1 0,0
Xsg13cmos5l_decap_8_4985 VPWR VGND sg13cmos5l_decap_8
* cell instance sg13cmos5l_decap_8_4986 r0 *1 0,0
Xsg13cmos5l_decap_8_4986 VPWR VGND sg13cmos5l_decap_8
* cell instance sg13cmos5l_decap_8_4987 r0 *1 0,0
Xsg13cmos5l_decap_8_4987 VPWR VGND sg13cmos5l_decap_8
* cell instance sg13cmos5l_decap_8_4988 r0 *1 0,0
Xsg13cmos5l_decap_8_4988 VPWR VGND sg13cmos5l_decap_8
* cell instance sg13cmos5l_decap_8_4989 r0 *1 0,0
Xsg13cmos5l_decap_8_4989 VPWR VGND sg13cmos5l_decap_8
* cell instance sg13cmos5l_decap_8_4990 r0 *1 0,0
Xsg13cmos5l_decap_8_4990 VPWR VGND sg13cmos5l_decap_8
* cell instance sg13cmos5l_decap_8_4991 r0 *1 0,0
Xsg13cmos5l_decap_8_4991 VPWR VGND sg13cmos5l_decap_8
* cell instance sg13cmos5l_decap_8_4992 r0 *1 0,0
Xsg13cmos5l_decap_8_4992 VPWR VGND sg13cmos5l_decap_8
* cell instance sg13cmos5l_decap_8_4993 r0 *1 0,0
Xsg13cmos5l_decap_8_4993 VPWR VGND sg13cmos5l_decap_8
* cell instance sg13cmos5l_decap_8_4994 r0 *1 0,0
Xsg13cmos5l_decap_8_4994 VPWR VGND sg13cmos5l_decap_8
* cell instance sg13cmos5l_decap_8_4995 r0 *1 0,0
Xsg13cmos5l_decap_8_4995 VPWR VGND sg13cmos5l_decap_8
* cell instance sg13cmos5l_decap_8_4996 r0 *1 0,0
Xsg13cmos5l_decap_8_4996 VPWR VGND sg13cmos5l_decap_8
* cell instance sg13cmos5l_decap_8_4997 r0 *1 0,0
Xsg13cmos5l_decap_8_4997 VPWR VGND sg13cmos5l_decap_8
* cell instance sg13cmos5l_decap_8_4998 r0 *1 0,0
Xsg13cmos5l_decap_8_4998 VPWR VGND sg13cmos5l_decap_8
* cell instance sg13cmos5l_decap_8_4999 r0 *1 0,0
Xsg13cmos5l_decap_8_4999 VPWR VGND sg13cmos5l_decap_8
* cell instance sg13cmos5l_decap_8_5000 r0 *1 0,0
Xsg13cmos5l_decap_8_5000 VPWR VGND sg13cmos5l_decap_8
* cell instance sg13cmos5l_decap_8_5001 r0 *1 0,0
Xsg13cmos5l_decap_8_5001 VPWR VGND sg13cmos5l_decap_8
* cell instance sg13cmos5l_decap_8_5002 r0 *1 0,0
Xsg13cmos5l_decap_8_5002 VPWR VGND sg13cmos5l_decap_8
* cell instance sg13cmos5l_decap_8_5003 r0 *1 0,0
Xsg13cmos5l_decap_8_5003 VPWR VGND sg13cmos5l_decap_8
* cell instance sg13cmos5l_decap_8_5004 r0 *1 0,0
Xsg13cmos5l_decap_8_5004 VPWR VGND sg13cmos5l_decap_8
* cell instance sg13cmos5l_decap_8_5005 r0 *1 0,0
Xsg13cmos5l_decap_8_5005 VPWR VGND sg13cmos5l_decap_8
* cell instance sg13cmos5l_decap_8_5006 r0 *1 0,0
Xsg13cmos5l_decap_8_5006 VPWR VGND sg13cmos5l_decap_8
* cell instance sg13cmos5l_decap_8_5007 r0 *1 0,0
Xsg13cmos5l_decap_8_5007 VPWR VGND sg13cmos5l_decap_8
* cell instance sg13cmos5l_decap_8_5008 r0 *1 0,0
Xsg13cmos5l_decap_8_5008 VPWR VGND sg13cmos5l_decap_8
* cell instance sg13cmos5l_decap_8_5009 r0 *1 0,0
Xsg13cmos5l_decap_8_5009 VPWR VGND sg13cmos5l_decap_8
* cell instance sg13cmos5l_decap_8_5010 r0 *1 0,0
Xsg13cmos5l_decap_8_5010 VPWR VGND sg13cmos5l_decap_8
* cell instance sg13cmos5l_decap_8_5011 r0 *1 0,0
Xsg13cmos5l_decap_8_5011 VPWR VGND sg13cmos5l_decap_8
* cell instance sg13cmos5l_decap_8_5012 r0 *1 0,0
Xsg13cmos5l_decap_8_5012 VPWR VGND sg13cmos5l_decap_8
* cell instance sg13cmos5l_decap_8_5013 r0 *1 0,0
Xsg13cmos5l_decap_8_5013 VPWR VGND sg13cmos5l_decap_8
* cell instance sg13cmos5l_decap_8_5014 r0 *1 0,0
Xsg13cmos5l_decap_8_5014 VPWR VGND sg13cmos5l_decap_8
* cell instance sg13cmos5l_decap_8_5015 r0 *1 0,0
Xsg13cmos5l_decap_8_5015 VPWR VGND sg13cmos5l_decap_8
* cell instance sg13cmos5l_decap_8_5016 r0 *1 0,0
Xsg13cmos5l_decap_8_5016 VPWR VGND sg13cmos5l_decap_8
* cell instance sg13cmos5l_decap_8_5017 r0 *1 0,0
Xsg13cmos5l_decap_8_5017 VPWR VGND sg13cmos5l_decap_8
* cell instance sg13cmos5l_decap_8_5018 r0 *1 0,0
Xsg13cmos5l_decap_8_5018 VPWR VGND sg13cmos5l_decap_8
* cell instance sg13cmos5l_decap_8_5019 r0 *1 0,0
Xsg13cmos5l_decap_8_5019 VPWR VGND sg13cmos5l_decap_8
* cell instance sg13cmos5l_decap_8_5020 r0 *1 0,0
Xsg13cmos5l_decap_8_5020 VPWR VGND sg13cmos5l_decap_8
* cell instance sg13cmos5l_decap_8_5021 r0 *1 0,0
Xsg13cmos5l_decap_8_5021 VPWR VGND sg13cmos5l_decap_8
* cell instance sg13cmos5l_decap_8_5022 r0 *1 0,0
Xsg13cmos5l_decap_8_5022 VPWR VGND sg13cmos5l_decap_8
* cell instance sg13cmos5l_decap_8_5023 r0 *1 0,0
Xsg13cmos5l_decap_8_5023 VPWR VGND sg13cmos5l_decap_8
* cell instance sg13cmos5l_decap_8_5024 r0 *1 0,0
Xsg13cmos5l_decap_8_5024 VPWR VGND sg13cmos5l_decap_8
* cell instance sg13cmos5l_decap_8_5025 r0 *1 0,0
Xsg13cmos5l_decap_8_5025 VPWR VGND sg13cmos5l_decap_8
* cell instance sg13cmos5l_decap_8_5026 r0 *1 0,0
Xsg13cmos5l_decap_8_5026 VPWR VGND sg13cmos5l_decap_8
* cell instance sg13cmos5l_decap_8_5027 r0 *1 0,0
Xsg13cmos5l_decap_8_5027 VPWR VGND sg13cmos5l_decap_8
* cell instance sg13cmos5l_decap_8_5028 r0 *1 0,0
Xsg13cmos5l_decap_8_5028 VPWR VGND sg13cmos5l_decap_8
* cell instance sg13cmos5l_decap_8_5029 r0 *1 0,0
Xsg13cmos5l_decap_8_5029 VPWR VGND sg13cmos5l_decap_8
* cell instance sg13cmos5l_decap_8_5030 r0 *1 0,0
Xsg13cmos5l_decap_8_5030 VPWR VGND sg13cmos5l_decap_8
* cell instance sg13cmos5l_decap_8_5031 r0 *1 0,0
Xsg13cmos5l_decap_8_5031 VPWR VGND sg13cmos5l_decap_8
* cell instance sg13cmos5l_decap_8_5032 r0 *1 0,0
Xsg13cmos5l_decap_8_5032 VPWR VGND sg13cmos5l_decap_8
* cell instance sg13cmos5l_decap_8_5033 r0 *1 0,0
Xsg13cmos5l_decap_8_5033 VPWR VGND sg13cmos5l_decap_8
* cell instance sg13cmos5l_decap_8_5034 r0 *1 0,0
Xsg13cmos5l_decap_8_5034 VPWR VGND sg13cmos5l_decap_8
* cell instance sg13cmos5l_decap_8_5035 r0 *1 0,0
Xsg13cmos5l_decap_8_5035 VPWR VGND sg13cmos5l_decap_8
* cell instance sg13cmos5l_decap_8_5036 r0 *1 0,0
Xsg13cmos5l_decap_8_5036 VPWR VGND sg13cmos5l_decap_8
* cell instance sg13cmos5l_decap_8_5037 r0 *1 0,0
Xsg13cmos5l_decap_8_5037 VPWR VGND sg13cmos5l_decap_8
* cell instance sg13cmos5l_decap_8_5038 r0 *1 0,0
Xsg13cmos5l_decap_8_5038 VPWR VGND sg13cmos5l_decap_8
* cell instance sg13cmos5l_decap_8_5039 r0 *1 0,0
Xsg13cmos5l_decap_8_5039 VPWR VGND sg13cmos5l_decap_8
* cell instance sg13cmos5l_decap_8_5040 r0 *1 0,0
Xsg13cmos5l_decap_8_5040 VPWR VGND sg13cmos5l_decap_8
* cell instance sg13cmos5l_decap_8_5041 r0 *1 0,0
Xsg13cmos5l_decap_8_5041 VPWR VGND sg13cmos5l_decap_8
* cell instance sg13cmos5l_decap_8_5042 r0 *1 0,0
Xsg13cmos5l_decap_8_5042 VPWR VGND sg13cmos5l_decap_8
* cell instance sg13cmos5l_decap_8_5043 r0 *1 0,0
Xsg13cmos5l_decap_8_5043 VPWR VGND sg13cmos5l_decap_8
* cell instance sg13cmos5l_decap_8_5044 r0 *1 0,0
Xsg13cmos5l_decap_8_5044 VPWR VGND sg13cmos5l_decap_8
* cell instance sg13cmos5l_decap_8_5045 r0 *1 0,0
Xsg13cmos5l_decap_8_5045 VPWR VGND sg13cmos5l_decap_8
* cell instance sg13cmos5l_decap_8_5046 r0 *1 0,0
Xsg13cmos5l_decap_8_5046 VPWR VGND sg13cmos5l_decap_8
* cell instance sg13cmos5l_decap_8_5047 r0 *1 0,0
Xsg13cmos5l_decap_8_5047 VPWR VGND sg13cmos5l_decap_8
* cell instance sg13cmos5l_decap_8_5048 r0 *1 0,0
Xsg13cmos5l_decap_8_5048 VPWR VGND sg13cmos5l_decap_8
* cell instance sg13cmos5l_decap_8_5049 r0 *1 0,0
Xsg13cmos5l_decap_8_5049 VPWR VGND sg13cmos5l_decap_8
* cell instance sg13cmos5l_decap_8_5050 r0 *1 0,0
Xsg13cmos5l_decap_8_5050 VPWR VGND sg13cmos5l_decap_8
* cell instance sg13cmos5l_decap_8_5051 r0 *1 0,0
Xsg13cmos5l_decap_8_5051 VPWR VGND sg13cmos5l_decap_8
* cell instance sg13cmos5l_decap_8_5052 r0 *1 0,0
Xsg13cmos5l_decap_8_5052 VPWR VGND sg13cmos5l_decap_8
* cell instance sg13cmos5l_decap_8_5053 r0 *1 0,0
Xsg13cmos5l_decap_8_5053 VPWR VGND sg13cmos5l_decap_8
* cell instance sg13cmos5l_decap_8_5054 r0 *1 0,0
Xsg13cmos5l_decap_8_5054 VPWR VGND sg13cmos5l_decap_8
* cell instance sg13cmos5l_decap_8_5055 r0 *1 0,0
Xsg13cmos5l_decap_8_5055 VPWR VGND sg13cmos5l_decap_8
* cell instance sg13cmos5l_decap_8_5056 r0 *1 0,0
Xsg13cmos5l_decap_8_5056 VPWR VGND sg13cmos5l_decap_8
* cell instance sg13cmos5l_decap_8_5057 r0 *1 0,0
Xsg13cmos5l_decap_8_5057 VPWR VGND sg13cmos5l_decap_8
* cell instance sg13cmos5l_decap_8_5058 r0 *1 0,0
Xsg13cmos5l_decap_8_5058 VPWR VGND sg13cmos5l_decap_8
* cell instance sg13cmos5l_decap_8_5059 r0 *1 0,0
Xsg13cmos5l_decap_8_5059 VPWR VGND sg13cmos5l_decap_8
* cell instance sg13cmos5l_decap_8_5060 r0 *1 0,0
Xsg13cmos5l_decap_8_5060 VPWR VGND sg13cmos5l_decap_8
* cell instance sg13cmos5l_decap_8_5061 r0 *1 0,0
Xsg13cmos5l_decap_8_5061 VPWR VGND sg13cmos5l_decap_8
* cell instance sg13cmos5l_decap_8_5062 r0 *1 0,0
Xsg13cmos5l_decap_8_5062 VPWR VGND sg13cmos5l_decap_8
* cell instance sg13cmos5l_decap_8_5063 r0 *1 0,0
Xsg13cmos5l_decap_8_5063 VPWR VGND sg13cmos5l_decap_8
* cell instance sg13cmos5l_decap_8_5064 r0 *1 0,0
Xsg13cmos5l_decap_8_5064 VPWR VGND sg13cmos5l_decap_8
* cell instance sg13cmos5l_decap_8_5065 r0 *1 0,0
Xsg13cmos5l_decap_8_5065 VPWR VGND sg13cmos5l_decap_8
* cell instance sg13cmos5l_decap_8_5066 r0 *1 0,0
Xsg13cmos5l_decap_8_5066 VPWR VGND sg13cmos5l_decap_8
* cell instance sg13cmos5l_decap_8_5067 r0 *1 0,0
Xsg13cmos5l_decap_8_5067 VPWR VGND sg13cmos5l_decap_8
* cell instance sg13cmos5l_decap_8_5068 r0 *1 0,0
Xsg13cmos5l_decap_8_5068 VPWR VGND sg13cmos5l_decap_8
* cell instance sg13cmos5l_decap_8_5069 r0 *1 0,0
Xsg13cmos5l_decap_8_5069 VPWR VGND sg13cmos5l_decap_8
* cell instance sg13cmos5l_decap_8_5070 r0 *1 0,0
Xsg13cmos5l_decap_8_5070 VPWR VGND sg13cmos5l_decap_8
* cell instance sg13cmos5l_decap_8_5071 r0 *1 0,0
Xsg13cmos5l_decap_8_5071 VPWR VGND sg13cmos5l_decap_8
* cell instance sg13cmos5l_decap_8_5072 r0 *1 0,0
Xsg13cmos5l_decap_8_5072 VPWR VGND sg13cmos5l_decap_8
* cell instance sg13cmos5l_decap_8_5073 r0 *1 0,0
Xsg13cmos5l_decap_8_5073 VPWR VGND sg13cmos5l_decap_8
* cell instance sg13cmos5l_decap_8_5074 r0 *1 0,0
Xsg13cmos5l_decap_8_5074 VPWR VGND sg13cmos5l_decap_8
* cell instance sg13cmos5l_decap_8_5075 r0 *1 0,0
Xsg13cmos5l_decap_8_5075 VPWR VGND sg13cmos5l_decap_8
* cell instance sg13cmos5l_decap_8_5076 r0 *1 0,0
Xsg13cmos5l_decap_8_5076 VPWR VGND sg13cmos5l_decap_8
* cell instance sg13cmos5l_decap_8_5077 r0 *1 0,0
Xsg13cmos5l_decap_8_5077 VPWR VGND sg13cmos5l_decap_8
* cell instance sg13cmos5l_decap_8_5078 r0 *1 0,0
Xsg13cmos5l_decap_8_5078 VPWR VGND sg13cmos5l_decap_8
* cell instance sg13cmos5l_decap_8_5079 r0 *1 0,0
Xsg13cmos5l_decap_8_5079 VPWR VGND sg13cmos5l_decap_8
* cell instance sg13cmos5l_decap_8_5080 r0 *1 0,0
Xsg13cmos5l_decap_8_5080 VPWR VGND sg13cmos5l_decap_8
* cell instance sg13cmos5l_decap_8_5081 r0 *1 0,0
Xsg13cmos5l_decap_8_5081 VPWR VGND sg13cmos5l_decap_8
* cell instance sg13cmos5l_decap_8_5082 r0 *1 0,0
Xsg13cmos5l_decap_8_5082 VPWR VGND sg13cmos5l_decap_8
* cell instance sg13cmos5l_decap_8_5083 r0 *1 0,0
Xsg13cmos5l_decap_8_5083 VPWR VGND sg13cmos5l_decap_8
* cell instance sg13cmos5l_decap_8_5084 r0 *1 0,0
Xsg13cmos5l_decap_8_5084 VPWR VGND sg13cmos5l_decap_8
* cell instance sg13cmos5l_decap_8_5085 r0 *1 0,0
Xsg13cmos5l_decap_8_5085 VPWR VGND sg13cmos5l_decap_8
* cell instance sg13cmos5l_decap_8_5086 r0 *1 0,0
Xsg13cmos5l_decap_8_5086 VPWR VGND sg13cmos5l_decap_8
* cell instance sg13cmos5l_decap_8_5087 r0 *1 0,0
Xsg13cmos5l_decap_8_5087 VPWR VGND sg13cmos5l_decap_8
* cell instance sg13cmos5l_decap_8_5088 r0 *1 0,0
Xsg13cmos5l_decap_8_5088 VPWR VGND sg13cmos5l_decap_8
* cell instance sg13cmos5l_decap_8_5089 r0 *1 0,0
Xsg13cmos5l_decap_8_5089 VPWR VGND sg13cmos5l_decap_8
* cell instance sg13cmos5l_decap_8_5090 r0 *1 0,0
Xsg13cmos5l_decap_8_5090 VPWR VGND sg13cmos5l_decap_8
* cell instance sg13cmos5l_decap_8_5091 r0 *1 0,0
Xsg13cmos5l_decap_8_5091 VPWR VGND sg13cmos5l_decap_8
* cell instance sg13cmos5l_decap_8_5092 r0 *1 0,0
Xsg13cmos5l_decap_8_5092 VPWR VGND sg13cmos5l_decap_8
* cell instance sg13cmos5l_decap_8_5093 r0 *1 0,0
Xsg13cmos5l_decap_8_5093 VPWR VGND sg13cmos5l_decap_8
* cell instance sg13cmos5l_decap_8_5094 r0 *1 0,0
Xsg13cmos5l_decap_8_5094 VPWR VGND sg13cmos5l_decap_8
* cell instance sg13cmos5l_decap_8_5095 r0 *1 0,0
Xsg13cmos5l_decap_8_5095 VPWR VGND sg13cmos5l_decap_8
* cell instance sg13cmos5l_decap_8_5096 r0 *1 0,0
Xsg13cmos5l_decap_8_5096 VPWR VGND sg13cmos5l_decap_8
* cell instance sg13cmos5l_decap_8_5097 r0 *1 0,0
Xsg13cmos5l_decap_8_5097 VPWR VGND sg13cmos5l_decap_8
* cell instance sg13cmos5l_decap_8_5098 r0 *1 0,0
Xsg13cmos5l_decap_8_5098 VPWR VGND sg13cmos5l_decap_8
* cell instance sg13cmos5l_decap_8_5099 r0 *1 0,0
Xsg13cmos5l_decap_8_5099 VPWR VGND sg13cmos5l_decap_8
* cell instance sg13cmos5l_decap_8_5100 r0 *1 0,0
Xsg13cmos5l_decap_8_5100 VPWR VGND sg13cmos5l_decap_8
* cell instance sg13cmos5l_decap_8_5101 r0 *1 0,0
Xsg13cmos5l_decap_8_5101 VPWR VGND sg13cmos5l_decap_8
* cell instance sg13cmos5l_decap_8_5102 r0 *1 0,0
Xsg13cmos5l_decap_8_5102 VPWR VGND sg13cmos5l_decap_8
* cell instance sg13cmos5l_decap_8_5103 r0 *1 0,0
Xsg13cmos5l_decap_8_5103 VPWR VGND sg13cmos5l_decap_8
* cell instance sg13cmos5l_decap_8_5104 r0 *1 0,0
Xsg13cmos5l_decap_8_5104 VPWR VGND sg13cmos5l_decap_8
* cell instance sg13cmos5l_decap_8_5105 r0 *1 0,0
Xsg13cmos5l_decap_8_5105 VPWR VGND sg13cmos5l_decap_8
* cell instance sg13cmos5l_decap_8_5106 r0 *1 0,0
Xsg13cmos5l_decap_8_5106 VPWR VGND sg13cmos5l_decap_8
* cell instance sg13cmos5l_decap_8_5107 r0 *1 0,0
Xsg13cmos5l_decap_8_5107 VPWR VGND sg13cmos5l_decap_8
* cell instance sg13cmos5l_decap_8_5108 r0 *1 0,0
Xsg13cmos5l_decap_8_5108 VPWR VGND sg13cmos5l_decap_8
* cell instance sg13cmos5l_decap_8_5109 r0 *1 0,0
Xsg13cmos5l_decap_8_5109 VPWR VGND sg13cmos5l_decap_8
* cell instance sg13cmos5l_decap_8_5110 r0 *1 0,0
Xsg13cmos5l_decap_8_5110 VPWR VGND sg13cmos5l_decap_8
* cell instance sg13cmos5l_decap_8_5111 r0 *1 0,0
Xsg13cmos5l_decap_8_5111 VPWR VGND sg13cmos5l_decap_8
* cell instance sg13cmos5l_decap_8_5112 r0 *1 0,0
Xsg13cmos5l_decap_8_5112 VPWR VGND sg13cmos5l_decap_8
* cell instance sg13cmos5l_decap_8_5113 r0 *1 0,0
Xsg13cmos5l_decap_8_5113 VPWR VGND sg13cmos5l_decap_8
* cell instance sg13cmos5l_decap_8_5114 r0 *1 0,0
Xsg13cmos5l_decap_8_5114 VPWR VGND sg13cmos5l_decap_8
* cell instance sg13cmos5l_decap_8_5115 r0 *1 0,0
Xsg13cmos5l_decap_8_5115 VPWR VGND sg13cmos5l_decap_8
* cell instance sg13cmos5l_decap_8_5116 r0 *1 0,0
Xsg13cmos5l_decap_8_5116 VPWR VGND sg13cmos5l_decap_8
* cell instance sg13cmos5l_decap_8_5117 r0 *1 0,0
Xsg13cmos5l_decap_8_5117 VPWR VGND sg13cmos5l_decap_8
* cell instance sg13cmos5l_decap_8_5118 r0 *1 0,0
Xsg13cmos5l_decap_8_5118 VPWR VGND sg13cmos5l_decap_8
* cell instance sg13cmos5l_decap_8_5119 r0 *1 0,0
Xsg13cmos5l_decap_8_5119 VPWR VGND sg13cmos5l_decap_8
* cell instance sg13cmos5l_decap_8_5120 r0 *1 0,0
Xsg13cmos5l_decap_8_5120 VPWR VGND sg13cmos5l_decap_8
* cell instance sg13cmos5l_decap_8_5121 r0 *1 0,0
Xsg13cmos5l_decap_8_5121 VPWR VGND sg13cmos5l_decap_8
* cell instance sg13cmos5l_decap_8_5122 r0 *1 0,0
Xsg13cmos5l_decap_8_5122 VPWR VGND sg13cmos5l_decap_8
* cell instance sg13cmos5l_decap_8_5123 r0 *1 0,0
Xsg13cmos5l_decap_8_5123 VPWR VGND sg13cmos5l_decap_8
* cell instance sg13cmos5l_decap_8_5124 r0 *1 0,0
Xsg13cmos5l_decap_8_5124 VPWR VGND sg13cmos5l_decap_8
* cell instance sg13cmos5l_decap_8_5125 r0 *1 0,0
Xsg13cmos5l_decap_8_5125 VPWR VGND sg13cmos5l_decap_8
* cell instance sg13cmos5l_decap_8_5126 r0 *1 0,0
Xsg13cmos5l_decap_8_5126 VPWR VGND sg13cmos5l_decap_8
* cell instance sg13cmos5l_decap_8_5127 r0 *1 0,0
Xsg13cmos5l_decap_8_5127 VPWR VGND sg13cmos5l_decap_8
* cell instance sg13cmos5l_decap_8_5128 r0 *1 0,0
Xsg13cmos5l_decap_8_5128 VPWR VGND sg13cmos5l_decap_8
* cell instance sg13cmos5l_decap_8_5129 r0 *1 0,0
Xsg13cmos5l_decap_8_5129 VPWR VGND sg13cmos5l_decap_8
* cell instance sg13cmos5l_decap_8_5130 r0 *1 0,0
Xsg13cmos5l_decap_8_5130 VPWR VGND sg13cmos5l_decap_8
* cell instance sg13cmos5l_decap_8_5131 r0 *1 0,0
Xsg13cmos5l_decap_8_5131 VPWR VGND sg13cmos5l_decap_8
* cell instance sg13cmos5l_decap_8_5132 r0 *1 0,0
Xsg13cmos5l_decap_8_5132 VPWR VGND sg13cmos5l_decap_8
* cell instance sg13cmos5l_decap_8_5133 r0 *1 0,0
Xsg13cmos5l_decap_8_5133 VPWR VGND sg13cmos5l_decap_8
* cell instance sg13cmos5l_decap_8_5134 r0 *1 0,0
Xsg13cmos5l_decap_8_5134 VPWR VGND sg13cmos5l_decap_8
* cell instance sg13cmos5l_decap_8_5135 r0 *1 0,0
Xsg13cmos5l_decap_8_5135 VPWR VGND sg13cmos5l_decap_8
* cell instance sg13cmos5l_decap_8_5136 r0 *1 0,0
Xsg13cmos5l_decap_8_5136 VPWR VGND sg13cmos5l_decap_8
* cell instance sg13cmos5l_decap_8_5137 r0 *1 0,0
Xsg13cmos5l_decap_8_5137 VPWR VGND sg13cmos5l_decap_8
* cell instance sg13cmos5l_decap_8_5138 r0 *1 0,0
Xsg13cmos5l_decap_8_5138 VPWR VGND sg13cmos5l_decap_8
* cell instance sg13cmos5l_decap_8_5139 r0 *1 0,0
Xsg13cmos5l_decap_8_5139 VPWR VGND sg13cmos5l_decap_8
* cell instance sg13cmos5l_decap_8_5140 r0 *1 0,0
Xsg13cmos5l_decap_8_5140 VPWR VGND sg13cmos5l_decap_8
* cell instance sg13cmos5l_decap_8_5141 r0 *1 0,0
Xsg13cmos5l_decap_8_5141 VPWR VGND sg13cmos5l_decap_8
* cell instance sg13cmos5l_decap_8_5142 r0 *1 0,0
Xsg13cmos5l_decap_8_5142 VPWR VGND sg13cmos5l_decap_8
* cell instance sg13cmos5l_decap_8_5143 r0 *1 0,0
Xsg13cmos5l_decap_8_5143 VPWR VGND sg13cmos5l_decap_8
* cell instance sg13cmos5l_decap_8_5144 r0 *1 0,0
Xsg13cmos5l_decap_8_5144 VPWR VGND sg13cmos5l_decap_8
* cell instance sg13cmos5l_decap_8_5145 r0 *1 0,0
Xsg13cmos5l_decap_8_5145 VPWR VGND sg13cmos5l_decap_8
* cell instance sg13cmos5l_decap_8_5146 r0 *1 0,0
Xsg13cmos5l_decap_8_5146 VPWR VGND sg13cmos5l_decap_8
* cell instance sg13cmos5l_decap_8_5147 r0 *1 0,0
Xsg13cmos5l_decap_8_5147 VPWR VGND sg13cmos5l_decap_8
* cell instance sg13cmos5l_decap_8_5148 r0 *1 0,0
Xsg13cmos5l_decap_8_5148 VPWR VGND sg13cmos5l_decap_8
* cell instance sg13cmos5l_decap_8_5149 r0 *1 0,0
Xsg13cmos5l_decap_8_5149 VPWR VGND sg13cmos5l_decap_8
* cell instance sg13cmos5l_decap_8_5150 r0 *1 0,0
Xsg13cmos5l_decap_8_5150 VPWR VGND sg13cmos5l_decap_8
* cell instance sg13cmos5l_decap_8_5151 r0 *1 0,0
Xsg13cmos5l_decap_8_5151 VPWR VGND sg13cmos5l_decap_8
* cell instance sg13cmos5l_decap_8_5152 r0 *1 0,0
Xsg13cmos5l_decap_8_5152 VPWR VGND sg13cmos5l_decap_8
* cell instance sg13cmos5l_decap_8_5153 r0 *1 0,0
Xsg13cmos5l_decap_8_5153 VPWR VGND sg13cmos5l_decap_8
* cell instance sg13cmos5l_decap_8_5154 r0 *1 0,0
Xsg13cmos5l_decap_8_5154 VPWR VGND sg13cmos5l_decap_8
* cell instance sg13cmos5l_decap_8_5155 r0 *1 0,0
Xsg13cmos5l_decap_8_5155 VPWR VGND sg13cmos5l_decap_8
* cell instance sg13cmos5l_decap_8_5156 r0 *1 0,0
Xsg13cmos5l_decap_8_5156 VPWR VGND sg13cmos5l_decap_8
* cell instance sg13cmos5l_decap_8_5157 r0 *1 0,0
Xsg13cmos5l_decap_8_5157 VPWR VGND sg13cmos5l_decap_8
* cell instance sg13cmos5l_decap_8_5158 r0 *1 0,0
Xsg13cmos5l_decap_8_5158 VPWR VGND sg13cmos5l_decap_8
* cell instance sg13cmos5l_decap_8_5159 r0 *1 0,0
Xsg13cmos5l_decap_8_5159 VPWR VGND sg13cmos5l_decap_8
* cell instance sg13cmos5l_decap_8_5160 r0 *1 0,0
Xsg13cmos5l_decap_8_5160 VPWR VGND sg13cmos5l_decap_8
* cell instance sg13cmos5l_decap_8_5161 r0 *1 0,0
Xsg13cmos5l_decap_8_5161 VPWR VGND sg13cmos5l_decap_8
* cell instance sg13cmos5l_decap_8_5162 r0 *1 0,0
Xsg13cmos5l_decap_8_5162 VPWR VGND sg13cmos5l_decap_8
* cell instance sg13cmos5l_decap_8_5163 r0 *1 0,0
Xsg13cmos5l_decap_8_5163 VPWR VGND sg13cmos5l_decap_8
* cell instance sg13cmos5l_decap_8_5164 r0 *1 0,0
Xsg13cmos5l_decap_8_5164 VPWR VGND sg13cmos5l_decap_8
* cell instance sg13cmos5l_decap_8_5165 r0 *1 0,0
Xsg13cmos5l_decap_8_5165 VPWR VGND sg13cmos5l_decap_8
* cell instance sg13cmos5l_decap_8_5166 r0 *1 0,0
Xsg13cmos5l_decap_8_5166 VPWR VGND sg13cmos5l_decap_8
* cell instance sg13cmos5l_decap_8_5167 r0 *1 0,0
Xsg13cmos5l_decap_8_5167 VPWR VGND sg13cmos5l_decap_8
* cell instance sg13cmos5l_decap_8_5168 r0 *1 0,0
Xsg13cmos5l_decap_8_5168 VPWR VGND sg13cmos5l_decap_8
* cell instance sg13cmos5l_decap_8_5169 r0 *1 0,0
Xsg13cmos5l_decap_8_5169 VPWR VGND sg13cmos5l_decap_8
* cell instance sg13cmos5l_decap_8_5170 r0 *1 0,0
Xsg13cmos5l_decap_8_5170 VPWR VGND sg13cmos5l_decap_8
* cell instance sg13cmos5l_decap_8_5171 r0 *1 0,0
Xsg13cmos5l_decap_8_5171 VPWR VGND sg13cmos5l_decap_8
* cell instance sg13cmos5l_decap_8_5172 r0 *1 0,0
Xsg13cmos5l_decap_8_5172 VPWR VGND sg13cmos5l_decap_8
* cell instance sg13cmos5l_decap_8_5173 r0 *1 0,0
Xsg13cmos5l_decap_8_5173 VPWR VGND sg13cmos5l_decap_8
* cell instance sg13cmos5l_decap_8_5174 r0 *1 0,0
Xsg13cmos5l_decap_8_5174 VPWR VGND sg13cmos5l_decap_8
* cell instance sg13cmos5l_decap_8_5175 r0 *1 0,0
Xsg13cmos5l_decap_8_5175 VPWR VGND sg13cmos5l_decap_8
* cell instance sg13cmos5l_decap_8_5176 r0 *1 0,0
Xsg13cmos5l_decap_8_5176 VPWR VGND sg13cmos5l_decap_8
* cell instance sg13cmos5l_decap_8_5177 r0 *1 0,0
Xsg13cmos5l_decap_8_5177 VPWR VGND sg13cmos5l_decap_8
* cell instance sg13cmos5l_decap_8_5178 r0 *1 0,0
Xsg13cmos5l_decap_8_5178 VPWR VGND sg13cmos5l_decap_8
* cell instance sg13cmos5l_decap_8_5179 r0 *1 0,0
Xsg13cmos5l_decap_8_5179 VPWR VGND sg13cmos5l_decap_8
* cell instance sg13cmos5l_decap_8_5180 r0 *1 0,0
Xsg13cmos5l_decap_8_5180 VPWR VGND sg13cmos5l_decap_8
* cell instance sg13cmos5l_decap_8_5181 r0 *1 0,0
Xsg13cmos5l_decap_8_5181 VPWR VGND sg13cmos5l_decap_8
* cell instance sg13cmos5l_decap_8_5182 r0 *1 0,0
Xsg13cmos5l_decap_8_5182 VPWR VGND sg13cmos5l_decap_8
* cell instance sg13cmos5l_decap_8_5183 r0 *1 0,0
Xsg13cmos5l_decap_8_5183 VPWR VGND sg13cmos5l_decap_8
* cell instance sg13cmos5l_decap_8_5184 r0 *1 0,0
Xsg13cmos5l_decap_8_5184 VPWR VGND sg13cmos5l_decap_8
* cell instance sg13cmos5l_decap_8_5185 r0 *1 0,0
Xsg13cmos5l_decap_8_5185 VPWR VGND sg13cmos5l_decap_8
* cell instance sg13cmos5l_decap_8_5186 r0 *1 0,0
Xsg13cmos5l_decap_8_5186 VPWR VGND sg13cmos5l_decap_8
* cell instance sg13cmos5l_decap_8_5187 r0 *1 0,0
Xsg13cmos5l_decap_8_5187 VPWR VGND sg13cmos5l_decap_8
* cell instance sg13cmos5l_decap_8_5188 r0 *1 0,0
Xsg13cmos5l_decap_8_5188 VPWR VGND sg13cmos5l_decap_8
* cell instance sg13cmos5l_decap_8_5189 r0 *1 0,0
Xsg13cmos5l_decap_8_5189 VPWR VGND sg13cmos5l_decap_8
* cell instance sg13cmos5l_decap_8_5190 r0 *1 0,0
Xsg13cmos5l_decap_8_5190 VPWR VGND sg13cmos5l_decap_8
* cell instance sg13cmos5l_decap_8_5191 r0 *1 0,0
Xsg13cmos5l_decap_8_5191 VPWR VGND sg13cmos5l_decap_8
* cell instance sg13cmos5l_decap_8_5192 r0 *1 0,0
Xsg13cmos5l_decap_8_5192 VPWR VGND sg13cmos5l_decap_8
* cell instance sg13cmos5l_decap_8_5193 r0 *1 0,0
Xsg13cmos5l_decap_8_5193 VPWR VGND sg13cmos5l_decap_8
* cell instance sg13cmos5l_decap_8_5194 r0 *1 0,0
Xsg13cmos5l_decap_8_5194 VPWR VGND sg13cmos5l_decap_8
* cell instance sg13cmos5l_decap_8_5195 r0 *1 0,0
Xsg13cmos5l_decap_8_5195 VPWR VGND sg13cmos5l_decap_8
* cell instance sg13cmos5l_decap_8_5196 r0 *1 0,0
Xsg13cmos5l_decap_8_5196 VPWR VGND sg13cmos5l_decap_8
* cell instance sg13cmos5l_decap_8_5197 r0 *1 0,0
Xsg13cmos5l_decap_8_5197 VPWR VGND sg13cmos5l_decap_8
* cell instance sg13cmos5l_decap_8_5198 r0 *1 0,0
Xsg13cmos5l_decap_8_5198 VPWR VGND sg13cmos5l_decap_8
* cell instance sg13cmos5l_decap_8_5199 r0 *1 0,0
Xsg13cmos5l_decap_8_5199 VPWR VGND sg13cmos5l_decap_8
* cell instance sg13cmos5l_decap_8_5200 r0 *1 0,0
Xsg13cmos5l_decap_8_5200 VPWR VGND sg13cmos5l_decap_8
* cell instance sg13cmos5l_decap_8_5201 r0 *1 0,0
Xsg13cmos5l_decap_8_5201 VPWR VGND sg13cmos5l_decap_8
* cell instance sg13cmos5l_decap_8_5202 r0 *1 0,0
Xsg13cmos5l_decap_8_5202 VPWR VGND sg13cmos5l_decap_8
* cell instance sg13cmos5l_decap_8_5203 r0 *1 0,0
Xsg13cmos5l_decap_8_5203 VPWR VGND sg13cmos5l_decap_8
* cell instance sg13cmos5l_decap_8_5204 r0 *1 0,0
Xsg13cmos5l_decap_8_5204 VPWR VGND sg13cmos5l_decap_8
* cell instance sg13cmos5l_decap_8_5205 r0 *1 0,0
Xsg13cmos5l_decap_8_5205 VPWR VGND sg13cmos5l_decap_8
* cell instance sg13cmos5l_decap_8_5206 r0 *1 0,0
Xsg13cmos5l_decap_8_5206 VPWR VGND sg13cmos5l_decap_8
* cell instance sg13cmos5l_decap_8_5207 r0 *1 0,0
Xsg13cmos5l_decap_8_5207 VPWR VGND sg13cmos5l_decap_8
* cell instance sg13cmos5l_decap_8_5208 r0 *1 0,0
Xsg13cmos5l_decap_8_5208 VPWR VGND sg13cmos5l_decap_8
* cell instance sg13cmos5l_decap_8_5209 r0 *1 0,0
Xsg13cmos5l_decap_8_5209 VPWR VGND sg13cmos5l_decap_8
* cell instance sg13cmos5l_decap_8_5210 r0 *1 0,0
Xsg13cmos5l_decap_8_5210 VPWR VGND sg13cmos5l_decap_8
* cell instance sg13cmos5l_decap_8_5211 r0 *1 0,0
Xsg13cmos5l_decap_8_5211 VPWR VGND sg13cmos5l_decap_8
* cell instance sg13cmos5l_decap_8_5212 r0 *1 0,0
Xsg13cmos5l_decap_8_5212 VPWR VGND sg13cmos5l_decap_8
* cell instance sg13cmos5l_decap_8_5213 r0 *1 0,0
Xsg13cmos5l_decap_8_5213 VPWR VGND sg13cmos5l_decap_8
* cell instance sg13cmos5l_decap_8_5214 r0 *1 0,0
Xsg13cmos5l_decap_8_5214 VPWR VGND sg13cmos5l_decap_8
* cell instance sg13cmos5l_decap_8_5215 r0 *1 0,0
Xsg13cmos5l_decap_8_5215 VPWR VGND sg13cmos5l_decap_8
* cell instance sg13cmos5l_decap_8_5216 r0 *1 0,0
Xsg13cmos5l_decap_8_5216 VPWR VGND sg13cmos5l_decap_8
* cell instance sg13cmos5l_decap_8_5217 r0 *1 0,0
Xsg13cmos5l_decap_8_5217 VPWR VGND sg13cmos5l_decap_8
* cell instance sg13cmos5l_decap_8_5218 r0 *1 0,0
Xsg13cmos5l_decap_8_5218 VPWR VGND sg13cmos5l_decap_8
* cell instance sg13cmos5l_decap_8_5219 r0 *1 0,0
Xsg13cmos5l_decap_8_5219 VPWR VGND sg13cmos5l_decap_8
* cell instance sg13cmos5l_decap_8_5220 r0 *1 0,0
Xsg13cmos5l_decap_8_5220 VPWR VGND sg13cmos5l_decap_8
* cell instance sg13cmos5l_decap_8_5221 r0 *1 0,0
Xsg13cmos5l_decap_8_5221 VPWR VGND sg13cmos5l_decap_8
* cell instance sg13cmos5l_decap_8_5222 r0 *1 0,0
Xsg13cmos5l_decap_8_5222 VPWR VGND sg13cmos5l_decap_8
* cell instance sg13cmos5l_decap_8_5223 r0 *1 0,0
Xsg13cmos5l_decap_8_5223 VPWR VGND sg13cmos5l_decap_8
* cell instance sg13cmos5l_decap_8_5224 r0 *1 0,0
Xsg13cmos5l_decap_8_5224 VPWR VGND sg13cmos5l_decap_8
* cell instance sg13cmos5l_decap_8_5225 r0 *1 0,0
Xsg13cmos5l_decap_8_5225 VPWR VGND sg13cmos5l_decap_8
* cell instance sg13cmos5l_decap_8_5226 r0 *1 0,0
Xsg13cmos5l_decap_8_5226 VPWR VGND sg13cmos5l_decap_8
* cell instance sg13cmos5l_decap_8_5227 r0 *1 0,0
Xsg13cmos5l_decap_8_5227 VPWR VGND sg13cmos5l_decap_8
* cell instance sg13cmos5l_decap_8_5228 r0 *1 0,0
Xsg13cmos5l_decap_8_5228 VPWR VGND sg13cmos5l_decap_8
* cell instance sg13cmos5l_decap_8_5229 r0 *1 0,0
Xsg13cmos5l_decap_8_5229 VPWR VGND sg13cmos5l_decap_8
* cell instance sg13cmos5l_decap_8_5230 r0 *1 0,0
Xsg13cmos5l_decap_8_5230 VPWR VGND sg13cmos5l_decap_8
* cell instance sg13cmos5l_decap_8_5231 r0 *1 0,0
Xsg13cmos5l_decap_8_5231 VPWR VGND sg13cmos5l_decap_8
* cell instance sg13cmos5l_decap_8_5232 r0 *1 0,0
Xsg13cmos5l_decap_8_5232 VPWR VGND sg13cmos5l_decap_8
* cell instance sg13cmos5l_decap_8_5233 r0 *1 0,0
Xsg13cmos5l_decap_8_5233 VPWR VGND sg13cmos5l_decap_8
* cell instance sg13cmos5l_decap_8_5234 r0 *1 0,0
Xsg13cmos5l_decap_8_5234 VPWR VGND sg13cmos5l_decap_8
* cell instance sg13cmos5l_decap_8_5235 r0 *1 0,0
Xsg13cmos5l_decap_8_5235 VPWR VGND sg13cmos5l_decap_8
* cell instance sg13cmos5l_decap_8_5236 r0 *1 0,0
Xsg13cmos5l_decap_8_5236 VPWR VGND sg13cmos5l_decap_8
* cell instance sg13cmos5l_decap_8_5237 r0 *1 0,0
Xsg13cmos5l_decap_8_5237 VPWR VGND sg13cmos5l_decap_8
* cell instance sg13cmos5l_decap_8_5238 r0 *1 0,0
Xsg13cmos5l_decap_8_5238 VPWR VGND sg13cmos5l_decap_8
* cell instance sg13cmos5l_decap_8_5239 r0 *1 0,0
Xsg13cmos5l_decap_8_5239 VPWR VGND sg13cmos5l_decap_8
* cell instance sg13cmos5l_decap_8_5240 r0 *1 0,0
Xsg13cmos5l_decap_8_5240 VPWR VGND sg13cmos5l_decap_8
* cell instance sg13cmos5l_decap_8_5241 r0 *1 0,0
Xsg13cmos5l_decap_8_5241 VPWR VGND sg13cmos5l_decap_8
* cell instance sg13cmos5l_decap_8_5242 r0 *1 0,0
Xsg13cmos5l_decap_8_5242 VPWR VGND sg13cmos5l_decap_8
* cell instance sg13cmos5l_decap_8_5243 r0 *1 0,0
Xsg13cmos5l_decap_8_5243 VPWR VGND sg13cmos5l_decap_8
* cell instance sg13cmos5l_decap_8_5244 r0 *1 0,0
Xsg13cmos5l_decap_8_5244 VPWR VGND sg13cmos5l_decap_8
* cell instance sg13cmos5l_decap_8_5245 r0 *1 0,0
Xsg13cmos5l_decap_8_5245 VPWR VGND sg13cmos5l_decap_8
* cell instance sg13cmos5l_decap_8_5246 r0 *1 0,0
Xsg13cmos5l_decap_8_5246 VPWR VGND sg13cmos5l_decap_8
* cell instance sg13cmos5l_decap_8_5247 r0 *1 0,0
Xsg13cmos5l_decap_8_5247 VPWR VGND sg13cmos5l_decap_8
* cell instance sg13cmos5l_decap_8_5248 r0 *1 0,0
Xsg13cmos5l_decap_8_5248 VPWR VGND sg13cmos5l_decap_8
* cell instance sg13cmos5l_decap_8_5249 r0 *1 0,0
Xsg13cmos5l_decap_8_5249 VPWR VGND sg13cmos5l_decap_8
* cell instance sg13cmos5l_decap_8_5250 r0 *1 0,0
Xsg13cmos5l_decap_8_5250 VPWR VGND sg13cmos5l_decap_8
* cell instance sg13cmos5l_decap_8_5251 r0 *1 0,0
Xsg13cmos5l_decap_8_5251 VPWR VGND sg13cmos5l_decap_8
* cell instance sg13cmos5l_decap_8_5252 r0 *1 0,0
Xsg13cmos5l_decap_8_5252 VPWR VGND sg13cmos5l_decap_8
* cell instance sg13cmos5l_decap_8_5253 r0 *1 0,0
Xsg13cmos5l_decap_8_5253 VPWR VGND sg13cmos5l_decap_8
* cell instance sg13cmos5l_decap_8_5254 r0 *1 0,0
Xsg13cmos5l_decap_8_5254 VPWR VGND sg13cmos5l_decap_8
* cell instance sg13cmos5l_decap_8_5255 r0 *1 0,0
Xsg13cmos5l_decap_8_5255 VPWR VGND sg13cmos5l_decap_8
* cell instance sg13cmos5l_decap_8_5256 r0 *1 0,0
Xsg13cmos5l_decap_8_5256 VPWR VGND sg13cmos5l_decap_8
* cell instance sg13cmos5l_decap_8_5257 r0 *1 0,0
Xsg13cmos5l_decap_8_5257 VPWR VGND sg13cmos5l_decap_8
* cell instance sg13cmos5l_decap_8_5258 r0 *1 0,0
Xsg13cmos5l_decap_8_5258 VPWR VGND sg13cmos5l_decap_8
* cell instance sg13cmos5l_decap_8_5259 r0 *1 0,0
Xsg13cmos5l_decap_8_5259 VPWR VGND sg13cmos5l_decap_8
* cell instance sg13cmos5l_decap_8_5260 r0 *1 0,0
Xsg13cmos5l_decap_8_5260 VPWR VGND sg13cmos5l_decap_8
* cell instance sg13cmos5l_decap_8_5261 r0 *1 0,0
Xsg13cmos5l_decap_8_5261 VPWR VGND sg13cmos5l_decap_8
* cell instance sg13cmos5l_decap_8_5262 r0 *1 0,0
Xsg13cmos5l_decap_8_5262 VPWR VGND sg13cmos5l_decap_8
* cell instance sg13cmos5l_decap_8_5263 r0 *1 0,0
Xsg13cmos5l_decap_8_5263 VPWR VGND sg13cmos5l_decap_8
* cell instance sg13cmos5l_decap_8_5264 r0 *1 0,0
Xsg13cmos5l_decap_8_5264 VPWR VGND sg13cmos5l_decap_8
* cell instance sg13cmos5l_decap_8_5265 r0 *1 0,0
Xsg13cmos5l_decap_8_5265 VPWR VGND sg13cmos5l_decap_8
* cell instance sg13cmos5l_decap_8_5266 r0 *1 0,0
Xsg13cmos5l_decap_8_5266 VPWR VGND sg13cmos5l_decap_8
* cell instance sg13cmos5l_decap_8_5267 r0 *1 0,0
Xsg13cmos5l_decap_8_5267 VPWR VGND sg13cmos5l_decap_8
* cell instance sg13cmos5l_decap_8_5268 r0 *1 0,0
Xsg13cmos5l_decap_8_5268 VPWR VGND sg13cmos5l_decap_8
* cell instance sg13cmos5l_decap_8_5269 r0 *1 0,0
Xsg13cmos5l_decap_8_5269 VPWR VGND sg13cmos5l_decap_8
* cell instance sg13cmos5l_decap_8_5270 r0 *1 0,0
Xsg13cmos5l_decap_8_5270 VPWR VGND sg13cmos5l_decap_8
* cell instance sg13cmos5l_decap_8_5271 r0 *1 0,0
Xsg13cmos5l_decap_8_5271 VPWR VGND sg13cmos5l_decap_8
* cell instance sg13cmos5l_decap_8_5272 r0 *1 0,0
Xsg13cmos5l_decap_8_5272 VPWR VGND sg13cmos5l_decap_8
* cell instance sg13cmos5l_decap_8_5273 r0 *1 0,0
Xsg13cmos5l_decap_8_5273 VPWR VGND sg13cmos5l_decap_8
* cell instance sg13cmos5l_decap_8_5274 r0 *1 0,0
Xsg13cmos5l_decap_8_5274 VPWR VGND sg13cmos5l_decap_8
* cell instance sg13cmos5l_decap_8_5275 r0 *1 0,0
Xsg13cmos5l_decap_8_5275 VPWR VGND sg13cmos5l_decap_8
* cell instance sg13cmos5l_decap_8_5276 r0 *1 0,0
Xsg13cmos5l_decap_8_5276 VPWR VGND sg13cmos5l_decap_8
* cell instance sg13cmos5l_decap_8_5277 r0 *1 0,0
Xsg13cmos5l_decap_8_5277 VPWR VGND sg13cmos5l_decap_8
* cell instance sg13cmos5l_decap_8_5278 r0 *1 0,0
Xsg13cmos5l_decap_8_5278 VPWR VGND sg13cmos5l_decap_8
* cell instance sg13cmos5l_decap_8_5279 r0 *1 0,0
Xsg13cmos5l_decap_8_5279 VPWR VGND sg13cmos5l_decap_8
* cell instance sg13cmos5l_decap_8_5280 r0 *1 0,0
Xsg13cmos5l_decap_8_5280 VPWR VGND sg13cmos5l_decap_8
* cell instance sg13cmos5l_decap_8_5281 r0 *1 0,0
Xsg13cmos5l_decap_8_5281 VPWR VGND sg13cmos5l_decap_8
* cell instance sg13cmos5l_decap_8_5282 r0 *1 0,0
Xsg13cmos5l_decap_8_5282 VPWR VGND sg13cmos5l_decap_8
* cell instance sg13cmos5l_decap_8_5283 r0 *1 0,0
Xsg13cmos5l_decap_8_5283 VPWR VGND sg13cmos5l_decap_8
* cell instance sg13cmos5l_decap_8_5284 r0 *1 0,0
Xsg13cmos5l_decap_8_5284 VPWR VGND sg13cmos5l_decap_8
* cell instance sg13cmos5l_decap_8_5285 r0 *1 0,0
Xsg13cmos5l_decap_8_5285 VPWR VGND sg13cmos5l_decap_8
* cell instance sg13cmos5l_decap_8_5286 r0 *1 0,0
Xsg13cmos5l_decap_8_5286 VPWR VGND sg13cmos5l_decap_8
* cell instance sg13cmos5l_decap_8_5287 r0 *1 0,0
Xsg13cmos5l_decap_8_5287 VPWR VGND sg13cmos5l_decap_8
* cell instance sg13cmos5l_decap_8_5288 r0 *1 0,0
Xsg13cmos5l_decap_8_5288 VPWR VGND sg13cmos5l_decap_8
* cell instance sg13cmos5l_decap_8_5289 r0 *1 0,0
Xsg13cmos5l_decap_8_5289 VPWR VGND sg13cmos5l_decap_8
* cell instance sg13cmos5l_decap_8_5290 r0 *1 0,0
Xsg13cmos5l_decap_8_5290 VPWR VGND sg13cmos5l_decap_8
* cell instance sg13cmos5l_decap_8_5291 r0 *1 0,0
Xsg13cmos5l_decap_8_5291 VPWR VGND sg13cmos5l_decap_8
* cell instance sg13cmos5l_decap_8_5292 r0 *1 0,0
Xsg13cmos5l_decap_8_5292 VPWR VGND sg13cmos5l_decap_8
* cell instance sg13cmos5l_decap_8_5293 r0 *1 0,0
Xsg13cmos5l_decap_8_5293 VPWR VGND sg13cmos5l_decap_8
* cell instance sg13cmos5l_decap_8_5294 r0 *1 0,0
Xsg13cmos5l_decap_8_5294 VPWR VGND sg13cmos5l_decap_8
* cell instance sg13cmos5l_decap_8_5295 r0 *1 0,0
Xsg13cmos5l_decap_8_5295 VPWR VGND sg13cmos5l_decap_8
* cell instance sg13cmos5l_decap_8_5296 r0 *1 0,0
Xsg13cmos5l_decap_8_5296 VPWR VGND sg13cmos5l_decap_8
* cell instance sg13cmos5l_decap_8_5297 r0 *1 0,0
Xsg13cmos5l_decap_8_5297 VPWR VGND sg13cmos5l_decap_8
* cell instance sg13cmos5l_decap_8_5298 r0 *1 0,0
Xsg13cmos5l_decap_8_5298 VPWR VGND sg13cmos5l_decap_8
* cell instance sg13cmos5l_decap_8_5299 r0 *1 0,0
Xsg13cmos5l_decap_8_5299 VPWR VGND sg13cmos5l_decap_8
* cell instance sg13cmos5l_decap_8_5300 r0 *1 0,0
Xsg13cmos5l_decap_8_5300 VPWR VGND sg13cmos5l_decap_8
* cell instance sg13cmos5l_decap_8_5301 r0 *1 0,0
Xsg13cmos5l_decap_8_5301 VPWR VGND sg13cmos5l_decap_8
* cell instance sg13cmos5l_decap_8_5302 r0 *1 0,0
Xsg13cmos5l_decap_8_5302 VPWR VGND sg13cmos5l_decap_8
* cell instance sg13cmos5l_decap_8_5303 r0 *1 0,0
Xsg13cmos5l_decap_8_5303 VPWR VGND sg13cmos5l_decap_8
* cell instance sg13cmos5l_decap_8_5304 r0 *1 0,0
Xsg13cmos5l_decap_8_5304 VPWR VGND sg13cmos5l_decap_8
* cell instance sg13cmos5l_decap_8_5305 r0 *1 0,0
Xsg13cmos5l_decap_8_5305 VPWR VGND sg13cmos5l_decap_8
* cell instance sg13cmos5l_decap_8_5306 r0 *1 0,0
Xsg13cmos5l_decap_8_5306 VPWR VGND sg13cmos5l_decap_8
* cell instance sg13cmos5l_decap_8_5307 r0 *1 0,0
Xsg13cmos5l_decap_8_5307 VPWR VGND sg13cmos5l_decap_8
* cell instance sg13cmos5l_decap_8_5308 r0 *1 0,0
Xsg13cmos5l_decap_8_5308 VPWR VGND sg13cmos5l_decap_8
* cell instance sg13cmos5l_decap_8_5309 r0 *1 0,0
Xsg13cmos5l_decap_8_5309 VPWR VGND sg13cmos5l_decap_8
* cell instance sg13cmos5l_decap_8_5310 r0 *1 0,0
Xsg13cmos5l_decap_8_5310 VPWR VGND sg13cmos5l_decap_8
* cell instance sg13cmos5l_decap_8_5311 r0 *1 0,0
Xsg13cmos5l_decap_8_5311 VPWR VGND sg13cmos5l_decap_8
* cell instance sg13cmos5l_decap_8_5312 r0 *1 0,0
Xsg13cmos5l_decap_8_5312 VPWR VGND sg13cmos5l_decap_8
* cell instance sg13cmos5l_decap_8_5313 r0 *1 0,0
Xsg13cmos5l_decap_8_5313 VPWR VGND sg13cmos5l_decap_8
* cell instance sg13cmos5l_decap_8_5314 r0 *1 0,0
Xsg13cmos5l_decap_8_5314 VPWR VGND sg13cmos5l_decap_8
* cell instance sg13cmos5l_decap_8_5315 r0 *1 0,0
Xsg13cmos5l_decap_8_5315 VPWR VGND sg13cmos5l_decap_8
* cell instance sg13cmos5l_decap_8_5316 r0 *1 0,0
Xsg13cmos5l_decap_8_5316 VPWR VGND sg13cmos5l_decap_8
* cell instance sg13cmos5l_decap_8_5317 r0 *1 0,0
Xsg13cmos5l_decap_8_5317 VPWR VGND sg13cmos5l_decap_8
* cell instance sg13cmos5l_decap_8_5318 r0 *1 0,0
Xsg13cmos5l_decap_8_5318 VPWR VGND sg13cmos5l_decap_8
* cell instance sg13cmos5l_decap_8_5319 r0 *1 0,0
Xsg13cmos5l_decap_8_5319 VPWR VGND sg13cmos5l_decap_8
* cell instance sg13cmos5l_decap_8_5320 r0 *1 0,0
Xsg13cmos5l_decap_8_5320 VPWR VGND sg13cmos5l_decap_8
* cell instance sg13cmos5l_decap_8_5321 r0 *1 0,0
Xsg13cmos5l_decap_8_5321 VPWR VGND sg13cmos5l_decap_8
* cell instance sg13cmos5l_decap_8_5322 r0 *1 0,0
Xsg13cmos5l_decap_8_5322 VPWR VGND sg13cmos5l_decap_8
* cell instance sg13cmos5l_decap_8_5323 r0 *1 0,0
Xsg13cmos5l_decap_8_5323 VPWR VGND sg13cmos5l_decap_8
* cell instance sg13cmos5l_decap_8_5324 r0 *1 0,0
Xsg13cmos5l_decap_8_5324 VPWR VGND sg13cmos5l_decap_8
* cell instance sg13cmos5l_decap_8_5325 r0 *1 0,0
Xsg13cmos5l_decap_8_5325 VPWR VGND sg13cmos5l_decap_8
* cell instance sg13cmos5l_decap_8_5326 r0 *1 0,0
Xsg13cmos5l_decap_8_5326 VPWR VGND sg13cmos5l_decap_8
* cell instance sg13cmos5l_decap_8_5327 r0 *1 0,0
Xsg13cmos5l_decap_8_5327 VPWR VGND sg13cmos5l_decap_8
* cell instance sg13cmos5l_decap_8_5328 r0 *1 0,0
Xsg13cmos5l_decap_8_5328 VPWR VGND sg13cmos5l_decap_8
* cell instance sg13cmos5l_decap_8_5329 r0 *1 0,0
Xsg13cmos5l_decap_8_5329 VPWR VGND sg13cmos5l_decap_8
* cell instance sg13cmos5l_decap_8_5330 r0 *1 0,0
Xsg13cmos5l_decap_8_5330 VPWR VGND sg13cmos5l_decap_8
* cell instance sg13cmos5l_decap_8_5331 r0 *1 0,0
Xsg13cmos5l_decap_8_5331 VPWR VGND sg13cmos5l_decap_8
* cell instance sg13cmos5l_decap_8_5332 r0 *1 0,0
Xsg13cmos5l_decap_8_5332 VPWR VGND sg13cmos5l_decap_8
* cell instance sg13cmos5l_decap_8_5333 r0 *1 0,0
Xsg13cmos5l_decap_8_5333 VPWR VGND sg13cmos5l_decap_8
* cell instance sg13cmos5l_decap_8_5334 r0 *1 0,0
Xsg13cmos5l_decap_8_5334 VPWR VGND sg13cmos5l_decap_8
* cell instance sg13cmos5l_decap_8_5335 r0 *1 0,0
Xsg13cmos5l_decap_8_5335 VPWR VGND sg13cmos5l_decap_8
* cell instance sg13cmos5l_decap_8_5336 r0 *1 0,0
Xsg13cmos5l_decap_8_5336 VPWR VGND sg13cmos5l_decap_8
* cell instance sg13cmos5l_decap_8_5337 r0 *1 0,0
Xsg13cmos5l_decap_8_5337 VPWR VGND sg13cmos5l_decap_8
* cell instance sg13cmos5l_decap_8_5338 r0 *1 0,0
Xsg13cmos5l_decap_8_5338 VPWR VGND sg13cmos5l_decap_8
* cell instance sg13cmos5l_decap_8_5339 r0 *1 0,0
Xsg13cmos5l_decap_8_5339 VPWR VGND sg13cmos5l_decap_8
* cell instance sg13cmos5l_decap_8_5340 r0 *1 0,0
Xsg13cmos5l_decap_8_5340 VPWR VGND sg13cmos5l_decap_8
* cell instance sg13cmos5l_decap_8_5341 r0 *1 0,0
Xsg13cmos5l_decap_8_5341 VPWR VGND sg13cmos5l_decap_8
* cell instance sg13cmos5l_decap_8_5342 r0 *1 0,0
Xsg13cmos5l_decap_8_5342 VPWR VGND sg13cmos5l_decap_8
* cell instance sg13cmos5l_decap_8_5343 r0 *1 0,0
Xsg13cmos5l_decap_8_5343 VPWR VGND sg13cmos5l_decap_8
* cell instance sg13cmos5l_decap_8_5344 r0 *1 0,0
Xsg13cmos5l_decap_8_5344 VPWR VGND sg13cmos5l_decap_8
* cell instance sg13cmos5l_decap_8_5345 r0 *1 0,0
Xsg13cmos5l_decap_8_5345 VPWR VGND sg13cmos5l_decap_8
* cell instance sg13cmos5l_decap_8_5346 r0 *1 0,0
Xsg13cmos5l_decap_8_5346 VPWR VGND sg13cmos5l_decap_8
* cell instance sg13cmos5l_decap_8_5347 r0 *1 0,0
Xsg13cmos5l_decap_8_5347 VPWR VGND sg13cmos5l_decap_8
* cell instance sg13cmos5l_decap_8_5348 r0 *1 0,0
Xsg13cmos5l_decap_8_5348 VPWR VGND sg13cmos5l_decap_8
* cell instance sg13cmos5l_decap_8_5349 r0 *1 0,0
Xsg13cmos5l_decap_8_5349 VPWR VGND sg13cmos5l_decap_8
* cell instance sg13cmos5l_decap_8_5350 r0 *1 0,0
Xsg13cmos5l_decap_8_5350 VPWR VGND sg13cmos5l_decap_8
* cell instance sg13cmos5l_decap_8_5351 r0 *1 0,0
Xsg13cmos5l_decap_8_5351 VPWR VGND sg13cmos5l_decap_8
* cell instance sg13cmos5l_decap_8_5352 r0 *1 0,0
Xsg13cmos5l_decap_8_5352 VPWR VGND sg13cmos5l_decap_8
* cell instance sg13cmos5l_decap_8_5353 r0 *1 0,0
Xsg13cmos5l_decap_8_5353 VPWR VGND sg13cmos5l_decap_8
* cell instance sg13cmos5l_decap_8_5354 r0 *1 0,0
Xsg13cmos5l_decap_8_5354 VPWR VGND sg13cmos5l_decap_8
* cell instance sg13cmos5l_decap_8_5355 r0 *1 0,0
Xsg13cmos5l_decap_8_5355 VPWR VGND sg13cmos5l_decap_8
* cell instance sg13cmos5l_decap_8_5356 r0 *1 0,0
Xsg13cmos5l_decap_8_5356 VPWR VGND sg13cmos5l_decap_8
* cell instance sg13cmos5l_decap_8_5357 r0 *1 0,0
Xsg13cmos5l_decap_8_5357 VPWR VGND sg13cmos5l_decap_8
* cell instance sg13cmos5l_decap_8_5358 r0 *1 0,0
Xsg13cmos5l_decap_8_5358 VPWR VGND sg13cmos5l_decap_8
* cell instance sg13cmos5l_decap_8_5359 r0 *1 0,0
Xsg13cmos5l_decap_8_5359 VPWR VGND sg13cmos5l_decap_8
* cell instance sg13cmos5l_decap_8_5360 r0 *1 0,0
Xsg13cmos5l_decap_8_5360 VPWR VGND sg13cmos5l_decap_8
* cell instance sg13cmos5l_decap_8_5361 r0 *1 0,0
Xsg13cmos5l_decap_8_5361 VPWR VGND sg13cmos5l_decap_8
* cell instance sg13cmos5l_decap_8_5362 r0 *1 0,0
Xsg13cmos5l_decap_8_5362 VPWR VGND sg13cmos5l_decap_8
* cell instance sg13cmos5l_decap_8_5363 r0 *1 0,0
Xsg13cmos5l_decap_8_5363 VPWR VGND sg13cmos5l_decap_8
* cell instance sg13cmos5l_decap_8_5364 r0 *1 0,0
Xsg13cmos5l_decap_8_5364 VPWR VGND sg13cmos5l_decap_8
* cell instance sg13cmos5l_decap_8_5365 r0 *1 0,0
Xsg13cmos5l_decap_8_5365 VPWR VGND sg13cmos5l_decap_8
* cell instance sg13cmos5l_decap_8_5366 r0 *1 0,0
Xsg13cmos5l_decap_8_5366 VPWR VGND sg13cmos5l_decap_8
* cell instance sg13cmos5l_decap_8_5367 r0 *1 0,0
Xsg13cmos5l_decap_8_5367 VPWR VGND sg13cmos5l_decap_8
* cell instance sg13cmos5l_decap_8_5368 r0 *1 0,0
Xsg13cmos5l_decap_8_5368 VPWR VGND sg13cmos5l_decap_8
* cell instance sg13cmos5l_decap_8_5369 r0 *1 0,0
Xsg13cmos5l_decap_8_5369 VPWR VGND sg13cmos5l_decap_8
* cell instance sg13cmos5l_decap_8_5370 r0 *1 0,0
Xsg13cmos5l_decap_8_5370 VPWR VGND sg13cmos5l_decap_8
* cell instance sg13cmos5l_decap_8_5371 r0 *1 0,0
Xsg13cmos5l_decap_8_5371 VPWR VGND sg13cmos5l_decap_8
* cell instance sg13cmos5l_decap_8_5372 r0 *1 0,0
Xsg13cmos5l_decap_8_5372 VPWR VGND sg13cmos5l_decap_8
* cell instance sg13cmos5l_decap_8_5373 r0 *1 0,0
Xsg13cmos5l_decap_8_5373 VPWR VGND sg13cmos5l_decap_8
* cell instance sg13cmos5l_decap_8_5374 r0 *1 0,0
Xsg13cmos5l_decap_8_5374 VPWR VGND sg13cmos5l_decap_8
* cell instance sg13cmos5l_decap_8_5375 r0 *1 0,0
Xsg13cmos5l_decap_8_5375 VPWR VGND sg13cmos5l_decap_8
* cell instance sg13cmos5l_decap_8_5376 r0 *1 0,0
Xsg13cmos5l_decap_8_5376 VPWR VGND sg13cmos5l_decap_8
* cell instance sg13cmos5l_decap_8_5377 r0 *1 0,0
Xsg13cmos5l_decap_8_5377 VPWR VGND sg13cmos5l_decap_8
* cell instance sg13cmos5l_decap_8_5378 r0 *1 0,0
Xsg13cmos5l_decap_8_5378 VPWR VGND sg13cmos5l_decap_8
* cell instance sg13cmos5l_decap_8_5379 r0 *1 0,0
Xsg13cmos5l_decap_8_5379 VPWR VGND sg13cmos5l_decap_8
* cell instance sg13cmos5l_decap_8_5380 r0 *1 0,0
Xsg13cmos5l_decap_8_5380 VPWR VGND sg13cmos5l_decap_8
* cell instance sg13cmos5l_decap_8_5381 r0 *1 0,0
Xsg13cmos5l_decap_8_5381 VPWR VGND sg13cmos5l_decap_8
* cell instance sg13cmos5l_decap_8_5382 r0 *1 0,0
Xsg13cmos5l_decap_8_5382 VPWR VGND sg13cmos5l_decap_8
* cell instance sg13cmos5l_decap_8_5383 r0 *1 0,0
Xsg13cmos5l_decap_8_5383 VPWR VGND sg13cmos5l_decap_8
* cell instance sg13cmos5l_decap_8_5384 r0 *1 0,0
Xsg13cmos5l_decap_8_5384 VPWR VGND sg13cmos5l_decap_8
* cell instance sg13cmos5l_decap_8_5385 r0 *1 0,0
Xsg13cmos5l_decap_8_5385 VPWR VGND sg13cmos5l_decap_8
* cell instance sg13cmos5l_decap_8_5386 r0 *1 0,0
Xsg13cmos5l_decap_8_5386 VPWR VGND sg13cmos5l_decap_8
* cell instance sg13cmos5l_decap_8_5387 r0 *1 0,0
Xsg13cmos5l_decap_8_5387 VPWR VGND sg13cmos5l_decap_8
* cell instance sg13cmos5l_decap_8_5388 r0 *1 0,0
Xsg13cmos5l_decap_8_5388 VPWR VGND sg13cmos5l_decap_8
* cell instance sg13cmos5l_decap_8_5389 r0 *1 0,0
Xsg13cmos5l_decap_8_5389 VPWR VGND sg13cmos5l_decap_8
* cell instance sg13cmos5l_decap_8_5390 r0 *1 0,0
Xsg13cmos5l_decap_8_5390 VPWR VGND sg13cmos5l_decap_8
* cell instance sg13cmos5l_decap_8_5391 r0 *1 0,0
Xsg13cmos5l_decap_8_5391 VPWR VGND sg13cmos5l_decap_8
* cell instance sg13cmos5l_decap_8_5392 r0 *1 0,0
Xsg13cmos5l_decap_8_5392 VPWR VGND sg13cmos5l_decap_8
* cell instance sg13cmos5l_decap_8_5393 r0 *1 0,0
Xsg13cmos5l_decap_8_5393 VPWR VGND sg13cmos5l_decap_8
* cell instance sg13cmos5l_decap_8_5394 r0 *1 0,0
Xsg13cmos5l_decap_8_5394 VPWR VGND sg13cmos5l_decap_8
* cell instance sg13cmos5l_decap_8_5395 r0 *1 0,0
Xsg13cmos5l_decap_8_5395 VPWR VGND sg13cmos5l_decap_8
* cell instance sg13cmos5l_decap_8_5396 r0 *1 0,0
Xsg13cmos5l_decap_8_5396 VPWR VGND sg13cmos5l_decap_8
* cell instance sg13cmos5l_decap_8_5397 r0 *1 0,0
Xsg13cmos5l_decap_8_5397 VPWR VGND sg13cmos5l_decap_8
* cell instance sg13cmos5l_decap_8_5398 r0 *1 0,0
Xsg13cmos5l_decap_8_5398 VPWR VGND sg13cmos5l_decap_8
* cell instance sg13cmos5l_decap_8_5399 r0 *1 0,0
Xsg13cmos5l_decap_8_5399 VPWR VGND sg13cmos5l_decap_8
* cell instance sg13cmos5l_decap_8_5400 r0 *1 0,0
Xsg13cmos5l_decap_8_5400 VPWR VGND sg13cmos5l_decap_8
* cell instance sg13cmos5l_decap_8_5401 r0 *1 0,0
Xsg13cmos5l_decap_8_5401 VPWR VGND sg13cmos5l_decap_8
* cell instance sg13cmos5l_decap_8_5402 r0 *1 0,0
Xsg13cmos5l_decap_8_5402 VPWR VGND sg13cmos5l_decap_8
* cell instance sg13cmos5l_decap_8_5403 r0 *1 0,0
Xsg13cmos5l_decap_8_5403 VPWR VGND sg13cmos5l_decap_8
* cell instance sg13cmos5l_decap_8_5404 r0 *1 0,0
Xsg13cmos5l_decap_8_5404 VPWR VGND sg13cmos5l_decap_8
* cell instance sg13cmos5l_decap_8_5405 r0 *1 0,0
Xsg13cmos5l_decap_8_5405 VPWR VGND sg13cmos5l_decap_8
* cell instance sg13cmos5l_decap_8_5406 r0 *1 0,0
Xsg13cmos5l_decap_8_5406 VPWR VGND sg13cmos5l_decap_8
* cell instance sg13cmos5l_decap_8_5407 r0 *1 0,0
Xsg13cmos5l_decap_8_5407 VPWR VGND sg13cmos5l_decap_8
* cell instance sg13cmos5l_decap_8_5408 r0 *1 0,0
Xsg13cmos5l_decap_8_5408 VPWR VGND sg13cmos5l_decap_8
* cell instance sg13cmos5l_decap_8_5409 r0 *1 0,0
Xsg13cmos5l_decap_8_5409 VPWR VGND sg13cmos5l_decap_8
* cell instance sg13cmos5l_decap_8_5410 r0 *1 0,0
Xsg13cmos5l_decap_8_5410 VPWR VGND sg13cmos5l_decap_8
* cell instance sg13cmos5l_decap_8_5411 r0 *1 0,0
Xsg13cmos5l_decap_8_5411 VPWR VGND sg13cmos5l_decap_8
* cell instance sg13cmos5l_decap_8_5412 r0 *1 0,0
Xsg13cmos5l_decap_8_5412 VPWR VGND sg13cmos5l_decap_8
* cell instance sg13cmos5l_decap_8_5413 r0 *1 0,0
Xsg13cmos5l_decap_8_5413 VPWR VGND sg13cmos5l_decap_8
* cell instance sg13cmos5l_decap_8_5414 r0 *1 0,0
Xsg13cmos5l_decap_8_5414 VPWR VGND sg13cmos5l_decap_8
* cell instance sg13cmos5l_decap_8_5415 r0 *1 0,0
Xsg13cmos5l_decap_8_5415 VPWR VGND sg13cmos5l_decap_8
* cell instance sg13cmos5l_decap_8_5416 r0 *1 0,0
Xsg13cmos5l_decap_8_5416 VPWR VGND sg13cmos5l_decap_8
* cell instance sg13cmos5l_decap_8_5417 r0 *1 0,0
Xsg13cmos5l_decap_8_5417 VPWR VGND sg13cmos5l_decap_8
* cell instance sg13cmos5l_decap_8_5418 r0 *1 0,0
Xsg13cmos5l_decap_8_5418 VPWR VGND sg13cmos5l_decap_8
* cell instance sg13cmos5l_decap_8_5419 r0 *1 0,0
Xsg13cmos5l_decap_8_5419 VPWR VGND sg13cmos5l_decap_8
* cell instance sg13cmos5l_decap_8_5420 r0 *1 0,0
Xsg13cmos5l_decap_8_5420 VPWR VGND sg13cmos5l_decap_8
* cell instance sg13cmos5l_decap_8_5421 r0 *1 0,0
Xsg13cmos5l_decap_8_5421 VPWR VGND sg13cmos5l_decap_8
* cell instance sg13cmos5l_decap_8_5422 r0 *1 0,0
Xsg13cmos5l_decap_8_5422 VPWR VGND sg13cmos5l_decap_8
* cell instance sg13cmos5l_decap_8_5423 r0 *1 0,0
Xsg13cmos5l_decap_8_5423 VPWR VGND sg13cmos5l_decap_8
* cell instance sg13cmos5l_decap_8_5424 r0 *1 0,0
Xsg13cmos5l_decap_8_5424 VPWR VGND sg13cmos5l_decap_8
* cell instance sg13cmos5l_decap_8_5425 r0 *1 0,0
Xsg13cmos5l_decap_8_5425 VPWR VGND sg13cmos5l_decap_8
* cell instance sg13cmos5l_decap_8_5426 r0 *1 0,0
Xsg13cmos5l_decap_8_5426 VPWR VGND sg13cmos5l_decap_8
* cell instance sg13cmos5l_decap_8_5427 r0 *1 0,0
Xsg13cmos5l_decap_8_5427 VPWR VGND sg13cmos5l_decap_8
* cell instance sg13cmos5l_decap_8_5428 r0 *1 0,0
Xsg13cmos5l_decap_8_5428 VPWR VGND sg13cmos5l_decap_8
* cell instance sg13cmos5l_decap_8_5429 r0 *1 0,0
Xsg13cmos5l_decap_8_5429 VPWR VGND sg13cmos5l_decap_8
* cell instance sg13cmos5l_decap_8_5430 r0 *1 0,0
Xsg13cmos5l_decap_8_5430 VPWR VGND sg13cmos5l_decap_8
* cell instance sg13cmos5l_decap_8_5431 r0 *1 0,0
Xsg13cmos5l_decap_8_5431 VPWR VGND sg13cmos5l_decap_8
* cell instance sg13cmos5l_decap_8_5432 r0 *1 0,0
Xsg13cmos5l_decap_8_5432 VPWR VGND sg13cmos5l_decap_8
* cell instance sg13cmos5l_decap_8_5433 r0 *1 0,0
Xsg13cmos5l_decap_8_5433 VPWR VGND sg13cmos5l_decap_8
* cell instance sg13cmos5l_decap_8_5434 r0 *1 0,0
Xsg13cmos5l_decap_8_5434 VPWR VGND sg13cmos5l_decap_8
* cell instance sg13cmos5l_decap_8_5435 r0 *1 0,0
Xsg13cmos5l_decap_8_5435 VPWR VGND sg13cmos5l_decap_8
* cell instance sg13cmos5l_decap_8_5436 r0 *1 0,0
Xsg13cmos5l_decap_8_5436 VPWR VGND sg13cmos5l_decap_8
* cell instance sg13cmos5l_decap_8_5437 r0 *1 0,0
Xsg13cmos5l_decap_8_5437 VPWR VGND sg13cmos5l_decap_8
* cell instance sg13cmos5l_decap_8_5438 r0 *1 0,0
Xsg13cmos5l_decap_8_5438 VPWR VGND sg13cmos5l_decap_8
* cell instance sg13cmos5l_decap_8_5439 r0 *1 0,0
Xsg13cmos5l_decap_8_5439 VPWR VGND sg13cmos5l_decap_8
* cell instance sg13cmos5l_decap_8_5440 r0 *1 0,0
Xsg13cmos5l_decap_8_5440 VPWR VGND sg13cmos5l_decap_8
* cell instance sg13cmos5l_decap_8_5441 r0 *1 0,0
Xsg13cmos5l_decap_8_5441 VPWR VGND sg13cmos5l_decap_8
* cell instance sg13cmos5l_decap_8_5442 r0 *1 0,0
Xsg13cmos5l_decap_8_5442 VPWR VGND sg13cmos5l_decap_8
* cell instance sg13cmos5l_decap_8_5443 r0 *1 0,0
Xsg13cmos5l_decap_8_5443 VPWR VGND sg13cmos5l_decap_8
* cell instance sg13cmos5l_decap_8_5444 r0 *1 0,0
Xsg13cmos5l_decap_8_5444 VPWR VGND sg13cmos5l_decap_8
* cell instance sg13cmos5l_decap_8_5445 r0 *1 0,0
Xsg13cmos5l_decap_8_5445 VPWR VGND sg13cmos5l_decap_8
* cell instance sg13cmos5l_decap_8_5446 r0 *1 0,0
Xsg13cmos5l_decap_8_5446 VPWR VGND sg13cmos5l_decap_8
* cell instance sg13cmos5l_decap_8_5447 r0 *1 0,0
Xsg13cmos5l_decap_8_5447 VPWR VGND sg13cmos5l_decap_8
* cell instance sg13cmos5l_decap_8_5448 r0 *1 0,0
Xsg13cmos5l_decap_8_5448 VPWR VGND sg13cmos5l_decap_8
* cell instance sg13cmos5l_decap_8_5449 r0 *1 0,0
Xsg13cmos5l_decap_8_5449 VPWR VGND sg13cmos5l_decap_8
* cell instance sg13cmos5l_decap_8_5450 r0 *1 0,0
Xsg13cmos5l_decap_8_5450 VPWR VGND sg13cmos5l_decap_8
* cell instance sg13cmos5l_decap_8_5451 r0 *1 0,0
Xsg13cmos5l_decap_8_5451 VPWR VGND sg13cmos5l_decap_8
* cell instance sg13cmos5l_decap_8_5452 r0 *1 0,0
Xsg13cmos5l_decap_8_5452 VPWR VGND sg13cmos5l_decap_8
* cell instance sg13cmos5l_decap_8_5453 r0 *1 0,0
Xsg13cmos5l_decap_8_5453 VPWR VGND sg13cmos5l_decap_8
* cell instance sg13cmos5l_decap_8_5454 r0 *1 0,0
Xsg13cmos5l_decap_8_5454 VPWR VGND sg13cmos5l_decap_8
* cell instance sg13cmos5l_decap_8_5455 r0 *1 0,0
Xsg13cmos5l_decap_8_5455 VPWR VGND sg13cmos5l_decap_8
* cell instance sg13cmos5l_decap_8_5456 r0 *1 0,0
Xsg13cmos5l_decap_8_5456 VPWR VGND sg13cmos5l_decap_8
* cell instance sg13cmos5l_decap_8_5457 r0 *1 0,0
Xsg13cmos5l_decap_8_5457 VPWR VGND sg13cmos5l_decap_8
* cell instance sg13cmos5l_decap_8_5458 r0 *1 0,0
Xsg13cmos5l_decap_8_5458 VPWR VGND sg13cmos5l_decap_8
* cell instance sg13cmos5l_decap_8_5459 r0 *1 0,0
Xsg13cmos5l_decap_8_5459 VPWR VGND sg13cmos5l_decap_8
* cell instance sg13cmos5l_decap_8_5460 r0 *1 0,0
Xsg13cmos5l_decap_8_5460 VPWR VGND sg13cmos5l_decap_8
* cell instance sg13cmos5l_decap_8_5461 r0 *1 0,0
Xsg13cmos5l_decap_8_5461 VPWR VGND sg13cmos5l_decap_8
* cell instance sg13cmos5l_decap_8_5462 r0 *1 0,0
Xsg13cmos5l_decap_8_5462 VPWR VGND sg13cmos5l_decap_8
* cell instance sg13cmos5l_decap_8_5463 r0 *1 0,0
Xsg13cmos5l_decap_8_5463 VPWR VGND sg13cmos5l_decap_8
* cell instance sg13cmos5l_decap_8_5464 r0 *1 0,0
Xsg13cmos5l_decap_8_5464 VPWR VGND sg13cmos5l_decap_8
* cell instance sg13cmos5l_decap_8_5465 r0 *1 0,0
Xsg13cmos5l_decap_8_5465 VPWR VGND sg13cmos5l_decap_8
* cell instance sg13cmos5l_decap_8_5466 r0 *1 0,0
Xsg13cmos5l_decap_8_5466 VPWR VGND sg13cmos5l_decap_8
* cell instance sg13cmos5l_decap_8_5467 r0 *1 0,0
Xsg13cmos5l_decap_8_5467 VPWR VGND sg13cmos5l_decap_8
* cell instance sg13cmos5l_decap_8_5468 r0 *1 0,0
Xsg13cmos5l_decap_8_5468 VPWR VGND sg13cmos5l_decap_8
* cell instance sg13cmos5l_decap_8_5469 r0 *1 0,0
Xsg13cmos5l_decap_8_5469 VPWR VGND sg13cmos5l_decap_8
* cell instance sg13cmos5l_decap_8_5470 r0 *1 0,0
Xsg13cmos5l_decap_8_5470 VPWR VGND sg13cmos5l_decap_8
* cell instance sg13cmos5l_decap_8_5471 r0 *1 0,0
Xsg13cmos5l_decap_8_5471 VPWR VGND sg13cmos5l_decap_8
* cell instance sg13cmos5l_decap_8_5472 r0 *1 0,0
Xsg13cmos5l_decap_8_5472 VPWR VGND sg13cmos5l_decap_8
* cell instance sg13cmos5l_decap_8_5473 r0 *1 0,0
Xsg13cmos5l_decap_8_5473 VPWR VGND sg13cmos5l_decap_8
* cell instance sg13cmos5l_decap_8_5474 r0 *1 0,0
Xsg13cmos5l_decap_8_5474 VPWR VGND sg13cmos5l_decap_8
* cell instance sg13cmos5l_decap_8_5475 r0 *1 0,0
Xsg13cmos5l_decap_8_5475 VPWR VGND sg13cmos5l_decap_8
* cell instance sg13cmos5l_decap_8_5476 r0 *1 0,0
Xsg13cmos5l_decap_8_5476 VPWR VGND sg13cmos5l_decap_8
* cell instance sg13cmos5l_decap_8_5477 r0 *1 0,0
Xsg13cmos5l_decap_8_5477 VPWR VGND sg13cmos5l_decap_8
* cell instance sg13cmos5l_decap_8_5478 r0 *1 0,0
Xsg13cmos5l_decap_8_5478 VPWR VGND sg13cmos5l_decap_8
* cell instance sg13cmos5l_decap_8_5479 r0 *1 0,0
Xsg13cmos5l_decap_8_5479 VPWR VGND sg13cmos5l_decap_8
* cell instance sg13cmos5l_decap_8_5480 r0 *1 0,0
Xsg13cmos5l_decap_8_5480 VPWR VGND sg13cmos5l_decap_8
* cell instance sg13cmos5l_decap_8_5481 r0 *1 0,0
Xsg13cmos5l_decap_8_5481 VPWR VGND sg13cmos5l_decap_8
* cell instance sg13cmos5l_decap_8_5482 r0 *1 0,0
Xsg13cmos5l_decap_8_5482 VPWR VGND sg13cmos5l_decap_8
* cell instance sg13cmos5l_decap_8_5483 r0 *1 0,0
Xsg13cmos5l_decap_8_5483 VPWR VGND sg13cmos5l_decap_8
* cell instance sg13cmos5l_decap_8_5484 r0 *1 0,0
Xsg13cmos5l_decap_8_5484 VPWR VGND sg13cmos5l_decap_8
* cell instance sg13cmos5l_decap_8_5485 r0 *1 0,0
Xsg13cmos5l_decap_8_5485 VPWR VGND sg13cmos5l_decap_8
* cell instance sg13cmos5l_decap_8_5486 r0 *1 0,0
Xsg13cmos5l_decap_8_5486 VPWR VGND sg13cmos5l_decap_8
* cell instance sg13cmos5l_decap_8_5487 r0 *1 0,0
Xsg13cmos5l_decap_8_5487 VPWR VGND sg13cmos5l_decap_8
* cell instance sg13cmos5l_decap_8_5488 r0 *1 0,0
Xsg13cmos5l_decap_8_5488 VPWR VGND sg13cmos5l_decap_8
* cell instance sg13cmos5l_decap_8_5489 r0 *1 0,0
Xsg13cmos5l_decap_8_5489 VPWR VGND sg13cmos5l_decap_8
* cell instance sg13cmos5l_decap_8_5490 r0 *1 0,0
Xsg13cmos5l_decap_8_5490 VPWR VGND sg13cmos5l_decap_8
* cell instance sg13cmos5l_decap_8_5491 r0 *1 0,0
Xsg13cmos5l_decap_8_5491 VPWR VGND sg13cmos5l_decap_8
* cell instance sg13cmos5l_decap_8_5492 r0 *1 0,0
Xsg13cmos5l_decap_8_5492 VPWR VGND sg13cmos5l_decap_8
* cell instance sg13cmos5l_decap_8_5493 r0 *1 0,0
Xsg13cmos5l_decap_8_5493 VPWR VGND sg13cmos5l_decap_8
* cell instance sg13cmos5l_decap_8_5494 r0 *1 0,0
Xsg13cmos5l_decap_8_5494 VPWR VGND sg13cmos5l_decap_8
* cell instance sg13cmos5l_decap_8_5495 r0 *1 0,0
Xsg13cmos5l_decap_8_5495 VPWR VGND sg13cmos5l_decap_8
* cell instance sg13cmos5l_decap_8_5496 r0 *1 0,0
Xsg13cmos5l_decap_8_5496 VPWR VGND sg13cmos5l_decap_8
* cell instance sg13cmos5l_decap_8_5497 r0 *1 0,0
Xsg13cmos5l_decap_8_5497 VPWR VGND sg13cmos5l_decap_8
* cell instance sg13cmos5l_decap_8_5498 r0 *1 0,0
Xsg13cmos5l_decap_8_5498 VPWR VGND sg13cmos5l_decap_8
* cell instance sg13cmos5l_decap_8_5499 r0 *1 0,0
Xsg13cmos5l_decap_8_5499 VPWR VGND sg13cmos5l_decap_8
* cell instance sg13cmos5l_decap_8_5500 r0 *1 0,0
Xsg13cmos5l_decap_8_5500 VPWR VGND sg13cmos5l_decap_8
* cell instance sg13cmos5l_decap_8_5501 r0 *1 0,0
Xsg13cmos5l_decap_8_5501 VPWR VGND sg13cmos5l_decap_8
* cell instance sg13cmos5l_decap_8_5502 r0 *1 0,0
Xsg13cmos5l_decap_8_5502 VPWR VGND sg13cmos5l_decap_8
* cell instance sg13cmos5l_decap_8_5503 r0 *1 0,0
Xsg13cmos5l_decap_8_5503 VPWR VGND sg13cmos5l_decap_8
* cell instance sg13cmos5l_decap_8_5504 r0 *1 0,0
Xsg13cmos5l_decap_8_5504 VPWR VGND sg13cmos5l_decap_8
* cell instance sg13cmos5l_decap_8_5505 r0 *1 0,0
Xsg13cmos5l_decap_8_5505 VPWR VGND sg13cmos5l_decap_8
* cell instance sg13cmos5l_decap_8_5506 r0 *1 0,0
Xsg13cmos5l_decap_8_5506 VPWR VGND sg13cmos5l_decap_8
* cell instance sg13cmos5l_decap_8_5507 r0 *1 0,0
Xsg13cmos5l_decap_8_5507 VPWR VGND sg13cmos5l_decap_8
* cell instance sg13cmos5l_decap_8_5508 r0 *1 0,0
Xsg13cmos5l_decap_8_5508 VPWR VGND sg13cmos5l_decap_8
* cell instance sg13cmos5l_decap_8_5509 r0 *1 0,0
Xsg13cmos5l_decap_8_5509 VPWR VGND sg13cmos5l_decap_8
* cell instance sg13cmos5l_decap_8_5510 r0 *1 0,0
Xsg13cmos5l_decap_8_5510 VPWR VGND sg13cmos5l_decap_8
* cell instance sg13cmos5l_decap_8_5511 r0 *1 0,0
Xsg13cmos5l_decap_8_5511 VPWR VGND sg13cmos5l_decap_8
* cell instance sg13cmos5l_decap_8_5512 r0 *1 0,0
Xsg13cmos5l_decap_8_5512 VPWR VGND sg13cmos5l_decap_8
* cell instance sg13cmos5l_decap_8_5513 r0 *1 0,0
Xsg13cmos5l_decap_8_5513 VPWR VGND sg13cmos5l_decap_8
* cell instance sg13cmos5l_decap_8_5514 r0 *1 0,0
Xsg13cmos5l_decap_8_5514 VPWR VGND sg13cmos5l_decap_8
* cell instance sg13cmos5l_decap_8_5515 r0 *1 0,0
Xsg13cmos5l_decap_8_5515 VPWR VGND sg13cmos5l_decap_8
* cell instance sg13cmos5l_decap_8_5516 r0 *1 0,0
Xsg13cmos5l_decap_8_5516 VPWR VGND sg13cmos5l_decap_8
* cell instance sg13cmos5l_decap_8_5517 r0 *1 0,0
Xsg13cmos5l_decap_8_5517 VPWR VGND sg13cmos5l_decap_8
* cell instance sg13cmos5l_decap_8_5518 r0 *1 0,0
Xsg13cmos5l_decap_8_5518 VPWR VGND sg13cmos5l_decap_8
* cell instance sg13cmos5l_decap_8_5519 r0 *1 0,0
Xsg13cmos5l_decap_8_5519 VPWR VGND sg13cmos5l_decap_8
* cell instance sg13cmos5l_decap_8_5520 r0 *1 0,0
Xsg13cmos5l_decap_8_5520 VPWR VGND sg13cmos5l_decap_8
* cell instance sg13cmos5l_decap_8_5521 r0 *1 0,0
Xsg13cmos5l_decap_8_5521 VPWR VGND sg13cmos5l_decap_8
* cell instance sg13cmos5l_decap_8_5522 r0 *1 0,0
Xsg13cmos5l_decap_8_5522 VPWR VGND sg13cmos5l_decap_8
* cell instance sg13cmos5l_decap_8_5523 r0 *1 0,0
Xsg13cmos5l_decap_8_5523 VPWR VGND sg13cmos5l_decap_8
* cell instance sg13cmos5l_decap_8_5524 r0 *1 0,0
Xsg13cmos5l_decap_8_5524 VPWR VGND sg13cmos5l_decap_8
* cell instance sg13cmos5l_decap_8_5525 r0 *1 0,0
Xsg13cmos5l_decap_8_5525 VPWR VGND sg13cmos5l_decap_8
* cell instance sg13cmos5l_decap_8_5526 r0 *1 0,0
Xsg13cmos5l_decap_8_5526 VPWR VGND sg13cmos5l_decap_8
* cell instance sg13cmos5l_decap_8_5527 r0 *1 0,0
Xsg13cmos5l_decap_8_5527 VPWR VGND sg13cmos5l_decap_8
* cell instance sg13cmos5l_decap_8_5528 r0 *1 0,0
Xsg13cmos5l_decap_8_5528 VPWR VGND sg13cmos5l_decap_8
* cell instance sg13cmos5l_decap_8_5529 r0 *1 0,0
Xsg13cmos5l_decap_8_5529 VPWR VGND sg13cmos5l_decap_8
* cell instance sg13cmos5l_decap_8_5530 r0 *1 0,0
Xsg13cmos5l_decap_8_5530 VPWR VGND sg13cmos5l_decap_8
* cell instance sg13cmos5l_decap_8_5531 r0 *1 0,0
Xsg13cmos5l_decap_8_5531 VPWR VGND sg13cmos5l_decap_8
* cell instance sg13cmos5l_decap_8_5532 r0 *1 0,0
Xsg13cmos5l_decap_8_5532 VPWR VGND sg13cmos5l_decap_8
* cell instance sg13cmos5l_decap_8_5533 r0 *1 0,0
Xsg13cmos5l_decap_8_5533 VPWR VGND sg13cmos5l_decap_8
* cell instance sg13cmos5l_decap_8_5534 r0 *1 0,0
Xsg13cmos5l_decap_8_5534 VPWR VGND sg13cmos5l_decap_8
* cell instance sg13cmos5l_decap_8_5535 r0 *1 0,0
Xsg13cmos5l_decap_8_5535 VPWR VGND sg13cmos5l_decap_8
* cell instance sg13cmos5l_decap_8_5536 r0 *1 0,0
Xsg13cmos5l_decap_8_5536 VPWR VGND sg13cmos5l_decap_8
* cell instance sg13cmos5l_decap_8_5537 r0 *1 0,0
Xsg13cmos5l_decap_8_5537 VPWR VGND sg13cmos5l_decap_8
* cell instance sg13cmos5l_decap_8_5538 r0 *1 0,0
Xsg13cmos5l_decap_8_5538 VPWR VGND sg13cmos5l_decap_8
* cell instance sg13cmos5l_decap_8_5539 r0 *1 0,0
Xsg13cmos5l_decap_8_5539 VPWR VGND sg13cmos5l_decap_8
* cell instance sg13cmos5l_decap_8_5540 r0 *1 0,0
Xsg13cmos5l_decap_8_5540 VPWR VGND sg13cmos5l_decap_8
* cell instance sg13cmos5l_decap_8_5541 r0 *1 0,0
Xsg13cmos5l_decap_8_5541 VPWR VGND sg13cmos5l_decap_8
* cell instance sg13cmos5l_decap_8_5542 r0 *1 0,0
Xsg13cmos5l_decap_8_5542 VPWR VGND sg13cmos5l_decap_8
* cell instance sg13cmos5l_decap_8_5543 r0 *1 0,0
Xsg13cmos5l_decap_8_5543 VPWR VGND sg13cmos5l_decap_8
* cell instance sg13cmos5l_decap_8_5544 r0 *1 0,0
Xsg13cmos5l_decap_8_5544 VPWR VGND sg13cmos5l_decap_8
* cell instance sg13cmos5l_decap_8_5545 r0 *1 0,0
Xsg13cmos5l_decap_8_5545 VPWR VGND sg13cmos5l_decap_8
* cell instance sg13cmos5l_decap_8_5546 r0 *1 0,0
Xsg13cmos5l_decap_8_5546 VPWR VGND sg13cmos5l_decap_8
* cell instance sg13cmos5l_decap_8_5547 r0 *1 0,0
Xsg13cmos5l_decap_8_5547 VPWR VGND sg13cmos5l_decap_8
* cell instance sg13cmos5l_decap_8_5548 r0 *1 0,0
Xsg13cmos5l_decap_8_5548 VPWR VGND sg13cmos5l_decap_8
* cell instance sg13cmos5l_decap_8_5549 r0 *1 0,0
Xsg13cmos5l_decap_8_5549 VPWR VGND sg13cmos5l_decap_8
* cell instance sg13cmos5l_decap_8_5550 r0 *1 0,0
Xsg13cmos5l_decap_8_5550 VPWR VGND sg13cmos5l_decap_8
* cell instance sg13cmos5l_decap_8_5551 r0 *1 0,0
Xsg13cmos5l_decap_8_5551 VPWR VGND sg13cmos5l_decap_8
* cell instance sg13cmos5l_decap_8_5552 r0 *1 0,0
Xsg13cmos5l_decap_8_5552 VPWR VGND sg13cmos5l_decap_8
* cell instance sg13cmos5l_decap_8_5553 r0 *1 0,0
Xsg13cmos5l_decap_8_5553 VPWR VGND sg13cmos5l_decap_8
* cell instance sg13cmos5l_decap_8_5554 r0 *1 0,0
Xsg13cmos5l_decap_8_5554 VPWR VGND sg13cmos5l_decap_8
* cell instance sg13cmos5l_decap_8_5555 r0 *1 0,0
Xsg13cmos5l_decap_8_5555 VPWR VGND sg13cmos5l_decap_8
* cell instance sg13cmos5l_decap_8_5556 r0 *1 0,0
Xsg13cmos5l_decap_8_5556 VPWR VGND sg13cmos5l_decap_8
* cell instance sg13cmos5l_decap_8_5557 r0 *1 0,0
Xsg13cmos5l_decap_8_5557 VPWR VGND sg13cmos5l_decap_8
* cell instance sg13cmos5l_decap_8_5558 r0 *1 0,0
Xsg13cmos5l_decap_8_5558 VPWR VGND sg13cmos5l_decap_8
* cell instance sg13cmos5l_decap_8_5559 r0 *1 0,0
Xsg13cmos5l_decap_8_5559 VPWR VGND sg13cmos5l_decap_8
* cell instance sg13cmos5l_decap_8_5560 r0 *1 0,0
Xsg13cmos5l_decap_8_5560 VPWR VGND sg13cmos5l_decap_8
* cell instance sg13cmos5l_decap_8_5561 r0 *1 0,0
Xsg13cmos5l_decap_8_5561 VPWR VGND sg13cmos5l_decap_8
* cell instance sg13cmos5l_decap_8_5562 r0 *1 0,0
Xsg13cmos5l_decap_8_5562 VPWR VGND sg13cmos5l_decap_8
* cell instance sg13cmos5l_decap_8_5563 r0 *1 0,0
Xsg13cmos5l_decap_8_5563 VPWR VGND sg13cmos5l_decap_8
* cell instance sg13cmos5l_decap_8_5564 r0 *1 0,0
Xsg13cmos5l_decap_8_5564 VPWR VGND sg13cmos5l_decap_8
* cell instance sg13cmos5l_decap_8_5565 r0 *1 0,0
Xsg13cmos5l_decap_8_5565 VPWR VGND sg13cmos5l_decap_8
* cell instance sg13cmos5l_decap_8_5566 r0 *1 0,0
Xsg13cmos5l_decap_8_5566 VPWR VGND sg13cmos5l_decap_8
* cell instance sg13cmos5l_decap_8_5567 r0 *1 0,0
Xsg13cmos5l_decap_8_5567 VPWR VGND sg13cmos5l_decap_8
* cell instance sg13cmos5l_decap_8_5568 r0 *1 0,0
Xsg13cmos5l_decap_8_5568 VPWR VGND sg13cmos5l_decap_8
* cell instance sg13cmos5l_decap_8_5569 r0 *1 0,0
Xsg13cmos5l_decap_8_5569 VPWR VGND sg13cmos5l_decap_8
* cell instance sg13cmos5l_decap_8_5570 r0 *1 0,0
Xsg13cmos5l_decap_8_5570 VPWR VGND sg13cmos5l_decap_8
* cell instance sg13cmos5l_decap_8_5571 r0 *1 0,0
Xsg13cmos5l_decap_8_5571 VPWR VGND sg13cmos5l_decap_8
* cell instance sg13cmos5l_decap_8_5572 r0 *1 0,0
Xsg13cmos5l_decap_8_5572 VPWR VGND sg13cmos5l_decap_8
* cell instance sg13cmos5l_decap_8_5573 r0 *1 0,0
Xsg13cmos5l_decap_8_5573 VPWR VGND sg13cmos5l_decap_8
* cell instance sg13cmos5l_decap_8_5574 r0 *1 0,0
Xsg13cmos5l_decap_8_5574 VPWR VGND sg13cmos5l_decap_8
* cell instance sg13cmos5l_decap_8_5575 r0 *1 0,0
Xsg13cmos5l_decap_8_5575 VPWR VGND sg13cmos5l_decap_8
* cell instance sg13cmos5l_decap_8_5576 r0 *1 0,0
Xsg13cmos5l_decap_8_5576 VPWR VGND sg13cmos5l_decap_8
* cell instance sg13cmos5l_decap_8_5577 r0 *1 0,0
Xsg13cmos5l_decap_8_5577 VPWR VGND sg13cmos5l_decap_8
* cell instance sg13cmos5l_decap_8_5578 r0 *1 0,0
Xsg13cmos5l_decap_8_5578 VPWR VGND sg13cmos5l_decap_8
* cell instance sg13cmos5l_decap_8_5579 r0 *1 0,0
Xsg13cmos5l_decap_8_5579 VPWR VGND sg13cmos5l_decap_8
* cell instance sg13cmos5l_decap_8_5580 r0 *1 0,0
Xsg13cmos5l_decap_8_5580 VPWR VGND sg13cmos5l_decap_8
* cell instance sg13cmos5l_decap_8_5581 r0 *1 0,0
Xsg13cmos5l_decap_8_5581 VPWR VGND sg13cmos5l_decap_8
* cell instance sg13cmos5l_decap_8_5582 r0 *1 0,0
Xsg13cmos5l_decap_8_5582 VPWR VGND sg13cmos5l_decap_8
* cell instance sg13cmos5l_decap_8_5583 r0 *1 0,0
Xsg13cmos5l_decap_8_5583 VPWR VGND sg13cmos5l_decap_8
* cell instance sg13cmos5l_decap_8_5584 r0 *1 0,0
Xsg13cmos5l_decap_8_5584 VPWR VGND sg13cmos5l_decap_8
* cell instance sg13cmos5l_decap_8_5585 r0 *1 0,0
Xsg13cmos5l_decap_8_5585 VPWR VGND sg13cmos5l_decap_8
* cell instance sg13cmos5l_decap_8_5586 r0 *1 0,0
Xsg13cmos5l_decap_8_5586 VPWR VGND sg13cmos5l_decap_8
* cell instance sg13cmos5l_decap_8_5587 r0 *1 0,0
Xsg13cmos5l_decap_8_5587 VPWR VGND sg13cmos5l_decap_8
* cell instance sg13cmos5l_decap_8_5588 r0 *1 0,0
Xsg13cmos5l_decap_8_5588 VPWR VGND sg13cmos5l_decap_8
* cell instance sg13cmos5l_decap_8_5589 r0 *1 0,0
Xsg13cmos5l_decap_8_5589 VPWR VGND sg13cmos5l_decap_8
* cell instance sg13cmos5l_decap_8_5590 r0 *1 0,0
Xsg13cmos5l_decap_8_5590 VPWR VGND sg13cmos5l_decap_8
* cell instance sg13cmos5l_decap_8_5591 r0 *1 0,0
Xsg13cmos5l_decap_8_5591 VPWR VGND sg13cmos5l_decap_8
* cell instance sg13cmos5l_decap_8_5592 r0 *1 0,0
Xsg13cmos5l_decap_8_5592 VPWR VGND sg13cmos5l_decap_8
* cell instance sg13cmos5l_decap_8_5593 r0 *1 0,0
Xsg13cmos5l_decap_8_5593 VPWR VGND sg13cmos5l_decap_8
* cell instance sg13cmos5l_decap_8_5594 r0 *1 0,0
Xsg13cmos5l_decap_8_5594 VPWR VGND sg13cmos5l_decap_8
* cell instance sg13cmos5l_decap_8_5595 r0 *1 0,0
Xsg13cmos5l_decap_8_5595 VPWR VGND sg13cmos5l_decap_8
* cell instance sg13cmos5l_decap_8_5596 r0 *1 0,0
Xsg13cmos5l_decap_8_5596 VPWR VGND sg13cmos5l_decap_8
* cell instance sg13cmos5l_decap_8_5597 r0 *1 0,0
Xsg13cmos5l_decap_8_5597 VPWR VGND sg13cmos5l_decap_8
* cell instance sg13cmos5l_decap_8_5598 r0 *1 0,0
Xsg13cmos5l_decap_8_5598 VPWR VGND sg13cmos5l_decap_8
* cell instance sg13cmos5l_decap_8_5599 r0 *1 0,0
Xsg13cmos5l_decap_8_5599 VPWR VGND sg13cmos5l_decap_8
* cell instance sg13cmos5l_decap_8_5600 r0 *1 0,0
Xsg13cmos5l_decap_8_5600 VPWR VGND sg13cmos5l_decap_8
* cell instance sg13cmos5l_decap_8_5601 r0 *1 0,0
Xsg13cmos5l_decap_8_5601 VPWR VGND sg13cmos5l_decap_8
* cell instance sg13cmos5l_decap_8_5602 r0 *1 0,0
Xsg13cmos5l_decap_8_5602 VPWR VGND sg13cmos5l_decap_8
* cell instance sg13cmos5l_decap_8_5603 r0 *1 0,0
Xsg13cmos5l_decap_8_5603 VPWR VGND sg13cmos5l_decap_8
* cell instance sg13cmos5l_decap_8_5604 r0 *1 0,0
Xsg13cmos5l_decap_8_5604 VPWR VGND sg13cmos5l_decap_8
* cell instance sg13cmos5l_decap_8_5605 r0 *1 0,0
Xsg13cmos5l_decap_8_5605 VPWR VGND sg13cmos5l_decap_8
* cell instance sg13cmos5l_decap_8_5606 r0 *1 0,0
Xsg13cmos5l_decap_8_5606 VPWR VGND sg13cmos5l_decap_8
* cell instance sg13cmos5l_decap_8_5607 r0 *1 0,0
Xsg13cmos5l_decap_8_5607 VPWR VGND sg13cmos5l_decap_8
* cell instance sg13cmos5l_decap_8_5608 r0 *1 0,0
Xsg13cmos5l_decap_8_5608 VPWR VGND sg13cmos5l_decap_8
* cell instance sg13cmos5l_decap_8_5609 r0 *1 0,0
Xsg13cmos5l_decap_8_5609 VPWR VGND sg13cmos5l_decap_8
* cell instance sg13cmos5l_decap_8_5610 r0 *1 0,0
Xsg13cmos5l_decap_8_5610 VPWR VGND sg13cmos5l_decap_8
* cell instance sg13cmos5l_decap_8_5611 r0 *1 0,0
Xsg13cmos5l_decap_8_5611 VPWR VGND sg13cmos5l_decap_8
* cell instance sg13cmos5l_decap_8_5612 r0 *1 0,0
Xsg13cmos5l_decap_8_5612 VPWR VGND sg13cmos5l_decap_8
* cell instance sg13cmos5l_decap_8_5613 r0 *1 0,0
Xsg13cmos5l_decap_8_5613 VPWR VGND sg13cmos5l_decap_8
* cell instance sg13cmos5l_decap_8_5614 r0 *1 0,0
Xsg13cmos5l_decap_8_5614 VPWR VGND sg13cmos5l_decap_8
* cell instance sg13cmos5l_decap_8_5615 r0 *1 0,0
Xsg13cmos5l_decap_8_5615 VPWR VGND sg13cmos5l_decap_8
* cell instance sg13cmos5l_decap_8_5616 r0 *1 0,0
Xsg13cmos5l_decap_8_5616 VPWR VGND sg13cmos5l_decap_8
* cell instance sg13cmos5l_decap_8_5617 r0 *1 0,0
Xsg13cmos5l_decap_8_5617 VPWR VGND sg13cmos5l_decap_8
* cell instance sg13cmos5l_decap_8_5618 r0 *1 0,0
Xsg13cmos5l_decap_8_5618 VPWR VGND sg13cmos5l_decap_8
* cell instance sg13cmos5l_decap_8_5619 r0 *1 0,0
Xsg13cmos5l_decap_8_5619 VPWR VGND sg13cmos5l_decap_8
* cell instance sg13cmos5l_decap_8_5620 r0 *1 0,0
Xsg13cmos5l_decap_8_5620 VPWR VGND sg13cmos5l_decap_8
* cell instance sg13cmos5l_decap_8_5621 r0 *1 0,0
Xsg13cmos5l_decap_8_5621 VPWR VGND sg13cmos5l_decap_8
* cell instance sg13cmos5l_decap_8_5622 r0 *1 0,0
Xsg13cmos5l_decap_8_5622 VPWR VGND sg13cmos5l_decap_8
* cell instance sg13cmos5l_decap_8_5623 r0 *1 0,0
Xsg13cmos5l_decap_8_5623 VPWR VGND sg13cmos5l_decap_8
* cell instance sg13cmos5l_decap_8_5624 r0 *1 0,0
Xsg13cmos5l_decap_8_5624 VPWR VGND sg13cmos5l_decap_8
* cell instance sg13cmos5l_decap_8_5625 r0 *1 0,0
Xsg13cmos5l_decap_8_5625 VPWR VGND sg13cmos5l_decap_8
* cell instance sg13cmos5l_decap_8_5626 r0 *1 0,0
Xsg13cmos5l_decap_8_5626 VPWR VGND sg13cmos5l_decap_8
* cell instance sg13cmos5l_decap_8_5627 r0 *1 0,0
Xsg13cmos5l_decap_8_5627 VPWR VGND sg13cmos5l_decap_8
* cell instance sg13cmos5l_decap_8_5628 r0 *1 0,0
Xsg13cmos5l_decap_8_5628 VPWR VGND sg13cmos5l_decap_8
* cell instance sg13cmos5l_decap_8_5629 r0 *1 0,0
Xsg13cmos5l_decap_8_5629 VPWR VGND sg13cmos5l_decap_8
* cell instance sg13cmos5l_decap_8_5630 r0 *1 0,0
Xsg13cmos5l_decap_8_5630 VPWR VGND sg13cmos5l_decap_8
* cell instance sg13cmos5l_decap_8_5631 r0 *1 0,0
Xsg13cmos5l_decap_8_5631 VPWR VGND sg13cmos5l_decap_8
* cell instance sg13cmos5l_decap_8_5632 r0 *1 0,0
Xsg13cmos5l_decap_8_5632 VPWR VGND sg13cmos5l_decap_8
* cell instance sg13cmos5l_decap_8_5633 r0 *1 0,0
Xsg13cmos5l_decap_8_5633 VPWR VGND sg13cmos5l_decap_8
* cell instance sg13cmos5l_decap_8_5634 r0 *1 0,0
Xsg13cmos5l_decap_8_5634 VPWR VGND sg13cmos5l_decap_8
* cell instance sg13cmos5l_decap_8_5635 r0 *1 0,0
Xsg13cmos5l_decap_8_5635 VPWR VGND sg13cmos5l_decap_8
* cell instance sg13cmos5l_decap_8_5636 r0 *1 0,0
Xsg13cmos5l_decap_8_5636 VPWR VGND sg13cmos5l_decap_8
* cell instance sg13cmos5l_decap_8_5637 r0 *1 0,0
Xsg13cmos5l_decap_8_5637 VPWR VGND sg13cmos5l_decap_8
* cell instance sg13cmos5l_decap_8_5638 r0 *1 0,0
Xsg13cmos5l_decap_8_5638 VPWR VGND sg13cmos5l_decap_8
* cell instance sg13cmos5l_decap_8_5639 r0 *1 0,0
Xsg13cmos5l_decap_8_5639 VPWR VGND sg13cmos5l_decap_8
* cell instance sg13cmos5l_decap_8_5640 r0 *1 0,0
Xsg13cmos5l_decap_8_5640 VPWR VGND sg13cmos5l_decap_8
* cell instance sg13cmos5l_decap_8_5641 r0 *1 0,0
Xsg13cmos5l_decap_8_5641 VPWR VGND sg13cmos5l_decap_8
* cell instance sg13cmos5l_decap_8_5642 r0 *1 0,0
Xsg13cmos5l_decap_8_5642 VPWR VGND sg13cmos5l_decap_8
* cell instance sg13cmos5l_decap_8_5643 r0 *1 0,0
Xsg13cmos5l_decap_8_5643 VPWR VGND sg13cmos5l_decap_8
* cell instance sg13cmos5l_decap_8_5644 r0 *1 0,0
Xsg13cmos5l_decap_8_5644 VPWR VGND sg13cmos5l_decap_8
* cell instance sg13cmos5l_decap_8_5645 r0 *1 0,0
Xsg13cmos5l_decap_8_5645 VPWR VGND sg13cmos5l_decap_8
* cell instance sg13cmos5l_decap_8_5646 r0 *1 0,0
Xsg13cmos5l_decap_8_5646 VPWR VGND sg13cmos5l_decap_8
* cell instance sg13cmos5l_decap_8_5647 r0 *1 0,0
Xsg13cmos5l_decap_8_5647 VPWR VGND sg13cmos5l_decap_8
* cell instance sg13cmos5l_decap_8_5648 r0 *1 0,0
Xsg13cmos5l_decap_8_5648 VPWR VGND sg13cmos5l_decap_8
* cell instance sg13cmos5l_decap_8_5649 r0 *1 0,0
Xsg13cmos5l_decap_8_5649 VPWR VGND sg13cmos5l_decap_8
* cell instance sg13cmos5l_decap_8_5650 r0 *1 0,0
Xsg13cmos5l_decap_8_5650 VPWR VGND sg13cmos5l_decap_8
* cell instance sg13cmos5l_decap_8_5651 r0 *1 0,0
Xsg13cmos5l_decap_8_5651 VPWR VGND sg13cmos5l_decap_8
* cell instance sg13cmos5l_decap_8_5652 r0 *1 0,0
Xsg13cmos5l_decap_8_5652 VPWR VGND sg13cmos5l_decap_8
* cell instance sg13cmos5l_decap_8_5653 r0 *1 0,0
Xsg13cmos5l_decap_8_5653 VPWR VGND sg13cmos5l_decap_8
* cell instance sg13cmos5l_decap_8_5654 r0 *1 0,0
Xsg13cmos5l_decap_8_5654 VPWR VGND sg13cmos5l_decap_8
* cell instance sg13cmos5l_decap_8_5655 r0 *1 0,0
Xsg13cmos5l_decap_8_5655 VPWR VGND sg13cmos5l_decap_8
* cell instance sg13cmos5l_decap_8_5656 r0 *1 0,0
Xsg13cmos5l_decap_8_5656 VPWR VGND sg13cmos5l_decap_8
* cell instance sg13cmos5l_decap_8_5657 r0 *1 0,0
Xsg13cmos5l_decap_8_5657 VPWR VGND sg13cmos5l_decap_8
* cell instance sg13cmos5l_decap_8_5658 r0 *1 0,0
Xsg13cmos5l_decap_8_5658 VPWR VGND sg13cmos5l_decap_8
* cell instance sg13cmos5l_decap_8_5659 r0 *1 0,0
Xsg13cmos5l_decap_8_5659 VPWR VGND sg13cmos5l_decap_8
* cell instance sg13cmos5l_decap_8_5660 r0 *1 0,0
Xsg13cmos5l_decap_8_5660 VPWR VGND sg13cmos5l_decap_8
* cell instance sg13cmos5l_decap_8_5661 r0 *1 0,0
Xsg13cmos5l_decap_8_5661 VPWR VGND sg13cmos5l_decap_8
* cell instance sg13cmos5l_decap_8_5662 r0 *1 0,0
Xsg13cmos5l_decap_8_5662 VPWR VGND sg13cmos5l_decap_8
* cell instance sg13cmos5l_decap_8_5663 r0 *1 0,0
Xsg13cmos5l_decap_8_5663 VPWR VGND sg13cmos5l_decap_8
* cell instance sg13cmos5l_decap_8_5664 r0 *1 0,0
Xsg13cmos5l_decap_8_5664 VPWR VGND sg13cmos5l_decap_8
* cell instance sg13cmos5l_decap_8_5665 r0 *1 0,0
Xsg13cmos5l_decap_8_5665 VPWR VGND sg13cmos5l_decap_8
* cell instance sg13cmos5l_decap_8_5666 r0 *1 0,0
Xsg13cmos5l_decap_8_5666 VPWR VGND sg13cmos5l_decap_8
* cell instance sg13cmos5l_decap_8_5667 r0 *1 0,0
Xsg13cmos5l_decap_8_5667 VPWR VGND sg13cmos5l_decap_8
* cell instance sg13cmos5l_decap_8_5668 r0 *1 0,0
Xsg13cmos5l_decap_8_5668 VPWR VGND sg13cmos5l_decap_8
* cell instance sg13cmos5l_decap_8_5669 r0 *1 0,0
Xsg13cmos5l_decap_8_5669 VPWR VGND sg13cmos5l_decap_8
* cell instance sg13cmos5l_decap_8_5670 r0 *1 0,0
Xsg13cmos5l_decap_8_5670 VPWR VGND sg13cmos5l_decap_8
* cell instance sg13cmos5l_decap_8_5671 r0 *1 0,0
Xsg13cmos5l_decap_8_5671 VPWR VGND sg13cmos5l_decap_8
* cell instance sg13cmos5l_decap_8_5672 r0 *1 0,0
Xsg13cmos5l_decap_8_5672 VPWR VGND sg13cmos5l_decap_8
* cell instance sg13cmos5l_decap_8_5673 r0 *1 0,0
Xsg13cmos5l_decap_8_5673 VPWR VGND sg13cmos5l_decap_8
* cell instance sg13cmos5l_decap_8_5674 r0 *1 0,0
Xsg13cmos5l_decap_8_5674 VPWR VGND sg13cmos5l_decap_8
* cell instance sg13cmos5l_decap_8_5675 r0 *1 0,0
Xsg13cmos5l_decap_8_5675 VPWR VGND sg13cmos5l_decap_8
* cell instance sg13cmos5l_decap_8_5676 r0 *1 0,0
Xsg13cmos5l_decap_8_5676 VPWR VGND sg13cmos5l_decap_8
* cell instance sg13cmos5l_decap_8_5677 r0 *1 0,0
Xsg13cmos5l_decap_8_5677 VPWR VGND sg13cmos5l_decap_8
* cell instance sg13cmos5l_decap_8_5678 r0 *1 0,0
Xsg13cmos5l_decap_8_5678 VPWR VGND sg13cmos5l_decap_8
* cell instance sg13cmos5l_decap_8_5679 r0 *1 0,0
Xsg13cmos5l_decap_8_5679 VPWR VGND sg13cmos5l_decap_8
* cell instance sg13cmos5l_decap_8_5680 r0 *1 0,0
Xsg13cmos5l_decap_8_5680 VPWR VGND sg13cmos5l_decap_8
* cell instance sg13cmos5l_decap_8_5681 r0 *1 0,0
Xsg13cmos5l_decap_8_5681 VPWR VGND sg13cmos5l_decap_8
* cell instance sg13cmos5l_decap_8_5682 r0 *1 0,0
Xsg13cmos5l_decap_8_5682 VPWR VGND sg13cmos5l_decap_8
* cell instance sg13cmos5l_decap_8_5683 r0 *1 0,0
Xsg13cmos5l_decap_8_5683 VPWR VGND sg13cmos5l_decap_8
* cell instance sg13cmos5l_decap_8_5684 r0 *1 0,0
Xsg13cmos5l_decap_8_5684 VPWR VGND sg13cmos5l_decap_8
* cell instance sg13cmos5l_decap_8_5685 r0 *1 0,0
Xsg13cmos5l_decap_8_5685 VPWR VGND sg13cmos5l_decap_8
* cell instance sg13cmos5l_decap_8_5686 r0 *1 0,0
Xsg13cmos5l_decap_8_5686 VPWR VGND sg13cmos5l_decap_8
* cell instance sg13cmos5l_decap_8_5687 r0 *1 0,0
Xsg13cmos5l_decap_8_5687 VPWR VGND sg13cmos5l_decap_8
* cell instance sg13cmos5l_decap_8_5688 r0 *1 0,0
Xsg13cmos5l_decap_8_5688 VPWR VGND sg13cmos5l_decap_8
* cell instance sg13cmos5l_decap_8_5689 r0 *1 0,0
Xsg13cmos5l_decap_8_5689 VPWR VGND sg13cmos5l_decap_8
* cell instance sg13cmos5l_decap_8_5690 r0 *1 0,0
Xsg13cmos5l_decap_8_5690 VPWR VGND sg13cmos5l_decap_8
* cell instance sg13cmos5l_decap_8_5691 r0 *1 0,0
Xsg13cmos5l_decap_8_5691 VPWR VGND sg13cmos5l_decap_8
* cell instance sg13cmos5l_decap_8_5692 r0 *1 0,0
Xsg13cmos5l_decap_8_5692 VPWR VGND sg13cmos5l_decap_8
* cell instance sg13cmos5l_decap_8_5693 r0 *1 0,0
Xsg13cmos5l_decap_8_5693 VPWR VGND sg13cmos5l_decap_8
* cell instance sg13cmos5l_decap_8_5694 r0 *1 0,0
Xsg13cmos5l_decap_8_5694 VPWR VGND sg13cmos5l_decap_8
* cell instance sg13cmos5l_decap_8_5695 r0 *1 0,0
Xsg13cmos5l_decap_8_5695 VPWR VGND sg13cmos5l_decap_8
* cell instance sg13cmos5l_decap_8_5696 r0 *1 0,0
Xsg13cmos5l_decap_8_5696 VPWR VGND sg13cmos5l_decap_8
* cell instance sg13cmos5l_decap_8_5697 r0 *1 0,0
Xsg13cmos5l_decap_8_5697 VPWR VGND sg13cmos5l_decap_8
* cell instance sg13cmos5l_decap_8_5698 r0 *1 0,0
Xsg13cmos5l_decap_8_5698 VPWR VGND sg13cmos5l_decap_8
* cell instance sg13cmos5l_decap_8_5699 r0 *1 0,0
Xsg13cmos5l_decap_8_5699 VPWR VGND sg13cmos5l_decap_8
* cell instance sg13cmos5l_decap_8_5700 r0 *1 0,0
Xsg13cmos5l_decap_8_5700 VPWR VGND sg13cmos5l_decap_8
* cell instance sg13cmos5l_decap_8_5701 r0 *1 0,0
Xsg13cmos5l_decap_8_5701 VPWR VGND sg13cmos5l_decap_8
* cell instance sg13cmos5l_decap_8_5702 r0 *1 0,0
Xsg13cmos5l_decap_8_5702 VPWR VGND sg13cmos5l_decap_8
* cell instance sg13cmos5l_decap_8_5703 r0 *1 0,0
Xsg13cmos5l_decap_8_5703 VPWR VGND sg13cmos5l_decap_8
* cell instance sg13cmos5l_decap_8_5704 r0 *1 0,0
Xsg13cmos5l_decap_8_5704 VPWR VGND sg13cmos5l_decap_8
* cell instance sg13cmos5l_decap_8_5705 r0 *1 0,0
Xsg13cmos5l_decap_8_5705 VPWR VGND sg13cmos5l_decap_8
* cell instance sg13cmos5l_decap_8_5706 r0 *1 0,0
Xsg13cmos5l_decap_8_5706 VPWR VGND sg13cmos5l_decap_8
* cell instance sg13cmos5l_decap_8_5707 r0 *1 0,0
Xsg13cmos5l_decap_8_5707 VPWR VGND sg13cmos5l_decap_8
* cell instance sg13cmos5l_decap_8_5708 r0 *1 0,0
Xsg13cmos5l_decap_8_5708 VPWR VGND sg13cmos5l_decap_8
* cell instance sg13cmos5l_decap_8_5709 r0 *1 0,0
Xsg13cmos5l_decap_8_5709 VPWR VGND sg13cmos5l_decap_8
* cell instance sg13cmos5l_decap_8_5710 r0 *1 0,0
Xsg13cmos5l_decap_8_5710 VPWR VGND sg13cmos5l_decap_8
* cell instance sg13cmos5l_decap_8_5711 r0 *1 0,0
Xsg13cmos5l_decap_8_5711 VPWR VGND sg13cmos5l_decap_8
* cell instance sg13cmos5l_decap_8_5712 r0 *1 0,0
Xsg13cmos5l_decap_8_5712 VPWR VGND sg13cmos5l_decap_8
* cell instance sg13cmos5l_decap_8_5713 r0 *1 0,0
Xsg13cmos5l_decap_8_5713 VPWR VGND sg13cmos5l_decap_8
* cell instance sg13cmos5l_decap_8_5714 r0 *1 0,0
Xsg13cmos5l_decap_8_5714 VPWR VGND sg13cmos5l_decap_8
* cell instance sg13cmos5l_decap_8_5715 r0 *1 0,0
Xsg13cmos5l_decap_8_5715 VPWR VGND sg13cmos5l_decap_8
* cell instance sg13cmos5l_decap_8_5716 r0 *1 0,0
Xsg13cmos5l_decap_8_5716 VPWR VGND sg13cmos5l_decap_8
* cell instance sg13cmos5l_decap_8_5717 r0 *1 0,0
Xsg13cmos5l_decap_8_5717 VPWR VGND sg13cmos5l_decap_8
* cell instance sg13cmos5l_decap_8_5718 r0 *1 0,0
Xsg13cmos5l_decap_8_5718 VPWR VGND sg13cmos5l_decap_8
* cell instance sg13cmos5l_decap_8_5719 r0 *1 0,0
Xsg13cmos5l_decap_8_5719 VPWR VGND sg13cmos5l_decap_8
* cell instance sg13cmos5l_decap_8_5720 r0 *1 0,0
Xsg13cmos5l_decap_8_5720 VPWR VGND sg13cmos5l_decap_8
* cell instance sg13cmos5l_decap_8_5721 r0 *1 0,0
Xsg13cmos5l_decap_8_5721 VPWR VGND sg13cmos5l_decap_8
* cell instance sg13cmos5l_decap_8_5722 r0 *1 0,0
Xsg13cmos5l_decap_8_5722 VPWR VGND sg13cmos5l_decap_8
* cell instance sg13cmos5l_decap_8_5723 r0 *1 0,0
Xsg13cmos5l_decap_8_5723 VPWR VGND sg13cmos5l_decap_8
* cell instance sg13cmos5l_decap_8_5724 r0 *1 0,0
Xsg13cmos5l_decap_8_5724 VPWR VGND sg13cmos5l_decap_8
* cell instance sg13cmos5l_decap_8_5725 r0 *1 0,0
Xsg13cmos5l_decap_8_5725 VPWR VGND sg13cmos5l_decap_8
* cell instance sg13cmos5l_decap_8_5726 r0 *1 0,0
Xsg13cmos5l_decap_8_5726 VPWR VGND sg13cmos5l_decap_8
* cell instance sg13cmos5l_decap_8_5727 r0 *1 0,0
Xsg13cmos5l_decap_8_5727 VPWR VGND sg13cmos5l_decap_8
* cell instance sg13cmos5l_decap_8_5728 r0 *1 0,0
Xsg13cmos5l_decap_8_5728 VPWR VGND sg13cmos5l_decap_8
* cell instance sg13cmos5l_decap_8_5729 r0 *1 0,0
Xsg13cmos5l_decap_8_5729 VPWR VGND sg13cmos5l_decap_8
* cell instance sg13cmos5l_decap_8_5730 r0 *1 0,0
Xsg13cmos5l_decap_8_5730 VPWR VGND sg13cmos5l_decap_8
* cell instance sg13cmos5l_decap_8_5731 r0 *1 0,0
Xsg13cmos5l_decap_8_5731 VPWR VGND sg13cmos5l_decap_8
* cell instance sg13cmos5l_decap_8_5732 r0 *1 0,0
Xsg13cmos5l_decap_8_5732 VPWR VGND sg13cmos5l_decap_8
* cell instance sg13cmos5l_decap_8_5733 r0 *1 0,0
Xsg13cmos5l_decap_8_5733 VPWR VGND sg13cmos5l_decap_8
* cell instance sg13cmos5l_decap_8_5734 r0 *1 0,0
Xsg13cmos5l_decap_8_5734 VPWR VGND sg13cmos5l_decap_8
* cell instance sg13cmos5l_decap_8_5735 r0 *1 0,0
Xsg13cmos5l_decap_8_5735 VPWR VGND sg13cmos5l_decap_8
* cell instance sg13cmos5l_decap_8_5736 r0 *1 0,0
Xsg13cmos5l_decap_8_5736 VPWR VGND sg13cmos5l_decap_8
* cell instance sg13cmos5l_decap_8_5737 r0 *1 0,0
Xsg13cmos5l_decap_8_5737 VPWR VGND sg13cmos5l_decap_8
* cell instance sg13cmos5l_decap_8_5738 r0 *1 0,0
Xsg13cmos5l_decap_8_5738 VPWR VGND sg13cmos5l_decap_8
* cell instance sg13cmos5l_decap_8_5739 r0 *1 0,0
Xsg13cmos5l_decap_8_5739 VPWR VGND sg13cmos5l_decap_8
* cell instance sg13cmos5l_decap_8_5740 r0 *1 0,0
Xsg13cmos5l_decap_8_5740 VPWR VGND sg13cmos5l_decap_8
* cell instance sg13cmos5l_decap_8_5741 r0 *1 0,0
Xsg13cmos5l_decap_8_5741 VPWR VGND sg13cmos5l_decap_8
* cell instance sg13cmos5l_decap_8_5742 r0 *1 0,0
Xsg13cmos5l_decap_8_5742 VPWR VGND sg13cmos5l_decap_8
* cell instance sg13cmos5l_decap_8_5743 r0 *1 0,0
Xsg13cmos5l_decap_8_5743 VPWR VGND sg13cmos5l_decap_8
* cell instance sg13cmos5l_decap_8_5744 r0 *1 0,0
Xsg13cmos5l_decap_8_5744 VPWR VGND sg13cmos5l_decap_8
* cell instance sg13cmos5l_decap_8_5745 r0 *1 0,0
Xsg13cmos5l_decap_8_5745 VPWR VGND sg13cmos5l_decap_8
* cell instance sg13cmos5l_dfrbpq_1_0 r0 *1 0,0
Xsg13cmos5l_dfrbpq_1_0 \$6581 \$11239 \$10208 \$11237 VPWR VGND
+ sg13cmos5l_dfrbpq_1
* cell instance sg13cmos5l_dfrbpq_1_1 r0 *1 0,0
Xsg13cmos5l_dfrbpq_1_1 \$1861 \$3487 \$3490 \$2073 VPWR VGND sg13cmos5l_dfrbpq_1
* cell instance sg13cmos5l_dfrbpq_1_2 r0 *1 0,0
Xsg13cmos5l_dfrbpq_1_2 \$2210 \$4320 \$4147 \$4233 VPWR VGND sg13cmos5l_dfrbpq_1
* cell instance sg13cmos5l_dfrbpq_1_3 r0 *1 0,0
Xsg13cmos5l_dfrbpq_1_3 \$4617 \$5717 \$5356 \$4233 VPWR VGND sg13cmos5l_dfrbpq_1
* cell instance sg13cmos5l_dfrbpq_1_4 r0 *1 0,0
Xsg13cmos5l_dfrbpq_1_4 \$7270 \$6827 \$5357 \$4233 VPWR VGND sg13cmos5l_dfrbpq_1
* cell instance sg13cmos5l_dfrbpq_1_5 r0 *1 0,0
Xsg13cmos5l_dfrbpq_1_5 \$7270 \$7702 \$7622 \$4233 VPWR VGND sg13cmos5l_dfrbpq_1
* cell instance sg13cmos5l_dfrbpq_1_6 r0 *1 0,0
Xsg13cmos5l_dfrbpq_1_6 \$1317 \$2072 \$1924 \$2073 VPWR VGND sg13cmos5l_dfrbpq_1
* cell instance sg13cmos5l_dfrbpq_1_7 r0 *1 0,0
Xsg13cmos5l_dfrbpq_1_7 \$1317 \$2450 \$2422 \$2073 VPWR VGND sg13cmos5l_dfrbpq_1
* cell instance sg13cmos5l_dfrbpq_1_8 r0 *1 0,0
Xsg13cmos5l_dfrbpq_1_8 \$1861 \$3059 \$3065 \$2073 VPWR VGND sg13cmos5l_dfrbpq_1
* cell instance sg13cmos5l_dfrbpq_1_9 r0 *1 0,0
Xsg13cmos5l_dfrbpq_1_9 \$2210 \$3741 \$3821 \$1306 VPWR VGND sg13cmos5l_dfrbpq_1
* cell instance sg13cmos5l_dfrbpq_1_10 r0 *1 0,0
Xsg13cmos5l_dfrbpq_1_10 \$2210 \$4067 \$3824 \$2073 VPWR VGND
+ sg13cmos5l_dfrbpq_1
* cell instance sg13cmos5l_dfrbpq_1_11 r0 *1 0,0
Xsg13cmos5l_dfrbpq_1_11 \$2210 \$4759 \$4087 \$4233 VPWR VGND
+ sg13cmos5l_dfrbpq_1
* cell instance sg13cmos5l_dfrbpq_1_12 r0 *1 0,0
Xsg13cmos5l_dfrbpq_1_12 \$1861 \$1874 \$1858 \$77 VPWR VGND sg13cmos5l_dfrbpq_1
* cell instance sg13cmos5l_dfrbpq_1_13 r0 *1 0,0
Xsg13cmos5l_dfrbpq_1_13 \$7861 \$10480 \$10209 \$11237 VPWR VGND
+ sg13cmos5l_dfrbpq_1
* cell instance sg13cmos5l_dfrbpq_1_14 r0 *1 0,0
Xsg13cmos5l_dfrbpq_1_14 \$4617 \$6566 \$5358 \$4233 VPWR VGND
+ sg13cmos5l_dfrbpq_1
* cell instance sg13cmos5l_dfrbpq_1_15 r0 *1 0,0
Xsg13cmos5l_dfrbpq_1_15 \$7270 \$8279 \$7704 \$4233 VPWR VGND
+ sg13cmos5l_dfrbpq_1
* cell instance sg13cmos5l_dfrbpq_1_16 r0 *1 0,0
Xsg13cmos5l_dfrbpq_1_16 \$1861 \$2875 \$3057 \$2073 VPWR VGND
+ sg13cmos5l_dfrbpq_1
* cell instance sg13cmos5l_dfrbpq_1_17 r0 *1 0,0
Xsg13cmos5l_dfrbpq_1_17 \$6581 \$10632 \$10210 \$11237 VPWR VGND
+ sg13cmos5l_dfrbpq_1
* cell instance sg13cmos5l_dfrbpq_1_18 r0 *1 0,0
Xsg13cmos5l_dfrbpq_1_18 \$1861 \$1859 \$1813 \$36 VPWR VGND sg13cmos5l_dfrbpq_1
* cell instance sg13cmos5l_dfrbpq_1_19 r0 *1 0,0
Xsg13cmos5l_dfrbpq_1_19 \$7270 \$8712 \$8572 \$4233 VPWR VGND
+ sg13cmos5l_dfrbpq_1
* cell instance sg13cmos5l_dfrbpq_1_20 r0 *1 0,0
Xsg13cmos5l_dfrbpq_1_20 \$1861 \$1793 \$1814 \$36 VPWR VGND sg13cmos5l_dfrbpq_1
* cell instance sg13cmos5l_dfrbpq_1_21 r0 *1 0,0
Xsg13cmos5l_dfrbpq_1_21 \$1317 \$2709 \$2719 \$2073 VPWR VGND
+ sg13cmos5l_dfrbpq_1
* cell instance sg13cmos5l_dfrbpq_1_22 r0 *1 0,0
Xsg13cmos5l_dfrbpq_1_22 \$7270 \$9285 \$9020 \$9320 VPWR VGND
+ sg13cmos5l_dfrbpq_1
* cell instance sg13cmos5l_dfrbpq_1_23 r0 *1 0,0
Xsg13cmos5l_dfrbpq_1_23 \$7270 \$10110 \$11074 \$11237 VPWR VGND
+ sg13cmos5l_dfrbpq_1
* cell instance sg13cmos5l_dfrbpq_1_24 r0 *1 0,0
Xsg13cmos5l_dfrbpq_1_24 \$6581 \$13721 uio_out[2] \$12712 VPWR VGND
+ sg13cmos5l_dfrbpq_1
* cell instance sg13cmos5l_dfrbpq_1_25 r0 *1 0,0
Xsg13cmos5l_dfrbpq_1_25 \$551 \$1074 \$846 \$77 VPWR VGND sg13cmos5l_dfrbpq_1
* cell instance sg13cmos5l_dfrbpq_1_26 r0 *1 0,0
Xsg13cmos5l_dfrbpq_1_26 \$6581 \$13774 uio_out[3] \$12712 VPWR VGND
+ sg13cmos5l_dfrbpq_1
* cell instance sg13cmos5l_dfrbpq_1_27 r0 *1 0,0
Xsg13cmos5l_dfrbpq_1_27 \$551 \$379 \$556 \$77 VPWR VGND sg13cmos5l_dfrbpq_1
* cell instance sg13cmos5l_dfrbpq_1_28 r0 *1 0,0
Xsg13cmos5l_dfrbpq_1_28 \$92 \$73 \$86 \$77 VPWR VGND sg13cmos5l_dfrbpq_1
* cell instance sg13cmos5l_dfrbpq_1_29 r0 *1 0,0
Xsg13cmos5l_dfrbpq_1_29 \$1317 \$1890 \$1900 \$77 VPWR VGND sg13cmos5l_dfrbpq_1
* cell instance sg13cmos5l_dfrbpq_1_30 r0 *1 0,0
Xsg13cmos5l_dfrbpq_1_30 \$92 \$207 \$219 \$77 VPWR VGND sg13cmos5l_dfrbpq_1
* cell instance sg13cmos5l_dfrbpq_1_31 r0 *1 0,0
Xsg13cmos5l_dfrbpq_1_31 \$1317 \$1309 \$856 \$77 VPWR VGND sg13cmos5l_dfrbpq_1
* cell instance sg13cmos5l_dfrbpq_1_32 r0 *1 0,0
Xsg13cmos5l_dfrbpq_1_32 \$2210 \$2209 \$2081 \$2073 VPWR VGND
+ sg13cmos5l_dfrbpq_1
* cell instance sg13cmos5l_dfrbpq_1_33 r0 *1 0,0
Xsg13cmos5l_dfrbpq_1_33 \$7861 \$12494 uio_out[5] \$12712 VPWR VGND
+ sg13cmos5l_dfrbpq_1
* cell instance sg13cmos5l_dfrbpq_1_34 r0 *1 0,0
Xsg13cmos5l_dfrbpq_1_34 \$6581 \$9758 \$9619 \$11237 VPWR VGND
+ sg13cmos5l_dfrbpq_1
* cell instance sg13cmos5l_dfrbpq_1_35 r0 *1 0,0
Xsg13cmos5l_dfrbpq_1_35 \$7861 \$12076 uio_out[6] \$12712 VPWR VGND
+ sg13cmos5l_dfrbpq_1
* cell instance sg13cmos5l_dfrbpq_1_36 r0 *1 0,0
Xsg13cmos5l_dfrbpq_1_36 \$7861 \$13586 uio_out[4] \$12712 VPWR VGND
+ sg13cmos5l_dfrbpq_1
* cell instance sg13cmos5l_dfrbpq_1_37 r0 *1 0,0
Xsg13cmos5l_dfrbpq_1_37 \$6581 \$11081 \$11079 \$11237 VPWR VGND
+ sg13cmos5l_dfrbpq_1
* cell instance sg13cmos5l_dfrbpq_1_38 r0 *1 0,0
Xsg13cmos5l_dfrbpq_1_38 \$7270 \$10211 \$10794 \$11237 VPWR VGND
+ sg13cmos5l_dfrbpq_1
* cell instance sg13cmos5l_dfrbpq_1_39 r0 *1 0,0
Xsg13cmos5l_dfrbpq_1_39 \$1317 \$1822 \$1833 \$36 VPWR VGND sg13cmos5l_dfrbpq_1
* cell instance sg13cmos5l_dfrbpq_1_40 r0 *1 0,0
Xsg13cmos5l_dfrbpq_1_40 \$1317 \$1862 \$1938 \$77 VPWR VGND sg13cmos5l_dfrbpq_1
* cell instance sg13cmos5l_dfrbpq_1_41 r0 *1 0,0
Xsg13cmos5l_dfrbpq_1_41 \$7861 \$10115 \$9620 \$11237 VPWR VGND
+ sg13cmos5l_dfrbpq_1
* cell instance sg13cmos5l_dfrbpq_1_42 r0 *1 0,0
Xsg13cmos5l_dfrbpq_1_42 \$7861 \$13786 uio_out[7] \$12712 VPWR VGND
+ sg13cmos5l_dfrbpq_1
* cell instance sg13cmos5l_dfrbpq_1_43 r0 *1 0,0
Xsg13cmos5l_dfrbpq_1_43 \$92 \$223 \$232 \$36 VPWR VGND sg13cmos5l_dfrbpq_1
* cell instance sg13cmos5l_dfrbpq_1_44 r0 *1 0,0
Xsg13cmos5l_dfrbpq_1_44 \$551 \$1094 \$1334 \$36 VPWR VGND sg13cmos5l_dfrbpq_1
* cell instance sg13cmos5l_dfrbpq_1_45 r0 *1 0,0
Xsg13cmos5l_dfrbpq_1_45 \$7119 \$13598 uo_out[4] \$11238 VPWR VGND
+ sg13cmos5l_dfrbpq_1
* cell instance sg13cmos5l_dfrbpq_1_46 r0 *1 0,0
Xsg13cmos5l_dfrbpq_1_46 \$7119 \$13700 uio_out[0] \$12148 VPWR VGND
+ sg13cmos5l_dfrbpq_1
* cell instance sg13cmos5l_dfrbpq_1_47 r0 *1 0,0
Xsg13cmos5l_dfrbpq_1_47 \$7119 \$13802 uo_out[3] \$11238 VPWR VGND
+ sg13cmos5l_dfrbpq_1
* cell instance sg13cmos5l_dfrbpq_1_48 r0 *1 0,0
Xsg13cmos5l_dfrbpq_1_48 \$92 \$33 \$45 \$36 VPWR VGND sg13cmos5l_dfrbpq_1
* cell instance sg13cmos5l_dfrbpq_1_49 r0 *1 0,0
Xsg13cmos5l_dfrbpq_1_49 \$4617 \$12501 uo_out[5] \$11238 VPWR VGND
+ sg13cmos5l_dfrbpq_1
* cell instance sg13cmos5l_dfrbpq_1_50 r0 *1 0,0
Xsg13cmos5l_dfrbpq_1_50 \$7119 \$13753 uo_out[0] \$11238 VPWR VGND
+ sg13cmos5l_dfrbpq_1
* cell instance sg13cmos5l_dfrbpq_1_51 r0 *1 0,0
Xsg13cmos5l_dfrbpq_1_51 \$551 \$1097 \$591 \$1306 VPWR VGND sg13cmos5l_dfrbpq_1
* cell instance sg13cmos5l_dfrbpq_1_52 r0 *1 0,0
Xsg13cmos5l_dfrbpq_1_52 \$92 \$95 \$236 \$36 VPWR VGND sg13cmos5l_dfrbpq_1
* cell instance sg13cmos5l_dfrbpq_1_53 r0 *1 0,0
Xsg13cmos5l_dfrbpq_1_53 \$4617 \$11248 uio_out[1] \$11238 VPWR VGND
+ sg13cmos5l_dfrbpq_1
* cell instance sg13cmos5l_dfrbpq_1_54 r0 *1 0,0
Xsg13cmos5l_dfrbpq_1_54 \$4617 \$11576 uo_out[1] \$11238 VPWR VGND
+ sg13cmos5l_dfrbpq_1
* cell instance sg13cmos5l_dfrbpq_1_55 r0 *1 0,0
Xsg13cmos5l_dfrbpq_1_55 \$4617 \$12260 uo_out[6] \$11238 VPWR VGND
+ sg13cmos5l_dfrbpq_1
* cell instance sg13cmos5l_dfrbpq_1_56 r0 *1 0,0
Xsg13cmos5l_dfrbpq_1_56 \$2210 \$3746 \$2085 \$1306 VPWR VGND
+ sg13cmos5l_dfrbpq_1
* cell instance sg13cmos5l_dfrbpq_1_57 r0 *1 0,0
Xsg13cmos5l_dfrbpq_1_57 \$7119 \$13612 uo_out[7] \$11238 VPWR VGND
+ sg13cmos5l_dfrbpq_1
* cell instance sg13cmos5l_dfrbpq_1_58 r0 *1 0,0
Xsg13cmos5l_dfrbpq_1_58 \$7119 \$13869 uo_out[2] \$9320 VPWR VGND
+ sg13cmos5l_dfrbpq_1
* cell instance sg13cmos5l_dfrbpq_1_59 r0 *1 0,0
Xsg13cmos5l_dfrbpq_1_59 \$551 \$47 \$59 \$50 VPWR VGND sg13cmos5l_dfrbpq_1
* cell instance sg13cmos5l_dfrbpq_1_60 r0 *1 0,0
Xsg13cmos5l_dfrbpq_1_60 \$92 \$107 \$119 \$50 VPWR VGND sg13cmos5l_dfrbpq_1
* cell instance sg13cmos5l_dfrbpq_1_61 r0 *1 0,0
Xsg13cmos5l_dfrbpq_1_61 \$551 \$1116 \$1355 \$50 VPWR VGND sg13cmos5l_dfrbpq_1
* cell instance sg13cmos5l_dfrbpq_1_62 r0 *1 0,0
Xsg13cmos5l_dfrbpq_1_62 \$759 \$876 \$537 \$50 VPWR VGND sg13cmos5l_dfrbpq_1
* cell instance sg13cmos5l_dfrbpq_1_63 r0 *1 0,0
Xsg13cmos5l_dfrbpq_1_63 \$92 \$120 \$266 \$50 VPWR VGND sg13cmos5l_dfrbpq_1
* cell instance sg13cmos5l_dfrbpq_1_64 r0 *1 0,0
Xsg13cmos5l_dfrbpq_1_64 \$759 \$1360 \$1372 \$50 VPWR VGND sg13cmos5l_dfrbpq_1
* cell instance sg13cmos5l_dfrbpq_1_65 r0 *1 0,0
Xsg13cmos5l_dfrbpq_1_65 \$277 \$269 \$268 \$272 VPWR VGND sg13cmos5l_dfrbpq_1
* cell instance sg13cmos5l_dfrbpq_1_66 r0 *1 0,0
Xsg13cmos5l_dfrbpq_1_66 \$759 \$888 \$1141 \$50 VPWR VGND sg13cmos5l_dfrbpq_1
* cell instance sg13cmos5l_dfrbpq_1_67 r0 *1 0,0
Xsg13cmos5l_dfrbpq_1_67 \$277 \$285 \$135 \$272 VPWR VGND sg13cmos5l_dfrbpq_1
* cell instance sg13cmos5l_dfrbpq_1_68 r0 *1 0,0
Xsg13cmos5l_dfrbpq_1_68 \$759 \$1378 \$1157 \$50 VPWR VGND sg13cmos5l_dfrbpq_1
* cell instance sg13cmos5l_dfrbpq_1_69 r0 *1 0,0
Xsg13cmos5l_dfrbpq_1_69 \$277 \$463 \$539 \$272 VPWR VGND sg13cmos5l_dfrbpq_1
* cell instance sg13cmos5l_dfrbpq_1_70 r0 *1 0,0
Xsg13cmos5l_dfrbpq_1_70 \$277 \$901 \$1064 \$272 VPWR VGND sg13cmos5l_dfrbpq_1
* cell instance sg13cmos5l_dfrbpq_1_71 r0 *1 0,0
Xsg13cmos5l_dfrbpq_1_71 \$277 \$620 \$632 \$272 VPWR VGND sg13cmos5l_dfrbpq_1
* cell instance sg13cmos5l_dfrbpq_1_72 r0 *1 0,0
Xsg13cmos5l_dfrbpq_1_72 \$277 \$299 \$144 \$272 VPWR VGND sg13cmos5l_dfrbpq_1
* cell instance sg13cmos5l_dfrbpq_1_73 r0 *1 0,0
Xsg13cmos5l_dfrbpq_1_73 \$759 \$1160 \$1633 \$315 VPWR VGND sg13cmos5l_dfrbpq_1
* cell instance sg13cmos5l_dfrbpq_1_74 r0 *1 0,0
Xsg13cmos5l_dfrbpq_1_74 \$759 \$474 \$485 \$315 VPWR VGND sg13cmos5l_dfrbpq_1
* cell instance sg13cmos5l_dfrbpq_1_75 r0 *1 0,0
Xsg13cmos5l_dfrbpq_1_75 \$320 \$917 \$928 \$315 VPWR VGND sg13cmos5l_dfrbpq_1
* cell instance sg13cmos5l_dfrbpq_1_76 r0 *1 0,0
Xsg13cmos5l_dfrbpq_1_76 \$320 \$769 \$1186 \$315 VPWR VGND sg13cmos5l_dfrbpq_1
* cell instance sg13cmos5l_dfrbpq_1_77 r0 *1 0,0
Xsg13cmos5l_dfrbpq_1_77 \$320 \$312 \$325 \$315 VPWR VGND sg13cmos5l_dfrbpq_1
* cell instance sg13cmos5l_dfrbpq_1_78 r0 *1 0,0
Xsg13cmos5l_dfrbpq_1_78 \$320 \$487 \$498 \$315 VPWR VGND sg13cmos5l_dfrbpq_1
* cell instance sg13cmos5l_dfrbpq_1_79 r0 *1 0,0
Xsg13cmos5l_dfrbpq_1_79 \$320 \$1187 \$934 \$315 VPWR VGND sg13cmos5l_dfrbpq_1
* cell instance sg13cmos5l_dfrbpq_1_80 r0 *1 0,0
Xsg13cmos5l_dfrbpq_1_80 \$326 \$158 \$338 \$315 VPWR VGND sg13cmos5l_dfrbpq_1
* cell instance sg13cmos5l_dfrbpq_1_81 r0 *1 0,0
Xsg13cmos5l_dfrbpq_1_81 \$320 \$159 \$172 \$163 VPWR VGND sg13cmos5l_dfrbpq_1
* cell instance sg13cmos5l_dfrbpq_1_82 r0 *1 0,0
Xsg13cmos5l_dfrbpq_1_82 \$326 \$19 \$173 \$163 VPWR VGND sg13cmos5l_dfrbpq_1
* cell instance sg13cmos5l_dfrbpq_1_83 r0 *1 0,0
Xsg13cmos5l_dfrbpq_1_83 \$326 \$661 \$965 \$163 VPWR VGND sg13cmos5l_dfrbpq_1
* cell instance sg13cmos5l_dfrbpq_1_84 r0 *1 0,0
Xsg13cmos5l_dfrbpq_1_84 \$1217 \$797 \$972 \$163 VPWR VGND sg13cmos5l_dfrbpq_1
* cell instance sg13cmos5l_dfrbpq_1_85 r0 *1 0,0
Xsg13cmos5l_dfrbpq_1_85 \$326 \$182 \$359 \$163 VPWR VGND sg13cmos5l_dfrbpq_1
* cell instance sg13cmos5l_dfrbpq_1_86 r0 *1 0,0
Xsg13cmos5l_dfrbpq_1_86 \$326 \$668 \$532 \$163 VPWR VGND sg13cmos5l_dfrbpq_1
* cell instance sg13cmos5l_dfrbpq_1_87 r0 *1 0,0
Xsg13cmos5l_dfrbpq_1_87 \$326 \$187 \$199 \$163 VPWR VGND sg13cmos5l_dfrbpq_1
* cell instance sg13cmos5l_dfrbpq_1_88 r0 *1 0,0
Xsg13cmos5l_dfrbpq_1_88 \$1217 \$1225 \$977 \$163 VPWR VGND sg13cmos5l_dfrbpq_1
* cell instance sg13cmos5l_dfrbpq_1_89 r0 *1 0,0
Xsg13cmos5l_dfrbpq_1_89 \$988 \$689 \$677 \$1243 VPWR VGND sg13cmos5l_dfrbpq_1
* cell instance sg13cmos5l_dfrbpq_1_90 r0 *1 0,0
Xsg13cmos5l_dfrbpq_1_90 \$988 \$981 \$1068 \$1243 VPWR VGND sg13cmos5l_dfrbpq_1
* cell instance sg13cmos5l_dfrbpq_1_91 r0 *1 0,0
Xsg13cmos5l_dfrbpq_1_91 \$988 \$1239 \$1252 \$1243 VPWR VGND sg13cmos5l_dfrbpq_1
* cell instance sg13cmos5l_dfrbpq_1_92 r0 *1 0,0
Xsg13cmos5l_dfrbpq_1_92 \$988 \$993 \$1071 \$1243 VPWR VGND sg13cmos5l_dfrbpq_1
* cell instance sg13cmos5l_dfrbpq_1_93 r0 *1 0,0
Xsg13cmos5l_dfrbpq_1_93 \$1217 \$1490 \$1265 \$1243 VPWR VGND
+ sg13cmos5l_dfrbpq_1
* cell instance sg13cmos5l_dfrbpq_1_94 r0 *1 0,0
Xsg13cmos5l_dfrbpq_1_94 \$988 \$1012 \$1023 \$1243 VPWR VGND sg13cmos5l_dfrbpq_1
* cell instance sg13cmos5l_dfrbpq_1_95 r0 *1 0,0
Xsg13cmos5l_dfrbpq_1_95 \$1217 \$1269 \$1281 \$1243 VPWR VGND
+ sg13cmos5l_dfrbpq_1
* cell instance sg13cmos5l_dfrbpq_1_96 r0 *1 0,0
Xsg13cmos5l_dfrbpq_1_96 \$1217 \$1035 \$1293 \$1243 VPWR VGND
+ sg13cmos5l_dfrbpq_1
* cell instance sg13cmos5l_dfrbpq_1_97 r0 *1 0,0
Xsg13cmos5l_dfrbpq_1_97 \$988 \$1043 \$1055 \$773 VPWR VGND sg13cmos5l_dfrbpq_1
* cell instance sg13cmos5l_dfrbpq_1_98 r0 *1 0,0
Xsg13cmos5l_dfrbpq_1_98 \$1217 \$1520 \$1532 \$773 VPWR VGND sg13cmos5l_dfrbpq_1
* cell instance sg13cmos5l_dlygate4sd3_1_0 r0 *1 0,0
Xsg13cmos5l_dlygate4sd3_1_0 \$1924 VPWR VGND \$2178 sg13cmos5l_dlygate4sd3_1
* cell instance sg13cmos5l_dlygate4sd3_1_1 r0 *1 0,0
Xsg13cmos5l_dlygate4sd3_1_1 \$3057 VPWR VGND \$2939 sg13cmos5l_dlygate4sd3_1
* cell instance sg13cmos5l_dlygate4sd3_1_2 r0 *1 0,0
Xsg13cmos5l_dlygate4sd3_1_2 \$4147 VPWR VGND \$4758 sg13cmos5l_dlygate4sd3_1
* cell instance sg13cmos5l_dlygate4sd3_1_3 r0 *1 0,0
Xsg13cmos5l_dlygate4sd3_1_3 \$7622 VPWR VGND \$9012 sg13cmos5l_dlygate4sd3_1
* cell instance sg13cmos5l_dlygate4sd3_1_4 r0 *1 0,0
Xsg13cmos5l_dlygate4sd3_1_4 \$1858 VPWR VGND \$1790 sg13cmos5l_dlygate4sd3_1
* cell instance sg13cmos5l_dlygate4sd3_1_5 r0 *1 0,0
Xsg13cmos5l_dlygate4sd3_1_5 \$10208 VPWR VGND \$12257 sg13cmos5l_dlygate4sd3_1
* cell instance sg13cmos5l_dlygate4sd3_1_6 r0 *1 0,0
Xsg13cmos5l_dlygate4sd3_1_6 \$10209 VPWR VGND \$10631 sg13cmos5l_dlygate4sd3_1
* cell instance sg13cmos5l_dlygate4sd3_1_7 r0 *1 0,0
Xsg13cmos5l_dlygate4sd3_1_7 \$3821 VPWR VGND \$3820 sg13cmos5l_dlygate4sd3_1
* cell instance sg13cmos5l_dlygate4sd3_1_8 r0 *1 0,0
Xsg13cmos5l_dlygate4sd3_1_8 \$10210 VPWR VGND \$10206 sg13cmos5l_dlygate4sd3_1
* cell instance sg13cmos5l_dlygate4sd3_1_9 r0 *1 0,0
Xsg13cmos5l_dlygate4sd3_1_9 \$3065 VPWR VGND \$3267 sg13cmos5l_dlygate4sd3_1
* cell instance sg13cmos5l_dlygate4sd3_1_10 r0 *1 0,0
Xsg13cmos5l_dlygate4sd3_1_10 \$3824 VPWR VGND \$4086 sg13cmos5l_dlygate4sd3_1
* cell instance sg13cmos5l_dlygate4sd3_1_11 r0 *1 0,0
Xsg13cmos5l_dlygate4sd3_1_11 \$5356 VPWR VGND \$5797 sg13cmos5l_dlygate4sd3_1
* cell instance sg13cmos5l_dlygate4sd3_1_12 r0 *1 0,0
Xsg13cmos5l_dlygate4sd3_1_12 \$7704 VPWR VGND \$7626 sg13cmos5l_dlygate4sd3_1
* cell instance sg13cmos5l_dlygate4sd3_1_13 r0 *1 0,0
Xsg13cmos5l_dlygate4sd3_1_13 \$1813 VPWR VGND \$2207 sg13cmos5l_dlygate4sd3_1
* cell instance sg13cmos5l_dlygate4sd3_1_14 r0 *1 0,0
Xsg13cmos5l_dlygate4sd3_1_14 \$3490 VPWR VGND \$3734 sg13cmos5l_dlygate4sd3_1
* cell instance sg13cmos5l_dlygate4sd3_1_15 r0 *1 0,0
Xsg13cmos5l_dlygate4sd3_1_15 \$4087 VPWR VGND \$4612 sg13cmos5l_dlygate4sd3_1
* cell instance sg13cmos5l_dlygate4sd3_1_16 r0 *1 0,0
Xsg13cmos5l_dlygate4sd3_1_16 \$5357 VPWR VGND \$6676 sg13cmos5l_dlygate4sd3_1
* cell instance sg13cmos5l_dlygate4sd3_1_17 r0 *1 0,0
Xsg13cmos5l_dlygate4sd3_1_17 \$11074 VPWR VGND \$10207 sg13cmos5l_dlygate4sd3_1
* cell instance sg13cmos5l_dlygate4sd3_1_18 r0 *1 0,0
Xsg13cmos5l_dlygate4sd3_1_18 \$2719 VPWR VGND \$2750 sg13cmos5l_dlygate4sd3_1
* cell instance sg13cmos5l_dlygate4sd3_1_19 r0 *1 0,0
Xsg13cmos5l_dlygate4sd3_1_19 \$9020 VPWR VGND \$9615 sg13cmos5l_dlygate4sd3_1
* cell instance sg13cmos5l_dlygate4sd3_1_20 r0 *1 0,0
Xsg13cmos5l_dlygate4sd3_1_20 \$1814 VPWR VGND \$1818 sg13cmos5l_dlygate4sd3_1
* cell instance sg13cmos5l_dlygate4sd3_1_21 r0 *1 0,0
Xsg13cmos5l_dlygate4sd3_1_21 \$5358 VPWR VGND \$6673 sg13cmos5l_dlygate4sd3_1
* cell instance sg13cmos5l_dlygate4sd3_1_22 r0 *1 0,0
Xsg13cmos5l_dlygate4sd3_1_22 \$2422 VPWR VGND \$2722 sg13cmos5l_dlygate4sd3_1
* cell instance sg13cmos5l_dlygate4sd3_1_23 r0 *1 0,0
Xsg13cmos5l_dlygate4sd3_1_23 \$8572 VPWR VGND \$9180 sg13cmos5l_dlygate4sd3_1
* cell instance sg13cmos5l_dlygate4sd3_1_24 r0 *1 0,0
Xsg13cmos5l_dlygate4sd3_1_24 \$376 VPWR VGND \$73 sg13cmos5l_dlygate4sd3_1
* cell instance sg13cmos5l_dlygate4sd3_1_25 r0 *1 0,0
Xsg13cmos5l_dlygate4sd3_1_25 \$11079 VPWR VGND \$11244 sg13cmos5l_dlygate4sd3_1
* cell instance sg13cmos5l_dlygate4sd3_1_26 r0 *1 0,0
Xsg13cmos5l_dlygate4sd3_1_26 \$846 VPWR VGND \$844 sg13cmos5l_dlygate4sd3_1
* cell instance sg13cmos5l_dlygate4sd3_1_27 r0 *1 0,0
Xsg13cmos5l_dlygate4sd3_1_27 \$203 VPWR VGND \$207 sg13cmos5l_dlygate4sd3_1
* cell instance sg13cmos5l_dlygate4sd3_1_28 r0 *1 0,0
Xsg13cmos5l_dlygate4sd3_1_28 \$1553 VPWR VGND \$1309 sg13cmos5l_dlygate4sd3_1
* cell instance sg13cmos5l_dlygate4sd3_1_29 r0 *1 0,0
Xsg13cmos5l_dlygate4sd3_1_29 \$691 VPWR VGND \$377 sg13cmos5l_dlygate4sd3_1
* cell instance sg13cmos5l_dlygate4sd3_1_30 r0 *1 0,0
Xsg13cmos5l_dlygate4sd3_1_30 \$26 VPWR VGND \$31 sg13cmos5l_dlygate4sd3_1
* cell instance sg13cmos5l_dlygate4sd3_1_31 r0 *1 0,0
Xsg13cmos5l_dlygate4sd3_1_31 \$1900 VPWR VGND \$2079 sg13cmos5l_dlygate4sd3_1
* cell instance sg13cmos5l_dlygate4sd3_1_32 r0 *1 0,0
Xsg13cmos5l_dlygate4sd3_1_32 uio_out[3] VPWR VGND \$13836
+ sg13cmos5l_dlygate4sd3_1
* cell instance sg13cmos5l_dlygate4sd3_1_33 r0 *1 0,0
Xsg13cmos5l_dlygate4sd3_1_33 uio_out[2] VPWR VGND \$13737
+ sg13cmos5l_dlygate4sd3_1
* cell instance sg13cmos5l_dlygate4sd3_1_34 r0 *1 0,0
Xsg13cmos5l_dlygate4sd3_1_34 \$86 VPWR VGND \$692 sg13cmos5l_dlygate4sd3_1
* cell instance sg13cmos5l_dlygate4sd3_1_35 r0 *1 0,0
Xsg13cmos5l_dlygate4sd3_1_35 \$851 VPWR VGND \$1074 sg13cmos5l_dlygate4sd3_1
* cell instance sg13cmos5l_dlygate4sd3_1_36 r0 *1 0,0
Xsg13cmos5l_dlygate4sd3_1_36 \$556 VPWR VGND \$387 sg13cmos5l_dlygate4sd3_1
* cell instance sg13cmos5l_dlygate4sd3_1_37 r0 *1 0,0
Xsg13cmos5l_dlygate4sd3_1_37 \$2081 VPWR VGND \$2456 sg13cmos5l_dlygate4sd3_1
* cell instance sg13cmos5l_dlygate4sd3_1_38 r0 *1 0,0
Xsg13cmos5l_dlygate4sd3_1_38 \$10794 VPWR VGND \$11245 sg13cmos5l_dlygate4sd3_1
* cell instance sg13cmos5l_dlygate4sd3_1_39 r0 *1 0,0
Xsg13cmos5l_dlygate4sd3_1_39 \$856 VPWR VGND \$700 sg13cmos5l_dlygate4sd3_1
* cell instance sg13cmos5l_dlygate4sd3_1_40 r0 *1 0,0
Xsg13cmos5l_dlygate4sd3_1_40 \$1833 VPWR VGND \$1821 sg13cmos5l_dlygate4sd3_1
* cell instance sg13cmos5l_dlygate4sd3_1_41 r0 *1 0,0
Xsg13cmos5l_dlygate4sd3_1_41 uio_out[4] VPWR VGND \$13691
+ sg13cmos5l_dlygate4sd3_1
* cell instance sg13cmos5l_dlygate4sd3_1_42 r0 *1 0,0
Xsg13cmos5l_dlygate4sd3_1_42 \$13746 VPWR VGND \$13786 sg13cmos5l_dlygate4sd3_1
* cell instance sg13cmos5l_dlygate4sd3_1_43 r0 *1 0,0
Xsg13cmos5l_dlygate4sd3_1_43 \$219 VPWR VGND \$87 sg13cmos5l_dlygate4sd3_1
* cell instance sg13cmos5l_dlygate4sd3_1_44 r0 *1 0,0
Xsg13cmos5l_dlygate4sd3_1_44 uio_out[5] VPWR VGND \$12593
+ sg13cmos5l_dlygate4sd3_1
* cell instance sg13cmos5l_dlygate4sd3_1_45 r0 *1 0,0
Xsg13cmos5l_dlygate4sd3_1_45 uio_out[6] VPWR VGND \$12295
+ sg13cmos5l_dlygate4sd3_1
* cell instance sg13cmos5l_dlygate4sd3_1_46 r0 *1 0,0
Xsg13cmos5l_dlygate4sd3_1_46 uio_out[7] VPWR VGND \$13745
+ sg13cmos5l_dlygate4sd3_1
* cell instance sg13cmos5l_dlygate4sd3_1_47 r0 *1 0,0
Xsg13cmos5l_dlygate4sd3_1_47 \$1938 VPWR VGND \$2080 sg13cmos5l_dlygate4sd3_1
* cell instance sg13cmos5l_dlygate4sd3_1_48 r0 *1 0,0
Xsg13cmos5l_dlygate4sd3_1_48 \$9619 VPWR VGND \$9617 sg13cmos5l_dlygate4sd3_1
* cell instance sg13cmos5l_dlygate4sd3_1_49 r0 *1 0,0
Xsg13cmos5l_dlygate4sd3_1_49 \$9620 VPWR VGND \$11095 sg13cmos5l_dlygate4sd3_1
* cell instance sg13cmos5l_dlygate4sd3_1_50 r0 *1 0,0
Xsg13cmos5l_dlygate4sd3_1_50 \$394 VPWR VGND \$223 sg13cmos5l_dlygate4sd3_1
* cell instance sg13cmos5l_dlygate4sd3_1_51 r0 *1 0,0
Xsg13cmos5l_dlygate4sd3_1_51 uo_out[3] VPWR VGND \$13801
+ sg13cmos5l_dlygate4sd3_1
* cell instance sg13cmos5l_dlygate4sd3_1_52 r0 *1 0,0
Xsg13cmos5l_dlygate4sd3_1_52 \$562 VPWR VGND \$393 sg13cmos5l_dlygate4sd3_1
* cell instance sg13cmos5l_dlygate4sd3_1_53 r0 *1 0,0
Xsg13cmos5l_dlygate4sd3_1_53 \$45 VPWR VGND \$89 sg13cmos5l_dlygate4sd3_1
* cell instance sg13cmos5l_dlygate4sd3_1_54 r0 *1 0,0
Xsg13cmos5l_dlygate4sd3_1_54 uo_out[4] VPWR VGND \$13321
+ sg13cmos5l_dlygate4sd3_1
* cell instance sg13cmos5l_dlygate4sd3_1_55 r0 *1 0,0
Xsg13cmos5l_dlygate4sd3_1_55 \$232 VPWR VGND \$399 sg13cmos5l_dlygate4sd3_1
* cell instance sg13cmos5l_dlygate4sd3_1_56 r0 *1 0,0
Xsg13cmos5l_dlygate4sd3_1_56 \$1334 VPWR VGND \$1845 sg13cmos5l_dlygate4sd3_1
* cell instance sg13cmos5l_dlygate4sd3_1_57 r0 *1 0,0
Xsg13cmos5l_dlygate4sd3_1_57 \$13608 VPWR VGND \$13612 sg13cmos5l_dlygate4sd3_1
* cell instance sg13cmos5l_dlygate4sd3_1_58 r0 *1 0,0
Xsg13cmos5l_dlygate4sd3_1_58 uo_out[1] VPWR VGND \$10795
+ sg13cmos5l_dlygate4sd3_1
* cell instance sg13cmos5l_dlygate4sd3_1_59 r0 *1 0,0
Xsg13cmos5l_dlygate4sd3_1_59 uio_out[1] VPWR VGND \$12259
+ sg13cmos5l_dlygate4sd3_1
* cell instance sg13cmos5l_dlygate4sd3_1_60 r0 *1 0,0
Xsg13cmos5l_dlygate4sd3_1_60 \$236 VPWR VGND \$408 sg13cmos5l_dlygate4sd3_1
* cell instance sg13cmos5l_dlygate4sd3_1_61 r0 *1 0,0
Xsg13cmos5l_dlygate4sd3_1_61 \$240 VPWR VGND \$33 sg13cmos5l_dlygate4sd3_1
* cell instance sg13cmos5l_dlygate4sd3_1_62 r0 *1 0,0
Xsg13cmos5l_dlygate4sd3_1_62 uo_out[0] VPWR VGND \$13617
+ sg13cmos5l_dlygate4sd3_1
* cell instance sg13cmos5l_dlygate4sd3_1_63 r0 *1 0,0
Xsg13cmos5l_dlygate4sd3_1_63 \$591 VPWR VGND \$1570 sg13cmos5l_dlygate4sd3_1
* cell instance sg13cmos5l_dlygate4sd3_1_64 r0 *1 0,0
Xsg13cmos5l_dlygate4sd3_1_64 uo_out[6] VPWR VGND \$13251
+ sg13cmos5l_dlygate4sd3_1
* cell instance sg13cmos5l_dlygate4sd3_1_65 r0 *1 0,0
Xsg13cmos5l_dlygate4sd3_1_65 uo_out[5] VPWR VGND \$12603
+ sg13cmos5l_dlygate4sd3_1
* cell instance sg13cmos5l_dlygate4sd3_1_66 r0 *1 0,0
Xsg13cmos5l_dlygate4sd3_1_66 \$2085 VPWR VGND \$3497 sg13cmos5l_dlygate4sd3_1
* cell instance sg13cmos5l_dlygate4sd3_1_67 r0 *1 0,0
Xsg13cmos5l_dlygate4sd3_1_67 uio_out[0] VPWR VGND \$13719
+ sg13cmos5l_dlygate4sd3_1
* cell instance sg13cmos5l_dlygate4sd3_1_68 r0 *1 0,0
Xsg13cmos5l_dlygate4sd3_1_68 uo_out[7] VPWR VGND \$13715
+ sg13cmos5l_dlygate4sd3_1
* cell instance sg13cmos5l_dlygate4sd3_1_69 r0 *1 0,0
Xsg13cmos5l_dlygate4sd3_1_69 \$59 VPWR VGND \$248 sg13cmos5l_dlygate4sd3_1
* cell instance sg13cmos5l_dlygate4sd3_1_70 r0 *1 0,0
Xsg13cmos5l_dlygate4sd3_1_70 \$711 VPWR VGND \$583 sg13cmos5l_dlygate4sd3_1
* cell instance sg13cmos5l_dlygate4sd3_1_71 r0 *1 0,0
Xsg13cmos5l_dlygate4sd3_1_71 \$245 VPWR VGND \$47 sg13cmos5l_dlygate4sd3_1
* cell instance sg13cmos5l_dlygate4sd3_1_72 r0 *1 0,0
Xsg13cmos5l_dlygate4sd3_1_72 uo_out[2] VPWR VGND \$13868
+ sg13cmos5l_dlygate4sd3_1
* cell instance sg13cmos5l_dlygate4sd3_1_73 r0 *1 0,0
Xsg13cmos5l_dlygate4sd3_1_73 \$119 VPWR VGND \$256 sg13cmos5l_dlygate4sd3_1
* cell instance sg13cmos5l_dlygate4sd3_1_74 r0 *1 0,0
Xsg13cmos5l_dlygate4sd3_1_74 \$423 VPWR VGND \$107 sg13cmos5l_dlygate4sd3_1
* cell instance sg13cmos5l_dlygate4sd3_1_75 r0 *1 0,0
Xsg13cmos5l_dlygate4sd3_1_75 \$1589 VPWR VGND \$1119 sg13cmos5l_dlygate4sd3_1
* cell instance sg13cmos5l_dlygate4sd3_1_76 r0 *1 0,0
Xsg13cmos5l_dlygate4sd3_1_76 \$1355 VPWR VGND \$1589 sg13cmos5l_dlygate4sd3_1
* cell instance sg13cmos5l_dlygate4sd3_1_77 r0 *1 0,0
Xsg13cmos5l_dlygate4sd3_1_77 \$1119 VPWR VGND \$1061 sg13cmos5l_dlygate4sd3_1
* cell instance sg13cmos5l_dlygate4sd3_1_78 r0 *1 0,0
Xsg13cmos5l_dlygate4sd3_1_78 \$721 VPWR VGND \$720 sg13cmos5l_dlygate4sd3_1
* cell instance sg13cmos5l_dlygate4sd3_1_79 r0 *1 0,0
Xsg13cmos5l_dlygate4sd3_1_79 \$268 VPWR VGND \$265 sg13cmos5l_dlygate4sd3_1
* cell instance sg13cmos5l_dlygate4sd3_1_80 r0 *1 0,0
Xsg13cmos5l_dlygate4sd3_1_80 \$435 VPWR VGND \$120 sg13cmos5l_dlygate4sd3_1
* cell instance sg13cmos5l_dlygate4sd3_1_81 r0 *1 0,0
Xsg13cmos5l_dlygate4sd3_1_81 \$537 VPWR VGND \$718 sg13cmos5l_dlygate4sd3_1
* cell instance sg13cmos5l_dlygate4sd3_1_82 r0 *1 0,0
Xsg13cmos5l_dlygate4sd3_1_82 \$1604 VPWR VGND \$1598 sg13cmos5l_dlygate4sd3_1
* cell instance sg13cmos5l_dlygate4sd3_1_83 r0 *1 0,0
Xsg13cmos5l_dlygate4sd3_1_83 \$1598 VPWR VGND \$887 sg13cmos5l_dlygate4sd3_1
* cell instance sg13cmos5l_dlygate4sd3_1_84 r0 *1 0,0
Xsg13cmos5l_dlygate4sd3_1_84 \$441 VPWR VGND \$269 sg13cmos5l_dlygate4sd3_1
* cell instance sg13cmos5l_dlygate4sd3_1_85 r0 *1 0,0
Xsg13cmos5l_dlygate4sd3_1_85 \$1372 VPWR VGND \$1604 sg13cmos5l_dlygate4sd3_1
* cell instance sg13cmos5l_dlygate4sd3_1_86 r0 *1 0,0
Xsg13cmos5l_dlygate4sd3_1_86 \$1141 VPWR VGND \$1144 sg13cmos5l_dlygate4sd3_1
* cell instance sg13cmos5l_dlygate4sd3_1_87 r0 *1 0,0
Xsg13cmos5l_dlygate4sd3_1_87 \$1144 VPWR VGND \$1613 sg13cmos5l_dlygate4sd3_1
* cell instance sg13cmos5l_dlygate4sd3_1_88 r0 *1 0,0
Xsg13cmos5l_dlygate4sd3_1_88 \$1613 VPWR VGND \$1617 sg13cmos5l_dlygate4sd3_1
* cell instance sg13cmos5l_dlygate4sd3_1_89 r0 *1 0,0
Xsg13cmos5l_dlygate4sd3_1_89 \$135 VPWR VGND \$134 sg13cmos5l_dlygate4sd3_1
* cell instance sg13cmos5l_dlygate4sd3_1_90 r0 *1 0,0
Xsg13cmos5l_dlygate4sd3_1_90 \$282 VPWR VGND \$285 sg13cmos5l_dlygate4sd3_1
* cell instance sg13cmos5l_dlygate4sd3_1_91 r0 *1 0,0
Xsg13cmos5l_dlygate4sd3_1_91 \$1377 VPWR VGND \$1551 sg13cmos5l_dlygate4sd3_1
* cell instance sg13cmos5l_dlygate4sd3_1_92 r0 *1 0,0
Xsg13cmos5l_dlygate4sd3_1_92 \$1390 VPWR VGND \$1377 sg13cmos5l_dlygate4sd3_1
* cell instance sg13cmos5l_dlygate4sd3_1_93 r0 *1 0,0
Xsg13cmos5l_dlygate4sd3_1_93 \$140 VPWR VGND \$463 sg13cmos5l_dlygate4sd3_1
* cell instance sg13cmos5l_dlygate4sd3_1_94 r0 *1 0,0
Xsg13cmos5l_dlygate4sd3_1_94 \$539 VPWR VGND \$455 sg13cmos5l_dlygate4sd3_1
* cell instance sg13cmos5l_dlygate4sd3_1_95 r0 *1 0,0
Xsg13cmos5l_dlygate4sd3_1_95 \$1157 VPWR VGND \$1390 sg13cmos5l_dlygate4sd3_1
* cell instance sg13cmos5l_dlygate4sd3_1_96 r0 *1 0,0
Xsg13cmos5l_dlygate4sd3_1_96 \$1387 VPWR VGND \$1632 sg13cmos5l_dlygate4sd3_1
* cell instance sg13cmos5l_dlygate4sd3_1_97 r0 *1 0,0
Xsg13cmos5l_dlygate4sd3_1_97 \$610 VPWR VGND \$620 sg13cmos5l_dlygate4sd3_1
* cell instance sg13cmos5l_dlygate4sd3_1_98 r0 *1 0,0
Xsg13cmos5l_dlygate4sd3_1_98 \$632 VPWR VGND \$142 sg13cmos5l_dlygate4sd3_1
* cell instance sg13cmos5l_dlygate4sd3_1_99 r0 *1 0,0
Xsg13cmos5l_dlygate4sd3_1_99 \$1064 VPWR VGND \$1394 sg13cmos5l_dlygate4sd3_1
* cell instance sg13cmos5l_dlygate4sd3_1_100 r0 *1 0,0
Xsg13cmos5l_dlygate4sd3_1_100 \$1633 VPWR VGND \$1637 sg13cmos5l_dlygate4sd3_1
* cell instance sg13cmos5l_dlygate4sd3_1_101 r0 *1 0,0
Xsg13cmos5l_dlygate4sd3_1_101 \$1637 VPWR VGND \$1397 sg13cmos5l_dlygate4sd3_1
* cell instance sg13cmos5l_dlygate4sd3_1_102 r0 *1 0,0
Xsg13cmos5l_dlygate4sd3_1_102 \$144 VPWR VGND \$143 sg13cmos5l_dlygate4sd3_1
* cell instance sg13cmos5l_dlygate4sd3_1_103 r0 *1 0,0
Xsg13cmos5l_dlygate4sd3_1_103 \$1397 VPWR VGND \$914 sg13cmos5l_dlygate4sd3_1
* cell instance sg13cmos5l_dlygate4sd3_1_104 r0 *1 0,0
Xsg13cmos5l_dlygate4sd3_1_104 \$485 VPWR VGND \$299 sg13cmos5l_dlygate4sd3_1
* cell instance sg13cmos5l_dlygate4sd3_1_105 r0 *1 0,0
Xsg13cmos5l_dlygate4sd3_1_105 \$1394 VPWR VGND \$1387 sg13cmos5l_dlygate4sd3_1
* cell instance sg13cmos5l_dlygate4sd3_1_106 r0 *1 0,0
Xsg13cmos5l_dlygate4sd3_1_106 \$1402 VPWR VGND \$1656 sg13cmos5l_dlygate4sd3_1
* cell instance sg13cmos5l_dlygate4sd3_1_107 r0 *1 0,0
Xsg13cmos5l_dlygate4sd3_1_107 \$1417 VPWR VGND \$1402 sg13cmos5l_dlygate4sd3_1
* cell instance sg13cmos5l_dlygate4sd3_1_108 r0 *1 0,0
Xsg13cmos5l_dlygate4sd3_1_108 \$928 VPWR VGND \$1417 sg13cmos5l_dlygate4sd3_1
* cell instance sg13cmos5l_dlygate4sd3_1_109 r0 *1 0,0
Xsg13cmos5l_dlygate4sd3_1_109 \$1186 VPWR VGND \$931 sg13cmos5l_dlygate4sd3_1
* cell instance sg13cmos5l_dlygate4sd3_1_110 r0 *1 0,0
Xsg13cmos5l_dlygate4sd3_1_110 \$151 VPWR VGND \$638 sg13cmos5l_dlygate4sd3_1
* cell instance sg13cmos5l_dlygate4sd3_1_111 r0 *1 0,0
Xsg13cmos5l_dlygate4sd3_1_111 \$777 VPWR VGND \$1664 sg13cmos5l_dlygate4sd3_1
* cell instance sg13cmos5l_dlygate4sd3_1_112 r0 *1 0,0
Xsg13cmos5l_dlygate4sd3_1_112 \$498 VPWR VGND \$647 sg13cmos5l_dlygate4sd3_1
* cell instance sg13cmos5l_dlygate4sd3_1_113 r0 *1 0,0
Xsg13cmos5l_dlygate4sd3_1_113 \$643 VPWR VGND \$1424 sg13cmos5l_dlygate4sd3_1
* cell instance sg13cmos5l_dlygate4sd3_1_114 r0 *1 0,0
Xsg13cmos5l_dlygate4sd3_1_114 \$500 VPWR VGND \$156 sg13cmos5l_dlygate4sd3_1
* cell instance sg13cmos5l_dlygate4sd3_1_115 r0 *1 0,0
Xsg13cmos5l_dlygate4sd3_1_115 \$647 VPWR VGND \$149 sg13cmos5l_dlygate4sd3_1
* cell instance sg13cmos5l_dlygate4sd3_1_116 r0 *1 0,0
Xsg13cmos5l_dlygate4sd3_1_116 \$325 VPWR VGND \$151 sg13cmos5l_dlygate4sd3_1
* cell instance sg13cmos5l_dlygate4sd3_1_117 r0 *1 0,0
Xsg13cmos5l_dlygate4sd3_1_117 \$934 VPWR VGND \$1199 sg13cmos5l_dlygate4sd3_1
* cell instance sg13cmos5l_dlygate4sd3_1_118 r0 *1 0,0
Xsg13cmos5l_dlygate4sd3_1_118 \$1428 VPWR VGND \$1432 sg13cmos5l_dlygate4sd3_1
* cell instance sg13cmos5l_dlygate4sd3_1_119 r0 *1 0,0
Xsg13cmos5l_dlygate4sd3_1_119 \$1199 VPWR VGND \$1407 sg13cmos5l_dlygate4sd3_1
* cell instance sg13cmos5l_dlygate4sd3_1_120 r0 *1 0,0
Xsg13cmos5l_dlygate4sd3_1_120 \$510 VPWR VGND \$1436 sg13cmos5l_dlygate4sd3_1
* cell instance sg13cmos5l_dlygate4sd3_1_121 r0 *1 0,0
Xsg13cmos5l_dlygate4sd3_1_121 \$341 VPWR VGND \$21 sg13cmos5l_dlygate4sd3_1
* cell instance sg13cmos5l_dlygate4sd3_1_122 r0 *1 0,0
Xsg13cmos5l_dlygate4sd3_1_122 \$338 VPWR VGND \$500 sg13cmos5l_dlygate4sd3_1
* cell instance sg13cmos5l_dlygate4sd3_1_123 r0 *1 0,0
Xsg13cmos5l_dlygate4sd3_1_123 \$172 VPWR VGND \$341 sg13cmos5l_dlygate4sd3_1
* cell instance sg13cmos5l_dlygate4sd3_1_124 r0 *1 0,0
Xsg13cmos5l_dlygate4sd3_1_124 \$654 VPWR VGND \$1440 sg13cmos5l_dlygate4sd3_1
* cell instance sg13cmos5l_dlygate4sd3_1_125 r0 *1 0,0
Xsg13cmos5l_dlygate4sd3_1_125 \$173 VPWR VGND \$177 sg13cmos5l_dlygate4sd3_1
* cell instance sg13cmos5l_dlygate4sd3_1_126 r0 *1 0,0
Xsg13cmos5l_dlygate4sd3_1_126 \$1205 VPWR VGND \$1209 sg13cmos5l_dlygate4sd3_1
* cell instance sg13cmos5l_dlygate4sd3_1_127 r0 *1 0,0
Xsg13cmos5l_dlygate4sd3_1_127 \$177 VPWR VGND \$22 sg13cmos5l_dlygate4sd3_1
* cell instance sg13cmos5l_dlygate4sd3_1_128 r0 *1 0,0
Xsg13cmos5l_dlygate4sd3_1_128 \$657 VPWR VGND \$1445 sg13cmos5l_dlygate4sd3_1
* cell instance sg13cmos5l_dlygate4sd3_1_129 r0 *1 0,0
Xsg13cmos5l_dlygate4sd3_1_129 \$790 VPWR VGND \$1676 sg13cmos5l_dlygate4sd3_1
* cell instance sg13cmos5l_dlygate4sd3_1_130 r0 *1 0,0
Xsg13cmos5l_dlygate4sd3_1_130 \$514 VPWR VGND \$1449 sg13cmos5l_dlygate4sd3_1
* cell instance sg13cmos5l_dlygate4sd3_1_131 r0 *1 0,0
Xsg13cmos5l_dlygate4sd3_1_131 \$965 VPWR VGND \$663 sg13cmos5l_dlygate4sd3_1
* cell instance sg13cmos5l_dlygate4sd3_1_132 r0 *1 0,0
Xsg13cmos5l_dlygate4sd3_1_132 \$799 VPWR VGND \$1669 sg13cmos5l_dlygate4sd3_1
* cell instance sg13cmos5l_dlygate4sd3_1_133 r0 *1 0,0
Xsg13cmos5l_dlygate4sd3_1_133 \$518 VPWR VGND \$513 sg13cmos5l_dlygate4sd3_1
* cell instance sg13cmos5l_dlygate4sd3_1_134 r0 *1 0,0
Xsg13cmos5l_dlygate4sd3_1_134 \$801 VPWR VGND \$517 sg13cmos5l_dlygate4sd3_1
* cell instance sg13cmos5l_dlygate4sd3_1_135 r0 *1 0,0
Xsg13cmos5l_dlygate4sd3_1_135 \$804 VPWR VGND \$515 sg13cmos5l_dlygate4sd3_1
* cell instance sg13cmos5l_dlygate4sd3_1_136 r0 *1 0,0
Xsg13cmos5l_dlygate4sd3_1_136 \$363 VPWR VGND \$348 sg13cmos5l_dlygate4sd3_1
* cell instance sg13cmos5l_dlygate4sd3_1_137 r0 *1 0,0
Xsg13cmos5l_dlygate4sd3_1_137 \$972 VPWR VGND \$665 sg13cmos5l_dlygate4sd3_1
* cell instance sg13cmos5l_dlygate4sd3_1_138 r0 *1 0,0
Xsg13cmos5l_dlygate4sd3_1_138 \$359 VPWR VGND \$518 sg13cmos5l_dlygate4sd3_1
* cell instance sg13cmos5l_dlygate4sd3_1_139 r0 *1 0,0
Xsg13cmos5l_dlygate4sd3_1_139 \$532 VPWR VGND \$804 sg13cmos5l_dlygate4sd3_1
* cell instance sg13cmos5l_dlygate4sd3_1_140 r0 *1 0,0
Xsg13cmos5l_dlygate4sd3_1_140 \$977 VPWR VGND \$808 sg13cmos5l_dlygate4sd3_1
* cell instance sg13cmos5l_dlygate4sd3_1_141 r0 *1 0,0
Xsg13cmos5l_dlygate4sd3_1_141 \$199 VPWR VGND \$363 sg13cmos5l_dlygate4sd3_1
* cell instance sg13cmos5l_dlygate4sd3_1_142 r0 *1 0,0
Xsg13cmos5l_dlygate4sd3_1_142 \$677 VPWR VGND \$675 sg13cmos5l_dlygate4sd3_1
* cell instance sg13cmos5l_dlygate4sd3_1_143 r0 *1 0,0
Xsg13cmos5l_dlygate4sd3_1_143 \$1068 VPWR VGND \$807 sg13cmos5l_dlygate4sd3_1
* cell instance sg13cmos5l_dlygate4sd3_1_144 r0 *1 0,0
Xsg13cmos5l_dlygate4sd3_1_144 \$534 VPWR VGND \$689 sg13cmos5l_dlygate4sd3_1
* cell instance sg13cmos5l_dlygate4sd3_1_145 r0 *1 0,0
Xsg13cmos5l_dlygate4sd3_1_145 \$1465 VPWR VGND \$981 sg13cmos5l_dlygate4sd3_1
* cell instance sg13cmos5l_dlygate4sd3_1_146 r0 *1 0,0
Xsg13cmos5l_dlygate4sd3_1_146 \$1475 VPWR VGND \$1722 sg13cmos5l_dlygate4sd3_1
* cell instance sg13cmos5l_dlygate4sd3_1_147 r0 *1 0,0
Xsg13cmos5l_dlygate4sd3_1_147 \$1724 VPWR VGND \$1475 sg13cmos5l_dlygate4sd3_1
* cell instance sg13cmos5l_dlygate4sd3_1_148 r0 *1 0,0
Xsg13cmos5l_dlygate4sd3_1_148 \$1252 VPWR VGND \$1724 sg13cmos5l_dlygate4sd3_1
* cell instance sg13cmos5l_dlygate4sd3_1_149 r0 *1 0,0
Xsg13cmos5l_dlygate4sd3_1_149 \$1730 VPWR VGND \$1486 sg13cmos5l_dlygate4sd3_1
* cell instance sg13cmos5l_dlygate4sd3_1_150 r0 *1 0,0
Xsg13cmos5l_dlygate4sd3_1_150 \$1071 VPWR VGND \$1730 sg13cmos5l_dlygate4sd3_1
* cell instance sg13cmos5l_dlygate4sd3_1_151 r0 *1 0,0
Xsg13cmos5l_dlygate4sd3_1_151 \$1486 VPWR VGND \$1737 sg13cmos5l_dlygate4sd3_1
* cell instance sg13cmos5l_dlygate4sd3_1_152 r0 *1 0,0
Xsg13cmos5l_dlygate4sd3_1_152 \$1742 VPWR VGND \$1489 sg13cmos5l_dlygate4sd3_1
* cell instance sg13cmos5l_dlygate4sd3_1_153 r0 *1 0,0
Xsg13cmos5l_dlygate4sd3_1_153 \$1265 VPWR VGND \$1742 sg13cmos5l_dlygate4sd3_1
* cell instance sg13cmos5l_dlygate4sd3_1_154 r0 *1 0,0
Xsg13cmos5l_dlygate4sd3_1_154 \$1489 VPWR VGND \$1751 sg13cmos5l_dlygate4sd3_1
* cell instance sg13cmos5l_dlygate4sd3_1_155 r0 *1 0,0
Xsg13cmos5l_dlygate4sd3_1_155 \$1023 VPWR VGND \$1509 sg13cmos5l_dlygate4sd3_1
* cell instance sg13cmos5l_dlygate4sd3_1_156 r0 *1 0,0
Xsg13cmos5l_dlygate4sd3_1_156 \$1509 VPWR VGND \$1499 sg13cmos5l_dlygate4sd3_1
* cell instance sg13cmos5l_dlygate4sd3_1_157 r0 *1 0,0
Xsg13cmos5l_dlygate4sd3_1_157 \$1514 VPWR VGND \$1505 sg13cmos5l_dlygate4sd3_1
* cell instance sg13cmos5l_dlygate4sd3_1_158 r0 *1 0,0
Xsg13cmos5l_dlygate4sd3_1_158 \$1499 VPWR VGND \$1758 sg13cmos5l_dlygate4sd3_1
* cell instance sg13cmos5l_dlygate4sd3_1_159 r0 *1 0,0
Xsg13cmos5l_dlygate4sd3_1_159 \$1281 VPWR VGND \$1514 sg13cmos5l_dlygate4sd3_1
* cell instance sg13cmos5l_dlygate4sd3_1_160 r0 *1 0,0
Xsg13cmos5l_dlygate4sd3_1_160 \$1505 VPWR VGND \$1767 sg13cmos5l_dlygate4sd3_1
* cell instance sg13cmos5l_dlygate4sd3_1_161 r0 *1 0,0
Xsg13cmos5l_dlygate4sd3_1_161 \$1295 VPWR VGND \$1034 sg13cmos5l_dlygate4sd3_1
* cell instance sg13cmos5l_dlygate4sd3_1_162 r0 *1 0,0
Xsg13cmos5l_dlygate4sd3_1_162 \$1293 VPWR VGND \$1295 sg13cmos5l_dlygate4sd3_1
* cell instance sg13cmos5l_dlygate4sd3_1_163 r0 *1 0,0
Xsg13cmos5l_dlygate4sd3_1_163 \$1055 VPWR VGND \$1301 sg13cmos5l_dlygate4sd3_1
* cell instance sg13cmos5l_dlygate4sd3_1_164 r0 *1 0,0
Xsg13cmos5l_dlygate4sd3_1_164 \$1034 VPWR VGND \$1537 sg13cmos5l_dlygate4sd3_1
* cell instance sg13cmos5l_dlygate4sd3_1_165 r0 *1 0,0
Xsg13cmos5l_dlygate4sd3_1_165 \$1301 VPWR VGND \$1523 sg13cmos5l_dlygate4sd3_1
* cell instance sg13cmos5l_dlygate4sd3_1_166 r0 *1 0,0
Xsg13cmos5l_dlygate4sd3_1_166 \$1523 VPWR VGND \$1534 sg13cmos5l_dlygate4sd3_1
* cell instance sg13cmos5l_dlygate4sd3_1_167 r0 *1 0,0
Xsg13cmos5l_dlygate4sd3_1_167 \$1532 VPWR VGND \$1777 sg13cmos5l_dlygate4sd3_1
* cell instance sg13cmos5l_dlygate4sd3_1_168 r0 *1 0,0
Xsg13cmos5l_dlygate4sd3_1_168 \$1777 VPWR VGND \$1781 sg13cmos5l_dlygate4sd3_1
* cell instance sg13cmos5l_dlygate4sd3_1_169 r0 *1 0,0
Xsg13cmos5l_dlygate4sd3_1_169 \$1781 VPWR VGND \$1785 sg13cmos5l_dlygate4sd3_1
* cell instance sg13cmos5l_fill_1_0 r0 *1 0,0
Xsg13cmos5l_fill_1_0 VPWR VGND sg13cmos5l_fill_1
* cell instance sg13cmos5l_fill_1_1 r0 *1 0,0
Xsg13cmos5l_fill_1_1 VPWR VGND sg13cmos5l_fill_1
* cell instance sg13cmos5l_fill_1_2 r0 *1 0,0
Xsg13cmos5l_fill_1_2 VPWR VGND sg13cmos5l_fill_1
* cell instance sg13cmos5l_fill_1_3 r0 *1 0,0
Xsg13cmos5l_fill_1_3 VPWR VGND sg13cmos5l_fill_1
* cell instance sg13cmos5l_fill_1_4 r0 *1 0,0
Xsg13cmos5l_fill_1_4 VPWR VGND sg13cmos5l_fill_1
* cell instance sg13cmos5l_fill_1_5 r0 *1 0,0
Xsg13cmos5l_fill_1_5 VPWR VGND sg13cmos5l_fill_1
* cell instance sg13cmos5l_fill_1_6 r0 *1 0,0
Xsg13cmos5l_fill_1_6 VPWR VGND sg13cmos5l_fill_1
* cell instance sg13cmos5l_fill_1_7 r0 *1 0,0
Xsg13cmos5l_fill_1_7 VPWR VGND sg13cmos5l_fill_1
* cell instance sg13cmos5l_fill_1_8 r0 *1 0,0
Xsg13cmos5l_fill_1_8 VPWR VGND sg13cmos5l_fill_1
* cell instance sg13cmos5l_fill_1_9 r0 *1 0,0
Xsg13cmos5l_fill_1_9 VPWR VGND sg13cmos5l_fill_1
* cell instance sg13cmos5l_fill_1_10 r0 *1 0,0
Xsg13cmos5l_fill_1_10 VPWR VGND sg13cmos5l_fill_1
* cell instance sg13cmos5l_fill_1_11 r0 *1 0,0
Xsg13cmos5l_fill_1_11 VPWR VGND sg13cmos5l_fill_1
* cell instance sg13cmos5l_fill_1_12 r0 *1 0,0
Xsg13cmos5l_fill_1_12 VPWR VGND sg13cmos5l_fill_1
* cell instance sg13cmos5l_fill_1_13 r0 *1 0,0
Xsg13cmos5l_fill_1_13 VPWR VGND sg13cmos5l_fill_1
* cell instance sg13cmos5l_fill_1_14 r0 *1 0,0
Xsg13cmos5l_fill_1_14 VPWR VGND sg13cmos5l_fill_1
* cell instance sg13cmos5l_fill_1_15 r0 *1 0,0
Xsg13cmos5l_fill_1_15 VPWR VGND sg13cmos5l_fill_1
* cell instance sg13cmos5l_fill_1_16 r0 *1 0,0
Xsg13cmos5l_fill_1_16 VPWR VGND sg13cmos5l_fill_1
* cell instance sg13cmos5l_fill_1_17 r0 *1 0,0
Xsg13cmos5l_fill_1_17 VPWR VGND sg13cmos5l_fill_1
* cell instance sg13cmos5l_fill_1_18 r0 *1 0,0
Xsg13cmos5l_fill_1_18 VPWR VGND sg13cmos5l_fill_1
* cell instance sg13cmos5l_fill_1_19 r0 *1 0,0
Xsg13cmos5l_fill_1_19 VPWR VGND sg13cmos5l_fill_1
* cell instance sg13cmos5l_fill_1_20 r0 *1 0,0
Xsg13cmos5l_fill_1_20 VPWR VGND sg13cmos5l_fill_1
* cell instance sg13cmos5l_fill_1_21 r0 *1 0,0
Xsg13cmos5l_fill_1_21 VPWR VGND sg13cmos5l_fill_1
* cell instance sg13cmos5l_fill_1_22 r0 *1 0,0
Xsg13cmos5l_fill_1_22 VPWR VGND sg13cmos5l_fill_1
* cell instance sg13cmos5l_fill_1_23 r0 *1 0,0
Xsg13cmos5l_fill_1_23 VPWR VGND sg13cmos5l_fill_1
* cell instance sg13cmos5l_fill_1_24 r0 *1 0,0
Xsg13cmos5l_fill_1_24 VPWR VGND sg13cmos5l_fill_1
* cell instance sg13cmos5l_fill_1_25 r0 *1 0,0
Xsg13cmos5l_fill_1_25 VPWR VGND sg13cmos5l_fill_1
* cell instance sg13cmos5l_fill_1_26 r0 *1 0,0
Xsg13cmos5l_fill_1_26 VPWR VGND sg13cmos5l_fill_1
* cell instance sg13cmos5l_fill_1_27 r0 *1 0,0
Xsg13cmos5l_fill_1_27 VPWR VGND sg13cmos5l_fill_1
* cell instance sg13cmos5l_fill_1_28 r0 *1 0,0
Xsg13cmos5l_fill_1_28 VPWR VGND sg13cmos5l_fill_1
* cell instance sg13cmos5l_fill_1_29 r0 *1 0,0
Xsg13cmos5l_fill_1_29 VPWR VGND sg13cmos5l_fill_1
* cell instance sg13cmos5l_fill_1_30 r0 *1 0,0
Xsg13cmos5l_fill_1_30 VPWR VGND sg13cmos5l_fill_1
* cell instance sg13cmos5l_fill_1_31 r0 *1 0,0
Xsg13cmos5l_fill_1_31 VPWR VGND sg13cmos5l_fill_1
* cell instance sg13cmos5l_fill_1_32 r0 *1 0,0
Xsg13cmos5l_fill_1_32 VPWR VGND sg13cmos5l_fill_1
* cell instance sg13cmos5l_fill_1_33 r0 *1 0,0
Xsg13cmos5l_fill_1_33 VPWR VGND sg13cmos5l_fill_1
* cell instance sg13cmos5l_fill_1_34 r0 *1 0,0
Xsg13cmos5l_fill_1_34 VPWR VGND sg13cmos5l_fill_1
* cell instance sg13cmos5l_fill_1_35 r0 *1 0,0
Xsg13cmos5l_fill_1_35 VPWR VGND sg13cmos5l_fill_1
* cell instance sg13cmos5l_fill_1_36 r0 *1 0,0
Xsg13cmos5l_fill_1_36 VPWR VGND sg13cmos5l_fill_1
* cell instance sg13cmos5l_fill_1_37 r0 *1 0,0
Xsg13cmos5l_fill_1_37 VPWR VGND sg13cmos5l_fill_1
* cell instance sg13cmos5l_fill_1_38 r0 *1 0,0
Xsg13cmos5l_fill_1_38 VPWR VGND sg13cmos5l_fill_1
* cell instance sg13cmos5l_fill_1_39 r0 *1 0,0
Xsg13cmos5l_fill_1_39 VPWR VGND sg13cmos5l_fill_1
* cell instance sg13cmos5l_fill_1_40 r0 *1 0,0
Xsg13cmos5l_fill_1_40 VPWR VGND sg13cmos5l_fill_1
* cell instance sg13cmos5l_fill_1_41 r0 *1 0,0
Xsg13cmos5l_fill_1_41 VPWR VGND sg13cmos5l_fill_1
* cell instance sg13cmos5l_fill_1_42 r0 *1 0,0
Xsg13cmos5l_fill_1_42 VPWR VGND sg13cmos5l_fill_1
* cell instance sg13cmos5l_fill_1_43 r0 *1 0,0
Xsg13cmos5l_fill_1_43 VPWR VGND sg13cmos5l_fill_1
* cell instance sg13cmos5l_fill_1_44 r0 *1 0,0
Xsg13cmos5l_fill_1_44 VPWR VGND sg13cmos5l_fill_1
* cell instance sg13cmos5l_fill_1_45 r0 *1 0,0
Xsg13cmos5l_fill_1_45 VPWR VGND sg13cmos5l_fill_1
* cell instance sg13cmos5l_fill_1_46 r0 *1 0,0
Xsg13cmos5l_fill_1_46 VPWR VGND sg13cmos5l_fill_1
* cell instance sg13cmos5l_fill_1_47 r0 *1 0,0
Xsg13cmos5l_fill_1_47 VPWR VGND sg13cmos5l_fill_1
* cell instance sg13cmos5l_fill_1_48 r0 *1 0,0
Xsg13cmos5l_fill_1_48 VPWR VGND sg13cmos5l_fill_1
* cell instance sg13cmos5l_fill_1_49 r0 *1 0,0
Xsg13cmos5l_fill_1_49 VPWR VGND sg13cmos5l_fill_1
* cell instance sg13cmos5l_fill_1_50 r0 *1 0,0
Xsg13cmos5l_fill_1_50 VPWR VGND sg13cmos5l_fill_1
* cell instance sg13cmos5l_fill_1_51 r0 *1 0,0
Xsg13cmos5l_fill_1_51 VPWR VGND sg13cmos5l_fill_1
* cell instance sg13cmos5l_fill_1_52 r0 *1 0,0
Xsg13cmos5l_fill_1_52 VPWR VGND sg13cmos5l_fill_1
* cell instance sg13cmos5l_fill_1_53 r0 *1 0,0
Xsg13cmos5l_fill_1_53 VPWR VGND sg13cmos5l_fill_1
* cell instance sg13cmos5l_fill_1_54 r0 *1 0,0
Xsg13cmos5l_fill_1_54 VPWR VGND sg13cmos5l_fill_1
* cell instance sg13cmos5l_fill_1_55 r0 *1 0,0
Xsg13cmos5l_fill_1_55 VPWR VGND sg13cmos5l_fill_1
* cell instance sg13cmos5l_fill_1_56 r0 *1 0,0
Xsg13cmos5l_fill_1_56 VPWR VGND sg13cmos5l_fill_1
* cell instance sg13cmos5l_fill_1_57 r0 *1 0,0
Xsg13cmos5l_fill_1_57 VPWR VGND sg13cmos5l_fill_1
* cell instance sg13cmos5l_fill_1_58 r0 *1 0,0
Xsg13cmos5l_fill_1_58 VPWR VGND sg13cmos5l_fill_1
* cell instance sg13cmos5l_fill_1_59 r0 *1 0,0
Xsg13cmos5l_fill_1_59 VPWR VGND sg13cmos5l_fill_1
* cell instance sg13cmos5l_fill_1_60 r0 *1 0,0
Xsg13cmos5l_fill_1_60 VPWR VGND sg13cmos5l_fill_1
* cell instance sg13cmos5l_fill_1_61 r0 *1 0,0
Xsg13cmos5l_fill_1_61 VPWR VGND sg13cmos5l_fill_1
* cell instance sg13cmos5l_fill_1_62 r0 *1 0,0
Xsg13cmos5l_fill_1_62 VPWR VGND sg13cmos5l_fill_1
* cell instance sg13cmos5l_fill_1_63 r0 *1 0,0
Xsg13cmos5l_fill_1_63 VPWR VGND sg13cmos5l_fill_1
* cell instance sg13cmos5l_fill_1_64 r0 *1 0,0
Xsg13cmos5l_fill_1_64 VPWR VGND sg13cmos5l_fill_1
* cell instance sg13cmos5l_fill_1_65 r0 *1 0,0
Xsg13cmos5l_fill_1_65 VPWR VGND sg13cmos5l_fill_1
* cell instance sg13cmos5l_fill_1_66 r0 *1 0,0
Xsg13cmos5l_fill_1_66 VPWR VGND sg13cmos5l_fill_1
* cell instance sg13cmos5l_fill_1_67 r0 *1 0,0
Xsg13cmos5l_fill_1_67 VPWR VGND sg13cmos5l_fill_1
* cell instance sg13cmos5l_fill_1_68 r0 *1 0,0
Xsg13cmos5l_fill_1_68 VPWR VGND sg13cmos5l_fill_1
* cell instance sg13cmos5l_fill_1_69 r0 *1 0,0
Xsg13cmos5l_fill_1_69 VPWR VGND sg13cmos5l_fill_1
* cell instance sg13cmos5l_fill_1_70 r0 *1 0,0
Xsg13cmos5l_fill_1_70 VPWR VGND sg13cmos5l_fill_1
* cell instance sg13cmos5l_fill_1_71 r0 *1 0,0
Xsg13cmos5l_fill_1_71 VPWR VGND sg13cmos5l_fill_1
* cell instance sg13cmos5l_fill_1_72 r0 *1 0,0
Xsg13cmos5l_fill_1_72 VPWR VGND sg13cmos5l_fill_1
* cell instance sg13cmos5l_fill_1_73 r0 *1 0,0
Xsg13cmos5l_fill_1_73 VPWR VGND sg13cmos5l_fill_1
* cell instance sg13cmos5l_fill_1_74 r0 *1 0,0
Xsg13cmos5l_fill_1_74 VPWR VGND sg13cmos5l_fill_1
* cell instance sg13cmos5l_fill_1_75 r0 *1 0,0
Xsg13cmos5l_fill_1_75 VPWR VGND sg13cmos5l_fill_1
* cell instance sg13cmos5l_fill_1_76 r0 *1 0,0
Xsg13cmos5l_fill_1_76 VPWR VGND sg13cmos5l_fill_1
* cell instance sg13cmos5l_fill_1_77 r0 *1 0,0
Xsg13cmos5l_fill_1_77 VPWR VGND sg13cmos5l_fill_1
* cell instance sg13cmos5l_fill_1_78 r0 *1 0,0
Xsg13cmos5l_fill_1_78 VPWR VGND sg13cmos5l_fill_1
* cell instance sg13cmos5l_fill_1_79 r0 *1 0,0
Xsg13cmos5l_fill_1_79 VPWR VGND sg13cmos5l_fill_1
* cell instance sg13cmos5l_fill_1_80 r0 *1 0,0
Xsg13cmos5l_fill_1_80 VPWR VGND sg13cmos5l_fill_1
* cell instance sg13cmos5l_fill_1_81 r0 *1 0,0
Xsg13cmos5l_fill_1_81 VPWR VGND sg13cmos5l_fill_1
* cell instance sg13cmos5l_fill_1_82 r0 *1 0,0
Xsg13cmos5l_fill_1_82 VPWR VGND sg13cmos5l_fill_1
* cell instance sg13cmos5l_fill_1_83 r0 *1 0,0
Xsg13cmos5l_fill_1_83 VPWR VGND sg13cmos5l_fill_1
* cell instance sg13cmos5l_fill_1_84 r0 *1 0,0
Xsg13cmos5l_fill_1_84 VPWR VGND sg13cmos5l_fill_1
* cell instance sg13cmos5l_fill_1_85 r0 *1 0,0
Xsg13cmos5l_fill_1_85 VPWR VGND sg13cmos5l_fill_1
* cell instance sg13cmos5l_fill_1_86 r0 *1 0,0
Xsg13cmos5l_fill_1_86 VPWR VGND sg13cmos5l_fill_1
* cell instance sg13cmos5l_fill_1_87 r0 *1 0,0
Xsg13cmos5l_fill_1_87 VPWR VGND sg13cmos5l_fill_1
* cell instance sg13cmos5l_fill_1_88 r0 *1 0,0
Xsg13cmos5l_fill_1_88 VPWR VGND sg13cmos5l_fill_1
* cell instance sg13cmos5l_fill_1_89 r0 *1 0,0
Xsg13cmos5l_fill_1_89 VPWR VGND sg13cmos5l_fill_1
* cell instance sg13cmos5l_fill_1_90 r0 *1 0,0
Xsg13cmos5l_fill_1_90 VPWR VGND sg13cmos5l_fill_1
* cell instance sg13cmos5l_fill_1_91 r0 *1 0,0
Xsg13cmos5l_fill_1_91 VPWR VGND sg13cmos5l_fill_1
* cell instance sg13cmos5l_fill_1_92 r0 *1 0,0
Xsg13cmos5l_fill_1_92 VPWR VGND sg13cmos5l_fill_1
* cell instance sg13cmos5l_fill_1_93 r0 *1 0,0
Xsg13cmos5l_fill_1_93 VPWR VGND sg13cmos5l_fill_1
* cell instance sg13cmos5l_fill_1_94 r0 *1 0,0
Xsg13cmos5l_fill_1_94 VPWR VGND sg13cmos5l_fill_1
* cell instance sg13cmos5l_fill_1_95 r0 *1 0,0
Xsg13cmos5l_fill_1_95 VPWR VGND sg13cmos5l_fill_1
* cell instance sg13cmos5l_fill_1_96 r0 *1 0,0
Xsg13cmos5l_fill_1_96 VPWR VGND sg13cmos5l_fill_1
* cell instance sg13cmos5l_fill_1_97 r0 *1 0,0
Xsg13cmos5l_fill_1_97 VPWR VGND sg13cmos5l_fill_1
* cell instance sg13cmos5l_fill_1_98 r0 *1 0,0
Xsg13cmos5l_fill_1_98 VPWR VGND sg13cmos5l_fill_1
* cell instance sg13cmos5l_fill_1_99 r0 *1 0,0
Xsg13cmos5l_fill_1_99 VPWR VGND sg13cmos5l_fill_1
* cell instance sg13cmos5l_fill_1_100 r0 *1 0,0
Xsg13cmos5l_fill_1_100 VPWR VGND sg13cmos5l_fill_1
* cell instance sg13cmos5l_fill_1_101 r0 *1 0,0
Xsg13cmos5l_fill_1_101 VPWR VGND sg13cmos5l_fill_1
* cell instance sg13cmos5l_fill_1_102 r0 *1 0,0
Xsg13cmos5l_fill_1_102 VPWR VGND sg13cmos5l_fill_1
* cell instance sg13cmos5l_fill_1_103 r0 *1 0,0
Xsg13cmos5l_fill_1_103 VPWR VGND sg13cmos5l_fill_1
* cell instance sg13cmos5l_fill_1_104 r0 *1 0,0
Xsg13cmos5l_fill_1_104 VPWR VGND sg13cmos5l_fill_1
* cell instance sg13cmos5l_fill_1_105 r0 *1 0,0
Xsg13cmos5l_fill_1_105 VPWR VGND sg13cmos5l_fill_1
* cell instance sg13cmos5l_fill_1_106 r0 *1 0,0
Xsg13cmos5l_fill_1_106 VPWR VGND sg13cmos5l_fill_1
* cell instance sg13cmos5l_fill_1_107 r0 *1 0,0
Xsg13cmos5l_fill_1_107 VPWR VGND sg13cmos5l_fill_1
* cell instance sg13cmos5l_fill_1_108 r0 *1 0,0
Xsg13cmos5l_fill_1_108 VPWR VGND sg13cmos5l_fill_1
* cell instance sg13cmos5l_fill_1_109 r0 *1 0,0
Xsg13cmos5l_fill_1_109 VPWR VGND sg13cmos5l_fill_1
* cell instance sg13cmos5l_fill_1_110 r0 *1 0,0
Xsg13cmos5l_fill_1_110 VPWR VGND sg13cmos5l_fill_1
* cell instance sg13cmos5l_fill_1_111 r0 *1 0,0
Xsg13cmos5l_fill_1_111 VPWR VGND sg13cmos5l_fill_1
* cell instance sg13cmos5l_fill_1_112 r0 *1 0,0
Xsg13cmos5l_fill_1_112 VPWR VGND sg13cmos5l_fill_1
* cell instance sg13cmos5l_fill_1_113 r0 *1 0,0
Xsg13cmos5l_fill_1_113 VPWR VGND sg13cmos5l_fill_1
* cell instance sg13cmos5l_fill_1_114 r0 *1 0,0
Xsg13cmos5l_fill_1_114 VPWR VGND sg13cmos5l_fill_1
* cell instance sg13cmos5l_fill_1_115 r0 *1 0,0
Xsg13cmos5l_fill_1_115 VPWR VGND sg13cmos5l_fill_1
* cell instance sg13cmos5l_fill_1_116 r0 *1 0,0
Xsg13cmos5l_fill_1_116 VPWR VGND sg13cmos5l_fill_1
* cell instance sg13cmos5l_fill_1_117 r0 *1 0,0
Xsg13cmos5l_fill_1_117 VPWR VGND sg13cmos5l_fill_1
* cell instance sg13cmos5l_fill_1_118 r0 *1 0,0
Xsg13cmos5l_fill_1_118 VPWR VGND sg13cmos5l_fill_1
* cell instance sg13cmos5l_fill_1_119 r0 *1 0,0
Xsg13cmos5l_fill_1_119 VPWR VGND sg13cmos5l_fill_1
* cell instance sg13cmos5l_fill_1_120 r0 *1 0,0
Xsg13cmos5l_fill_1_120 VPWR VGND sg13cmos5l_fill_1
* cell instance sg13cmos5l_fill_1_121 r0 *1 0,0
Xsg13cmos5l_fill_1_121 VPWR VGND sg13cmos5l_fill_1
* cell instance sg13cmos5l_fill_1_122 r0 *1 0,0
Xsg13cmos5l_fill_1_122 VPWR VGND sg13cmos5l_fill_1
* cell instance sg13cmos5l_fill_1_123 r0 *1 0,0
Xsg13cmos5l_fill_1_123 VPWR VGND sg13cmos5l_fill_1
* cell instance sg13cmos5l_fill_1_124 r0 *1 0,0
Xsg13cmos5l_fill_1_124 VPWR VGND sg13cmos5l_fill_1
* cell instance sg13cmos5l_fill_1_125 r0 *1 0,0
Xsg13cmos5l_fill_1_125 VPWR VGND sg13cmos5l_fill_1
* cell instance sg13cmos5l_fill_1_126 r0 *1 0,0
Xsg13cmos5l_fill_1_126 VPWR VGND sg13cmos5l_fill_1
* cell instance sg13cmos5l_fill_1_127 r0 *1 0,0
Xsg13cmos5l_fill_1_127 VPWR VGND sg13cmos5l_fill_1
* cell instance sg13cmos5l_fill_1_128 r0 *1 0,0
Xsg13cmos5l_fill_1_128 VPWR VGND sg13cmos5l_fill_1
* cell instance sg13cmos5l_fill_1_129 r0 *1 0,0
Xsg13cmos5l_fill_1_129 VPWR VGND sg13cmos5l_fill_1
* cell instance sg13cmos5l_fill_1_130 r0 *1 0,0
Xsg13cmos5l_fill_1_130 VPWR VGND sg13cmos5l_fill_1
* cell instance sg13cmos5l_fill_1_131 r0 *1 0,0
Xsg13cmos5l_fill_1_131 VPWR VGND sg13cmos5l_fill_1
* cell instance sg13cmos5l_fill_1_132 r0 *1 0,0
Xsg13cmos5l_fill_1_132 VPWR VGND sg13cmos5l_fill_1
* cell instance sg13cmos5l_fill_1_133 r0 *1 0,0
Xsg13cmos5l_fill_1_133 VPWR VGND sg13cmos5l_fill_1
* cell instance sg13cmos5l_fill_1_134 r0 *1 0,0
Xsg13cmos5l_fill_1_134 VPWR VGND sg13cmos5l_fill_1
* cell instance sg13cmos5l_fill_1_135 r0 *1 0,0
Xsg13cmos5l_fill_1_135 VPWR VGND sg13cmos5l_fill_1
* cell instance sg13cmos5l_fill_1_136 r0 *1 0,0
Xsg13cmos5l_fill_1_136 VPWR VGND sg13cmos5l_fill_1
* cell instance sg13cmos5l_fill_1_137 r0 *1 0,0
Xsg13cmos5l_fill_1_137 VPWR VGND sg13cmos5l_fill_1
* cell instance sg13cmos5l_fill_1_138 r0 *1 0,0
Xsg13cmos5l_fill_1_138 VPWR VGND sg13cmos5l_fill_1
* cell instance sg13cmos5l_fill_1_139 r0 *1 0,0
Xsg13cmos5l_fill_1_139 VPWR VGND sg13cmos5l_fill_1
* cell instance sg13cmos5l_fill_1_140 r0 *1 0,0
Xsg13cmos5l_fill_1_140 VPWR VGND sg13cmos5l_fill_1
* cell instance sg13cmos5l_fill_1_141 r0 *1 0,0
Xsg13cmos5l_fill_1_141 VPWR VGND sg13cmos5l_fill_1
* cell instance sg13cmos5l_fill_1_142 r0 *1 0,0
Xsg13cmos5l_fill_1_142 VPWR VGND sg13cmos5l_fill_1
* cell instance sg13cmos5l_fill_1_143 r0 *1 0,0
Xsg13cmos5l_fill_1_143 VPWR VGND sg13cmos5l_fill_1
* cell instance sg13cmos5l_fill_1_144 r0 *1 0,0
Xsg13cmos5l_fill_1_144 VPWR VGND sg13cmos5l_fill_1
* cell instance sg13cmos5l_fill_1_145 r0 *1 0,0
Xsg13cmos5l_fill_1_145 VPWR VGND sg13cmos5l_fill_1
* cell instance sg13cmos5l_fill_1_146 r0 *1 0,0
Xsg13cmos5l_fill_1_146 VPWR VGND sg13cmos5l_fill_1
* cell instance sg13cmos5l_fill_1_147 r0 *1 0,0
Xsg13cmos5l_fill_1_147 VPWR VGND sg13cmos5l_fill_1
* cell instance sg13cmos5l_fill_1_148 r0 *1 0,0
Xsg13cmos5l_fill_1_148 VPWR VGND sg13cmos5l_fill_1
* cell instance sg13cmos5l_fill_1_149 r0 *1 0,0
Xsg13cmos5l_fill_1_149 VPWR VGND sg13cmos5l_fill_1
* cell instance sg13cmos5l_fill_1_150 r0 *1 0,0
Xsg13cmos5l_fill_1_150 VPWR VGND sg13cmos5l_fill_1
* cell instance sg13cmos5l_fill_1_151 r0 *1 0,0
Xsg13cmos5l_fill_1_151 VPWR VGND sg13cmos5l_fill_1
* cell instance sg13cmos5l_fill_1_152 r0 *1 0,0
Xsg13cmos5l_fill_1_152 VPWR VGND sg13cmos5l_fill_1
* cell instance sg13cmos5l_fill_1_153 r0 *1 0,0
Xsg13cmos5l_fill_1_153 VPWR VGND sg13cmos5l_fill_1
* cell instance sg13cmos5l_fill_1_154 r0 *1 0,0
Xsg13cmos5l_fill_1_154 VPWR VGND sg13cmos5l_fill_1
* cell instance sg13cmos5l_fill_1_155 r0 *1 0,0
Xsg13cmos5l_fill_1_155 VPWR VGND sg13cmos5l_fill_1
* cell instance sg13cmos5l_fill_1_156 r0 *1 0,0
Xsg13cmos5l_fill_1_156 VPWR VGND sg13cmos5l_fill_1
* cell instance sg13cmos5l_fill_1_157 r0 *1 0,0
Xsg13cmos5l_fill_1_157 VPWR VGND sg13cmos5l_fill_1
* cell instance sg13cmos5l_fill_1_158 r0 *1 0,0
Xsg13cmos5l_fill_1_158 VPWR VGND sg13cmos5l_fill_1
* cell instance sg13cmos5l_fill_1_159 r0 *1 0,0
Xsg13cmos5l_fill_1_159 VPWR VGND sg13cmos5l_fill_1
* cell instance sg13cmos5l_fill_1_160 r0 *1 0,0
Xsg13cmos5l_fill_1_160 VPWR VGND sg13cmos5l_fill_1
* cell instance sg13cmos5l_fill_1_161 r0 *1 0,0
Xsg13cmos5l_fill_1_161 VPWR VGND sg13cmos5l_fill_1
* cell instance sg13cmos5l_fill_1_162 r0 *1 0,0
Xsg13cmos5l_fill_1_162 VPWR VGND sg13cmos5l_fill_1
* cell instance sg13cmos5l_fill_1_163 r0 *1 0,0
Xsg13cmos5l_fill_1_163 VPWR VGND sg13cmos5l_fill_1
* cell instance sg13cmos5l_fill_1_164 r0 *1 0,0
Xsg13cmos5l_fill_1_164 VPWR VGND sg13cmos5l_fill_1
* cell instance sg13cmos5l_fill_1_165 r0 *1 0,0
Xsg13cmos5l_fill_1_165 VPWR VGND sg13cmos5l_fill_1
* cell instance sg13cmos5l_fill_1_166 r0 *1 0,0
Xsg13cmos5l_fill_1_166 VPWR VGND sg13cmos5l_fill_1
* cell instance sg13cmos5l_fill_1_167 r0 *1 0,0
Xsg13cmos5l_fill_1_167 VPWR VGND sg13cmos5l_fill_1
* cell instance sg13cmos5l_fill_1_168 r0 *1 0,0
Xsg13cmos5l_fill_1_168 VPWR VGND sg13cmos5l_fill_1
* cell instance sg13cmos5l_fill_1_169 r0 *1 0,0
Xsg13cmos5l_fill_1_169 VPWR VGND sg13cmos5l_fill_1
* cell instance sg13cmos5l_fill_1_170 r0 *1 0,0
Xsg13cmos5l_fill_1_170 VPWR VGND sg13cmos5l_fill_1
* cell instance sg13cmos5l_fill_1_171 r0 *1 0,0
Xsg13cmos5l_fill_1_171 VPWR VGND sg13cmos5l_fill_1
* cell instance sg13cmos5l_fill_1_172 r0 *1 0,0
Xsg13cmos5l_fill_1_172 VPWR VGND sg13cmos5l_fill_1
* cell instance sg13cmos5l_fill_1_173 r0 *1 0,0
Xsg13cmos5l_fill_1_173 VPWR VGND sg13cmos5l_fill_1
* cell instance sg13cmos5l_fill_1_174 r0 *1 0,0
Xsg13cmos5l_fill_1_174 VPWR VGND sg13cmos5l_fill_1
* cell instance sg13cmos5l_fill_1_175 r0 *1 0,0
Xsg13cmos5l_fill_1_175 VPWR VGND sg13cmos5l_fill_1
* cell instance sg13cmos5l_fill_1_176 r0 *1 0,0
Xsg13cmos5l_fill_1_176 VPWR VGND sg13cmos5l_fill_1
* cell instance sg13cmos5l_fill_1_177 r0 *1 0,0
Xsg13cmos5l_fill_1_177 VPWR VGND sg13cmos5l_fill_1
* cell instance sg13cmos5l_fill_1_178 r0 *1 0,0
Xsg13cmos5l_fill_1_178 VPWR VGND sg13cmos5l_fill_1
* cell instance sg13cmos5l_fill_1_179 r0 *1 0,0
Xsg13cmos5l_fill_1_179 VPWR VGND sg13cmos5l_fill_1
* cell instance sg13cmos5l_fill_1_180 r0 *1 0,0
Xsg13cmos5l_fill_1_180 VPWR VGND sg13cmos5l_fill_1
* cell instance sg13cmos5l_fill_1_181 r0 *1 0,0
Xsg13cmos5l_fill_1_181 VPWR VGND sg13cmos5l_fill_1
* cell instance sg13cmos5l_fill_1_182 r0 *1 0,0
Xsg13cmos5l_fill_1_182 VPWR VGND sg13cmos5l_fill_1
* cell instance sg13cmos5l_fill_1_183 r0 *1 0,0
Xsg13cmos5l_fill_1_183 VPWR VGND sg13cmos5l_fill_1
* cell instance sg13cmos5l_fill_1_184 r0 *1 0,0
Xsg13cmos5l_fill_1_184 VPWR VGND sg13cmos5l_fill_1
* cell instance sg13cmos5l_fill_1_185 r0 *1 0,0
Xsg13cmos5l_fill_1_185 VPWR VGND sg13cmos5l_fill_1
* cell instance sg13cmos5l_fill_1_186 r0 *1 0,0
Xsg13cmos5l_fill_1_186 VPWR VGND sg13cmos5l_fill_1
* cell instance sg13cmos5l_fill_1_187 r0 *1 0,0
Xsg13cmos5l_fill_1_187 VPWR VGND sg13cmos5l_fill_1
* cell instance sg13cmos5l_fill_1_188 r0 *1 0,0
Xsg13cmos5l_fill_1_188 VPWR VGND sg13cmos5l_fill_1
* cell instance sg13cmos5l_fill_1_189 r0 *1 0,0
Xsg13cmos5l_fill_1_189 VPWR VGND sg13cmos5l_fill_1
* cell instance sg13cmos5l_fill_1_190 r0 *1 0,0
Xsg13cmos5l_fill_1_190 VPWR VGND sg13cmos5l_fill_1
* cell instance sg13cmos5l_fill_1_191 r0 *1 0,0
Xsg13cmos5l_fill_1_191 VPWR VGND sg13cmos5l_fill_1
* cell instance sg13cmos5l_fill_1_192 r0 *1 0,0
Xsg13cmos5l_fill_1_192 VPWR VGND sg13cmos5l_fill_1
* cell instance sg13cmos5l_fill_1_193 r0 *1 0,0
Xsg13cmos5l_fill_1_193 VPWR VGND sg13cmos5l_fill_1
* cell instance sg13cmos5l_fill_1_194 r0 *1 0,0
Xsg13cmos5l_fill_1_194 VPWR VGND sg13cmos5l_fill_1
* cell instance sg13cmos5l_fill_1_195 r0 *1 0,0
Xsg13cmos5l_fill_1_195 VPWR VGND sg13cmos5l_fill_1
* cell instance sg13cmos5l_fill_1_196 r0 *1 0,0
Xsg13cmos5l_fill_1_196 VPWR VGND sg13cmos5l_fill_1
* cell instance sg13cmos5l_fill_1_197 r0 *1 0,0
Xsg13cmos5l_fill_1_197 VPWR VGND sg13cmos5l_fill_1
* cell instance sg13cmos5l_fill_1_198 r0 *1 0,0
Xsg13cmos5l_fill_1_198 VPWR VGND sg13cmos5l_fill_1
* cell instance sg13cmos5l_fill_1_199 r0 *1 0,0
Xsg13cmos5l_fill_1_199 VPWR VGND sg13cmos5l_fill_1
* cell instance sg13cmos5l_fill_1_200 r0 *1 0,0
Xsg13cmos5l_fill_1_200 VPWR VGND sg13cmos5l_fill_1
* cell instance sg13cmos5l_fill_1_201 r0 *1 0,0
Xsg13cmos5l_fill_1_201 VPWR VGND sg13cmos5l_fill_1
* cell instance sg13cmos5l_fill_1_202 r0 *1 0,0
Xsg13cmos5l_fill_1_202 VPWR VGND sg13cmos5l_fill_1
* cell instance sg13cmos5l_fill_1_203 r0 *1 0,0
Xsg13cmos5l_fill_1_203 VPWR VGND sg13cmos5l_fill_1
* cell instance sg13cmos5l_fill_1_204 r0 *1 0,0
Xsg13cmos5l_fill_1_204 VPWR VGND sg13cmos5l_fill_1
* cell instance sg13cmos5l_fill_1_205 r0 *1 0,0
Xsg13cmos5l_fill_1_205 VPWR VGND sg13cmos5l_fill_1
* cell instance sg13cmos5l_fill_1_206 r0 *1 0,0
Xsg13cmos5l_fill_1_206 VPWR VGND sg13cmos5l_fill_1
* cell instance sg13cmos5l_fill_1_207 r0 *1 0,0
Xsg13cmos5l_fill_1_207 VPWR VGND sg13cmos5l_fill_1
* cell instance sg13cmos5l_fill_1_208 r0 *1 0,0
Xsg13cmos5l_fill_1_208 VPWR VGND sg13cmos5l_fill_1
* cell instance sg13cmos5l_fill_1_209 r0 *1 0,0
Xsg13cmos5l_fill_1_209 VPWR VGND sg13cmos5l_fill_1
* cell instance sg13cmos5l_fill_1_210 r0 *1 0,0
Xsg13cmos5l_fill_1_210 VPWR VGND sg13cmos5l_fill_1
* cell instance sg13cmos5l_fill_1_211 r0 *1 0,0
Xsg13cmos5l_fill_1_211 VPWR VGND sg13cmos5l_fill_1
* cell instance sg13cmos5l_fill_1_212 r0 *1 0,0
Xsg13cmos5l_fill_1_212 VPWR VGND sg13cmos5l_fill_1
* cell instance sg13cmos5l_fill_1_213 r0 *1 0,0
Xsg13cmos5l_fill_1_213 VPWR VGND sg13cmos5l_fill_1
* cell instance sg13cmos5l_fill_1_214 r0 *1 0,0
Xsg13cmos5l_fill_1_214 VPWR VGND sg13cmos5l_fill_1
* cell instance sg13cmos5l_fill_1_215 r0 *1 0,0
Xsg13cmos5l_fill_1_215 VPWR VGND sg13cmos5l_fill_1
* cell instance sg13cmos5l_fill_1_216 r0 *1 0,0
Xsg13cmos5l_fill_1_216 VPWR VGND sg13cmos5l_fill_1
* cell instance sg13cmos5l_fill_1_217 r0 *1 0,0
Xsg13cmos5l_fill_1_217 VPWR VGND sg13cmos5l_fill_1
* cell instance sg13cmos5l_fill_1_218 r0 *1 0,0
Xsg13cmos5l_fill_1_218 VPWR VGND sg13cmos5l_fill_1
* cell instance sg13cmos5l_fill_1_219 r0 *1 0,0
Xsg13cmos5l_fill_1_219 VPWR VGND sg13cmos5l_fill_1
* cell instance sg13cmos5l_fill_1_220 r0 *1 0,0
Xsg13cmos5l_fill_1_220 VPWR VGND sg13cmos5l_fill_1
* cell instance sg13cmos5l_fill_2_0 r0 *1 0,0
Xsg13cmos5l_fill_2_0 VPWR VGND sg13cmos5l_fill_2
* cell instance sg13cmos5l_fill_2_1 r0 *1 0,0
Xsg13cmos5l_fill_2_1 VPWR VGND sg13cmos5l_fill_2
* cell instance sg13cmos5l_fill_2_2 r0 *1 0,0
Xsg13cmos5l_fill_2_2 VPWR VGND sg13cmos5l_fill_2
* cell instance sg13cmos5l_fill_2_3 r0 *1 0,0
Xsg13cmos5l_fill_2_3 VPWR VGND sg13cmos5l_fill_2
* cell instance sg13cmos5l_fill_2_4 r0 *1 0,0
Xsg13cmos5l_fill_2_4 VPWR VGND sg13cmos5l_fill_2
* cell instance sg13cmos5l_fill_2_5 r0 *1 0,0
Xsg13cmos5l_fill_2_5 VPWR VGND sg13cmos5l_fill_2
* cell instance sg13cmos5l_fill_2_6 r0 *1 0,0
Xsg13cmos5l_fill_2_6 VPWR VGND sg13cmos5l_fill_2
* cell instance sg13cmos5l_fill_2_7 r0 *1 0,0
Xsg13cmos5l_fill_2_7 VPWR VGND sg13cmos5l_fill_2
* cell instance sg13cmos5l_fill_2_8 r0 *1 0,0
Xsg13cmos5l_fill_2_8 VPWR VGND sg13cmos5l_fill_2
* cell instance sg13cmos5l_fill_2_9 r0 *1 0,0
Xsg13cmos5l_fill_2_9 VPWR VGND sg13cmos5l_fill_2
* cell instance sg13cmos5l_fill_2_10 r0 *1 0,0
Xsg13cmos5l_fill_2_10 VPWR VGND sg13cmos5l_fill_2
* cell instance sg13cmos5l_fill_2_11 r0 *1 0,0
Xsg13cmos5l_fill_2_11 VPWR VGND sg13cmos5l_fill_2
* cell instance sg13cmos5l_fill_2_12 r0 *1 0,0
Xsg13cmos5l_fill_2_12 VPWR VGND sg13cmos5l_fill_2
* cell instance sg13cmos5l_fill_2_13 r0 *1 0,0
Xsg13cmos5l_fill_2_13 VPWR VGND sg13cmos5l_fill_2
* cell instance sg13cmos5l_fill_2_14 r0 *1 0,0
Xsg13cmos5l_fill_2_14 VPWR VGND sg13cmos5l_fill_2
* cell instance sg13cmos5l_fill_2_15 r0 *1 0,0
Xsg13cmos5l_fill_2_15 VPWR VGND sg13cmos5l_fill_2
* cell instance sg13cmos5l_fill_2_16 r0 *1 0,0
Xsg13cmos5l_fill_2_16 VPWR VGND sg13cmos5l_fill_2
* cell instance sg13cmos5l_fill_2_17 r0 *1 0,0
Xsg13cmos5l_fill_2_17 VPWR VGND sg13cmos5l_fill_2
* cell instance sg13cmos5l_fill_2_18 r0 *1 0,0
Xsg13cmos5l_fill_2_18 VPWR VGND sg13cmos5l_fill_2
* cell instance sg13cmos5l_fill_2_19 r0 *1 0,0
Xsg13cmos5l_fill_2_19 VPWR VGND sg13cmos5l_fill_2
* cell instance sg13cmos5l_fill_2_20 r0 *1 0,0
Xsg13cmos5l_fill_2_20 VPWR VGND sg13cmos5l_fill_2
* cell instance sg13cmos5l_fill_2_21 r0 *1 0,0
Xsg13cmos5l_fill_2_21 VPWR VGND sg13cmos5l_fill_2
* cell instance sg13cmos5l_fill_2_22 r0 *1 0,0
Xsg13cmos5l_fill_2_22 VPWR VGND sg13cmos5l_fill_2
* cell instance sg13cmos5l_fill_2_23 r0 *1 0,0
Xsg13cmos5l_fill_2_23 VPWR VGND sg13cmos5l_fill_2
* cell instance sg13cmos5l_fill_2_24 r0 *1 0,0
Xsg13cmos5l_fill_2_24 VPWR VGND sg13cmos5l_fill_2
* cell instance sg13cmos5l_fill_2_25 r0 *1 0,0
Xsg13cmos5l_fill_2_25 VPWR VGND sg13cmos5l_fill_2
* cell instance sg13cmos5l_fill_2_26 r0 *1 0,0
Xsg13cmos5l_fill_2_26 VPWR VGND sg13cmos5l_fill_2
* cell instance sg13cmos5l_fill_2_27 r0 *1 0,0
Xsg13cmos5l_fill_2_27 VPWR VGND sg13cmos5l_fill_2
* cell instance sg13cmos5l_fill_2_28 r0 *1 0,0
Xsg13cmos5l_fill_2_28 VPWR VGND sg13cmos5l_fill_2
* cell instance sg13cmos5l_fill_2_29 r0 *1 0,0
Xsg13cmos5l_fill_2_29 VPWR VGND sg13cmos5l_fill_2
* cell instance sg13cmos5l_fill_2_30 r0 *1 0,0
Xsg13cmos5l_fill_2_30 VPWR VGND sg13cmos5l_fill_2
* cell instance sg13cmos5l_fill_2_31 r0 *1 0,0
Xsg13cmos5l_fill_2_31 VPWR VGND sg13cmos5l_fill_2
* cell instance sg13cmos5l_fill_2_32 r0 *1 0,0
Xsg13cmos5l_fill_2_32 VPWR VGND sg13cmos5l_fill_2
* cell instance sg13cmos5l_fill_2_33 r0 *1 0,0
Xsg13cmos5l_fill_2_33 VPWR VGND sg13cmos5l_fill_2
* cell instance sg13cmos5l_fill_2_34 r0 *1 0,0
Xsg13cmos5l_fill_2_34 VPWR VGND sg13cmos5l_fill_2
* cell instance sg13cmos5l_fill_2_35 r0 *1 0,0
Xsg13cmos5l_fill_2_35 VPWR VGND sg13cmos5l_fill_2
* cell instance sg13cmos5l_fill_2_36 r0 *1 0,0
Xsg13cmos5l_fill_2_36 VPWR VGND sg13cmos5l_fill_2
* cell instance sg13cmos5l_fill_2_37 r0 *1 0,0
Xsg13cmos5l_fill_2_37 VPWR VGND sg13cmos5l_fill_2
* cell instance sg13cmos5l_fill_2_38 r0 *1 0,0
Xsg13cmos5l_fill_2_38 VPWR VGND sg13cmos5l_fill_2
* cell instance sg13cmos5l_fill_2_39 r0 *1 0,0
Xsg13cmos5l_fill_2_39 VPWR VGND sg13cmos5l_fill_2
* cell instance sg13cmos5l_fill_2_40 r0 *1 0,0
Xsg13cmos5l_fill_2_40 VPWR VGND sg13cmos5l_fill_2
* cell instance sg13cmos5l_fill_2_41 r0 *1 0,0
Xsg13cmos5l_fill_2_41 VPWR VGND sg13cmos5l_fill_2
* cell instance sg13cmos5l_fill_2_42 r0 *1 0,0
Xsg13cmos5l_fill_2_42 VPWR VGND sg13cmos5l_fill_2
* cell instance sg13cmos5l_fill_2_43 r0 *1 0,0
Xsg13cmos5l_fill_2_43 VPWR VGND sg13cmos5l_fill_2
* cell instance sg13cmos5l_fill_2_44 r0 *1 0,0
Xsg13cmos5l_fill_2_44 VPWR VGND sg13cmos5l_fill_2
* cell instance sg13cmos5l_fill_2_45 r0 *1 0,0
Xsg13cmos5l_fill_2_45 VPWR VGND sg13cmos5l_fill_2
* cell instance sg13cmos5l_fill_2_46 r0 *1 0,0
Xsg13cmos5l_fill_2_46 VPWR VGND sg13cmos5l_fill_2
* cell instance sg13cmos5l_fill_2_47 r0 *1 0,0
Xsg13cmos5l_fill_2_47 VPWR VGND sg13cmos5l_fill_2
* cell instance sg13cmos5l_fill_2_48 r0 *1 0,0
Xsg13cmos5l_fill_2_48 VPWR VGND sg13cmos5l_fill_2
* cell instance sg13cmos5l_fill_2_49 r0 *1 0,0
Xsg13cmos5l_fill_2_49 VPWR VGND sg13cmos5l_fill_2
* cell instance sg13cmos5l_fill_2_50 r0 *1 0,0
Xsg13cmos5l_fill_2_50 VPWR VGND sg13cmos5l_fill_2
* cell instance sg13cmos5l_fill_2_51 r0 *1 0,0
Xsg13cmos5l_fill_2_51 VPWR VGND sg13cmos5l_fill_2
* cell instance sg13cmos5l_fill_2_52 r0 *1 0,0
Xsg13cmos5l_fill_2_52 VPWR VGND sg13cmos5l_fill_2
* cell instance sg13cmos5l_fill_2_53 r0 *1 0,0
Xsg13cmos5l_fill_2_53 VPWR VGND sg13cmos5l_fill_2
* cell instance sg13cmos5l_fill_2_54 r0 *1 0,0
Xsg13cmos5l_fill_2_54 VPWR VGND sg13cmos5l_fill_2
* cell instance sg13cmos5l_fill_2_55 r0 *1 0,0
Xsg13cmos5l_fill_2_55 VPWR VGND sg13cmos5l_fill_2
* cell instance sg13cmos5l_fill_2_56 r0 *1 0,0
Xsg13cmos5l_fill_2_56 VPWR VGND sg13cmos5l_fill_2
* cell instance sg13cmos5l_fill_2_57 r0 *1 0,0
Xsg13cmos5l_fill_2_57 VPWR VGND sg13cmos5l_fill_2
* cell instance sg13cmos5l_fill_2_58 r0 *1 0,0
Xsg13cmos5l_fill_2_58 VPWR VGND sg13cmos5l_fill_2
* cell instance sg13cmos5l_fill_2_59 r0 *1 0,0
Xsg13cmos5l_fill_2_59 VPWR VGND sg13cmos5l_fill_2
* cell instance sg13cmos5l_fill_2_60 r0 *1 0,0
Xsg13cmos5l_fill_2_60 VPWR VGND sg13cmos5l_fill_2
* cell instance sg13cmos5l_fill_2_61 r0 *1 0,0
Xsg13cmos5l_fill_2_61 VPWR VGND sg13cmos5l_fill_2
* cell instance sg13cmos5l_fill_2_62 r0 *1 0,0
Xsg13cmos5l_fill_2_62 VPWR VGND sg13cmos5l_fill_2
* cell instance sg13cmos5l_fill_2_63 r0 *1 0,0
Xsg13cmos5l_fill_2_63 VPWR VGND sg13cmos5l_fill_2
* cell instance sg13cmos5l_fill_2_64 r0 *1 0,0
Xsg13cmos5l_fill_2_64 VPWR VGND sg13cmos5l_fill_2
* cell instance sg13cmos5l_fill_2_65 r0 *1 0,0
Xsg13cmos5l_fill_2_65 VPWR VGND sg13cmos5l_fill_2
* cell instance sg13cmos5l_fill_2_66 r0 *1 0,0
Xsg13cmos5l_fill_2_66 VPWR VGND sg13cmos5l_fill_2
* cell instance sg13cmos5l_fill_2_67 r0 *1 0,0
Xsg13cmos5l_fill_2_67 VPWR VGND sg13cmos5l_fill_2
* cell instance sg13cmos5l_fill_2_68 r0 *1 0,0
Xsg13cmos5l_fill_2_68 VPWR VGND sg13cmos5l_fill_2
* cell instance sg13cmos5l_fill_2_69 r0 *1 0,0
Xsg13cmos5l_fill_2_69 VPWR VGND sg13cmos5l_fill_2
* cell instance sg13cmos5l_fill_2_70 r0 *1 0,0
Xsg13cmos5l_fill_2_70 VPWR VGND sg13cmos5l_fill_2
* cell instance sg13cmos5l_fill_2_71 r0 *1 0,0
Xsg13cmos5l_fill_2_71 VPWR VGND sg13cmos5l_fill_2
* cell instance sg13cmos5l_fill_2_72 r0 *1 0,0
Xsg13cmos5l_fill_2_72 VPWR VGND sg13cmos5l_fill_2
* cell instance sg13cmos5l_fill_2_73 r0 *1 0,0
Xsg13cmos5l_fill_2_73 VPWR VGND sg13cmos5l_fill_2
* cell instance sg13cmos5l_fill_2_74 r0 *1 0,0
Xsg13cmos5l_fill_2_74 VPWR VGND sg13cmos5l_fill_2
* cell instance sg13cmos5l_fill_2_75 r0 *1 0,0
Xsg13cmos5l_fill_2_75 VPWR VGND sg13cmos5l_fill_2
* cell instance sg13cmos5l_fill_2_76 r0 *1 0,0
Xsg13cmos5l_fill_2_76 VPWR VGND sg13cmos5l_fill_2
* cell instance sg13cmos5l_fill_2_77 r0 *1 0,0
Xsg13cmos5l_fill_2_77 VPWR VGND sg13cmos5l_fill_2
* cell instance sg13cmos5l_fill_2_78 r0 *1 0,0
Xsg13cmos5l_fill_2_78 VPWR VGND sg13cmos5l_fill_2
* cell instance sg13cmos5l_fill_2_79 r0 *1 0,0
Xsg13cmos5l_fill_2_79 VPWR VGND sg13cmos5l_fill_2
* cell instance sg13cmos5l_fill_2_80 r0 *1 0,0
Xsg13cmos5l_fill_2_80 VPWR VGND sg13cmos5l_fill_2
* cell instance sg13cmos5l_fill_2_81 r0 *1 0,0
Xsg13cmos5l_fill_2_81 VPWR VGND sg13cmos5l_fill_2
* cell instance sg13cmos5l_fill_2_82 r0 *1 0,0
Xsg13cmos5l_fill_2_82 VPWR VGND sg13cmos5l_fill_2
* cell instance sg13cmos5l_fill_2_83 r0 *1 0,0
Xsg13cmos5l_fill_2_83 VPWR VGND sg13cmos5l_fill_2
* cell instance sg13cmos5l_fill_2_84 r0 *1 0,0
Xsg13cmos5l_fill_2_84 VPWR VGND sg13cmos5l_fill_2
* cell instance sg13cmos5l_fill_2_85 r0 *1 0,0
Xsg13cmos5l_fill_2_85 VPWR VGND sg13cmos5l_fill_2
* cell instance sg13cmos5l_fill_2_86 r0 *1 0,0
Xsg13cmos5l_fill_2_86 VPWR VGND sg13cmos5l_fill_2
* cell instance sg13cmos5l_fill_2_87 r0 *1 0,0
Xsg13cmos5l_fill_2_87 VPWR VGND sg13cmos5l_fill_2
* cell instance sg13cmos5l_fill_2_88 r0 *1 0,0
Xsg13cmos5l_fill_2_88 VPWR VGND sg13cmos5l_fill_2
* cell instance sg13cmos5l_fill_2_89 r0 *1 0,0
Xsg13cmos5l_fill_2_89 VPWR VGND sg13cmos5l_fill_2
* cell instance sg13cmos5l_fill_2_90 r0 *1 0,0
Xsg13cmos5l_fill_2_90 VPWR VGND sg13cmos5l_fill_2
* cell instance sg13cmos5l_fill_2_91 r0 *1 0,0
Xsg13cmos5l_fill_2_91 VPWR VGND sg13cmos5l_fill_2
* cell instance sg13cmos5l_fill_2_92 r0 *1 0,0
Xsg13cmos5l_fill_2_92 VPWR VGND sg13cmos5l_fill_2
* cell instance sg13cmos5l_fill_2_93 r0 *1 0,0
Xsg13cmos5l_fill_2_93 VPWR VGND sg13cmos5l_fill_2
* cell instance sg13cmos5l_fill_2_94 r0 *1 0,0
Xsg13cmos5l_fill_2_94 VPWR VGND sg13cmos5l_fill_2
* cell instance sg13cmos5l_fill_2_95 r0 *1 0,0
Xsg13cmos5l_fill_2_95 VPWR VGND sg13cmos5l_fill_2
* cell instance sg13cmos5l_fill_2_96 r0 *1 0,0
Xsg13cmos5l_fill_2_96 VPWR VGND sg13cmos5l_fill_2
* cell instance sg13cmos5l_fill_2_97 r0 *1 0,0
Xsg13cmos5l_fill_2_97 VPWR VGND sg13cmos5l_fill_2
* cell instance sg13cmos5l_fill_2_98 r0 *1 0,0
Xsg13cmos5l_fill_2_98 VPWR VGND sg13cmos5l_fill_2
* cell instance sg13cmos5l_fill_2_99 r0 *1 0,0
Xsg13cmos5l_fill_2_99 VPWR VGND sg13cmos5l_fill_2
* cell instance sg13cmos5l_fill_2_100 r0 *1 0,0
Xsg13cmos5l_fill_2_100 VPWR VGND sg13cmos5l_fill_2
* cell instance sg13cmos5l_fill_2_101 r0 *1 0,0
Xsg13cmos5l_fill_2_101 VPWR VGND sg13cmos5l_fill_2
* cell instance sg13cmos5l_fill_2_102 r0 *1 0,0
Xsg13cmos5l_fill_2_102 VPWR VGND sg13cmos5l_fill_2
* cell instance sg13cmos5l_fill_2_103 r0 *1 0,0
Xsg13cmos5l_fill_2_103 VPWR VGND sg13cmos5l_fill_2
* cell instance sg13cmos5l_fill_2_104 r0 *1 0,0
Xsg13cmos5l_fill_2_104 VPWR VGND sg13cmos5l_fill_2
* cell instance sg13cmos5l_fill_2_105 r0 *1 0,0
Xsg13cmos5l_fill_2_105 VPWR VGND sg13cmos5l_fill_2
* cell instance sg13cmos5l_fill_2_106 r0 *1 0,0
Xsg13cmos5l_fill_2_106 VPWR VGND sg13cmos5l_fill_2
* cell instance sg13cmos5l_fill_2_107 r0 *1 0,0
Xsg13cmos5l_fill_2_107 VPWR VGND sg13cmos5l_fill_2
* cell instance sg13cmos5l_fill_2_108 r0 *1 0,0
Xsg13cmos5l_fill_2_108 VPWR VGND sg13cmos5l_fill_2
* cell instance sg13cmos5l_fill_2_109 r0 *1 0,0
Xsg13cmos5l_fill_2_109 VPWR VGND sg13cmos5l_fill_2
* cell instance sg13cmos5l_fill_2_110 r0 *1 0,0
Xsg13cmos5l_fill_2_110 VPWR VGND sg13cmos5l_fill_2
* cell instance sg13cmos5l_fill_2_111 r0 *1 0,0
Xsg13cmos5l_fill_2_111 VPWR VGND sg13cmos5l_fill_2
* cell instance sg13cmos5l_fill_2_112 r0 *1 0,0
Xsg13cmos5l_fill_2_112 VPWR VGND sg13cmos5l_fill_2
* cell instance sg13cmos5l_fill_2_113 r0 *1 0,0
Xsg13cmos5l_fill_2_113 VPWR VGND sg13cmos5l_fill_2
* cell instance sg13cmos5l_fill_2_114 r0 *1 0,0
Xsg13cmos5l_fill_2_114 VPWR VGND sg13cmos5l_fill_2
* cell instance sg13cmos5l_fill_2_115 r0 *1 0,0
Xsg13cmos5l_fill_2_115 VPWR VGND sg13cmos5l_fill_2
* cell instance sg13cmos5l_fill_2_116 r0 *1 0,0
Xsg13cmos5l_fill_2_116 VPWR VGND sg13cmos5l_fill_2
* cell instance sg13cmos5l_fill_2_117 r0 *1 0,0
Xsg13cmos5l_fill_2_117 VPWR VGND sg13cmos5l_fill_2
* cell instance sg13cmos5l_fill_2_118 r0 *1 0,0
Xsg13cmos5l_fill_2_118 VPWR VGND sg13cmos5l_fill_2
* cell instance sg13cmos5l_fill_2_119 r0 *1 0,0
Xsg13cmos5l_fill_2_119 VPWR VGND sg13cmos5l_fill_2
* cell instance sg13cmos5l_fill_2_120 r0 *1 0,0
Xsg13cmos5l_fill_2_120 VPWR VGND sg13cmos5l_fill_2
* cell instance sg13cmos5l_fill_2_121 r0 *1 0,0
Xsg13cmos5l_fill_2_121 VPWR VGND sg13cmos5l_fill_2
* cell instance sg13cmos5l_fill_2_122 r0 *1 0,0
Xsg13cmos5l_fill_2_122 VPWR VGND sg13cmos5l_fill_2
* cell instance sg13cmos5l_fill_2_123 r0 *1 0,0
Xsg13cmos5l_fill_2_123 VPWR VGND sg13cmos5l_fill_2
* cell instance sg13cmos5l_fill_2_124 r0 *1 0,0
Xsg13cmos5l_fill_2_124 VPWR VGND sg13cmos5l_fill_2
* cell instance sg13cmos5l_fill_2_125 r0 *1 0,0
Xsg13cmos5l_fill_2_125 VPWR VGND sg13cmos5l_fill_2
* cell instance sg13cmos5l_fill_2_126 r0 *1 0,0
Xsg13cmos5l_fill_2_126 VPWR VGND sg13cmos5l_fill_2
* cell instance sg13cmos5l_fill_2_127 r0 *1 0,0
Xsg13cmos5l_fill_2_127 VPWR VGND sg13cmos5l_fill_2
* cell instance sg13cmos5l_fill_2_128 r0 *1 0,0
Xsg13cmos5l_fill_2_128 VPWR VGND sg13cmos5l_fill_2
* cell instance sg13cmos5l_fill_2_129 r0 *1 0,0
Xsg13cmos5l_fill_2_129 VPWR VGND sg13cmos5l_fill_2
* cell instance sg13cmos5l_fill_2_130 r0 *1 0,0
Xsg13cmos5l_fill_2_130 VPWR VGND sg13cmos5l_fill_2
* cell instance sg13cmos5l_fill_2_131 r0 *1 0,0
Xsg13cmos5l_fill_2_131 VPWR VGND sg13cmos5l_fill_2
* cell instance sg13cmos5l_fill_2_132 r0 *1 0,0
Xsg13cmos5l_fill_2_132 VPWR VGND sg13cmos5l_fill_2
* cell instance sg13cmos5l_fill_2_133 r0 *1 0,0
Xsg13cmos5l_fill_2_133 VPWR VGND sg13cmos5l_fill_2
* cell instance sg13cmos5l_fill_2_134 r0 *1 0,0
Xsg13cmos5l_fill_2_134 VPWR VGND sg13cmos5l_fill_2
* cell instance sg13cmos5l_fill_2_135 r0 *1 0,0
Xsg13cmos5l_fill_2_135 VPWR VGND sg13cmos5l_fill_2
* cell instance sg13cmos5l_fill_2_136 r0 *1 0,0
Xsg13cmos5l_fill_2_136 VPWR VGND sg13cmos5l_fill_2
* cell instance sg13cmos5l_fill_2_137 r0 *1 0,0
Xsg13cmos5l_fill_2_137 VPWR VGND sg13cmos5l_fill_2
* cell instance sg13cmos5l_fill_2_138 r0 *1 0,0
Xsg13cmos5l_fill_2_138 VPWR VGND sg13cmos5l_fill_2
* cell instance sg13cmos5l_fill_2_139 r0 *1 0,0
Xsg13cmos5l_fill_2_139 VPWR VGND sg13cmos5l_fill_2
* cell instance sg13cmos5l_fill_2_140 r0 *1 0,0
Xsg13cmos5l_fill_2_140 VPWR VGND sg13cmos5l_fill_2
* cell instance sg13cmos5l_fill_2_141 r0 *1 0,0
Xsg13cmos5l_fill_2_141 VPWR VGND sg13cmos5l_fill_2
* cell instance sg13cmos5l_fill_2_142 r0 *1 0,0
Xsg13cmos5l_fill_2_142 VPWR VGND sg13cmos5l_fill_2
* cell instance sg13cmos5l_fill_2_143 r0 *1 0,0
Xsg13cmos5l_fill_2_143 VPWR VGND sg13cmos5l_fill_2
* cell instance sg13cmos5l_fill_2_144 r0 *1 0,0
Xsg13cmos5l_fill_2_144 VPWR VGND sg13cmos5l_fill_2
* cell instance sg13cmos5l_fill_2_145 r0 *1 0,0
Xsg13cmos5l_fill_2_145 VPWR VGND sg13cmos5l_fill_2
* cell instance sg13cmos5l_fill_2_146 r0 *1 0,0
Xsg13cmos5l_fill_2_146 VPWR VGND sg13cmos5l_fill_2
* cell instance sg13cmos5l_fill_2_147 r0 *1 0,0
Xsg13cmos5l_fill_2_147 VPWR VGND sg13cmos5l_fill_2
* cell instance sg13cmos5l_fill_2_148 r0 *1 0,0
Xsg13cmos5l_fill_2_148 VPWR VGND sg13cmos5l_fill_2
* cell instance sg13cmos5l_fill_2_149 r0 *1 0,0
Xsg13cmos5l_fill_2_149 VPWR VGND sg13cmos5l_fill_2
* cell instance sg13cmos5l_fill_2_150 r0 *1 0,0
Xsg13cmos5l_fill_2_150 VPWR VGND sg13cmos5l_fill_2
* cell instance sg13cmos5l_fill_2_151 r0 *1 0,0
Xsg13cmos5l_fill_2_151 VPWR VGND sg13cmos5l_fill_2
* cell instance sg13cmos5l_fill_2_152 r0 *1 0,0
Xsg13cmos5l_fill_2_152 VPWR VGND sg13cmos5l_fill_2
* cell instance sg13cmos5l_fill_2_153 r0 *1 0,0
Xsg13cmos5l_fill_2_153 VPWR VGND sg13cmos5l_fill_2
* cell instance sg13cmos5l_fill_2_154 r0 *1 0,0
Xsg13cmos5l_fill_2_154 VPWR VGND sg13cmos5l_fill_2
* cell instance sg13cmos5l_fill_2_155 r0 *1 0,0
Xsg13cmos5l_fill_2_155 VPWR VGND sg13cmos5l_fill_2
* cell instance sg13cmos5l_fill_2_156 r0 *1 0,0
Xsg13cmos5l_fill_2_156 VPWR VGND sg13cmos5l_fill_2
* cell instance sg13cmos5l_fill_2_157 r0 *1 0,0
Xsg13cmos5l_fill_2_157 VPWR VGND sg13cmos5l_fill_2
* cell instance sg13cmos5l_fill_2_158 r0 *1 0,0
Xsg13cmos5l_fill_2_158 VPWR VGND sg13cmos5l_fill_2
* cell instance sg13cmos5l_fill_2_159 r0 *1 0,0
Xsg13cmos5l_fill_2_159 VPWR VGND sg13cmos5l_fill_2
* cell instance sg13cmos5l_fill_2_160 r0 *1 0,0
Xsg13cmos5l_fill_2_160 VPWR VGND sg13cmos5l_fill_2
* cell instance sg13cmos5l_fill_2_161 r0 *1 0,0
Xsg13cmos5l_fill_2_161 VPWR VGND sg13cmos5l_fill_2
* cell instance sg13cmos5l_fill_2_162 r0 *1 0,0
Xsg13cmos5l_fill_2_162 VPWR VGND sg13cmos5l_fill_2
* cell instance sg13cmos5l_fill_2_163 r0 *1 0,0
Xsg13cmos5l_fill_2_163 VPWR VGND sg13cmos5l_fill_2
* cell instance sg13cmos5l_fill_2_164 r0 *1 0,0
Xsg13cmos5l_fill_2_164 VPWR VGND sg13cmos5l_fill_2
* cell instance sg13cmos5l_fill_2_165 r0 *1 0,0
Xsg13cmos5l_fill_2_165 VPWR VGND sg13cmos5l_fill_2
* cell instance sg13cmos5l_fill_2_166 r0 *1 0,0
Xsg13cmos5l_fill_2_166 VPWR VGND sg13cmos5l_fill_2
* cell instance sg13cmos5l_fill_2_167 r0 *1 0,0
Xsg13cmos5l_fill_2_167 VPWR VGND sg13cmos5l_fill_2
* cell instance sg13cmos5l_fill_2_168 r0 *1 0,0
Xsg13cmos5l_fill_2_168 VPWR VGND sg13cmos5l_fill_2
* cell instance sg13cmos5l_fill_2_169 r0 *1 0,0
Xsg13cmos5l_fill_2_169 VPWR VGND sg13cmos5l_fill_2
* cell instance sg13cmos5l_fill_2_170 r0 *1 0,0
Xsg13cmos5l_fill_2_170 VPWR VGND sg13cmos5l_fill_2
* cell instance sg13cmos5l_fill_2_171 r0 *1 0,0
Xsg13cmos5l_fill_2_171 VPWR VGND sg13cmos5l_fill_2
* cell instance sg13cmos5l_fill_2_172 r0 *1 0,0
Xsg13cmos5l_fill_2_172 VPWR VGND sg13cmos5l_fill_2
* cell instance sg13cmos5l_fill_2_173 r0 *1 0,0
Xsg13cmos5l_fill_2_173 VPWR VGND sg13cmos5l_fill_2
* cell instance sg13cmos5l_fill_2_174 r0 *1 0,0
Xsg13cmos5l_fill_2_174 VPWR VGND sg13cmos5l_fill_2
* cell instance sg13cmos5l_fill_2_175 r0 *1 0,0
Xsg13cmos5l_fill_2_175 VPWR VGND sg13cmos5l_fill_2
* cell instance sg13cmos5l_fill_2_176 r0 *1 0,0
Xsg13cmos5l_fill_2_176 VPWR VGND sg13cmos5l_fill_2
* cell instance sg13cmos5l_fill_2_177 r0 *1 0,0
Xsg13cmos5l_fill_2_177 VPWR VGND sg13cmos5l_fill_2
* cell instance sg13cmos5l_fill_2_178 r0 *1 0,0
Xsg13cmos5l_fill_2_178 VPWR VGND sg13cmos5l_fill_2
* cell instance sg13cmos5l_fill_2_179 r0 *1 0,0
Xsg13cmos5l_fill_2_179 VPWR VGND sg13cmos5l_fill_2
* cell instance sg13cmos5l_fill_2_180 r0 *1 0,0
Xsg13cmos5l_fill_2_180 VPWR VGND sg13cmos5l_fill_2
* cell instance sg13cmos5l_fill_2_181 r0 *1 0,0
Xsg13cmos5l_fill_2_181 VPWR VGND sg13cmos5l_fill_2
* cell instance sg13cmos5l_fill_2_182 r0 *1 0,0
Xsg13cmos5l_fill_2_182 VPWR VGND sg13cmos5l_fill_2
* cell instance sg13cmos5l_fill_2_183 r0 *1 0,0
Xsg13cmos5l_fill_2_183 VPWR VGND sg13cmos5l_fill_2
* cell instance sg13cmos5l_fill_2_184 r0 *1 0,0
Xsg13cmos5l_fill_2_184 VPWR VGND sg13cmos5l_fill_2
* cell instance sg13cmos5l_fill_2_185 r0 *1 0,0
Xsg13cmos5l_fill_2_185 VPWR VGND sg13cmos5l_fill_2
* cell instance sg13cmos5l_fill_2_186 r0 *1 0,0
Xsg13cmos5l_fill_2_186 VPWR VGND sg13cmos5l_fill_2
* cell instance sg13cmos5l_fill_2_187 r0 *1 0,0
Xsg13cmos5l_fill_2_187 VPWR VGND sg13cmos5l_fill_2
* cell instance sg13cmos5l_fill_2_188 r0 *1 0,0
Xsg13cmos5l_fill_2_188 VPWR VGND sg13cmos5l_fill_2
* cell instance sg13cmos5l_fill_2_189 r0 *1 0,0
Xsg13cmos5l_fill_2_189 VPWR VGND sg13cmos5l_fill_2
* cell instance sg13cmos5l_fill_2_190 r0 *1 0,0
Xsg13cmos5l_fill_2_190 VPWR VGND sg13cmos5l_fill_2
* cell instance sg13cmos5l_fill_2_191 r0 *1 0,0
Xsg13cmos5l_fill_2_191 VPWR VGND sg13cmos5l_fill_2
* cell instance sg13cmos5l_fill_2_192 r0 *1 0,0
Xsg13cmos5l_fill_2_192 VPWR VGND sg13cmos5l_fill_2
* cell instance sg13cmos5l_fill_2_193 r0 *1 0,0
Xsg13cmos5l_fill_2_193 VPWR VGND sg13cmos5l_fill_2
* cell instance sg13cmos5l_fill_2_194 r0 *1 0,0
Xsg13cmos5l_fill_2_194 VPWR VGND sg13cmos5l_fill_2
* cell instance sg13cmos5l_fill_2_195 r0 *1 0,0
Xsg13cmos5l_fill_2_195 VPWR VGND sg13cmos5l_fill_2
* cell instance sg13cmos5l_fill_2_196 r0 *1 0,0
Xsg13cmos5l_fill_2_196 VPWR VGND sg13cmos5l_fill_2
* cell instance sg13cmos5l_fill_2_197 r0 *1 0,0
Xsg13cmos5l_fill_2_197 VPWR VGND sg13cmos5l_fill_2
* cell instance sg13cmos5l_fill_2_198 r0 *1 0,0
Xsg13cmos5l_fill_2_198 VPWR VGND sg13cmos5l_fill_2
* cell instance sg13cmos5l_fill_2_199 r0 *1 0,0
Xsg13cmos5l_fill_2_199 VPWR VGND sg13cmos5l_fill_2
* cell instance sg13cmos5l_fill_2_200 r0 *1 0,0
Xsg13cmos5l_fill_2_200 VPWR VGND sg13cmos5l_fill_2
* cell instance sg13cmos5l_fill_2_201 r0 *1 0,0
Xsg13cmos5l_fill_2_201 VPWR VGND sg13cmos5l_fill_2
* cell instance sg13cmos5l_fill_2_202 r0 *1 0,0
Xsg13cmos5l_fill_2_202 VPWR VGND sg13cmos5l_fill_2
* cell instance sg13cmos5l_fill_2_203 r0 *1 0,0
Xsg13cmos5l_fill_2_203 VPWR VGND sg13cmos5l_fill_2
* cell instance sg13cmos5l_fill_2_204 r0 *1 0,0
Xsg13cmos5l_fill_2_204 VPWR VGND sg13cmos5l_fill_2
* cell instance sg13cmos5l_fill_2_205 r0 *1 0,0
Xsg13cmos5l_fill_2_205 VPWR VGND sg13cmos5l_fill_2
* cell instance sg13cmos5l_fill_2_206 r0 *1 0,0
Xsg13cmos5l_fill_2_206 VPWR VGND sg13cmos5l_fill_2
* cell instance sg13cmos5l_fill_2_207 r0 *1 0,0
Xsg13cmos5l_fill_2_207 VPWR VGND sg13cmos5l_fill_2
* cell instance sg13cmos5l_inv_1_0 r0 *1 0,0
Xsg13cmos5l_inv_1_0 \$4613 VPWR VGND \$4614 sg13cmos5l_inv_1
* cell instance sg13cmos5l_inv_1_1 r0 *1 0,0
Xsg13cmos5l_inv_1_1 \$1861 VPWR VGND \$3514 sg13cmos5l_inv_1
* cell instance sg13cmos5l_inv_1_2 r0 *1 0,0
Xsg13cmos5l_inv_1_2 \$844 VPWR VGND \$845 sg13cmos5l_inv_1
* cell instance sg13cmos5l_inv_1_3 r0 *1 0,0
Xsg13cmos5l_inv_1_3 \$2208 VPWR VGND \$2723 sg13cmos5l_inv_1
* cell instance sg13cmos5l_inv_1_4 r0 *1 0,0
Xsg13cmos5l_inv_1_4 \$2271 VPWR VGND \$2426 sg13cmos5l_inv_1
* cell instance sg13cmos5l_inv_1_5 r0 *1 0,0
Xsg13cmos5l_inv_1_5 \$2210 VPWR VGND \$4018 sg13cmos5l_inv_1
* cell instance sg13cmos5l_inv_1_6 r0 *1 0,0
Xsg13cmos5l_inv_1_6 \$5141 VPWR VGND \$4236 sg13cmos5l_inv_1
* cell instance sg13cmos5l_inv_1_7 r0 *1 0,0
Xsg13cmos5l_inv_1_7 \$4081 VPWR VGND \$7271 sg13cmos5l_inv_1
* cell instance sg13cmos5l_inv_1_8 r0 *1 0,0
Xsg13cmos5l_inv_1_8 \$4617 VPWR VGND \$4615 sg13cmos5l_inv_1
* cell instance sg13cmos5l_inv_1_9 r0 *1 0,0
Xsg13cmos5l_inv_1_9 \$1563 VPWR VGND \$1093 sg13cmos5l_inv_1
* cell instance sg13cmos5l_inv_1_10 r0 *1 0,0
Xsg13cmos5l_inv_1_10 \$1564 VPWR VGND \$1546 sg13cmos5l_inv_1
* cell instance sg13cmos5l_inv_1_11 r0 *1 0,0
Xsg13cmos5l_inv_1_11 \$392 VPWR VGND \$1864 sg13cmos5l_inv_1
* cell instance sg13cmos5l_inv_1_12 r0 *1 0,0
Xsg13cmos5l_inv_1_12 \$859 VPWR VGND \$2274 sg13cmos5l_inv_1
* cell instance sg13cmos5l_inv_1_13 r0 *1 0,0
Xsg13cmos5l_inv_1_13 \$1865 VPWR VGND \$1565 sg13cmos5l_inv_1
* cell instance sg13cmos5l_inv_1_14 r0 *1 0,0
Xsg13cmos5l_inv_1_14 \$6581 VPWR VGND \$7630 sg13cmos5l_inv_1
* cell instance sg13cmos5l_inv_1_15 r0 *1 0,0
Xsg13cmos5l_inv_1_15 \$1846 VPWR VGND \$861 sg13cmos5l_inv_1
* cell instance sg13cmos5l_inv_1_16 r0 *1 0,0
Xsg13cmos5l_inv_1_16 \$1852 VPWR VGND \$1566 sg13cmos5l_inv_1
* cell instance sg13cmos5l_inv_1_17 r0 *1 0,0
Xsg13cmos5l_inv_1_17 \$2082 VPWR VGND \$10040 sg13cmos5l_inv_1
* cell instance sg13cmos5l_inv_1_18 r0 *1 0,0
Xsg13cmos5l_inv_1_18 \$89 VPWR VGND \$404 sg13cmos5l_inv_1
* cell instance sg13cmos5l_inv_1_19 r0 *1 0,0
Xsg13cmos5l_inv_1_19 \$412 VPWR VGND \$560 sg13cmos5l_inv_1
* cell instance sg13cmos5l_inv_1_20 r0 *1 0,0
Xsg13cmos5l_inv_1_20 \$3832 VPWR VGND \$8788 sg13cmos5l_inv_1
* cell instance sg13cmos5l_inv_1_21 r0 *1 0,0
Xsg13cmos5l_inv_1_21 \$3497 VPWR VGND \$3833 sg13cmos5l_inv_1
* cell instance sg13cmos5l_inv_1_22 r0 *1 0,0
Xsg13cmos5l_inv_1_22 \$408 VPWR VGND \$574 sg13cmos5l_inv_1
* cell instance sg13cmos5l_inv_1_23 r0 *1 0,0
Xsg13cmos5l_inv_1_23 \$7861 VPWR VGND \$8130 sg13cmos5l_inv_1
* cell instance sg13cmos5l_inv_1_24 r0 *1 0,0
Xsg13cmos5l_inv_1_24 \$1562 VPWR VGND \$1855 sg13cmos5l_inv_1
* cell instance sg13cmos5l_inv_1_25 r0 *1 0,0
Xsg13cmos5l_inv_1_25 \$7119 VPWR VGND \$7120 sg13cmos5l_inv_1
* cell instance sg13cmos5l_inv_1_26 r0 *1 0,0
Xsg13cmos5l_inv_1_26 \$1576 VPWR VGND \$1342 sg13cmos5l_inv_1
* cell instance sg13cmos5l_inv_1_27 r0 *1 0,0
Xsg13cmos5l_inv_1_27 \$256 VPWR VGND \$428 sg13cmos5l_inv_1
* cell instance sg13cmos5l_inv_1_28 r0 *1 0,0
Xsg13cmos5l_inv_1_28 \$266 VPWR VGND \$264 sg13cmos5l_inv_1
* cell instance sg13cmos5l_inv_1_29 r0 *1 0,0
Xsg13cmos5l_inv_1_29 \$265 VPWR VGND \$267 sg13cmos5l_inv_1
* cell instance sg13cmos5l_inv_1_30 r0 *1 0,0
Xsg13cmos5l_inv_1_30 \$134 VPWR VGND \$582 sg13cmos5l_inv_1
* cell instance sg13cmos5l_inv_1_31 r0 *1 0,0
Xsg13cmos5l_inv_1_31 \$551 VPWR VGND \$751 sg13cmos5l_inv_1
* cell instance sg13cmos5l_inv_1_32 r0 *1 0,0
Xsg13cmos5l_inv_1_32 \$759 VPWR VGND \$899 sg13cmos5l_inv_1
* cell instance sg13cmos5l_inv_1_33 r0 *1 0,0
Xsg13cmos5l_inv_1_33 \$277 VPWR VGND \$912 sg13cmos5l_inv_1
* cell instance sg13cmos5l_inv_1_34 r0 *1 0,0
Xsg13cmos5l_inv_1_34 \$320 VPWR VGND \$771 sg13cmos5l_inv_1
* cell instance sg13cmos5l_inv_1_35 r0 *1 0,0
Xsg13cmos5l_inv_1_35 \$326 VPWR VGND \$327 sg13cmos5l_inv_1
* cell instance sg13cmos5l_inv_1_36 r0 *1 0,0
Xsg13cmos5l_inv_1_36 \$1407 VPWR VGND \$652 sg13cmos5l_inv_1
* cell instance sg13cmos5l_inv_1_37 r0 *1 0,0
Xsg13cmos5l_inv_1_37 \$179 VPWR VGND \$180 sg13cmos5l_inv_1
* cell instance sg13cmos5l_inv_1_38 r0 *1 0,0
Xsg13cmos5l_inv_1_38 \$665 VPWR VGND \$796 sg13cmos5l_inv_1
* cell instance sg13cmos5l_inv_1_39 r0 *1 0,0
Xsg13cmos5l_inv_1_39 \$675 VPWR VGND \$676 sg13cmos5l_inv_1
* cell instance sg13cmos5l_inv_1_40 r0 *1 0,0
Xsg13cmos5l_inv_1_40 \$988 VPWR VGND \$826 sg13cmos5l_inv_1
* cell instance sg13cmos5l_inv_1_41 r0 *1 0,0
Xsg13cmos5l_inv_1_41 \$1217 VPWR VGND \$827 sg13cmos5l_inv_1
* cell instance sg13cmos5l_mux2_1_0 r0 *1 0,0
Xsg13cmos5l_mux2_1_0 \$3734 \$3740 \$2179 VPWR VGND \$3487 sg13cmos5l_mux2_1
* cell instance sg13cmos5l_mux2_1_1 r0 *1 0,0
Xsg13cmos5l_mux2_1_1 \$4758 \$4757 \$2206 VPWR VGND \$4320 sg13cmos5l_mux2_1
* cell instance sg13cmos5l_mux2_1_2 r0 *1 0,0
Xsg13cmos5l_mux2_1_2 \$1790 \$1888 \$1871 VPWR VGND \$1874 sg13cmos5l_mux2_1
* cell instance sg13cmos5l_mux2_1_3 r0 *1 0,0
Xsg13cmos5l_mux2_1_3 \$6673 \$4757 \$1878 VPWR VGND \$6566 sg13cmos5l_mux2_1
* cell instance sg13cmos5l_mux2_1_4 r0 *1 0,0
Xsg13cmos5l_mux2_1_4 \$2722 \$2749 \$1871 VPWR VGND \$2450 sg13cmos5l_mux2_1
* cell instance sg13cmos5l_mux2_1_5 r0 *1 0,0
Xsg13cmos5l_mux2_1_5 \$2939 \$2749 \$2179 VPWR VGND \$2875 sg13cmos5l_mux2_1
* cell instance sg13cmos5l_mux2_1_6 r0 *1 0,0
Xsg13cmos5l_mux2_1_6 \$10631 \$7632 \$2206 VPWR VGND \$10480 sg13cmos5l_mux2_1
* cell instance sg13cmos5l_mux2_1_7 r0 *1 0,0
Xsg13cmos5l_mux2_1_7 \$7626 \$8711 \$2179 VPWR VGND \$8279 sg13cmos5l_mux2_1
* cell instance sg13cmos5l_mux2_1_8 r0 *1 0,0
Xsg13cmos5l_mux2_1_8 \$2178 \$1888 \$2206 VPWR VGND \$2072 sg13cmos5l_mux2_1
* cell instance sg13cmos5l_mux2_1_9 r0 *1 0,0
Xsg13cmos5l_mux2_1_9 \$5797 \$4757 \$1871 VPWR VGND \$5717 sg13cmos5l_mux2_1
* cell instance sg13cmos5l_mux2_1_10 r0 *1 0,0
Xsg13cmos5l_mux2_1_10 \$10206 \$7632 \$2179 VPWR VGND \$10632 sg13cmos5l_mux2_1
* cell instance sg13cmos5l_mux2_1_11 r0 *1 0,0
Xsg13cmos5l_mux2_1_11 \$12257 \$7632 \$1871 VPWR VGND \$11239 sg13cmos5l_mux2_1
* cell instance sg13cmos5l_mux2_1_12 r0 *1 0,0
Xsg13cmos5l_mux2_1_12 \$2750 \$2749 \$1878 VPWR VGND \$2709 sg13cmos5l_mux2_1
* cell instance sg13cmos5l_mux2_1_13 r0 *1 0,0
Xsg13cmos5l_mux2_1_13 \$4612 \$3740 \$1871 VPWR VGND \$4759 sg13cmos5l_mux2_1
* cell instance sg13cmos5l_mux2_1_14 r0 *1 0,0
Xsg13cmos5l_mux2_1_14 \$9012 \$8711 \$1871 VPWR VGND \$7702 sg13cmos5l_mux2_1
* cell instance sg13cmos5l_mux2_1_15 r0 *1 0,0
Xsg13cmos5l_mux2_1_15 \$3267 \$2749 \$2206 VPWR VGND \$3059 sg13cmos5l_mux2_1
* cell instance sg13cmos5l_mux2_1_16 r0 *1 0,0
Xsg13cmos5l_mux2_1_16 \$4086 \$3740 \$2206 VPWR VGND \$4067 sg13cmos5l_mux2_1
* cell instance sg13cmos5l_mux2_1_17 r0 *1 0,0
Xsg13cmos5l_mux2_1_17 \$9180 \$8711 \$2206 VPWR VGND \$8712 sg13cmos5l_mux2_1
* cell instance sg13cmos5l_mux2_1_18 r0 *1 0,0
Xsg13cmos5l_mux2_1_18 \$3820 \$3740 \$1878 VPWR VGND \$3741 sg13cmos5l_mux2_1
* cell instance sg13cmos5l_mux2_1_19 r0 *1 0,0
Xsg13cmos5l_mux2_1_19 \$2207 \$1888 \$2179 VPWR VGND \$1859 sg13cmos5l_mux2_1
* cell instance sg13cmos5l_mux2_1_20 r0 *1 0,0
Xsg13cmos5l_mux2_1_20 \$10207 \$7632 \$1878 VPWR VGND \$10110 sg13cmos5l_mux2_1
* cell instance sg13cmos5l_mux2_1_21 r0 *1 0,0
Xsg13cmos5l_mux2_1_21 \$9615 \$8711 \$1878 VPWR VGND \$9285 sg13cmos5l_mux2_1
* cell instance sg13cmos5l_mux2_1_22 r0 *1 0,0
Xsg13cmos5l_mux2_1_22 \$1818 \$1888 \$1878 VPWR VGND \$1793 sg13cmos5l_mux2_1
* cell instance sg13cmos5l_mux2_1_23 r0 *1 0,0
Xsg13cmos5l_mux2_1_23 \$6676 \$4757 \$2179 VPWR VGND \$6827 sg13cmos5l_mux2_1
* cell instance sg13cmos5l_mux2_1_24 r0 *1 0,0
Xsg13cmos5l_mux2_1_24 \$4091 \$13737 \$12258 VPWR VGND \$13721 sg13cmos5l_mux2_1
* cell instance sg13cmos5l_mux2_1_25 r0 *1 0,0
Xsg13cmos5l_mux2_1_25 \$11244 \$6653 \$1871 VPWR VGND \$11081 sg13cmos5l_mux2_1
* cell instance sg13cmos5l_mux2_1_26 r0 *1 0,0
Xsg13cmos5l_mux2_1_26 \$2079 \$1933 \$1871 VPWR VGND \$1890 sg13cmos5l_mux2_1
* cell instance sg13cmos5l_mux2_1_27 r0 *1 0,0
Xsg13cmos5l_mux2_1_27 \$5720 \$12593 \$12258 VPWR VGND \$12494 sg13cmos5l_mux2_1
* cell instance sg13cmos5l_mux2_1_28 r0 *1 0,0
Xsg13cmos5l_mux2_1_28 \$11095 \$6653 \$1878 VPWR VGND \$10115 sg13cmos5l_mux2_1
* cell instance sg13cmos5l_mux2_1_29 r0 *1 0,0
Xsg13cmos5l_mux2_1_29 \$3274 \$13836 \$12258 VPWR VGND \$13774 sg13cmos5l_mux2_1
* cell instance sg13cmos5l_mux2_1_30 r0 *1 0,0
Xsg13cmos5l_mux2_1_30 \$1821 \$1933 \$1878 VPWR VGND \$1822 sg13cmos5l_mux2_1
* cell instance sg13cmos5l_mux2_1_31 r0 *1 0,0
Xsg13cmos5l_mux2_1_31 \$11245 \$6653 \$2179 VPWR VGND \$10211 sg13cmos5l_mux2_1
* cell instance sg13cmos5l_mux2_1_32 r0 *1 0,0
Xsg13cmos5l_mux2_1_32 \$2456 \$1933 \$2206 VPWR VGND \$2209 sg13cmos5l_mux2_1
* cell instance sg13cmos5l_mux2_1_33 r0 *1 0,0
Xsg13cmos5l_mux2_1_33 \$2080 \$1933 \$2179 VPWR VGND \$1862 sg13cmos5l_mux2_1
* cell instance sg13cmos5l_mux2_1_34 r0 *1 0,0
Xsg13cmos5l_mux2_1_34 \$9617 \$6653 \$2206 VPWR VGND \$9758 sg13cmos5l_mux2_1
* cell instance sg13cmos5l_mux2_1_35 r0 *1 0,0
Xsg13cmos5l_mux2_1_35 \$9181 \$12295 \$12258 VPWR VGND \$12076 sg13cmos5l_mux2_1
* cell instance sg13cmos5l_mux2_1_36 r0 *1 0,0
Xsg13cmos5l_mux2_1_36 \$388 \$387 \$374 VPWR VGND \$379 sg13cmos5l_mux2_1
* cell instance sg13cmos5l_mux2_1_37 r0 *1 0,0
Xsg13cmos5l_mux2_1_37 \$4765 \$13691 \$12258 VPWR VGND \$13586 sg13cmos5l_mux2_1
* cell instance sg13cmos5l_mux2_1_38 r0 *1 0,0
Xsg13cmos5l_mux2_1_38 \$700 \$1323 \$365 VPWR VGND \$1553 sg13cmos5l_mux2_1
* cell instance sg13cmos5l_mux2_1_39 r0 *1 0,0
Xsg13cmos5l_mux2_1_39 \$9527 \$13745 \$12258 VPWR VGND \$13746 sg13cmos5l_mux2_1
* cell instance sg13cmos5l_mux2_1_40 r0 *1 0,0
Xsg13cmos5l_mux2_1_40 \$4765 \$13321 \$10796 VPWR VGND \$13598 sg13cmos5l_mux2_1
* cell instance sg13cmos5l_mux2_1_41 r0 *1 0,0
Xsg13cmos5l_mux2_1_41 \$3274 \$13801 \$10796 VPWR VGND \$13802 sg13cmos5l_mux2_1
* cell instance sg13cmos5l_mux2_1_42 r0 *1 0,0
Xsg13cmos5l_mux2_1_42 \$5720 \$12603 \$10796 VPWR VGND \$12501 sg13cmos5l_mux2_1
* cell instance sg13cmos5l_mux2_1_43 r0 *1 0,0
Xsg13cmos5l_mux2_1_43 \$2434 \$13719 \$12258 VPWR VGND \$13700 sg13cmos5l_mux2_1
* cell instance sg13cmos5l_mux2_1_44 r0 *1 0,0
Xsg13cmos5l_mux2_1_44 \$2174 \$10795 \$10796 VPWR VGND \$11576 sg13cmos5l_mux2_1
* cell instance sg13cmos5l_mux2_1_45 r0 *1 0,0
Xsg13cmos5l_mux2_1_45 \$2174 \$12259 \$12258 VPWR VGND \$11248 sg13cmos5l_mux2_1
* cell instance sg13cmos5l_mux2_1_46 r0 *1 0,0
Xsg13cmos5l_mux2_1_46 \$2434 \$13617 \$10796 VPWR VGND \$13753 sg13cmos5l_mux2_1
* cell instance sg13cmos5l_mux2_1_47 r0 *1 0,0
Xsg13cmos5l_mux2_1_47 \$9181 \$13251 \$10796 VPWR VGND \$12260 sg13cmos5l_mux2_1
* cell instance sg13cmos5l_mux2_1_48 r0 *1 0,0
Xsg13cmos5l_mux2_1_48 \$823 \$1692 \$2085 VPWR VGND \$1856 sg13cmos5l_mux2_1
* cell instance sg13cmos5l_mux2_1_49 r0 *1 0,0
Xsg13cmos5l_mux2_1_49 \$9527 \$13715 \$10796 VPWR VGND \$13608 sg13cmos5l_mux2_1
* cell instance sg13cmos5l_mux2_1_50 r0 *1 0,0
Xsg13cmos5l_mux2_1_50 \$4091 \$13868 \$10796 VPWR VGND \$13869 sg13cmos5l_mux2_1
* cell instance sg13cmos5l_mux2_1_51 r0 *1 0,0
Xsg13cmos5l_mux2_1_51 \$1120 \$1119 \$1369 VPWR VGND \$1116 sg13cmos5l_mux2_1
* cell instance sg13cmos5l_mux2_1_52 r0 *1 0,0
Xsg13cmos5l_mux2_1_52 \$1119 \$1598 \$1369 VPWR VGND \$1360 sg13cmos5l_mux2_1
* cell instance sg13cmos5l_mux2_1_53 r0 *1 0,0
Xsg13cmos5l_mux2_1_53 \$13888 \$929 \$13900 VPWR VGND \$9624 sg13cmos5l_mux2_1
* cell instance sg13cmos5l_mux2_1_54 r0 *1 0,0
Xsg13cmos5l_mux2_1_54 \$13891 \$13905 \$13900 VPWR VGND \$9623 sg13cmos5l_mux2_1
* cell instance sg13cmos5l_mux2_1_55 r0 *1 0,0
Xsg13cmos5l_mux2_1_55 \$13894 \$13908 \$13900 VPWR VGND \$8716 sg13cmos5l_mux2_1
* cell instance sg13cmos5l_mux2_1_56 r0 *1 0,0
Xsg13cmos5l_mux2_1_56 \$1598 \$1613 \$1369 VPWR VGND \$888 sg13cmos5l_mux2_1
* cell instance sg13cmos5l_mux2_1_57 r0 *1 0,0
Xsg13cmos5l_mux2_1_57 \$13818 \$13819 \$13900 VPWR VGND \$9182 sg13cmos5l_mux2_1
* cell instance sg13cmos5l_mux2_1_58 r0 *1 0,0
Xsg13cmos5l_mux2_1_58 \$1613 \$1377 \$1369 VPWR VGND \$1378 sg13cmos5l_mux2_1
* cell instance sg13cmos5l_mux2_1_59 r0 *1 0,0
Xsg13cmos5l_mux2_1_59 \$13899 \$13913 \$13900 VPWR VGND \$9622 sg13cmos5l_mux2_1
* cell instance sg13cmos5l_mux2_1_60 r0 *1 0,0
Xsg13cmos5l_mux2_1_60 \$13816 \$13916 \$13900 VPWR VGND \$4769 sg13cmos5l_mux2_1
* cell instance sg13cmos5l_mux2_1_61 r0 *1 0,0
Xsg13cmos5l_mux2_1_61 \$13919 \$1120 \$13900 VPWR VGND \$3495 sg13cmos5l_mux2_1
* cell instance sg13cmos5l_mux2_1_62 r0 *1 0,0
Xsg13cmos5l_mux2_1_62 \$13923 \$13922 \$13900 VPWR VGND \$9030 sg13cmos5l_mux2_1
* cell instance sg13cmos5l_mux2_1_63 r0 *1 0,0
Xsg13cmos5l_mux2_1_63 \$1377 \$1387 \$1369 VPWR VGND \$901 sg13cmos5l_mux2_1
* cell instance sg13cmos5l_mux2_1_64 r0 *1 0,0
Xsg13cmos5l_mux2_1_64 \$1387 \$1397 \$1369 VPWR VGND \$1160 sg13cmos5l_mux2_1
* cell instance sg13cmos5l_mux2_1_65 r0 *1 0,0
Xsg13cmos5l_mux2_1_65 \$1397 \$1402 \$1369 VPWR VGND \$917 sg13cmos5l_mux2_1
* cell instance sg13cmos5l_mux2_1_66 r0 *1 0,0
Xsg13cmos5l_mux2_1_66 \$638 \$47 \$508 VPWR VGND \$643 sg13cmos5l_mux2_1
* cell instance sg13cmos5l_mux2_1_67 r0 *1 0,0
Xsg13cmos5l_mux2_1_67 \$149 \$107 \$508 VPWR VGND \$777 sg13cmos5l_mux2_1
* cell instance sg13cmos5l_mux2_1_68 r0 *1 0,0
Xsg13cmos5l_mux2_1_68 \$156 \$285 \$652 VPWR VGND \$654 sg13cmos5l_mux2_1
* cell instance sg13cmos5l_mux2_1_69 r0 *1 0,0
Xsg13cmos5l_mux2_1_69 \$22 \$463 \$508 VPWR VGND \$657 sg13cmos5l_mux2_1
* cell instance sg13cmos5l_mux2_1_70 r0 *1 0,0
Xsg13cmos5l_mux2_1_70 \$21 \$620 \$508 VPWR VGND \$790 sg13cmos5l_mux2_1
* cell instance sg13cmos5l_mux2_1_71 r0 *1 0,0
Xsg13cmos5l_mux2_1_71 \$348 \$120 \$508 VPWR VGND \$510 sg13cmos5l_mux2_1
* cell instance sg13cmos5l_mux2_1_72 r0 *1 0,0
Xsg13cmos5l_mux2_1_72 \$515 \$876 \$508 VPWR VGND \$1205 sg13cmos5l_mux2_1
* cell instance sg13cmos5l_mux2_1_73 r0 *1 0,0
Xsg13cmos5l_mux2_1_73 \$513 \$269 \$508 VPWR VGND \$514 sg13cmos5l_mux2_1
* cell instance sg13cmos5l_mux2_1_74 r0 *1 0,0
Xsg13cmos5l_mux2_1_74 \$1402 \$1475 \$1369 VPWR VGND \$1239 sg13cmos5l_mux2_1
* cell instance sg13cmos5l_mux2_1_75 r0 *1 0,0
Xsg13cmos5l_mux2_1_75 \$1475 \$1486 \$1474 VPWR VGND \$993 sg13cmos5l_mux2_1
* cell instance sg13cmos5l_mux2_1_76 r0 *1 0,0
Xsg13cmos5l_mux2_1_76 \$1486 \$1489 \$1474 VPWR VGND \$1490 sg13cmos5l_mux2_1
* cell instance sg13cmos5l_mux2_1_77 r0 *1 0,0
Xsg13cmos5l_mux2_1_77 \$1489 \$1499 \$1474 VPWR VGND \$1012 sg13cmos5l_mux2_1
* cell instance sg13cmos5l_mux2_1_78 r0 *1 0,0
Xsg13cmos5l_mux2_1_78 \$1499 \$1505 \$1474 VPWR VGND \$1269 sg13cmos5l_mux2_1
* cell instance sg13cmos5l_mux2_1_79 r0 *1 0,0
Xsg13cmos5l_mux2_1_79 \$1505 \$1034 \$1474 VPWR VGND \$1035 sg13cmos5l_mux2_1
* cell instance sg13cmos5l_mux2_1_80 r0 *1 0,0
Xsg13cmos5l_mux2_1_80 \$1034 \$1523 \$1474 VPWR VGND \$1043 sg13cmos5l_mux2_1
* cell instance sg13cmos5l_mux2_1_81 r0 *1 0,0
Xsg13cmos5l_mux2_1_81 \$1523 \$1781 \$1474 VPWR VGND \$1520 sg13cmos5l_mux2_1
* cell instance sg13cmos5l_mux4_1_0 r0 *1 0,0
Xsg13cmos5l_mux4_1_0 \$5356 \$4147 \$5357 \$5358 \$2208 \$2271 VPWR VGND \$4091
+ sg13cmos5l_mux4_1
* cell instance sg13cmos5l_mux4_1_1 r0 *1 0,0
Xsg13cmos5l_mux4_1_1 \$5356 \$4147 \$5357 \$5358 \$2078 \$1911 VPWR VGND \$4093
+ sg13cmos5l_mux4_1
* cell instance sg13cmos5l_mux4_1_2 r0 *1 0,0
Xsg13cmos5l_mux4_1_2 \$4087 \$3824 \$3490 \$3821 \$2078 \$2082 VPWR VGND \$4081
+ sg13cmos5l_mux4_1
* cell instance sg13cmos5l_mux4_1_3 r0 *1 0,0
Xsg13cmos5l_mux4_1_3 \$1858 \$1924 \$1813 \$1814 \$2208 \$2271 VPWR VGND \$2174
+ sg13cmos5l_mux4_1
* cell instance sg13cmos5l_mux4_1_4 r0 *1 0,0
Xsg13cmos5l_mux4_1_4 \$2422 \$3065 \$3057 \$2719 \$2208 \$2271 VPWR VGND \$3274
+ sg13cmos5l_mux4_1
* cell instance sg13cmos5l_mux4_1_5 r0 *1 0,0
Xsg13cmos5l_mux4_1_5 \$10208 \$10209 \$10210 \$11074 \$2272 \$1450 VPWR VGND
+ \$9181 sg13cmos5l_mux4_1
* cell instance sg13cmos5l_mux4_1_6 r0 *1 0,0
Xsg13cmos5l_mux4_1_6 \$1858 \$1924 \$1813 \$1814 \$2078 \$2082 VPWR VGND \$1930
+ sg13cmos5l_mux4_1
* cell instance sg13cmos5l_mux4_1_7 r0 *1 0,0
Xsg13cmos5l_mux4_1_7 \$2422 \$3065 \$3057 \$2719 \$2078 \$2082 VPWR VGND \$3017
+ sg13cmos5l_mux4_1
* cell instance sg13cmos5l_mux4_1_8 r0 *1 0,0
Xsg13cmos5l_mux4_1_8 \$7622 \$8572 \$7704 \$9020 \$2272 \$1450 VPWR VGND \$4765
+ sg13cmos5l_mux4_1
* cell instance sg13cmos5l_mux4_1_9 r0 *1 0,0
Xsg13cmos5l_mux4_1_9 \$10208 \$10209 \$10210 \$11074 \$2078 \$2082 VPWR VGND
+ \$9183 sg13cmos5l_mux4_1
* cell instance sg13cmos5l_mux4_1_10 r0 *1 0,0
Xsg13cmos5l_mux4_1_10 \$7622 \$8572 \$7704 \$9020 \$2078 \$1911 VPWR VGND
+ \$8282 sg13cmos5l_mux4_1
* cell instance sg13cmos5l_mux4_1_11 r0 *1 0,0
Xsg13cmos5l_mux4_1_11 \$1900 \$2081 \$1938 \$1833 \$2208 \$2271 VPWR VGND
+ \$2434 sg13cmos5l_mux4_1
* cell instance sg13cmos5l_mux4_1_12 r0 *1 0,0
Xsg13cmos5l_mux4_1_12 \$1900 \$2081 \$1938 \$1833 \$2078 \$2082 VPWR VGND
+ \$2138 sg13cmos5l_mux4_1
* cell instance sg13cmos5l_mux4_1_13 r0 *1 0,0
Xsg13cmos5l_mux4_1_13 \$11079 \$9619 \$10794 \$9620 \$2272 \$1450 VPWR VGND
+ \$9527 sg13cmos5l_mux4_1
* cell instance sg13cmos5l_mux4_1_14 r0 *1 0,0
Xsg13cmos5l_mux4_1_14 \$11079 \$9619 \$10794 \$9620 \$2078 \$2082 VPWR VGND
+ \$8717 sg13cmos5l_mux4_1
* cell instance sg13cmos5l_nand2_1_0 r0 *1 0,0
Xsg13cmos5l_nand2_1_0 \$6496 \$4076 VPWR VGND \$6426 sg13cmos5l_nand2_1
* cell instance sg13cmos5l_nand2_1_1 r0 *1 0,0
Xsg13cmos5l_nand2_1_1 \$692 \$200 VPWR VGND \$691 sg13cmos5l_nand2_1
* cell instance sg13cmos5l_nand2_1_2 r0 *1 0,0
Xsg13cmos5l_nand2_1_2 \$365 \$693 VPWR VGND \$206 sg13cmos5l_nand2_1
* cell instance sg13cmos5l_nand2_1_3 r0 *1 0,0
Xsg13cmos5l_nand2_1_3 \$2174 \$1930 VPWR VGND \$3018 sg13cmos5l_nand2_1
* cell instance sg13cmos5l_nand2_1_4 r0 *1 0,0
Xsg13cmos5l_nand2_1_4 \$87 \$206 VPWR VGND \$26 sg13cmos5l_nand2_1
* cell instance sg13cmos5l_nand2_1_5 r0 *1 0,0
Xsg13cmos5l_nand2_1_5 \$6577 \$4076 VPWR VGND \$6679 sg13cmos5l_nand2_1
* cell instance sg13cmos5l_nand2_1_6 r0 *1 0,0
Xsg13cmos5l_nand2_1_6 \$3491 \$3493 VPWR VGND \$3736 sg13cmos5l_nand2_1
* cell instance sg13cmos5l_nand2_1_7 r0 *1 0,0
Xsg13cmos5l_nand2_1_7 \$560 \$1093 VPWR VGND \$854 sg13cmos5l_nand2_1
* cell instance sg13cmos5l_nand2_1_8 r0 *1 0,0
Xsg13cmos5l_nand2_1_8 \$2434 \$2138 VPWR VGND \$3206 sg13cmos5l_nand2_1
* cell instance sg13cmos5l_nand2_1_9 r0 *1 0,0
Xsg13cmos5l_nand2_1_9 \$4097 \$3268 VPWR VGND \$4082 sg13cmos5l_nand2_1
* cell instance sg13cmos5l_nand2_1_10 r0 *1 0,0
Xsg13cmos5l_nand2_1_10 \$560 \$859 VPWR VGND \$703 sg13cmos5l_nand2_1
* cell instance sg13cmos5l_nand2_1_11 r0 *1 0,0
Xsg13cmos5l_nand2_1_11 \$3206 \$3097 VPWR VGND \$3207 sg13cmos5l_nand2_1
* cell instance sg13cmos5l_nand2_1_12 r0 *1 0,0
Xsg13cmos5l_nand2_1_12 \$9181 \$9183 VPWR VGND \$3832 sg13cmos5l_nand2_1
* cell instance sg13cmos5l_nand2_1_13 r0 *1 0,0
Xsg13cmos5l_nand2_1_13 \$7273 \$3268 VPWR VGND \$4166 sg13cmos5l_nand2_1
* cell instance sg13cmos5l_nand2_1_14 r0 *1 0,0
Xsg13cmos5l_nand2_1_14 \$9527 \$8717 VPWR VGND \$7273 sg13cmos5l_nand2_1
* cell instance sg13cmos5l_nand2_1_15 r0 *1 0,0
Xsg13cmos5l_nand2_1_15 \$2078 \$2892 VPWR VGND \$2435 sg13cmos5l_nand2_1
* cell instance sg13cmos5l_nand2_1_16 r0 *1 0,0
Xsg13cmos5l_nand2_1_16 \$1869 \$1910 VPWR VGND \$1569 sg13cmos5l_nand2_1
* cell instance sg13cmos5l_nand2_1_17 r0 *1 0,0
Xsg13cmos5l_nand2_1_17 \$1692 \$823 VPWR VGND \$1571 sg13cmos5l_nand2_1
* cell instance sg13cmos5l_nand2_1_18 r0 *1 0,0
Xsg13cmos5l_nand2_1_18 \$1574 \$1573 VPWR VGND \$1343 sg13cmos5l_nand2_1
* cell instance sg13cmos5l_nand2_1_19 r0 *1 0,0
Xsg13cmos5l_nand2_1_19 \$412 \$403 VPWR VGND \$260 sg13cmos5l_nand2_1
* cell instance sg13cmos5l_nand2_1_20 r0 *1 0,0
Xsg13cmos5l_nand2_1_20 \$707 \$250 VPWR VGND \$576 sg13cmos5l_nand2_1
* cell instance sg13cmos5l_nand2_1_21 r0 *1 0,0
Xsg13cmos5l_nand2_1_21 \$1112 \$1109 VPWR VGND \$867 sg13cmos5l_nand2_1
* cell instance sg13cmos5l_nand2_1_22 r0 *1 0,0
Xsg13cmos5l_nand2_1_22 \$260 \$867 VPWR VGND \$587 sg13cmos5l_nand2_1
* cell instance sg13cmos5l_nand2_1_23 r0 *1 0,0
Xsg13cmos5l_nand2_1_23 \$256 \$255 VPWR VGND \$247 sg13cmos5l_nand2_1
* cell instance sg13cmos5l_nand2_1_24 r0 *1 0,0
Xsg13cmos5l_nand2_1_24 \$260 \$261 VPWR VGND \$717 sg13cmos5l_nand2_1
* cell instance sg13cmos5l_nand2_1_25 r0 *1 0,0
Xsg13cmos5l_nand2_1_25 \$455 \$728 VPWR VGND \$132 sg13cmos5l_nand2_1
* cell instance sg13cmos5l_nand2_1_26 r0 *1 0,0
Xsg13cmos5l_nand2_1_26 \$134 \$728 VPWR VGND \$133 sg13cmos5l_nand2_1
* cell instance sg13cmos5l_nand2_1_27 r0 *1 0,0
Xsg13cmos5l_nand2_1_27 \$299 \$143 VPWR VGND \$139 sg13cmos5l_nand2_1
* cell instance sg13cmos5l_nand2_1_28 r0 *1 0,0
Xsg13cmos5l_nand2_1_28 \$1407 \$929 VPWR VGND \$1413 sg13cmos5l_nand2_1
* cell instance sg13cmos5l_nand2_1_29 r0 *1 0,0
Xsg13cmos5l_nand2_1_29 \$149 \$150 VPWR VGND \$639 sg13cmos5l_nand2_1
* cell instance sg13cmos5l_nand2_1_30 r0 *1 0,0
Xsg13cmos5l_nand2_1_30 \$149 \$638 VPWR VGND \$499 sg13cmos5l_nand2_1
* cell instance sg13cmos5l_nand2_1_31 r0 *1 0,0
Xsg13cmos5l_nand2_1_31 \$665 \$779 VPWR VGND \$800 sg13cmos5l_nand2_1
* cell instance sg13cmos5l_nand2b_1_0 r0 *1 0,0
Xsg13cmos5l_nand2b_1_0 \$2271 \$3824 VPWR VGND \$3735 sg13cmos5l_nand2b_1
* cell instance sg13cmos5l_nand2b_1_1 r0 *1 0,0
Xsg13cmos5l_nand2b_1_1 \$2208 \$3490 VPWR VGND \$3447 sg13cmos5l_nand2b_1
* cell instance sg13cmos5l_nand2b_1_2 r0 *1 0,0
Xsg13cmos5l_nand2b_1_2 \$6357 \$6426 VPWR VGND \$6427 sg13cmos5l_nand2b_1
* cell instance sg13cmos5l_nand2b_1_3 r0 *1 0,0
Xsg13cmos5l_nand2b_1_3 \$8282 \$4765 VPWR VGND \$6677 sg13cmos5l_nand2b_1
* cell instance sg13cmos5l_nand2b_1_4 r0 *1 0,0
Xsg13cmos5l_nand2b_1_4 \$3491 \$3517 VPWR VGND \$4094 sg13cmos5l_nand2b_1
* cell instance sg13cmos5l_nand2b_1_5 r0 *1 0,0
Xsg13cmos5l_nand2b_1_5 \$3018 \$3268 VPWR VGND \$3070 sg13cmos5l_nand2b_1
* cell instance sg13cmos5l_nand2b_1_6 r0 *1 0,0
Xsg13cmos5l_nand2b_1_6 \$3517 \$3020 VPWR VGND \$4237 sg13cmos5l_nand2b_1
* cell instance sg13cmos5l_nand2b_1_7 r0 *1 0,0
Xsg13cmos5l_nand2b_1_7 \$856 \$398 VPWR VGND \$853 sg13cmos5l_nand2b_1
* cell instance sg13cmos5l_nand2b_1_8 r0 *1 0,0
Xsg13cmos5l_nand2b_1_8 \$5794 \$7272 VPWR VGND \$6496 sg13cmos5l_nand2b_1
* cell instance sg13cmos5l_nand2b_1_9 r0 *1 0,0
Xsg13cmos5l_nand2b_1_9 \$398 \$700 VPWR VGND \$858 sg13cmos5l_nand2b_1
* cell instance sg13cmos5l_nand2b_1_10 r0 *1 0,0
Xsg13cmos5l_nand2b_1_10 \$2434 \$2138 VPWR VGND \$3072 sg13cmos5l_nand2b_1
* cell instance sg13cmos5l_nand2b_1_11 r0 *1 0,0
Xsg13cmos5l_nand2b_1_11 \$5794 \$5140 VPWR VGND \$5221 sg13cmos5l_nand2b_1
* cell instance sg13cmos5l_nand2b_1_12 r0 *1 0,0
Xsg13cmos5l_nand2b_1_12 \$398 \$705 VPWR VGND \$567 sg13cmos5l_nand2b_1
* cell instance sg13cmos5l_nand2b_1_13 r0 *1 0,0
Xsg13cmos5l_nand2b_1_13 \$3206 \$3268 VPWR VGND \$3262 sg13cmos5l_nand2b_1
* cell instance sg13cmos5l_nand2b_1_14 r0 *1 0,0
Xsg13cmos5l_nand2b_1_14 \$5361 \$4083 VPWR VGND \$5144 sg13cmos5l_nand2b_1
* cell instance sg13cmos5l_nand2b_1_15 r0 *1 0,0
Xsg13cmos5l_nand2b_1_15 \$1692 \$823 VPWR VGND \$1849 sg13cmos5l_nand2b_1
* cell instance sg13cmos5l_nand2b_1_16 r0 *1 0,0
Xsg13cmos5l_nand2b_1_16 \$823 \$1692 VPWR VGND \$1909 sg13cmos5l_nand2b_1
* cell instance sg13cmos5l_nand2b_1_17 r0 *1 0,0
Xsg13cmos5l_nand2b_1_17 \$1869 \$1910 VPWR VGND \$1948 sg13cmos5l_nand2b_1
* cell instance sg13cmos5l_nand2b_1_18 r0 *1 0,0
Xsg13cmos5l_nand2b_1_18 \$9183 \$9181 VPWR VGND \$8278 sg13cmos5l_nand2b_1
* cell instance sg13cmos5l_nand2b_1_19 r0 *1 0,0
Xsg13cmos5l_nand2b_1_19 \$1910 \$1869 VPWR VGND \$2458 sg13cmos5l_nand2b_1
* cell instance sg13cmos5l_nand2b_1_20 r0 *1 0,0
Xsg13cmos5l_nand2b_1_20 \$1573 \$1574 VPWR VGND \$1111 sg13cmos5l_nand2b_1
* cell instance sg13cmos5l_nand2b_1_21 r0 *1 0,0
Xsg13cmos5l_nand2b_1_21 \$1337 \$1111 VPWR VGND \$1112 sg13cmos5l_nand2b_1
* cell instance sg13cmos5l_nand2b_1_22 r0 *1 0,0
Xsg13cmos5l_nand2b_1_22 \$403 \$250 VPWR VGND \$579 sg13cmos5l_nand2b_1
* cell instance sg13cmos5l_nand2b_1_23 r0 *1 0,0
Xsg13cmos5l_nand2b_1_23 \$690 \$863 VPWR VGND \$418 sg13cmos5l_nand2b_1
* cell instance sg13cmos5l_nand2b_1_24 r0 *1 0,0
Xsg13cmos5l_nand2b_1_24 \$707 \$560 VPWR VGND \$261 sg13cmos5l_nand2b_1
* cell instance sg13cmos5l_nand2b_1_25 r0 *1 0,0
Xsg13cmos5l_nand2b_1_25 \$580 \$709 VPWR VGND \$685 sg13cmos5l_nand2b_1
* cell instance sg13cmos5l_nand2b_1_26 r0 *1 0,0
Xsg13cmos5l_nand2b_1_26 \$690 \$880 VPWR VGND \$875 sg13cmos5l_nand2b_1
* cell instance sg13cmos5l_nand2b_1_27 r0 *1 0,0
Xsg13cmos5l_nand2b_1_27 \$638 \$639 VPWR VGND \$312 sg13cmos5l_nand2b_1
* cell instance sg13cmos5l_nand2b_1_28 r0 *1 0,0
Xsg13cmos5l_nand2b_1_28 \$1669 \$1407 VPWR VGND \$1428 sg13cmos5l_nand2b_1
* cell instance sg13cmos5l_nand3_1_0 r0 *1 0,0
Xsg13cmos5l_nand3_1_0 \$2271 \$2208 \$3821 VPWR VGND \$3788 sg13cmos5l_nand3_1
* cell instance sg13cmos5l_nand3_1_1 r0 *1 0,0
Xsg13cmos5l_nand3_1_1 \$4614 \$3513 \$4081 VPWR VGND \$5140 sg13cmos5l_nand3_1
* cell instance sg13cmos5l_nand3_1_2 r0 *1 0,0
Xsg13cmos5l_nand3_1_2 \$5359 \$6426 \$6677 VPWR VGND \$6575 sg13cmos5l_nand3_1
* cell instance sg13cmos5l_nand3_1_3 r0 *1 0,0
Xsg13cmos5l_nand3_1_3 \$6679 \$6575 \$6678 VPWR VGND \$4762 sg13cmos5l_nand3_1
* cell instance sg13cmos5l_nand3_1_4 r0 *1 0,0
Xsg13cmos5l_nand3_1_4 \$8577 \$8283 \$7705 VPWR VGND \$5360 sg13cmos5l_nand3_1
* cell instance sg13cmos5l_nand3_1_5 r0 *1 0,0
Xsg13cmos5l_nand3_1_5 \$9025 \$8715 \$8144 VPWR VGND \$6680 sg13cmos5l_nand3_1
* cell instance sg13cmos5l_nand3_1_6 r0 *1 0,0
Xsg13cmos5l_nand3_1_6 \$5137 \$5140 \$4767 VPWR VGND \$5724 sg13cmos5l_nand3_1
* cell instance sg13cmos5l_nand3_1_7 r0 *1 0,0
Xsg13cmos5l_nand3_1_7 \$5141 \$2921 \$4766 VPWR VGND \$4100 sg13cmos5l_nand3_1
* cell instance sg13cmos5l_nand3_1_8 r0 *1 0,0
Xsg13cmos5l_nand3_1_8 \$1547 \$2437 \$2435 VPWR VGND \$2755 sg13cmos5l_nand3_1
* cell instance sg13cmos5l_nand3_1_9 r0 *1 0,0
Xsg13cmos5l_nand3_1_9 \$2082 \$2078 \$1908 VPWR VGND \$12258 sg13cmos5l_nand3_1
* cell instance sg13cmos5l_nand3_1_10 r0 *1 0,0
Xsg13cmos5l_nand3_1_10 \$3832 \$3018 \$3206 VPWR VGND \$3795 sg13cmos5l_nand3_1
* cell instance sg13cmos5l_nand3_1_11 r0 *1 0,0
Xsg13cmos5l_nand3_1_11 \$10040 \$2894 \$1908 VPWR VGND \$10796
+ sg13cmos5l_nand3_1
* cell instance sg13cmos5l_nand3_1_12 r0 *1 0,0
Xsg13cmos5l_nand3_1_12 \$8856 \$9529 \$8578 VPWR VGND \$6682 sg13cmos5l_nand3_1
* cell instance sg13cmos5l_nand3_1_13 r0 *1 0,0
Xsg13cmos5l_nand3_1_13 \$1692 \$823 \$1910 VPWR VGND \$1576 sg13cmos5l_nand3_1
* cell instance sg13cmos5l_nand3_1_14 r0 *1 0,0
Xsg13cmos5l_nand3_1_14 \$9184 \$9033 \$8720 VPWR VGND \$7275 sg13cmos5l_nand3_1
* cell instance sg13cmos5l_nand3_1_15 r0 *1 0,0
Xsg13cmos5l_nand3_1_15 \$261 \$257 \$247 VPWR VGND \$253 sg13cmos5l_nand3_1
* cell instance sg13cmos5l_nand3_1_16 r0 *1 0,0
Xsg13cmos5l_nand3_1_16 \$260 \$261 \$263 VPWR VGND \$262 sg13cmos5l_nand3_1
* cell instance sg13cmos5l_nand3_1_17 r0 *1 0,0
Xsg13cmos5l_nand3_1_17 \$718 \$880 \$728 VPWR VGND \$721 sg13cmos5l_nand3_1
* cell instance sg13cmos5l_nand3_1_18 r0 *1 0,0
Xsg13cmos5l_nand3_1_18 \$605 \$452 \$457 VPWR VGND \$612 sg13cmos5l_nand3_1
* cell instance sg13cmos5l_nand3_1_19 r0 *1 0,0
Xsg13cmos5l_nand3_1_19 \$455 \$142 \$448 VPWR VGND \$457 sg13cmos5l_nand3_1
* cell instance sg13cmos5l_nand3_1_20 r0 *1 0,0
Xsg13cmos5l_nand3_1_20 \$934 \$1186 \$929 VPWR VGND \$766 sg13cmos5l_nand3_1
* cell instance sg13cmos5l_nand3_1_21 r0 *1 0,0
Xsg13cmos5l_nand3_1_21 \$22 \$21 \$20 VPWR VGND \$18 sg13cmos5l_nand3_1
* cell instance sg13cmos5l_nand3_1_22 r0 *1 0,0
Xsg13cmos5l_nand3_1_22 \$22 \$21 \$156 VPWR VGND \$339 sg13cmos5l_nand3_1
* cell instance sg13cmos5l_nand3_1_23 r0 *1 0,0
Xsg13cmos5l_nand3_1_23 \$515 \$348 \$513 VPWR VGND \$505 sg13cmos5l_nand3_1
* cell instance sg13cmos5l_nand3_1_24 r0 *1 0,0
Xsg13cmos5l_nand3_1_24 \$665 \$977 \$779 VPWR VGND \$1463 sg13cmos5l_nand3_1
* cell instance sg13cmos5l_nand3_1_25 r0 *1 0,0
Xsg13cmos5l_nand3_1_25 \$808 \$807 \$675 VPWR VGND \$798 sg13cmos5l_nand3_1
* cell instance sg13cmos5l_nand3b_1_0 r0 *1 0,0
Xsg13cmos5l_nand3b_1_0 \$3492 \$3736 \$3501 VPWR VGND \$3519 sg13cmos5l_nand3b_1
* cell instance sg13cmos5l_nand3b_1_1 r0 *1 0,0
Xsg13cmos5l_nand3b_1_1 \$3737 \$3738 \$3207 VPWR VGND \$3522 sg13cmos5l_nand3b_1
* cell instance sg13cmos5l_nand3b_1_2 r0 *1 0,0
Xsg13cmos5l_nand3b_1_2 \$4046 \$3069 \$3207 VPWR VGND \$4026 sg13cmos5l_nand3b_1
* cell instance sg13cmos5l_nand4_1_0 r0 *1 0,0
Xsg13cmos5l_nand4_1_0 \$3499 \$3447 \$3788 \$3735 VPWR VGND \$3513
+ sg13cmos5l_nand4_1
* cell instance sg13cmos5l_nand4_1_1 r0 *1 0,0
Xsg13cmos5l_nand4_1_1 \$4322 \$4428 \$4154 \$4237 VPWR VGND \$3827
+ sg13cmos5l_nand4_1
* cell instance sg13cmos5l_nand4_1_2 r0 *1 0,0
Xsg13cmos5l_nand4_1_2 \$2885 \$2944 \$2728 \$3070 VPWR VGND \$2890
+ sg13cmos5l_nand4_1
* cell instance sg13cmos5l_nand4_1_3 r0 *1 0,0
Xsg13cmos5l_nand4_1_3 \$408 \$404 \$561 \$88 VPWR VGND \$403 sg13cmos5l_nand4_1
* cell instance sg13cmos5l_nand4_1_4 r0 *1 0,0
Xsg13cmos5l_nand4_1_4 \$4161 \$4324 \$4082 \$4323 VPWR VGND \$4045
+ sg13cmos5l_nand4_1
* cell instance sg13cmos5l_nand4_1_5 r0 *1 0,0
Xsg13cmos5l_nand4_1_5 \$3270 \$3269 \$3075 \$3262 VPWR VGND \$3076
+ sg13cmos5l_nand4_1
* cell instance sg13cmos5l_nand4_1_6 r0 *1 0,0
Xsg13cmos5l_nand4_1_6 \$665 \$808 \$807 \$779 VPWR VGND \$806 sg13cmos5l_nand4_1
* cell instance sg13cmos5l_nor2_1_0 r0 *1 0,0
Xsg13cmos5l_nor2_1_0 \$3499 \$2755 VPWR VGND \$1871 sg13cmos5l_nor2_1
* cell instance sg13cmos5l_nor2_1_1 r0 *1 0,0
Xsg13cmos5l_nor2_1_1 \$3492 \$3825 VPWR VGND \$3789 sg13cmos5l_nor2_1
* cell instance sg13cmos5l_nor2_1_2 r0 *1 0,0
Xsg13cmos5l_nor2_1_2 \$3274 \$3017 VPWR VGND \$5141 sg13cmos5l_nor2_1
* cell instance sg13cmos5l_nor2_1_3 r0 *1 0,0
Xsg13cmos5l_nor2_1_3 \$3491 \$3493 VPWR VGND \$3492 sg13cmos5l_nor2_1
* cell instance sg13cmos5l_nor2_1_4 r0 *1 0,0
Xsg13cmos5l_nor2_1_4 \$5794 \$5362 VPWR VGND \$5721 sg13cmos5l_nor2_1
* cell instance sg13cmos5l_nor2_1_5 r0 *1 0,0
Xsg13cmos5l_nor2_1_5 \$391 \$392 VPWR VGND \$202 sg13cmos5l_nor2_1
* cell instance sg13cmos5l_nor2_1_6 r0 *1 0,0
Xsg13cmos5l_nor2_1_6 \$692 \$87 VPWR VGND \$88 sg13cmos5l_nor2_1
* cell instance sg13cmos5l_nor2_1_7 r0 *1 0,0
Xsg13cmos5l_nor2_1_7 \$560 \$88 VPWR VGND \$205 sg13cmos5l_nor2_1
* cell instance sg13cmos5l_nor2_1_8 r0 *1 0,0
Xsg13cmos5l_nor2_1_8 \$391 \$1562 VPWR VGND \$375 sg13cmos5l_nor2_1
* cell instance sg13cmos5l_nor2_1_9 r0 *1 0,0
Xsg13cmos5l_nor2_1_9 \$399 \$396 VPWR VGND \$562 sg13cmos5l_nor2_1
* cell instance sg13cmos5l_nor2_1_10 r0 *1 0,0
Xsg13cmos5l_nor2_1_10 \$89 \$365 VPWR VGND \$90 sg13cmos5l_nor2_1
* cell instance sg13cmos5l_nor2_1_11 r0 *1 0,0
Xsg13cmos5l_nor2_1_11 \$1849 \$2458 VPWR VGND \$2761 sg13cmos5l_nor2_1
* cell instance sg13cmos5l_nor2_1_12 r0 *1 0,0
Xsg13cmos5l_nor2_1_12 \$1571 \$2458 VPWR VGND \$2729 sg13cmos5l_nor2_1
* cell instance sg13cmos5l_nor2_1_13 r0 *1 0,0
Xsg13cmos5l_nor2_1_13 \$1909 \$2458 VPWR VGND \$2436 sg13cmos5l_nor2_1
* cell instance sg13cmos5l_nor2_1_14 r0 *1 0,0
Xsg13cmos5l_nor2_1_14 \$863 \$875 VPWR VGND \$1547 sg13cmos5l_nor2_1
* cell instance sg13cmos5l_nor2_1_15 r0 *1 0,0
Xsg13cmos5l_nor2_1_15 \$412 \$861 VPWR VGND \$568 sg13cmos5l_nor2_1
* cell instance sg13cmos5l_nor2_1_16 r0 *1 0,0
Xsg13cmos5l_nor2_1_16 \$863 \$1566 VPWR VGND \$572 sg13cmos5l_nor2_1
* cell instance sg13cmos5l_nor2_1_17 r0 *1 0,0
Xsg13cmos5l_nor2_1_17 \$5223 \$5224 VPWR VGND \$6214 sg13cmos5l_nor2_1
* cell instance sg13cmos5l_nor2_1_18 r0 *1 0,0
Xsg13cmos5l_nor2_1_18 \$408 \$365 VPWR VGND \$409 sg13cmos5l_nor2_1
* cell instance sg13cmos5l_nor2_1_19 r0 *1 0,0
Xsg13cmos5l_nor2_1_19 \$412 \$1565 VPWR VGND \$410 sg13cmos5l_nor2_1
* cell instance sg13cmos5l_nor2_1_20 r0 *1 0,0
Xsg13cmos5l_nor2_1_20 \$1571 \$2459 VPWR VGND \$2731 sg13cmos5l_nor2_1
* cell instance sg13cmos5l_nor2_1_21 r0 *1 0,0
Xsg13cmos5l_nor2_1_21 \$1948 \$1849 VPWR VGND \$2416 sg13cmos5l_nor2_1
* cell instance sg13cmos5l_nor2_1_22 r0 *1 0,0
Xsg13cmos5l_nor2_1_22 \$1909 \$2459 VPWR VGND \$3078 sg13cmos5l_nor2_1
* cell instance sg13cmos5l_nor2_1_23 r0 *1 0,0
Xsg13cmos5l_nor2_1_23 \$3501 \$3020 VPWR VGND \$4724 sg13cmos5l_nor2_1
* cell instance sg13cmos5l_nor2_1_24 r0 *1 0,0
Xsg13cmos5l_nor2_1_24 \$1571 \$1569 VPWR VGND \$1337 sg13cmos5l_nor2_1
* cell instance sg13cmos5l_nor2_1_25 r0 *1 0,0
Xsg13cmos5l_nor2_1_25 \$1692 \$1948 VPWR VGND \$2763 sg13cmos5l_nor2_1
* cell instance sg13cmos5l_nor2_1_26 r0 *1 0,0
Xsg13cmos5l_nor2_1_26 \$1869 \$1576 VPWR VGND \$1574 sg13cmos5l_nor2_1
* cell instance sg13cmos5l_nor2_1_27 r0 *1 0,0
Xsg13cmos5l_nor2_1_27 \$1569 \$1856 VPWR VGND \$589 sg13cmos5l_nor2_1
* cell instance sg13cmos5l_nor2_1_28 r0 *1 0,0
Xsg13cmos5l_nor2_1_28 \$863 \$1855 VPWR VGND \$577 sg13cmos5l_nor2_1
* cell instance sg13cmos5l_nor2_1_29 r0 *1 0,0
Xsg13cmos5l_nor2_1_29 \$412 \$690 VPWR VGND \$868 sg13cmos5l_nor2_1
* cell instance sg13cmos5l_nor2_1_30 r0 *1 0,0
Xsg13cmos5l_nor2_1_30 \$690 \$139 VPWR VGND \$706 sg13cmos5l_nor2_1
* cell instance sg13cmos5l_nor2_1_31 r0 *1 0,0
Xsg13cmos5l_nor2_1_31 \$718 \$717 VPWR VGND \$716 sg13cmos5l_nor2_1
* cell instance sg13cmos5l_nor2_1_32 r0 *1 0,0
Xsg13cmos5l_nor2_1_32 \$2082 \$2894 VPWR VGND \$13900 sg13cmos5l_nor2_1
* cell instance sg13cmos5l_nor2_1_33 r0 *1 0,0
Xsg13cmos5l_nor2_1_33 \$427 \$717 VPWR VGND \$605 sg13cmos5l_nor2_1
* cell instance sg13cmos5l_nor2_1_34 r0 *1 0,0
Xsg13cmos5l_nor2_1_34 \$582 \$457 VPWR VGND \$255 sg13cmos5l_nor2_1
* cell instance sg13cmos5l_nor2_1_35 r0 *1 0,0
Xsg13cmos5l_nor2_1_35 \$148 \$486 VPWR VGND \$487 sg13cmos5l_nor2_1
* cell instance sg13cmos5l_nor2_1_36 r0 *1 0,0
Xsg13cmos5l_nor2_1_36 \$1407 \$929 VPWR VGND \$1408 sg13cmos5l_nor2_1
* cell instance sg13cmos5l_nor2_1_37 r0 *1 0,0
Xsg13cmos5l_nor2_1_37 \$638 \$639 VPWR VGND \$486 sg13cmos5l_nor2_1
* cell instance sg13cmos5l_nor2_1_38 r0 *1 0,0
Xsg13cmos5l_nor2_1_38 \$149 \$150 VPWR VGND \$148 sg13cmos5l_nor2_1
* cell instance sg13cmos5l_nor2_1_39 r0 *1 0,0
Xsg13cmos5l_nor2_1_39 \$20 \$183 VPWR VGND \$182 sg13cmos5l_nor2_1
* cell instance sg13cmos5l_nor2b_1_0 r0 *1 0,0
Xsg13cmos5l_nor2b_1_0 \$3017 \$3274 VPWR VGND \$3790 sg13cmos5l_nor2b_1
* cell instance sg13cmos5l_nor2b_1_1 r0 *1 0,0
Xsg13cmos5l_nor2b_1_1 \$4093 \$4091 VPWR VGND \$3825 sg13cmos5l_nor2b_1
* cell instance sg13cmos5l_nor2b_1_2 r0 *1 0,0
Xsg13cmos5l_nor2b_1_2 \$7106 \$3501 VPWR VGND \$6678 sg13cmos5l_nor2b_1
* cell instance sg13cmos5l_nor2b_1_3 r0 *1 0,0
Xsg13cmos5l_nor2b_1_3 \$1930 \$2174 VPWR VGND \$3275 sg13cmos5l_nor2b_1
* cell instance sg13cmos5l_nor2b_1_4 r0 *1 0,0
Xsg13cmos5l_nor2b_1_4 \$5140 \$3268 VPWR VGND \$7776 sg13cmos5l_nor2b_1
* cell instance sg13cmos5l_nor2b_1_5 r0 *1 0,0
Xsg13cmos5l_nor2b_1_5 \$5794 \$7272 VPWR VGND \$4767 sg13cmos5l_nor2b_1
* cell instance sg13cmos5l_nor2b_1_6 r0 *1 0,0
Xsg13cmos5l_nor2b_1_6 \$5362 \$5649 VPWR VGND \$4098 sg13cmos5l_nor2b_1
* cell instance sg13cmos5l_nor2b_1_7 r0 *1 0,0
Xsg13cmos5l_nor2b_1_7 \$7273 \$2761 VPWR VGND \$8719 sg13cmos5l_nor2b_1
* cell instance sg13cmos5l_nor2b_1_8 r0 *1 0,0
Xsg13cmos5l_nor2b_1_8 \$1910 \$1869 VPWR VGND \$2275 sg13cmos5l_nor2b_1
* cell instance sg13cmos5l_nor2b_1_9 r0 *1 0,0
Xsg13cmos5l_nor2b_1_9 \$61 \$18 VPWR VGND \$159 sg13cmos5l_nor2b_1
* cell instance sg13cmos5l_nor3_1_0 r0 *1 0,0
Xsg13cmos5l_nor3_1_0 \$2271 \$2208 \$4087 VPWR VGND \$4613 sg13cmos5l_nor3_1
* cell instance sg13cmos5l_nor3_1_1 r0 *1 0,0
Xsg13cmos5l_nor3_1_1 \$2426 \$2208 \$2755 VPWR VGND \$2179 sg13cmos5l_nor3_1
* cell instance sg13cmos5l_nor3_1_2 r0 *1 0,0
Xsg13cmos5l_nor3_1_2 \$2271 \$2723 \$2755 VPWR VGND \$2206 sg13cmos5l_nor3_1
* cell instance sg13cmos5l_nor3_1_3 r0 *1 0,0
Xsg13cmos5l_nor3_1_3 \$2426 \$2723 \$2755 VPWR VGND \$1878 sg13cmos5l_nor3_1
* cell instance sg13cmos5l_nor3_1_4 r0 *1 0,0
Xsg13cmos5l_nor3_1_4 \$5141 \$4158 \$6496 VPWR VGND \$5362 sg13cmos5l_nor3_1
* cell instance sg13cmos5l_nor3_1_5 r0 *1 0,0
Xsg13cmos5l_nor3_1_5 \$236 \$45 \$399 VPWR VGND \$398 sg13cmos5l_nor3_1
* cell instance sg13cmos5l_nor3_1_6 r0 *1 0,0
Xsg13cmos5l_nor3_1_6 \$5141 \$4158 \$5724 VPWR VGND \$5223 sg13cmos5l_nor3_1
* cell instance sg13cmos5l_nor3_1_7 r0 *1 0,0
Xsg13cmos5l_nor3_1_7 \$3074 \$3522 \$4100 VPWR VGND \$4099 sg13cmos5l_nor3_1
* cell instance sg13cmos5l_nor3_1_8 r0 *1 0,0
Xsg13cmos5l_nor3_1_8 \$2762 \$3501 \$3020 VPWR VGND \$3261 sg13cmos5l_nor3_1
* cell instance sg13cmos5l_nor3_1_9 r0 *1 0,0
Xsg13cmos5l_nor3_1_9 \$1692 \$823 \$2458 VPWR VGND \$2896 sg13cmos5l_nor3_1
* cell instance sg13cmos5l_nor3_1_10 r0 *1 0,0
Xsg13cmos5l_nor3_1_10 \$1864 \$1569 \$1849 VPWR VGND \$1786 sg13cmos5l_nor3_1
* cell instance sg13cmos5l_nor3_1_11 r0 *1 0,0
Xsg13cmos5l_nor3_1_11 \$505 \$339 \$499 VPWR VGND \$506 sg13cmos5l_nor3_1
* cell instance sg13cmos5l_nor4_1_0 r0 *1 0,0
Xsg13cmos5l_nor4_1_0 \$399 \$700 \$387 \$844 VPWR VGND \$561 sg13cmos5l_nor4_1
* cell instance sg13cmos5l_nor4_1_1 r0 *1 0,0
Xsg13cmos5l_nor4_1_1 \$4767 \$5359 \$4026 \$4619 VPWR VGND \$4618
+ sg13cmos5l_nor4_1
* cell instance sg13cmos5l_nor4_1_2 r0 *1 0,0
Xsg13cmos5l_nor4_1_2 \$7706 \$7707 \$5137 \$7272 VPWR VGND \$4766
+ sg13cmos5l_nor4_1
* cell instance sg13cmos5l_nor4_1_3 r0 *1 0,0
Xsg13cmos5l_nor4_1_3 \$2275 \$3074 \$3522 \$4098 VPWR VGND \$4083
+ sg13cmos5l_nor4_1
* cell instance sg13cmos5l_nor4_1_4 r0 *1 0,0
Xsg13cmos5l_nor4_1_4 \$392 \$1563 \$859 \$1562 VPWR VGND \$1847
+ sg13cmos5l_nor4_1
* cell instance sg13cmos5l_nor4_1_5 r0 *1 0,0
Xsg13cmos5l_nor4_1_5 \$863 \$875 \$1948 \$1909 VPWR VGND \$1908
+ sg13cmos5l_nor4_1
* cell instance sg13cmos5l_nor4_1_6 r0 *1 0,0
Xsg13cmos5l_nor4_1_6 \$2275 \$2762 \$2763 \$2760 VPWR VGND \$2730
+ sg13cmos5l_nor4_1
* cell instance sg13cmos5l_nor4_1_7 r0 *1 0,0
Xsg13cmos5l_nor4_1_7 \$2082 \$1692 \$823 \$1948 VPWR VGND \$2945
+ sg13cmos5l_nor4_1
* cell instance sg13cmos5l_nor4_1_8 r0 *1 0,0
Xsg13cmos5l_nor4_1_8 \$3451 \$4099 \$4618 \$4101 VPWR VGND \$3928
+ sg13cmos5l_nor4_1
* cell instance sg13cmos5l_nor4_1_9 r0 *1 0,0
Xsg13cmos5l_nor4_1_9 \$5221 \$4157 \$3795 \$4166 VPWR VGND \$4101
+ sg13cmos5l_nor4_1
* cell instance sg13cmos5l_nor4_1_10 r0 *1 0,0
Xsg13cmos5l_nor4_1_10 \$10040 \$1692 \$823 \$1948 VPWR VGND \$2759
+ sg13cmos5l_nor4_1
* cell instance sg13cmos5l_nor4_1_11 r0 *1 0,0
Xsg13cmos5l_nor4_1_11 \$1865 \$1852 \$1564 \$1846 VPWR VGND \$1853
+ sg13cmos5l_nor4_1
* cell instance sg13cmos5l_nor4_1_12 r0 *1 0,0
Xsg13cmos5l_nor4_1_12 \$663 \$505 \$339 \$179 VPWR VGND \$150 sg13cmos5l_nor4_1
* cell instance sg13cmos5l_nor4_1_13 r0 *1 0,0
Xsg13cmos5l_nor4_1_13 \$663 \$796 \$1413 \$798 VPWR VGND \$799 sg13cmos5l_nor4_1
* cell instance sg13cmos5l_nor4_1_14 r0 *1 0,0
Xsg13cmos5l_nor4_1_14 \$663 \$798 \$506 \$800 VPWR VGND \$801 sg13cmos5l_nor4_1
* cell instance sg13cmos5l_o21ai_1_0 r0 *1 0,0
Xsg13cmos5l_o21ai_1_0 \$374 \$375 \$377 VPWR VGND \$376 sg13cmos5l_o21ai_1
* cell instance sg13cmos5l_o21ai_1_1 r0 *1 0,0
Xsg13cmos5l_o21ai_1_1 \$200 \$202 \$31 VPWR VGND \$203 sg13cmos5l_o21ai_1
* cell instance sg13cmos5l_o21ai_1_2 r0 *1 0,0
Xsg13cmos5l_o21ai_1_2 \$4094 \$3493 \$4019 VPWR VGND \$4076 sg13cmos5l_o21ai_1
* cell instance sg13cmos5l_o21ai_1_3 r0 *1 0,0
Xsg13cmos5l_o21ai_1_3 \$2174 \$1930 \$2886 VPWR VGND \$2885 sg13cmos5l_o21ai_1
* cell instance sg13cmos5l_o21ai_1_4 r0 *1 0,0
Xsg13cmos5l_o21ai_1_4 \$6496 \$4076 \$3501 VPWR VGND \$6357 sg13cmos5l_o21ai_1
* cell instance sg13cmos5l_o21ai_1_5 r0 *1 0,0
Xsg13cmos5l_o21ai_1_5 \$853 \$693 \$854 VPWR VGND \$850 sg13cmos5l_o21ai_1
* cell instance sg13cmos5l_o21ai_1_6 r0 *1 0,0
Xsg13cmos5l_o21ai_1_6 \$5141 \$4158 \$6496 VPWR VGND \$5649 sg13cmos5l_o21ai_1
* cell instance sg13cmos5l_o21ai_1_7 r0 *1 0,0
Xsg13cmos5l_o21ai_1_7 \$391 \$1546 \$1089 VPWR VGND \$1323 sg13cmos5l_o21ai_1
* cell instance sg13cmos5l_o21ai_1_8 r0 *1 0,0
Xsg13cmos5l_o21ai_1_8 \$844 \$853 \$391 VPWR VGND \$693 sg13cmos5l_o21ai_1
* cell instance sg13cmos5l_o21ai_1_9 r0 *1 0,0
Xsg13cmos5l_o21ai_1_9 \$560 \$387 \$703 VPWR VGND \$388 sg13cmos5l_o21ai_1
* cell instance sg13cmos5l_o21ai_1_10 r0 *1 0,0
Xsg13cmos5l_o21ai_1_10 \$3069 \$3206 \$3018 VPWR VGND \$3520 sg13cmos5l_o21ai_1
* cell instance sg13cmos5l_o21ai_1_11 r0 *1 0,0
Xsg13cmos5l_o21ai_1_11 \$236 \$45 \$399 VPWR VGND \$705 sg13cmos5l_o21ai_1
* cell instance sg13cmos5l_o21ai_1_12 r0 *1 0,0
Xsg13cmos5l_o21ai_1_12 \$1849 \$2459 \$2084 VPWR VGND \$2437 sg13cmos5l_o21ai_1
* cell instance sg13cmos5l_o21ai_1_13 r0 *1 0,0
Xsg13cmos5l_o21ai_1_13 \$4046 \$7109 \$3501 VPWR VGND \$7274 sg13cmos5l_o21ai_1
* cell instance sg13cmos5l_o21ai_1_14 r0 *1 0,0
Xsg13cmos5l_o21ai_1_14 \$2275 \$2762 \$1547 VPWR VGND \$3451 sg13cmos5l_o21ai_1
* cell instance sg13cmos5l_o21ai_1_15 r0 *1 0,0
Xsg13cmos5l_o21ai_1_15 \$5223 \$5224 \$4046 VPWR VGND \$5145 sg13cmos5l_o21ai_1
* cell instance sg13cmos5l_o21ai_1_16 r0 *1 0,0
Xsg13cmos5l_o21ai_1_16 \$4091 \$4093 \$2921 VPWR VGND \$4323 sg13cmos5l_o21ai_1
* cell instance sg13cmos5l_o21ai_1_17 r0 *1 0,0
Xsg13cmos5l_o21ai_1_17 \$4046 \$7109 \$8278 VPWR VGND \$8129 sg13cmos5l_o21ai_1
* cell instance sg13cmos5l_o21ai_1_18 r0 *1 0,0
Xsg13cmos5l_o21ai_1_18 \$5801 \$5726 \$2731 VPWR VGND \$6428 sg13cmos5l_o21ai_1
* cell instance sg13cmos5l_o21ai_1_19 r0 *1 0,0
Xsg13cmos5l_o21ai_1_19 \$863 \$1111 \$260 VPWR VGND \$865 sg13cmos5l_o21ai_1
* cell instance sg13cmos5l_o21ai_1_20 r0 *1 0,0
Xsg13cmos5l_o21ai_1_20 \$1342 \$589 \$1343 VPWR VGND \$707 sg13cmos5l_o21ai_1
* cell instance sg13cmos5l_o21ai_1_21 r0 *1 0,0
Xsg13cmos5l_o21ai_1_21 \$707 \$1786 \$868 VPWR VGND \$709 sg13cmos5l_o21ai_1
* cell instance sg13cmos5l_o21ai_1_22 r0 *1 0,0
Xsg13cmos5l_o21ai_1_22 \$875 \$872 \$720 VPWR VGND \$876 sg13cmos5l_o21ai_1
* cell instance sg13cmos5l_or2_1_0 r0 *1 0,0
Xsg13cmos5l_or2_1_0 \$2271 \$2208 VPWR VGND \$3499 sg13cmos5l_or2_1
* cell instance sg13cmos5l_or2_1_1 r0 *1 0,0
Xsg13cmos5l_or2_1_1 \$206 \$205 VPWR VGND \$374 sg13cmos5l_or2_1
* cell instance sg13cmos5l_or2_1_2 r0 *1 0,0
Xsg13cmos5l_or2_1_2 \$4765 \$8282 VPWR VGND \$7272 sg13cmos5l_or2_1
* cell instance sg13cmos5l_or2_1_3 r0 *1 0,0
Xsg13cmos5l_or2_1_3 \$4097 \$4235 VPWR VGND \$4157 sg13cmos5l_or2_1
* cell instance sg13cmos5l_or2_1_4 r0 *1 0,0
Xsg13cmos5l_or2_1_4 \$2434 \$2138 VPWR VGND \$3097 sg13cmos5l_or2_1
* cell instance sg13cmos5l_or2_1_5 r0 *1 0,0
Xsg13cmos5l_or2_1_5 \$9181 \$9183 VPWR VGND \$7707 sg13cmos5l_or2_1
* cell instance sg13cmos5l_or2_1_6 r0 *1 0,0
Xsg13cmos5l_or2_1_6 \$9527 \$8717 VPWR VGND \$7706 sg13cmos5l_or2_1
* cell instance sg13cmos5l_or2_1_7 r0 *1 0,0
Xsg13cmos5l_or2_1_7 \$1869 \$1910 VPWR VGND \$2459 sg13cmos5l_or2_1
* cell instance sg13cmos5l_or2_1_8 r0 *1 0,0
Xsg13cmos5l_or2_1_8 \$3207 \$3261 VPWR VGND \$3270 sg13cmos5l_or2_1
* cell instance sg13cmos5l_or2_1_9 r0 *1 0,0
Xsg13cmos5l_or2_1_9 \$690 \$587 VPWR VGND \$728 sg13cmos5l_or2_1
* cell instance sg13cmos5l_or2_1_10 r0 *1 0,0
Xsg13cmos5l_or2_1_10 \$299 \$637 VPWR VGND \$474 sg13cmos5l_or2_1
* cell instance sg13cmos5l_or2_1_11 r0 *1 0,0
Xsg13cmos5l_or2_1_11 \$676 \$806 VPWR VGND \$179 sg13cmos5l_or2_1
* cell instance sg13cmos5l_or3_1_0 r0 *1 0,0
Xsg13cmos5l_or3_1_0 \$4768 \$4094 \$4724 VPWR VGND \$4619 sg13cmos5l_or3_1
* cell instance sg13cmos5l_or3_1_1 r0 *1 0,0
Xsg13cmos5l_or3_1_1 \$717 \$602 \$448 VPWR VGND \$373 sg13cmos5l_or3_1
* cell instance sg13cmos5l_or4_1_0 r0 *1 0,0
Xsg13cmos5l_or4_1_0 \$5801 \$5726 \$5800 \$5144 VPWR VGND \$3927
+ sg13cmos5l_or4_1
* cell instance sg13cmos5l_tiehi_0 r0 *1 0,0
Xsg13cmos5l_tiehi_0 \$1583 VPWR VGND sg13cmos5l_tiehi
* cell instance sg13cmos5l_tiehi_1 r0 *1 0,0
Xsg13cmos5l_tiehi_1 \$1358 VPWR VGND sg13cmos5l_tiehi
* cell instance sg13cmos5l_tiehi_2 r0 *1 0,0
Xsg13cmos5l_tiehi_2 \$724 VPWR VGND sg13cmos5l_tiehi
* cell instance sg13cmos5l_tiehi_3 r0 *1 0,0
Xsg13cmos5l_tiehi_3 \$748 VPWR VGND sg13cmos5l_tiehi
* cell instance sg13cmos5l_tiehi_4 r0 *1 0,0
Xsg13cmos5l_tiehi_4 \$1624 VPWR VGND sg13cmos5l_tiehi
* cell instance sg13cmos5l_tiehi_5 r0 *1 0,0
Xsg13cmos5l_tiehi_5 \$298 VPWR VGND sg13cmos5l_tiehi
* cell instance sg13cmos5l_tiehi_6 r0 *1 0,0
Xsg13cmos5l_tiehi_6 \$1405 VPWR VGND sg13cmos5l_tiehi
* cell instance sg13cmos5l_tiehi_7 r0 *1 0,0
Xsg13cmos5l_tiehi_7 \$1651 VPWR VGND sg13cmos5l_tiehi
* cell instance sg13cmos5l_tiehi_8 r0 *1 0,0
Xsg13cmos5l_tiehi_8 \$769 VPWR VGND sg13cmos5l_tiehi
* cell instance sg13cmos5l_tiehi_9 r0 *1 0,0
Xsg13cmos5l_tiehi_9 \$1701 VPWR VGND sg13cmos5l_tiehi
* cell instance sg13cmos5l_tiehi_10 r0 *1 0,0
Xsg13cmos5l_tiehi_10 \$1705 VPWR VGND sg13cmos5l_tiehi
* cell instance sg13cmos5l_tiehi_11 r0 *1 0,0
Xsg13cmos5l_tiehi_11 \$1482 VPWR VGND sg13cmos5l_tiehi
* cell instance sg13cmos5l_tiehi_12 r0 *1 0,0
Xsg13cmos5l_tiehi_12 \$1494 VPWR VGND sg13cmos5l_tiehi
* cell instance sg13cmos5l_tiehi_13 r0 *1 0,0
Xsg13cmos5l_tiehi_13 \$1498 VPWR VGND sg13cmos5l_tiehi
* cell instance sg13cmos5l_tiehi_14 r0 *1 0,0
Xsg13cmos5l_tiehi_14 \$1026 VPWR VGND sg13cmos5l_tiehi
* cell instance sg13cmos5l_tiehi_15 r0 *1 0,0
Xsg13cmos5l_tiehi_15 \$1038 VPWR VGND sg13cmos5l_tiehi
* cell instance sg13cmos5l_tiehi_16 r0 *1 0,0
Xsg13cmos5l_tiehi_16 \$838 VPWR VGND sg13cmos5l_tiehi
* cell instance sg13cmos5l_tiehi_17 r0 *1 0,0
Xsg13cmos5l_tiehi_17 \$1304 VPWR VGND sg13cmos5l_tiehi
* cell instance sg13cmos5l_tielo_0 r0 *1 0,0
Xsg13cmos5l_tielo_0 uio_oe[7] VPWR VGND sg13cmos5l_tielo
* cell instance sg13cmos5l_tielo_1 r0 *1 0,0
Xsg13cmos5l_tielo_1 uio_oe[5] VPWR VGND sg13cmos5l_tielo
* cell instance sg13cmos5l_tielo_2 r0 *1 0,0
Xsg13cmos5l_tielo_2 uio_oe[6] VPWR VGND sg13cmos5l_tielo
* cell instance sg13cmos5l_tielo_3 r0 *1 0,0
Xsg13cmos5l_tielo_3 uio_oe[4] VPWR VGND sg13cmos5l_tielo
* cell instance sg13cmos5l_tielo_4 r0 *1 0,0
Xsg13cmos5l_tielo_4 uio_oe[3] VPWR VGND sg13cmos5l_tielo
* cell instance sg13cmos5l_tielo_5 r0 *1 0,0
Xsg13cmos5l_tielo_5 uio_oe[1] VPWR VGND sg13cmos5l_tielo
* cell instance sg13cmos5l_tielo_6 r0 *1 0,0
Xsg13cmos5l_tielo_6 uio_oe[2] VPWR VGND sg13cmos5l_tielo
* cell instance sg13cmos5l_tielo_7 r0 *1 0,0
Xsg13cmos5l_tielo_7 uio_oe[0] VPWR VGND sg13cmos5l_tielo
* cell instance sg13cmos5l_tielo_8 r0 *1 0,0
Xsg13cmos5l_tielo_8 \$1912 VPWR VGND sg13cmos5l_tielo
* cell instance sg13cmos5l_tielo_9 r0 *1 0,0
Xsg13cmos5l_tielo_9 \$1579 VPWR VGND sg13cmos5l_tielo
* cell instance sg13cmos5l_tielo_10 r0 *1 0,0
Xsg13cmos5l_tielo_10 \$1587 VPWR VGND sg13cmos5l_tielo
* cell instance sg13cmos5l_tielo_11 r0 *1 0,0
Xsg13cmos5l_tielo_11 \$1124 VPWR VGND sg13cmos5l_tielo
* cell instance sg13cmos5l_tielo_12 r0 *1 0,0
Xsg13cmos5l_tielo_12 \$1601 VPWR VGND sg13cmos5l_tielo
* cell instance sg13cmos5l_tielo_13 r0 *1 0,0
Xsg13cmos5l_tielo_13 \$732 VPWR VGND sg13cmos5l_tielo
* cell instance sg13cmos5l_tielo_14 r0 *1 0,0
Xsg13cmos5l_tielo_14 \$736 VPWR VGND sg13cmos5l_tielo
* cell instance sg13cmos5l_tielo_15 r0 *1 0,0
Xsg13cmos5l_tielo_15 \$1138 VPWR VGND sg13cmos5l_tielo
* cell instance sg13cmos5l_tielo_16 r0 *1 0,0
Xsg13cmos5l_tielo_16 \$740 VPWR VGND sg13cmos5l_tielo
* cell instance sg13cmos5l_tielo_17 r0 *1 0,0
Xsg13cmos5l_tielo_17 \$744 VPWR VGND sg13cmos5l_tielo
* cell instance sg13cmos5l_tielo_18 r0 *1 0,0
Xsg13cmos5l_tielo_18 \$1620 VPWR VGND sg13cmos5l_tielo
* cell instance sg13cmos5l_tielo_19 r0 *1 0,0
Xsg13cmos5l_tielo_19 \$1381 VPWR VGND sg13cmos5l_tielo
* cell instance sg13cmos5l_tielo_20 r0 *1 0,0
Xsg13cmos5l_tielo_20 \$764 VPWR VGND sg13cmos5l_tielo
* cell instance sg13cmos5l_tielo_21 r0 *1 0,0
Xsg13cmos5l_tielo_21 \$1307 VPWR VGND sg13cmos5l_tielo
* cell instance sg13cmos5l_tielo_22 r0 *1 0,0
Xsg13cmos5l_tielo_22 \$1647 VPWR VGND sg13cmos5l_tielo
* cell instance sg13cmos5l_tielo_23 r0 *1 0,0
Xsg13cmos5l_tielo_23 \$1411 VPWR VGND sg13cmos5l_tielo
* cell instance sg13cmos5l_tielo_24 r0 *1 0,0
Xsg13cmos5l_tielo_24 \$938 VPWR VGND sg13cmos5l_tielo
* cell instance sg13cmos5l_tielo_25 r0 *1 0,0
Xsg13cmos5l_tielo_25 \$942 VPWR VGND sg13cmos5l_tielo
* cell instance sg13cmos5l_tielo_26 r0 *1 0,0
Xsg13cmos5l_tielo_26 \$946 VPWR VGND sg13cmos5l_tielo
* cell instance sg13cmos5l_tielo_27 r0 *1 0,0
Xsg13cmos5l_tielo_27 \$950 VPWR VGND sg13cmos5l_tielo
* cell instance sg13cmos5l_tielo_28 r0 *1 0,0
Xsg13cmos5l_tielo_28 \$786 VPWR VGND sg13cmos5l_tielo
* cell instance sg13cmos5l_tielo_29 r0 *1 0,0
Xsg13cmos5l_tielo_29 \$2204 VPWR VGND sg13cmos5l_tielo
* cell instance sg13cmos5l_tielo_30 r0 *1 0,0
Xsg13cmos5l_tielo_30 \$1682 VPWR VGND sg13cmos5l_tielo
* cell instance sg13cmos5l_tielo_31 r0 *1 0,0
Xsg13cmos5l_tielo_31 \$1443 VPWR VGND sg13cmos5l_tielo
* cell instance sg13cmos5l_tielo_32 r0 *1 0,0
Xsg13cmos5l_tielo_32 \$1686 VPWR VGND sg13cmos5l_tielo
* cell instance sg13cmos5l_tielo_33 r0 *1 0,0
Xsg13cmos5l_tielo_33 \$1690 VPWR VGND sg13cmos5l_tielo
* cell instance sg13cmos5l_tielo_34 r0 *1 0,0
Xsg13cmos5l_tielo_34 \$1857 VPWR VGND sg13cmos5l_tielo
* cell instance sg13cmos5l_tielo_35 r0 *1 0,0
Xsg13cmos5l_tielo_35 \$1458 VPWR VGND sg13cmos5l_tielo
* cell instance sg13cmos5l_tielo_36 r0 *1 0,0
Xsg13cmos5l_tielo_36 \$1697 VPWR VGND sg13cmos5l_tielo
* cell instance sg13cmos5l_tielo_37 r0 *1 0,0
Xsg13cmos5l_tielo_37 \$1709 VPWR VGND sg13cmos5l_tielo
* cell instance sg13cmos5l_tielo_38 r0 *1 0,0
Xsg13cmos5l_tielo_38 \$1713 VPWR VGND sg13cmos5l_tielo
* cell instance sg13cmos5l_tielo_39 r0 *1 0,0
Xsg13cmos5l_tielo_39 \$1717 VPWR VGND sg13cmos5l_tielo
* cell instance sg13cmos5l_tielo_40 r0 *1 0,0
Xsg13cmos5l_tielo_40 \$1478 VPWR VGND sg13cmos5l_tielo
* cell instance sg13cmos5l_tielo_41 r0 *1 0,0
Xsg13cmos5l_tielo_41 \$1006 VPWR VGND sg13cmos5l_tielo
* cell instance sg13cmos5l_tielo_42 r0 *1 0,0
Xsg13cmos5l_tielo_42 \$1010 VPWR VGND sg13cmos5l_tielo
* cell instance sg13cmos5l_tielo_43 r0 *1 0,0
Xsg13cmos5l_tielo_43 \$1308 VPWR VGND sg13cmos5l_tielo
* cell instance sg13cmos5l_tielo_44 r0 *1 0,0
Xsg13cmos5l_tielo_44 \$1030 VPWR VGND sg13cmos5l_tielo
* cell instance sg13cmos5l_tielo_45 r0 *1 0,0
Xsg13cmos5l_tielo_45 \$1512 VPWR VGND sg13cmos5l_tielo
* cell instance sg13cmos5l_tielo_46 r0 *1 0,0
Xsg13cmos5l_tielo_46 \$830 VPWR VGND sg13cmos5l_tielo
* cell instance sg13cmos5l_tielo_47 r0 *1 0,0
Xsg13cmos5l_tielo_47 \$1042 VPWR VGND sg13cmos5l_tielo
* cell instance sg13cmos5l_tielo_48 r0 *1 0,0
Xsg13cmos5l_tielo_48 \$834 VPWR VGND sg13cmos5l_tielo
* cell instance sg13cmos5l_tielo_49 r0 *1 0,0
Xsg13cmos5l_tielo_49 \$842 VPWR VGND sg13cmos5l_tielo
* cell instance sg13cmos5l_tielo_50 r0 *1 0,0
Xsg13cmos5l_tielo_50 \$1058 VPWR VGND sg13cmos5l_tielo
* cell instance sg13cmos5l_tielo_51 r0 *1 0,0
Xsg13cmos5l_tielo_51 \$1541 VPWR VGND sg13cmos5l_tielo
* cell instance sg13cmos5l_tielo_52 r0 *1 0,0
Xsg13cmos5l_tielo_52 \$1914 VPWR VGND sg13cmos5l_tielo
* cell instance sg13cmos5l_xnor2_1_0 r0 *1 0,0
Xsg13cmos5l_xnor2_1_0 \$3274 \$3017 VPWR VGND \$3517 sg13cmos5l_xnor2_1
* cell instance sg13cmos5l_xnor2_1_1 r0 *1 0,0
Xsg13cmos5l_xnor2_1_1 \$3517 \$3789 VPWR VGND \$3925 sg13cmos5l_xnor2_1
* cell instance sg13cmos5l_xnor2_1_2 r0 *1 0,0
Xsg13cmos5l_xnor2_1_2 \$2174 \$1930 VPWR VGND \$3069 sg13cmos5l_xnor2_1
* cell instance sg13cmos5l_xnor2_1_3 r0 *1 0,0
Xsg13cmos5l_xnor2_1_3 \$5359 \$5721 VPWR VGND \$5361 sg13cmos5l_xnor2_1
* cell instance sg13cmos5l_xnor2_1_4 r0 *1 0,0
Xsg13cmos5l_xnor2_1_4 \$3491 \$3520 VPWR VGND \$3738 sg13cmos5l_xnor2_1
* cell instance sg13cmos5l_xnor2_1_5 r0 *1 0,0
Xsg13cmos5l_xnor2_1_5 \$236 \$89 VPWR VGND \$239 sg13cmos5l_xnor2_1
* cell instance sg13cmos5l_xnor2_1_6 r0 *1 0,0
Xsg13cmos5l_xnor2_1_6 \$4046 \$6214 VPWR VGND \$5800 sg13cmos5l_xnor2_1
* cell instance sg13cmos5l_xnor2_1_7 r0 *1 0,0
Xsg13cmos5l_xnor2_1_7 \$4768 \$8129 VPWR VGND \$7276 sg13cmos5l_xnor2_1
* cell instance sg13cmos5l_xnor2_1_8 r0 *1 0,0
Xsg13cmos5l_xnor2_1_8 \$248 \$247 VPWR VGND \$250 sg13cmos5l_xnor2_1
* cell instance sg13cmos5l_xnor2_1_9 r0 *1 0,0
Xsg13cmos5l_xnor2_1_9 \$134 \$457 VPWR VGND \$458 sg13cmos5l_xnor2_1
* cell instance sg13cmos5l_xnor2_1_10 r0 *1 0,0
Xsg13cmos5l_xnor2_1_10 \$156 \$18 VPWR VGND \$158 sg13cmos5l_xnor2_1
* cell instance sg13cmos5l_xnor2_1_11 r0 *1 0,0
Xsg13cmos5l_xnor2_1_11 \$796 \$779 VPWR VGND \$797 sg13cmos5l_xnor2_1
* cell instance sg13cmos5l_xnor2_1_12 r0 *1 0,0
Xsg13cmos5l_xnor2_1_12 \$808 \$800 VPWR VGND \$1225 sg13cmos5l_xnor2_1
* cell instance sg13cmos5l_xnor2_1_13 r0 *1 0,0
Xsg13cmos5l_xnor2_1_13 \$807 \$1463 VPWR VGND \$1465 sg13cmos5l_xnor2_1
* cell instance sg13cmos5l_xnor2_1_14 r0 *1 0,0
Xsg13cmos5l_xnor2_1_14 \$675 \$806 VPWR VGND \$534 sg13cmos5l_xnor2_1
* cell instance sg13cmos5l_xor2_1_0 r0 *1 0,0
Xsg13cmos5l_xor2_1_0 \$4091 \$4093 VPWR VGND \$3491 sg13cmos5l_xor2_1
* cell instance sg13cmos5l_xor2_1_1 r0 *1 0,0
Xsg13cmos5l_xor2_1_1 \$3069 \$3072 VPWR VGND \$3073 sg13cmos5l_xor2_1
* cell instance sg13cmos5l_xor2_1_2 r0 *1 0,0
Xsg13cmos5l_xor2_1_2 \$3517 \$3829 VPWR VGND \$3737 sg13cmos5l_xor2_1
* cell instance sg13cmos5l_xor2_1_3 r0 *1 0,0
Xsg13cmos5l_xor2_1_3 \$3069 \$3206 VPWR VGND \$3074 sg13cmos5l_xor2_1
* cell instance sg13cmos5l_xor2_1_4 r0 *1 0,0
Xsg13cmos5l_xor2_1_4 \$3491 \$3520 VPWR VGND \$3831 sg13cmos5l_xor2_1
* cell instance sg13cmos5l_xor2_1_5 r0 *1 0,0
Xsg13cmos5l_xor2_1_5 \$537 \$266 VPWR VGND \$263 sg13cmos5l_xor2_1
* cell instance sg13cmos5l_xor2_1_6 r0 *1 0,0
Xsg13cmos5l_xor2_1_6 \$455 \$448 VPWR VGND \$607 sg13cmos5l_xor2_1
* cell instance sg13cmos5l_xor2_1_7 r0 *1 0,0
Xsg13cmos5l_xor2_1_7 \$22 \$20 VPWR VGND \$19 sg13cmos5l_xor2_1
* cell instance sg13cmos5l_xor2_1_8 r0 *1 0,0
Xsg13cmos5l_xor2_1_8 \$515 \$517 VPWR VGND \$668 sg13cmos5l_xor2_1
* cell instance sg13cmos5l_xor2_1_9 r0 *1 0,0
Xsg13cmos5l_xor2_1_9 \$348 \$181 VPWR VGND \$187 sg13cmos5l_xor2_1
.ENDS tt_um_2amlogic_protocol_emulator

* cell sg13cmos5l_xor2_1
* pin A
* pin B
* pin VDD
* pin VSS
* pin X
.SUBCKT sg13cmos5l_xor2_1 A B VDD VSS X
.ENDS sg13cmos5l_xor2_1

* cell sg13cmos5l_xnor2_1
* pin A
* pin B
* pin VDD
* pin VSS
* pin Y
.SUBCKT sg13cmos5l_xnor2_1 A B VDD VSS Y
.ENDS sg13cmos5l_xnor2_1

* cell sg13cmos5l_tielo
* pin L_LO
* pin VDD
* pin VSS
.SUBCKT sg13cmos5l_tielo L_LO VDD VSS
.ENDS sg13cmos5l_tielo

* cell sg13cmos5l_tiehi
* pin L_HI
* pin VDD
* pin VSS
.SUBCKT sg13cmos5l_tiehi L_HI VDD VSS
.ENDS sg13cmos5l_tiehi

* cell sg13cmos5l_or4_1
* pin A
* pin B
* pin C
* pin D
* pin VDD
* pin VSS
* pin X
.SUBCKT sg13cmos5l_or4_1 A B C D VDD VSS X
.ENDS sg13cmos5l_or4_1

* cell sg13cmos5l_or3_1
* pin A
* pin B
* pin C
* pin VDD
* pin VSS
* pin X
.SUBCKT sg13cmos5l_or3_1 A B C VDD VSS X
.ENDS sg13cmos5l_or3_1

* cell sg13cmos5l_or2_1
* pin A
* pin B
* pin VDD
* pin VSS
* pin X
.SUBCKT sg13cmos5l_or2_1 A B VDD VSS X
.ENDS sg13cmos5l_or2_1

* cell sg13cmos5l_o21ai_1
* pin A1
* pin A2
* pin B1
* pin VDD
* pin VSS
* pin Y
.SUBCKT sg13cmos5l_o21ai_1 A1 A2 B1 VDD VSS Y
.ENDS sg13cmos5l_o21ai_1

* cell sg13cmos5l_nor4_1
* pin A
* pin B
* pin C
* pin D
* pin VDD
* pin VSS
* pin Y
.SUBCKT sg13cmos5l_nor4_1 A B C D VDD VSS Y
.ENDS sg13cmos5l_nor4_1

* cell sg13cmos5l_nor3_1
* pin A
* pin B
* pin C
* pin VDD
* pin VSS
* pin Y
.SUBCKT sg13cmos5l_nor3_1 A B C VDD VSS Y
.ENDS sg13cmos5l_nor3_1

* cell sg13cmos5l_nor2b_1
* pin A
* pin B_N
* pin VDD
* pin VSS
* pin Y
.SUBCKT sg13cmos5l_nor2b_1 A B_N VDD VSS Y
.ENDS sg13cmos5l_nor2b_1

* cell sg13cmos5l_nor2_1
* pin A
* pin B
* pin VDD
* pin VSS
* pin Y
.SUBCKT sg13cmos5l_nor2_1 A B VDD VSS Y
.ENDS sg13cmos5l_nor2_1

* cell sg13cmos5l_nand4_1
* pin A
* pin B
* pin C
* pin D
* pin VDD
* pin VSS
* pin Y
.SUBCKT sg13cmos5l_nand4_1 A B C D VDD VSS Y
.ENDS sg13cmos5l_nand4_1

* cell sg13cmos5l_nand3b_1
* pin A_N
* pin B
* pin C
* pin VDD
* pin VSS
* pin Y
.SUBCKT sg13cmos5l_nand3b_1 A_N B C VDD VSS Y
.ENDS sg13cmos5l_nand3b_1

* cell sg13cmos5l_nand3_1
* pin A
* pin B
* pin C
* pin VDD
* pin VSS
* pin Y
.SUBCKT sg13cmos5l_nand3_1 A B C VDD VSS Y
.ENDS sg13cmos5l_nand3_1

* cell sg13cmos5l_nand2b_1
* pin A_N
* pin B
* pin VDD
* pin VSS
* pin Y
.SUBCKT sg13cmos5l_nand2b_1 A_N B VDD VSS Y
.ENDS sg13cmos5l_nand2b_1

* cell sg13cmos5l_nand2_1
* pin A
* pin B
* pin VDD
* pin VSS
* pin Y
.SUBCKT sg13cmos5l_nand2_1 A B VDD VSS Y
.ENDS sg13cmos5l_nand2_1

* cell sg13cmos5l_mux4_1
* pin A0
* pin A1
* pin A2
* pin A3
* pin S0
* pin S1
* pin VDD
* pin VSS
* pin X
.SUBCKT sg13cmos5l_mux4_1 A0 A1 A2 A3 S0 S1 VDD VSS X
.ENDS sg13cmos5l_mux4_1

* cell sg13cmos5l_mux2_1
* pin A0
* pin A1
* pin S
* pin VDD
* pin VSS
* pin X
.SUBCKT sg13cmos5l_mux2_1 A0 A1 S VDD VSS X
.ENDS sg13cmos5l_mux2_1

* cell sg13cmos5l_inv_1
* pin A
* pin VDD
* pin VSS
* pin Y
.SUBCKT sg13cmos5l_inv_1 A VDD VSS Y
.ENDS sg13cmos5l_inv_1

* cell sg13cmos5l_fill_2
* pin VDD
* pin VSS
.SUBCKT sg13cmos5l_fill_2 VDD VSS
.ENDS sg13cmos5l_fill_2

* cell sg13cmos5l_fill_1
* pin VDD
* pin VSS
.SUBCKT sg13cmos5l_fill_1 VDD VSS
.ENDS sg13cmos5l_fill_1

* cell sg13cmos5l_dlygate4sd3_1
* pin A
* pin VDD
* pin VSS
* pin X
.SUBCKT sg13cmos5l_dlygate4sd3_1 A VDD VSS X
.ENDS sg13cmos5l_dlygate4sd3_1

* cell sg13cmos5l_dfrbpq_1
* pin CLK
* pin D
* pin Q
* pin RESET_B
* pin VDD
* pin VSS
.SUBCKT sg13cmos5l_dfrbpq_1 CLK D Q RESET_B VDD VSS
.ENDS sg13cmos5l_dfrbpq_1

* cell sg13cmos5l_decap_8
* pin VDD
* pin VSS
.SUBCKT sg13cmos5l_decap_8 VDD VSS
.ENDS sg13cmos5l_decap_8

* cell sg13cmos5l_decap_4
* pin VDD
* pin VSS
.SUBCKT sg13cmos5l_decap_4 VDD VSS
.ENDS sg13cmos5l_decap_4

* cell sg13cmos5l_buf_8
* pin A
* pin VDD
* pin VSS
* pin X
.SUBCKT sg13cmos5l_buf_8 A VDD VSS X
.ENDS sg13cmos5l_buf_8

* cell sg13cmos5l_buf_4
* pin A
* pin VDD
* pin VSS
* pin X
.SUBCKT sg13cmos5l_buf_4 A VDD VSS X
.ENDS sg13cmos5l_buf_4

* cell sg13cmos5l_buf_1
* pin A
* pin VDD
* pin VSS
* pin X
.SUBCKT sg13cmos5l_buf_1 A VDD VSS X
.ENDS sg13cmos5l_buf_1

* cell sg13cmos5l_antennanp
* pin A
* pin VDD
* pin VSS
.SUBCKT sg13cmos5l_antennanp A VDD VSS
.ENDS sg13cmos5l_antennanp

* cell sg13cmos5l_and3_1
* pin A
* pin B
* pin C
* pin VDD
* pin VSS
* pin X
.SUBCKT sg13cmos5l_and3_1 A B C VDD VSS X
.ENDS sg13cmos5l_and3_1

* cell sg13cmos5l_and2_1
* pin A
* pin B
* pin VDD
* pin VSS
* pin X
.SUBCKT sg13cmos5l_and2_1 A B VDD VSS X
.ENDS sg13cmos5l_and2_1

* cell sg13cmos5l_a22oi_1
* pin A1
* pin A2
* pin B1
* pin B2
* pin VDD
* pin VSS
* pin Y
.SUBCKT sg13cmos5l_a22oi_1 A1 A2 B1 B2 VDD VSS Y
.ENDS sg13cmos5l_a22oi_1

* cell sg13cmos5l_a221oi_1
* pin A1
* pin A2
* pin B1
* pin B2
* pin C1
* pin VDD
* pin VSS
* pin Y
.SUBCKT sg13cmos5l_a221oi_1 A1 A2 B1 B2 C1 VDD VSS Y
.ENDS sg13cmos5l_a221oi_1

* cell sg13cmos5l_a21oi_1
* pin A1
* pin A2
* pin B1
* pin VDD
* pin VSS
* pin Y
.SUBCKT sg13cmos5l_a21oi_1 A1 A2 B1 VDD VSS Y
.ENDS sg13cmos5l_a21oi_1

* cell sg13cmos5l_a21o_1
* pin A1
* pin A2
* pin B1
* pin VDD
* pin VSS
* pin X
.SUBCKT sg13cmos5l_a21o_1 A1 A2 B1 VDD VSS X
.ENDS sg13cmos5l_a21o_1

* cell RM_IHPSG13_1P_256x16_c2_bm_bist
* pin A_ADDR<0>
* pin A_ADDR<1>
* pin A_ADDR<2>
* pin A_ADDR<3>
* pin A_ADDR<4>
* pin A_ADDR<5>
* pin A_ADDR<6>
* pin A_ADDR<7>
* pin A_BIST_ADDR<0>
* pin A_BIST_ADDR<1>
* pin A_BIST_ADDR<2>
* pin A_BIST_ADDR<3>
* pin A_BIST_ADDR<4>
* pin A_BIST_ADDR<5>
* pin A_BIST_ADDR<6>
* pin A_BIST_ADDR<7>
* pin A_BIST_BM<0>
* pin A_BIST_BM<10>
* pin A_BIST_BM<11>
* pin A_BIST_BM<12>
* pin A_BIST_BM<13>
* pin A_BIST_BM<14>
* pin A_BIST_BM<15>
* pin A_BIST_BM<1>
* pin A_BIST_BM<2>
* pin A_BIST_BM<3>
* pin A_BIST_BM<4>
* pin A_BIST_BM<5>
* pin A_BIST_BM<6>
* pin A_BIST_BM<7>
* pin A_BIST_BM<8>
* pin A_BIST_BM<9>
* pin A_BIST_CLK
* pin A_BIST_DIN<0>
* pin A_BIST_DIN<10>
* pin A_BIST_DIN<11>
* pin A_BIST_DIN<12>
* pin A_BIST_DIN<13>
* pin A_BIST_DIN<14>
* pin A_BIST_DIN<15>
* pin A_BIST_DIN<1>
* pin A_BIST_DIN<2>
* pin A_BIST_DIN<3>
* pin A_BIST_DIN<4>
* pin A_BIST_DIN<5>
* pin A_BIST_DIN<6>
* pin A_BIST_DIN<7>
* pin A_BIST_DIN<8>
* pin A_BIST_DIN<9>
* pin A_BIST_EN
* pin A_BIST_MEN
* pin A_BIST_REN
* pin A_BIST_WEN
* pin A_BM<0>
* pin A_BM<10>
* pin A_BM<11>
* pin A_BM<12>
* pin A_BM<13>
* pin A_BM<14>
* pin A_BM<15>
* pin A_BM<1>
* pin A_BM<2>
* pin A_BM<3>
* pin A_BM<4>
* pin A_BM<5>
* pin A_BM<6>
* pin A_BM<7>
* pin A_BM<8>
* pin A_BM<9>
* pin A_CLK
* pin A_DIN<0>
* pin A_DIN<10>
* pin A_DIN<11>
* pin A_DIN<12>
* pin A_DIN<13>
* pin A_DIN<14>
* pin A_DIN<15>
* pin A_DIN<1>
* pin A_DIN<2>
* pin A_DIN<3>
* pin A_DIN<4>
* pin A_DIN<5>
* pin A_DIN<6>
* pin A_DIN<7>
* pin A_DIN<8>
* pin A_DIN<9>
* pin A_DLY
* pin A_DOUT<0>
* pin A_DOUT<10>
* pin A_DOUT<11>
* pin A_DOUT<12>
* pin A_DOUT<13>
* pin A_DOUT<14>
* pin A_DOUT<15>
* pin A_DOUT<1>
* pin A_DOUT<2>
* pin A_DOUT<3>
* pin A_DOUT<4>
* pin A_DOUT<5>
* pin A_DOUT<6>
* pin A_DOUT<7>
* pin A_DOUT<8>
* pin A_DOUT<9>
* pin A_MEN
* pin A_REN
* pin A_WEN
* pin VDD!
* pin VDDARRAY!
* pin VSS!
.SUBCKT RM_IHPSG13_1P_256x16_c2_bm_bist A_ADDR<0> A_ADDR<1> A_ADDR<2> A_ADDR<3>
+ A_ADDR<4> A_ADDR<5> A_ADDR<6> A_ADDR<7> A_BIST_ADDR<0> A_BIST_ADDR<1>
+ A_BIST_ADDR<2> A_BIST_ADDR<3> A_BIST_ADDR<4> A_BIST_ADDR<5> A_BIST_ADDR<6>
+ A_BIST_ADDR<7> A_BIST_BM<0> A_BIST_BM<10> A_BIST_BM<11> A_BIST_BM<12>
+ A_BIST_BM<13> A_BIST_BM<14> A_BIST_BM<15> A_BIST_BM<1> A_BIST_BM<2>
+ A_BIST_BM<3> A_BIST_BM<4> A_BIST_BM<5> A_BIST_BM<6> A_BIST_BM<7> A_BIST_BM<8>
+ A_BIST_BM<9> A_BIST_CLK A_BIST_DIN<0> A_BIST_DIN<10> A_BIST_DIN<11>
+ A_BIST_DIN<12> A_BIST_DIN<13> A_BIST_DIN<14> A_BIST_DIN<15> A_BIST_DIN<1>
+ A_BIST_DIN<2> A_BIST_DIN<3> A_BIST_DIN<4> A_BIST_DIN<5> A_BIST_DIN<6>
+ A_BIST_DIN<7> A_BIST_DIN<8> A_BIST_DIN<9> A_BIST_EN A_BIST_MEN A_BIST_REN
+ A_BIST_WEN A_BM<0> A_BM<10> A_BM<11> A_BM<12> A_BM<13> A_BM<14> A_BM<15>
+ A_BM<1> A_BM<2> A_BM<3> A_BM<4> A_BM<5> A_BM<6> A_BM<7> A_BM<8> A_BM<9> A_CLK
+ A_DIN<0> A_DIN<10> A_DIN<11> A_DIN<12> A_DIN<13> A_DIN<14> A_DIN<15> A_DIN<1>
+ A_DIN<2> A_DIN<3> A_DIN<4> A_DIN<5> A_DIN<6> A_DIN<7> A_DIN<8> A_DIN<9> A_DLY
+ A_DOUT<0> A_DOUT<10> A_DOUT<11> A_DOUT<12> A_DOUT<13> A_DOUT<14> A_DOUT<15>
+ A_DOUT<1> A_DOUT<2> A_DOUT<3> A_DOUT<4> A_DOUT<5> A_DOUT<6> A_DOUT<7>
+ A_DOUT<8> A_DOUT<9> A_MEN A_REN A_WEN VDD! VDDARRAY! VSS!
.ENDS RM_IHPSG13_1P_256x16_c2_bm_bist
