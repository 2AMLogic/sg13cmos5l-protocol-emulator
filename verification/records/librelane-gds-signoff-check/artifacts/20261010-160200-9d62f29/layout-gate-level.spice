* extracted by klt extract --deck sg13cmos5l

* cell tt_um_2amlogic_protocol_emulator
* pin VGND
* pin VPWR
* pin clk
* pin rst_n
* pin ui_in[0]
* pin ui_in[1]
* pin ui_in[2]
* pin ui_in[3]
* pin ui_in[4]
* pin ui_in[5]
* pin ui_in[6]
* pin ui_in[7]
* pin uio_in[0]
* pin uio_in[1]
* pin uio_in[2]
* pin uio_in[3]
* pin uio_in[4]
* pin uio_in[5]
* pin uio_in[6]
* pin uio_in[7]
* pin uio_oe[0]
* pin uio_oe[1]
* pin uio_oe[2]
* pin uio_oe[3]
* pin uio_oe[4]
* pin uio_oe[5]
* pin uio_oe[6]
* pin uio_oe[7]
* pin uio_out[0]
* pin uio_out[1]
* pin uio_out[2]
* pin uio_out[3]
* pin uio_out[4]
* pin uio_out[5]
* pin uio_out[6]
* pin uio_out[7]
* pin uo_out[0]
* pin uo_out[1]
* pin uo_out[2]
* pin uo_out[3]
* pin uo_out[4]
* pin uo_out[5]
* pin uo_out[6]
* pin uo_out[7]
* pin ena
.SUBCKT tt_um_2amlogic_protocol_emulator VGND VPWR clk rst_n ui_in[0] ui_in[1]
+ ui_in[2] ui_in[3] ui_in[4] ui_in[5] ui_in[6] ui_in[7] uio_in[0] uio_in[1]
+ uio_in[2] uio_in[3] uio_in[4] uio_in[5] uio_in[6] uio_in[7] uio_oe[0]
+ uio_oe[1] uio_oe[2] uio_oe[3] uio_oe[4] uio_oe[5] uio_oe[6] uio_oe[7]
+ uio_out[0] uio_out[1] uio_out[2] uio_out[3] uio_out[4] uio_out[5] uio_out[6]
+ uio_out[7] uo_out[0] uo_out[1] uo_out[2] uo_out[3] uo_out[4] uo_out[5]
+ uo_out[6] uo_out[7] ena
* cell instance RM_IHPSG13_1P_256x16_c2_bm_bist_0 r0 *1 0,0
XRM_IHPSG13_1P_256x16_c2_bm_bist_0 \$6328 \$6121 \$6132 \$6338 \$6587 \$6127
+ \$6320 \$6111 \$6331 \$5923 \$5813 \$6581 \$6594 \$6590 \$6560 \$6564 \$6451
+ \$6641 \$6651 \$6663 \$6674 \$6688 \$6700 \$6467 \$6481 \$6292 \$6507 \$6523
+ \$6534 \$6552 \$6609 \$6625 \$6100 \$6787 \$6361 \$6653 \$6667 \$6680 \$6692
+ \$6957 \$6462 \$6477 \$6493 \$6503 \$6515 \$6531 \$6548 \$6614 \$6629 \$7246
+ \$6309 \$6573 \$6311 \$6458 \$6637 \$6367 \$6659 \$6672 \$6684 \$6696 \$6473
+ \$6489 \$6296 \$6511 \$6527 \$6540 \$6556 \$6605 \$6621 \$6570 \$6954 \$6643
+ \$6792 \$6872 \$6920 \$6956 \$6960 \$6784 \$6788 \$6854 \$6894 \$6981 \$6871
+ \$6486 \$6615 \$6631 \$6598 \$4857 \$3824 \$3608 \$4705 \$4706 \$3982 \$4353
+ \$4252 \$4507 \$4251 \$3780 \$4149 \$6267 \$3525 \$4341 \$3974 \$5925 \$6120
+ \$7848 VPWR VPWR VGND RM_IHPSG13_1P_256x16_c2_bm_bist
* cell instance sg13cmos5l_a21o_1_0 r0 *1 0,0
Xsg13cmos5l_a21o_1_0 \$6732 \$6021 \$6730 VPWR VGND \$6844 sg13cmos5l_a21o_1
* cell instance sg13cmos5l_a21o_1_1 r0 *1 0,0
Xsg13cmos5l_a21o_1_1 \$6908 \$4844 \$4086 VPWR VGND \$6905 sg13cmos5l_a21o_1
* cell instance sg13cmos5l_a21o_1_2 r0 *1 0,0
Xsg13cmos5l_a21o_1_2 \$3719 \$1205 \$4036 VPWR VGND \$3912 sg13cmos5l_a21o_1
* cell instance sg13cmos5l_a21o_1_3 r0 *1 0,0
Xsg13cmos5l_a21o_1_3 \$1076 \$2312 \$1793 VPWR VGND \$3139 sg13cmos5l_a21o_1
* cell instance sg13cmos5l_a21o_1_4 r0 *1 0,0
Xsg13cmos5l_a21o_1_4 \$1323 \$1410 \$1324 VPWR VGND \$1319 sg13cmos5l_a21o_1
* cell instance sg13cmos5l_a21o_1_5 r0 *1 0,0
Xsg13cmos5l_a21o_1_5 \$1324 \$1185 \$2701 VPWR VGND \$2716 sg13cmos5l_a21o_1
* cell instance sg13cmos5l_a21o_1_6 r0 *1 0,0
Xsg13cmos5l_a21o_1_6 \$3353 \$4664 \$4668 VPWR VGND \$4833 sg13cmos5l_a21o_1
* cell instance sg13cmos5l_a21o_1_7 r0 *1 0,0
Xsg13cmos5l_a21o_1_7 \$1348 \$401 \$1347 VPWR VGND \$1349 sg13cmos5l_a21o_1
* cell instance sg13cmos5l_a21o_1_8 r0 *1 0,0
Xsg13cmos5l_a21o_1_8 \$5516 \$5646 \$4986 VPWR VGND \$5894 sg13cmos5l_a21o_1
* cell instance sg13cmos5l_a21o_1_9 r0 *1 0,0
Xsg13cmos5l_a21o_1_9 \$1845 \$1846 \$1843 VPWR VGND \$1839 sg13cmos5l_a21o_1
* cell instance sg13cmos5l_a21o_1_10 r0 *1 0,0
Xsg13cmos5l_a21o_1_10 \$1845 \$2029 \$1843 VPWR VGND \$2025 sg13cmos5l_a21o_1
* cell instance sg13cmos5l_a21o_1_11 r0 *1 0,0
Xsg13cmos5l_a21o_1_11 \$1845 \$2027 \$1839 VPWR VGND \$1854 sg13cmos5l_a21o_1
* cell instance sg13cmos5l_a21o_1_12 r0 *1 0,0
Xsg13cmos5l_a21o_1_12 \$433 \$419 \$558 VPWR VGND \$327 sg13cmos5l_a21o_1
* cell instance sg13cmos5l_a21o_1_13 r0 *1 0,0
Xsg13cmos5l_a21o_1_13 \$3786 \$3675 \$3596 VPWR VGND \$8 sg13cmos5l_a21o_1
* cell instance sg13cmos5l_a21o_1_14 r0 *1 0,0
Xsg13cmos5l_a21o_1_14 \$2198 \$2208 \$2284 VPWR VGND \$2205 sg13cmos5l_a21o_1
* cell instance sg13cmos5l_a21o_1_15 r0 *1 0,0
Xsg13cmos5l_a21o_1_15 \$4862 \$3592 \$4545 VPWR VGND \$2210 sg13cmos5l_a21o_1
* cell instance sg13cmos5l_a21o_1_16 r0 *1 0,0
Xsg13cmos5l_a21o_1_16 \$205 \$427 \$705 VPWR VGND \$703 sg13cmos5l_a21o_1
* cell instance sg13cmos5l_a21o_1_17 r0 *1 0,0
Xsg13cmos5l_a21o_1_17 \$558 \$18 \$205 VPWR VGND \$106 sg13cmos5l_a21o_1
* cell instance sg13cmos5l_a21o_1_18 r0 *1 0,0
Xsg13cmos5l_a21o_1_18 \$201 \$14 \$1133 VPWR VGND \$1395 sg13cmos5l_a21o_1
* cell instance sg13cmos5l_a21o_1_19 r0 *1 0,0
Xsg13cmos5l_a21o_1_19 \$3785 \$3966 \$2576 VPWR VGND \$3968 sg13cmos5l_a21o_1
* cell instance sg13cmos5l_a21o_1_20 r0 *1 0,0
Xsg13cmos5l_a21o_1_20 \$2997 \$3302 \$3022 VPWR VGND \$2887 sg13cmos5l_a21o_1
* cell instance sg13cmos5l_a21o_1_21 r0 *1 0,0
Xsg13cmos5l_a21o_1_21 \$2049 \$2214 \$1876 VPWR VGND \$2047 sg13cmos5l_a21o_1
* cell instance sg13cmos5l_a21o_1_22 r0 *1 0,0
Xsg13cmos5l_a21o_1_22 \$862 \$26 \$93 VPWR VGND \$712 sg13cmos5l_a21o_1
* cell instance sg13cmos5l_a21o_1_23 r0 *1 0,0
Xsg13cmos5l_a21o_1_23 \$1000 \$862 \$1261 VPWR VGND \$997 sg13cmos5l_a21o_1
* cell instance sg13cmos5l_a21o_1_24 r0 *1 0,0
Xsg13cmos5l_a21o_1_24 \$2541 \$2208 \$2284 VPWR VGND \$2777 sg13cmos5l_a21o_1
* cell instance sg13cmos5l_a21o_1_25 r0 *1 0,0
Xsg13cmos5l_a21o_1_25 \$3299 \$2208 \$2284 VPWR VGND \$3417 sg13cmos5l_a21o_1
* cell instance sg13cmos5l_a21o_1_26 r0 *1 0,0
Xsg13cmos5l_a21o_1_26 \$3550 \$2208 \$2284 VPWR VGND \$2891 sg13cmos5l_a21o_1
* cell instance sg13cmos5l_a21o_1_27 r0 *1 0,0
Xsg13cmos5l_a21o_1_27 \$2460 \$2231 \$3967 VPWR VGND \$3600 sg13cmos5l_a21o_1
* cell instance sg13cmos5l_a21o_1_28 r0 *1 0,0
Xsg13cmos5l_a21o_1_28 \$216 \$117 \$69 VPWR VGND \$217 sg13cmos5l_a21o_1
* cell instance sg13cmos5l_a21o_1_29 r0 *1 0,0
Xsg13cmos5l_a21o_1_29 \$1694 \$2588 \$2586 VPWR VGND \$2583 sg13cmos5l_a21o_1
* cell instance sg13cmos5l_a21o_1_30 r0 *1 0,0
Xsg13cmos5l_a21o_1_30 \$3409 \$3974 \$4175 VPWR VGND \$2260 sg13cmos5l_a21o_1
* cell instance sg13cmos5l_a21o_1_31 r0 *1 0,0
Xsg13cmos5l_a21o_1_31 \$433 \$328 \$345 VPWR VGND \$441 sg13cmos5l_a21o_1
* cell instance sg13cmos5l_a21o_1_32 r0 *1 0,0
Xsg13cmos5l_a21o_1_32 \$1275 \$1566 \$573 VPWR VGND \$1563 sg13cmos5l_a21o_1
* cell instance sg13cmos5l_a21o_1_33 r0 *1 0,0
Xsg13cmos5l_a21o_1_33 \$41 \$571 \$1579 VPWR VGND \$1914 sg13cmos5l_a21o_1
* cell instance sg13cmos5l_a21o_1_34 r0 *1 0,0
Xsg13cmos5l_a21o_1_34 \$68 \$36 \$343 VPWR VGND \$446 sg13cmos5l_a21o_1
* cell instance sg13cmos5l_a21o_1_35 r0 *1 0,0
Xsg13cmos5l_a21o_1_35 \$5026 \$4883 \$5029 VPWR VGND \$5035 sg13cmos5l_a21o_1
* cell instance sg13cmos5l_a21o_1_36 r0 *1 0,0
Xsg13cmos5l_a21o_1_36 \$5762 \$5760 \$5581 VPWR VGND \$5763 sg13cmos5l_a21o_1
* cell instance sg13cmos5l_a21o_1_37 r0 *1 0,0
Xsg13cmos5l_a21o_1_37 \$5974 \$6873 \$6856 VPWR VGND \$6801 sg13cmos5l_a21o_1
* cell instance sg13cmos5l_a21o_1_38 r0 *1 0,0
Xsg13cmos5l_a21o_1_38 \$3445 \$3685 \$3634 VPWR VGND \$2523 sg13cmos5l_a21o_1
* cell instance sg13cmos5l_a21o_1_39 r0 *1 0,0
Xsg13cmos5l_a21o_1_39 \$4725 \$4706 \$4892 VPWR VGND \$3071 sg13cmos5l_a21o_1
* cell instance sg13cmos5l_a21o_1_40 r0 *1 0,0
Xsg13cmos5l_a21o_1_40 \$4732 \$4379 \$4012 VPWR VGND \$4729 sg13cmos5l_a21o_1
* cell instance sg13cmos5l_a21o_1_41 r0 *1 0,0
Xsg13cmos5l_a21o_1_41 \$5589 \$6185 \$6187 VPWR VGND \$6394 sg13cmos5l_a21o_1
* cell instance sg13cmos5l_a21o_1_42 r0 *1 0,0
Xsg13cmos5l_a21o_1_42 \$3456 \$3452 \$3454 VPWR VGND \$3677 sg13cmos5l_a21o_1
* cell instance sg13cmos5l_a21oi_1_0 r0 *1 0,0
Xsg13cmos5l_a21oi_1_0 \$605 \$1592 \$1431 VPWR VGND \$1590 sg13cmos5l_a21oi_1
* cell instance sg13cmos5l_a21oi_1_1 r0 *1 0,0
Xsg13cmos5l_a21oi_1_1 \$786 \$1920 \$2115 VPWR VGND \$1931 sg13cmos5l_a21oi_1
* cell instance sg13cmos5l_a21oi_1_2 r0 *1 0,0
Xsg13cmos5l_a21oi_1_2 \$1052 \$3896 \$3897 VPWR VGND \$4062 sg13cmos5l_a21oi_1
* cell instance sg13cmos5l_a21oi_1_3 r0 *1 0,0
Xsg13cmos5l_a21oi_1_3 \$605 \$606 \$602 VPWR VGND \$603 sg13cmos5l_a21oi_1
* cell instance sg13cmos5l_a21oi_1_4 r0 *1 0,0
Xsg13cmos5l_a21oi_1_4 \$232 \$6018 \$5612 VPWR VGND \$5613 sg13cmos5l_a21oi_1
* cell instance sg13cmos5l_a21oi_1_5 r0 *1 0,0
Xsg13cmos5l_a21oi_1_5 \$56 \$6789 \$9737 VPWR VGND \$9934 sg13cmos5l_a21oi_1
* cell instance sg13cmos5l_a21oi_1_6 r0 *1 0,0
Xsg13cmos5l_a21oi_1_6 \$605 \$1032 \$1030 VPWR VGND \$1029 sg13cmos5l_a21oi_1
* cell instance sg13cmos5l_a21oi_1_7 r0 *1 0,0
Xsg13cmos5l_a21oi_1_7 \$1052 \$2302 \$2299 VPWR VGND \$2300 sg13cmos5l_a21oi_1
* cell instance sg13cmos5l_a21oi_1_8 r0 *1 0,0
Xsg13cmos5l_a21oi_1_8 \$1052 \$2678 \$2912 VPWR VGND \$3100 sg13cmos5l_a21oi_1
* cell instance sg13cmos5l_a21oi_1_9 r0 *1 0,0
Xsg13cmos5l_a21oi_1_9 \$2725 \$7240 \$7532 VPWR VGND \$7714 sg13cmos5l_a21oi_1
* cell instance sg13cmos5l_a21oi_1_10 r0 *1 0,0
Xsg13cmos5l_a21oi_1_10 \$1787 \$4256 \$4254 VPWR VGND \$4405 sg13cmos5l_a21oi_1
* cell instance sg13cmos5l_a21oi_1_11 r0 *1 0,0
Xsg13cmos5l_a21oi_1_11 \$1362 \$6789 \$11970 VPWR VGND \$11817
+ sg13cmos5l_a21oi_1
* cell instance sg13cmos5l_a21oi_1_12 r0 *1 0,0
Xsg13cmos5l_a21oi_1_12 \$1052 \$3320 \$3319 VPWR VGND \$3476 sg13cmos5l_a21oi_1
* cell instance sg13cmos5l_a21oi_1_13 r0 *1 0,0
Xsg13cmos5l_a21oi_1_13 \$228 \$4256 \$4628 VPWR VGND \$4629 sg13cmos5l_a21oi_1
* cell instance sg13cmos5l_a21oi_1_14 r0 *1 0,0
Xsg13cmos5l_a21oi_1_14 \$1787 \$4936 \$5245 VPWR VGND \$5414 sg13cmos5l_a21oi_1
* cell instance sg13cmos5l_a21oi_1_15 r0 *1 0,0
Xsg13cmos5l_a21oi_1_15 \$2120 \$2121 \$1936 VPWR VGND \$2114 sg13cmos5l_a21oi_1
* cell instance sg13cmos5l_a21oi_1_16 r0 *1 0,0
Xsg13cmos5l_a21oi_1_16 \$249 \$4936 \$4929 VPWR VGND \$5095 sg13cmos5l_a21oi_1
* cell instance sg13cmos5l_a21oi_1_17 r0 *1 0,0
Xsg13cmos5l_a21oi_1_17 \$1359 \$6789 \$10918 VPWR VGND \$11381
+ sg13cmos5l_a21oi_1
* cell instance sg13cmos5l_a21oi_1_18 r0 *1 0,0
Xsg13cmos5l_a21oi_1_18 \$2524 \$7240 \$7715 VPWR VGND \$7829 sg13cmos5l_a21oi_1
* cell instance sg13cmos5l_a21oi_1_19 r0 *1 0,0
Xsg13cmos5l_a21oi_1_19 \$3325 \$3328 \$3326 VPWR VGND \$3327 sg13cmos5l_a21oi_1
* cell instance sg13cmos5l_a21oi_1_20 r0 *1 0,0
Xsg13cmos5l_a21oi_1_20 \$249 \$4256 \$4918 VPWR VGND \$4930 sg13cmos5l_a21oi_1
* cell instance sg13cmos5l_a21oi_1_21 r0 *1 0,0
Xsg13cmos5l_a21oi_1_21 \$58 \$16428 \$16427 VPWR VGND \$16520 sg13cmos5l_a21oi_1
* cell instance sg13cmos5l_a21oi_1_22 r0 *1 0,0
Xsg13cmos5l_a21oi_1_22 \$2524 \$16428 \$17270 VPWR VGND \$17429
+ sg13cmos5l_a21oi_1
* cell instance sg13cmos5l_a21oi_1_23 r0 *1 0,0
Xsg13cmos5l_a21oi_1_23 \$613 \$616 \$614 VPWR VGND \$607 sg13cmos5l_a21oi_1
* cell instance sg13cmos5l_a21oi_1_24 r0 *1 0,0
Xsg13cmos5l_a21oi_1_24 \$58 \$14404 \$15317 VPWR VGND \$15157 sg13cmos5l_a21oi_1
* cell instance sg13cmos5l_a21oi_1_25 r0 *1 0,0
Xsg13cmos5l_a21oi_1_25 \$605 \$756 \$753 VPWR VGND \$754 sg13cmos5l_a21oi_1
* cell instance sg13cmos5l_a21oi_1_26 r0 *1 0,0
Xsg13cmos5l_a21oi_1_26 \$367 \$4256 \$4615 VPWR VGND \$4632 sg13cmos5l_a21oi_1
* cell instance sg13cmos5l_a21oi_1_27 r0 *1 0,0
Xsg13cmos5l_a21oi_1_27 \$2524 \$14404 \$14403 VPWR VGND \$14314
+ sg13cmos5l_a21oi_1
* cell instance sg13cmos5l_a21oi_1_28 r0 *1 0,0
Xsg13cmos5l_a21oi_1_28 \$1460 \$1602 \$1762 VPWR VGND \$1442 sg13cmos5l_a21oi_1
* cell instance sg13cmos5l_a21oi_1_29 r0 *1 0,0
Xsg13cmos5l_a21oi_1_29 \$2120 \$2481 \$2305 VPWR VGND \$2304 sg13cmos5l_a21oi_1
* cell instance sg13cmos5l_a21oi_1_30 r0 *1 0,0
Xsg13cmos5l_a21oi_1_30 \$3325 \$4075 \$3902 VPWR VGND \$3900 sg13cmos5l_a21oi_1
* cell instance sg13cmos5l_a21oi_1_31 r0 *1 0,0
Xsg13cmos5l_a21oi_1_31 \$2120 \$2920 \$2919 VPWR VGND \$2917 sg13cmos5l_a21oi_1
* cell instance sg13cmos5l_a21oi_1_32 r0 *1 0,0
Xsg13cmos5l_a21oi_1_32 \$613 \$1182 \$1034 VPWR VGND \$1285 sg13cmos5l_a21oi_1
* cell instance sg13cmos5l_a21oi_1_33 r0 *1 0,0
Xsg13cmos5l_a21oi_1_33 \$189 \$4936 \$5110 VPWR VGND \$5111 sg13cmos5l_a21oi_1
* cell instance sg13cmos5l_a21oi_1_34 r0 *1 0,0
Xsg13cmos5l_a21oi_1_34 \$605 \$1445 \$1306 VPWR VGND \$1444 sg13cmos5l_a21oi_1
* cell instance sg13cmos5l_a21oi_1_35 r0 *1 0,0
Xsg13cmos5l_a21oi_1_35 \$2725 \$14404 \$14887 VPWR VGND \$15318
+ sg13cmos5l_a21oi_1
* cell instance sg13cmos5l_a21oi_1_36 r0 *1 0,0
Xsg13cmos5l_a21oi_1_36 \$1052 \$2925 \$4260 VPWR VGND \$4259 sg13cmos5l_a21oi_1
* cell instance sg13cmos5l_a21oi_1_37 r0 *1 0,0
Xsg13cmos5l_a21oi_1_37 uio_out[7] \$8556 \$18740 VPWR VGND uio_oe[7]
+ sg13cmos5l_a21oi_1
* cell instance sg13cmos5l_a21oi_1_38 r0 *1 0,0
Xsg13cmos5l_a21oi_1_38 \$2965 \$14404 \$13808 VPWR VGND \$14407
+ sg13cmos5l_a21oi_1
* cell instance sg13cmos5l_a21oi_1_39 r0 *1 0,0
Xsg13cmos5l_a21oi_1_39 \$367 \$240 \$239 VPWR VGND \$356 sg13cmos5l_a21oi_1
* cell instance sg13cmos5l_a21oi_1_40 r0 *1 0,0
Xsg13cmos5l_a21oi_1_40 \$2965 \$14413 \$18970 VPWR VGND \$18741
+ sg13cmos5l_a21oi_1
* cell instance sg13cmos5l_a21oi_1_41 r0 *1 0,0
Xsg13cmos5l_a21oi_1_41 \$228 \$240 \$242 VPWR VGND \$241 sg13cmos5l_a21oi_1
* cell instance sg13cmos5l_a21oi_1_42 r0 *1 0,0
Xsg13cmos5l_a21oi_1_42 \$2725 \$16428 \$15829 VPWR VGND \$16272
+ sg13cmos5l_a21oi_1
* cell instance sg13cmos5l_a21oi_1_43 r0 *1 0,0
Xsg13cmos5l_a21oi_1_43 \$178 \$7240 \$7260 VPWR VGND \$7241 sg13cmos5l_a21oi_1
* cell instance sg13cmos5l_a21oi_1_44 r0 *1 0,0
Xsg13cmos5l_a21oi_1_44 \$613 \$1188 \$907 VPWR VGND \$752 sg13cmos5l_a21oi_1
* cell instance sg13cmos5l_a21oi_1_45 r0 *1 0,0
Xsg13cmos5l_a21oi_1_45 \$1052 \$2487 \$2687 VPWR VGND \$2686 sg13cmos5l_a21oi_1
* cell instance sg13cmos5l_a21oi_1_46 r0 *1 0,0
Xsg13cmos5l_a21oi_1_46 \$367 \$6018 \$6421 VPWR VGND \$6743 sg13cmos5l_a21oi_1
* cell instance sg13cmos5l_a21oi_1_47 r0 *1 0,0
Xsg13cmos5l_a21oi_1_47 \$605 \$1036 \$369 VPWR VGND \$460 sg13cmos5l_a21oi_1
* cell instance sg13cmos5l_a21oi_1_48 r0 *1 0,0
Xsg13cmos5l_a21oi_1_48 uio_out[5] \$10923 \$16073 VPWR VGND uio_oe[5]
+ sg13cmos5l_a21oi_1
* cell instance sg13cmos5l_a21oi_1_49 r0 *1 0,0
Xsg13cmos5l_a21oi_1_49 \$232 \$4936 \$4795 VPWR VGND \$4943 sg13cmos5l_a21oi_1
* cell instance sg13cmos5l_a21oi_1_50 r0 *1 0,0
Xsg13cmos5l_a21oi_1_50 \$2281 \$7240 \$6867 VPWR VGND \$6892 sg13cmos5l_a21oi_1
* cell instance sg13cmos5l_a21oi_1_51 r0 *1 0,0
Xsg13cmos5l_a21oi_1_51 \$178 \$16428 \$18029 VPWR VGND \$18320
+ sg13cmos5l_a21oi_1
* cell instance sg13cmos5l_a21oi_1_52 r0 *1 0,0
Xsg13cmos5l_a21oi_1_52 \$82 \$4265 \$4643 VPWR VGND \$4796 sg13cmos5l_a21oi_1
* cell instance sg13cmos5l_a21oi_1_53 r0 *1 0,0
Xsg13cmos5l_a21oi_1_53 uio_out[6] \$7901 \$19417 VPWR VGND uio_oe[6]
+ sg13cmos5l_a21oi_1
* cell instance sg13cmos5l_a21oi_1_54 r0 *1 0,0
Xsg13cmos5l_a21oi_1_54 \$3325 \$4082 \$4080 VPWR VGND \$4081 sg13cmos5l_a21oi_1
* cell instance sg13cmos5l_a21oi_1_55 r0 *1 0,0
Xsg13cmos5l_a21oi_1_55 \$249 \$240 \$374 VPWR VGND \$250 sg13cmos5l_a21oi_1
* cell instance sg13cmos5l_a21oi_1_56 r0 *1 0,0
Xsg13cmos5l_a21oi_1_56 \$228 \$4654 \$5260 VPWR VGND \$5259 sg13cmos5l_a21oi_1
* cell instance sg13cmos5l_a21oi_1_57 r0 *1 0,0
Xsg13cmos5l_a21oi_1_57 \$951 \$6018 \$6193 VPWR VGND \$6234 sg13cmos5l_a21oi_1
* cell instance sg13cmos5l_a21oi_1_58 r0 *1 0,0
Xsg13cmos5l_a21oi_1_58 \$605 \$763 \$625 VPWR VGND \$761 sg13cmos5l_a21oi_1
* cell instance sg13cmos5l_a21oi_1_59 r0 *1 0,0
Xsg13cmos5l_a21oi_1_59 \$2281 \$4265 \$4267 VPWR VGND \$4266 sg13cmos5l_a21oi_1
* cell instance sg13cmos5l_a21oi_1_60 r0 *1 0,0
Xsg13cmos5l_a21oi_1_60 \$1460 \$1313 \$1311 VPWR VGND \$1304 sg13cmos5l_a21oi_1
* cell instance sg13cmos5l_a21oi_1_61 r0 *1 0,0
Xsg13cmos5l_a21oi_1_61 \$605 \$1769 \$1950 VPWR VGND \$1773 sg13cmos5l_a21oi_1
* cell instance sg13cmos5l_a21oi_1_62 r0 *1 0,0
Xsg13cmos5l_a21oi_1_62 uio_out[3] \$17273 \$19418 VPWR VGND uio_oe[3]
+ sg13cmos5l_a21oi_1
* cell instance sg13cmos5l_a21oi_1_63 r0 *1 0,0
Xsg13cmos5l_a21oi_1_63 \$2001 \$15156 \$14410 VPWR VGND \$14323
+ sg13cmos5l_a21oi_1
* cell instance sg13cmos5l_a21oi_1_64 r0 *1 0,0
Xsg13cmos5l_a21oi_1_64 \$2001 \$11305 \$16953 VPWR VGND \$17025
+ sg13cmos5l_a21oi_1
* cell instance sg13cmos5l_a21oi_1_65 r0 *1 0,0
Xsg13cmos5l_a21oi_1_65 \$178 \$15156 \$15434 VPWR VGND \$15324
+ sg13cmos5l_a21oi_1
* cell instance sg13cmos5l_a21oi_1_66 r0 *1 0,0
Xsg13cmos5l_a21oi_1_66 \$3325 \$3910 \$3516 VPWR VGND \$3713 sg13cmos5l_a21oi_1
* cell instance sg13cmos5l_a21oi_1_67 r0 *1 0,0
Xsg13cmos5l_a21oi_1_67 \$1052 \$3513 \$3714 VPWR VGND \$3710 sg13cmos5l_a21oi_1
* cell instance sg13cmos5l_a21oi_1_68 r0 *1 0,0
Xsg13cmos5l_a21oi_1_68 \$613 \$477 \$378 VPWR VGND \$368 sg13cmos5l_a21oi_1
* cell instance sg13cmos5l_a21oi_1_69 r0 *1 0,0
Xsg13cmos5l_a21oi_1_69 uio_out[2] \$5640 \$17720 VPWR VGND uio_oe[2]
+ sg13cmos5l_a21oi_1
* cell instance sg13cmos5l_a21oi_1_70 r0 *1 0,0
Xsg13cmos5l_a21oi_1_70 \$2120 \$2132 \$1953 VPWR VGND \$2131 sg13cmos5l_a21oi_1
* cell instance sg13cmos5l_a21oi_1_71 r0 *1 0,0
Xsg13cmos5l_a21oi_1_71 \$2281 \$4654 \$4947 VPWR VGND \$4948 sg13cmos5l_a21oi_1
* cell instance sg13cmos5l_a21oi_1_72 r0 *1 0,0
Xsg13cmos5l_a21oi_1_72 uio_out[4] \$6439 \$17721 VPWR VGND uio_oe[4]
+ sg13cmos5l_a21oi_1
* cell instance sg13cmos5l_a21oi_1_73 r0 *1 0,0
Xsg13cmos5l_a21oi_1_73 \$2120 \$2929 \$2698 VPWR VGND \$2922 sg13cmos5l_a21oi_1
* cell instance sg13cmos5l_a21oi_1_74 r0 *1 0,0
Xsg13cmos5l_a21oi_1_74 \$82 \$267 \$80 VPWR VGND \$79 sg13cmos5l_a21oi_1
* cell instance sg13cmos5l_a21oi_1_75 r0 *1 0,0
Xsg13cmos5l_a21oi_1_75 \$1770 \$1202 \$1777 VPWR VGND \$1784 sg13cmos5l_a21oi_1
* cell instance sg13cmos5l_a21oi_1_76 r0 *1 0,0
Xsg13cmos5l_a21oi_1_76 \$2281 \$270 \$4652 VPWR VGND \$4651 sg13cmos5l_a21oi_1
* cell instance sg13cmos5l_a21oi_1_77 r0 *1 0,0
Xsg13cmos5l_a21oi_1_77 \$632 \$777 \$633 VPWR VGND \$624 sg13cmos5l_a21oi_1
* cell instance sg13cmos5l_a21oi_1_78 r0 *1 0,0
Xsg13cmos5l_a21oi_1_78 uio_out[1] \$6775 \$19338 VPWR VGND uio_oe[1]
+ sg13cmos5l_a21oi_1
* cell instance sg13cmos5l_a21oi_1_79 r0 *1 0,0
Xsg13cmos5l_a21oi_1_79 \$539 \$15156 \$15435 VPWR VGND \$15165
+ sg13cmos5l_a21oi_1
* cell instance sg13cmos5l_a21oi_1_80 r0 *1 0,0
Xsg13cmos5l_a21oi_1_80 \$4087 \$480 \$4036 VPWR VGND \$4086 sg13cmos5l_a21oi_1
* cell instance sg13cmos5l_a21oi_1_81 r0 *1 0,0
Xsg13cmos5l_a21oi_1_81 \$539 \$14413 \$16949 VPWR VGND \$16805
+ sg13cmos5l_a21oi_1
* cell instance sg13cmos5l_a21oi_1_82 r0 *1 0,0
Xsg13cmos5l_a21oi_1_82 \$367 \$267 \$383 VPWR VGND \$384 sg13cmos5l_a21oi_1
* cell instance sg13cmos5l_a21oi_1_83 r0 *1 0,0
Xsg13cmos5l_a21oi_1_83 \$2282 \$4277 \$4036 VPWR VGND \$4270 sg13cmos5l_a21oi_1
* cell instance sg13cmos5l_a21oi_1_84 r0 *1 0,0
Xsg13cmos5l_a21oi_1_84 \$1787 \$270 \$4408 VPWR VGND \$4467 sg13cmos5l_a21oi_1
* cell instance sg13cmos5l_a21oi_1_85 r0 *1 0,0
Xsg13cmos5l_a21oi_1_85 \$82 \$240 \$83 VPWR VGND \$159 sg13cmos5l_a21oi_1
* cell instance sg13cmos5l_a21oi_1_86 r0 *1 0,0
Xsg13cmos5l_a21oi_1_86 \$951 \$15156 \$15166 VPWR VGND \$14328
+ sg13cmos5l_a21oi_1
* cell instance sg13cmos5l_a21oi_1_87 r0 *1 0,0
Xsg13cmos5l_a21oi_1_87 \$1963 \$2320 \$2494 VPWR VGND \$1765 sg13cmos5l_a21oi_1
* cell instance sg13cmos5l_a21oi_1_88 r0 *1 0,0
Xsg13cmos5l_a21oi_1_88 \$778 \$2706 \$2702 VPWR VGND \$2704 sg13cmos5l_a21oi_1
* cell instance sg13cmos5l_a21oi_1_89 r0 *1 0,0
Xsg13cmos5l_a21oi_1_89 \$367 \$4654 \$5271 VPWR VGND \$5270 sg13cmos5l_a21oi_1
* cell instance sg13cmos5l_a21oi_1_90 r0 *1 0,0
Xsg13cmos5l_a21oi_1_90 \$4481 \$4957 \$5010 VPWR VGND \$5642 sg13cmos5l_a21oi_1
* cell instance sg13cmos5l_a21oi_1_91 r0 *1 0,0
Xsg13cmos5l_a21oi_1_91 \$786 \$1616 \$1614 VPWR VGND \$1465 sg13cmos5l_a21oi_1
* cell instance sg13cmos5l_a21oi_1_92 r0 *1 0,0
Xsg13cmos5l_a21oi_1_92 \$632 \$919 \$920 VPWR VGND \$921 sg13cmos5l_a21oi_1
* cell instance sg13cmos5l_a21oi_1_93 r0 *1 0,0
Xsg13cmos5l_a21oi_1_93 \$389 \$3722 \$4036 VPWR VGND \$4037 sg13cmos5l_a21oi_1
* cell instance sg13cmos5l_a21oi_1_94 r0 *1 0,0
Xsg13cmos5l_a21oi_1_94 \$629 \$1618 \$1479 VPWR VGND \$1612 sg13cmos5l_a21oi_1
* cell instance sg13cmos5l_a21oi_1_95 r0 *1 0,0
Xsg13cmos5l_a21oi_1_95 \$951 \$14413 \$14412 VPWR VGND \$14331
+ sg13cmos5l_a21oi_1
* cell instance sg13cmos5l_a21oi_1_96 r0 *1 0,0
Xsg13cmos5l_a21oi_1_96 \$249 \$267 \$272 VPWR VGND \$273 sg13cmos5l_a21oi_1
* cell instance sg13cmos5l_a21oi_1_97 r0 *1 0,0
Xsg13cmos5l_a21oi_1_97 \$786 \$778 \$784 VPWR VGND \$785 sg13cmos5l_a21oi_1
* cell instance sg13cmos5l_a21oi_1_98 r0 *1 0,0
Xsg13cmos5l_a21oi_1_98 uio_out[0] \$11218 \$15167 VPWR VGND uio_oe[0]
+ sg13cmos5l_a21oi_1
* cell instance sg13cmos5l_a21oi_1_99 r0 *1 0,0
Xsg13cmos5l_a21oi_1_99 \$6746 \$5636 \$5010 VPWR VGND \$6777 sg13cmos5l_a21oi_1
* cell instance sg13cmos5l_a21oi_1_100 r0 *1 0,0
Xsg13cmos5l_a21oi_1_100 \$2321 \$2710 \$3524 VPWR VGND \$2937 sg13cmos5l_a21oi_1
* cell instance sg13cmos5l_a21oi_1_101 r0 *1 0,0
Xsg13cmos5l_a21oi_1_101 \$2491 \$2710 \$3145 VPWR VGND \$3144 sg13cmos5l_a21oi_1
* cell instance sg13cmos5l_a21oi_1_102 r0 *1 0,0
Xsg13cmos5l_a21oi_1_102 \$4670 \$5870 \$7843 VPWR VGND \$8538 sg13cmos5l_a21oi_1
* cell instance sg13cmos5l_a21oi_1_103 r0 *1 0,0
Xsg13cmos5l_a21oi_1_103 \$3729 \$4038 \$3728 VPWR VGND \$3917 sg13cmos5l_a21oi_1
* cell instance sg13cmos5l_a21oi_1_104 r0 *1 0,0
Xsg13cmos5l_a21oi_1_104 \$4851 \$4677 \$4759 VPWR VGND \$5870 sg13cmos5l_a21oi_1
* cell instance sg13cmos5l_a21oi_1_105 r0 *1 0,0
Xsg13cmos5l_a21oi_1_105 \$632 \$1056 \$936 VPWR VGND \$1057 sg13cmos5l_a21oi_1
* cell instance sg13cmos5l_a21oi_1_106 r0 *1 0,0
Xsg13cmos5l_a21oi_1_106 \$1032 \$1209 \$2323 VPWR VGND \$2498 sg13cmos5l_a21oi_1
* cell instance sg13cmos5l_a21oi_1_107 r0 *1 0,0
Xsg13cmos5l_a21oi_1_107 \$6436 \$3920 \$5010 VPWR VGND \$6785 sg13cmos5l_a21oi_1
* cell instance sg13cmos5l_a21oi_1_108 r0 *1 0,0
Xsg13cmos5l_a21oi_1_108 \$1770 \$1625 \$1324 VPWR VGND \$1623 sg13cmos5l_a21oi_1
* cell instance sg13cmos5l_a21oi_1_109 r0 *1 0,0
Xsg13cmos5l_a21oi_1_109 \$228 \$267 \$173 VPWR VGND \$174 sg13cmos5l_a21oi_1
* cell instance sg13cmos5l_a21oi_1_110 r0 *1 0,0
Xsg13cmos5l_a21oi_1_110 \$504 \$1212 \$1060 VPWR VGND \$1211 sg13cmos5l_a21oi_1
* cell instance sg13cmos5l_a21oi_1_111 r0 *1 0,0
Xsg13cmos5l_a21oi_1_111 \$632 \$500 \$394 VPWR VGND \$395 sg13cmos5l_a21oi_1
* cell instance sg13cmos5l_a21oi_1_112 r0 *1 0,0
Xsg13cmos5l_a21oi_1_112 \$3352 \$4663 \$4485 VPWR VGND \$4664 sg13cmos5l_a21oi_1
* cell instance sg13cmos5l_a21oi_1_113 r0 *1 0,0
Xsg13cmos5l_a21oi_1_113 \$232 \$287 \$286 VPWR VGND \$288 sg13cmos5l_a21oi_1
* cell instance sg13cmos5l_a21oi_1_114 r0 *1 0,0
Xsg13cmos5l_a21oi_1_114 \$504 \$505 \$646 VPWR VGND \$502 sg13cmos5l_a21oi_1
* cell instance sg13cmos5l_a21oi_1_115 r0 *1 0,0
Xsg13cmos5l_a21oi_1_115 \$3109 \$1410 \$3524 VPWR VGND \$3530 sg13cmos5l_a21oi_1
* cell instance sg13cmos5l_a21oi_1_116 r0 *1 0,0
Xsg13cmos5l_a21oi_1_116 \$4487 \$4662 \$2324 VPWR VGND \$4668 sg13cmos5l_a21oi_1
* cell instance sg13cmos5l_a21oi_1_117 r0 *1 0,0
Xsg13cmos5l_a21oi_1_117 \$807 \$2098 \$1627 VPWR VGND \$1974 sg13cmos5l_a21oi_1
* cell instance sg13cmos5l_a21oi_1_118 r0 *1 0,0
Xsg13cmos5l_a21oi_1_118 \$807 \$808 \$805 VPWR VGND \$804 sg13cmos5l_a21oi_1
* cell instance sg13cmos5l_a21oi_1_119 r0 *1 0,0
Xsg13cmos5l_a21oi_1_119 \$232 \$4104 \$4298 VPWR VGND \$4299 sg13cmos5l_a21oi_1
* cell instance sg13cmos5l_a21oi_1_120 r0 *1 0,0
Xsg13cmos5l_a21oi_1_120 \$504 \$1628 \$1629 VPWR VGND \$1630 sg13cmos5l_a21oi_1
* cell instance sg13cmos5l_a21oi_1_121 r0 *1 0,0
Xsg13cmos5l_a21oi_1_121 \$504 \$799 \$803 VPWR VGND \$809 sg13cmos5l_a21oi_1
* cell instance sg13cmos5l_a21oi_1_122 r0 *1 0,0
Xsg13cmos5l_a21oi_1_122 \$1765 \$2710 \$3524 VPWR VGND \$2948 sg13cmos5l_a21oi_1
* cell instance sg13cmos5l_a21oi_1_123 r0 *1 0,0
Xsg13cmos5l_a21oi_1_123 \$2935 \$1981 \$2952 VPWR VGND \$3151 sg13cmos5l_a21oi_1
* cell instance sg13cmos5l_a21oi_1_124 r0 *1 0,0
Xsg13cmos5l_a21oi_1_124 \$189 \$287 \$403 VPWR VGND \$187 sg13cmos5l_a21oi_1
* cell instance sg13cmos5l_a21oi_1_125 r0 *1 0,0
Xsg13cmos5l_a21oi_1_125 \$2135 \$1644 \$2701 VPWR VGND \$2720 sg13cmos5l_a21oi_1
* cell instance sg13cmos5l_a21oi_1_126 r0 *1 0,0
Xsg13cmos5l_a21oi_1_126 \$519 \$3924 \$4036 VPWR VGND \$4100 sg13cmos5l_a21oi_1
* cell instance sg13cmos5l_a21oi_1_127 r0 *1 0,0
Xsg13cmos5l_a21oi_1_127 \$2281 \$287 \$2333 VPWR VGND \$2335 sg13cmos5l_a21oi_1
* cell instance sg13cmos5l_a21oi_1_128 r0 *1 0,0
Xsg13cmos5l_a21oi_1_128 \$1787 \$287 \$3317 VPWR VGND \$3153 sg13cmos5l_a21oi_1
* cell instance sg13cmos5l_a21oi_1_129 r0 *1 0,0
Xsg13cmos5l_a21oi_1_129 \$189 \$192 \$523 VPWR VGND \$522 sg13cmos5l_a21oi_1
* cell instance sg13cmos5l_a21oi_1_130 r0 *1 0,0
Xsg13cmos5l_a21oi_1_130 \$189 \$4104 \$4103 VPWR VGND \$4312 sg13cmos5l_a21oi_1
* cell instance sg13cmos5l_a21oi_1_131 r0 *1 0,0
Xsg13cmos5l_a21oi_1_131 \$232 \$192 \$193 VPWR VGND \$194 sg13cmos5l_a21oi_1
* cell instance sg13cmos5l_a21oi_1_132 r0 *1 0,0
Xsg13cmos5l_a21oi_1_132 \$2965 \$3744 \$3930 VPWR VGND \$3931 sg13cmos5l_a21oi_1
* cell instance sg13cmos5l_a21oi_1_133 r0 *1 0,0
Xsg13cmos5l_a21oi_1_133 \$1787 \$3744 \$3743 VPWR VGND \$3745 sg13cmos5l_a21oi_1
* cell instance sg13cmos5l_a21oi_1_134 r0 *1 0,0
Xsg13cmos5l_a21oi_1_134 \$504 \$1337 \$1228 VPWR VGND \$1339 sg13cmos5l_a21oi_1
* cell instance sg13cmos5l_a21oi_1_135 r0 *1 0,0
Xsg13cmos5l_a21oi_1_135 \$807 \$883 \$655 VPWR VGND \$659 sg13cmos5l_a21oi_1
* cell instance sg13cmos5l_a21oi_1_136 r0 *1 0,0
Xsg13cmos5l_a21oi_1_136 \$413 \$1232 \$1231 VPWR VGND \$1227 sg13cmos5l_a21oi_1
* cell instance sg13cmos5l_a21oi_1_137 r0 *1 0,0
Xsg13cmos5l_a21oi_1_137 \$666 \$825 \$661 VPWR VGND \$830 sg13cmos5l_a21oi_1
* cell instance sg13cmos5l_a21oi_1_138 r0 *1 0,0
Xsg13cmos5l_a21oi_1_138 \$1357 \$3379 \$2723 VPWR VGND \$2959 sg13cmos5l_a21oi_1
* cell instance sg13cmos5l_a21oi_1_139 r0 *1 0,0
Xsg13cmos5l_a21oi_1_139 \$1986 \$2322 \$2348 VPWR VGND \$2349 sg13cmos5l_a21oi_1
* cell instance sg13cmos5l_a21oi_1_140 r0 *1 0,0
Xsg13cmos5l_a21oi_1_140 \$1191 \$1807 \$1805 VPWR VGND \$1235 sg13cmos5l_a21oi_1
* cell instance sg13cmos5l_a21oi_1_141 r0 *1 0,0
Xsg13cmos5l_a21oi_1_141 \$666 \$1980 \$2150 VPWR VGND \$2149 sg13cmos5l_a21oi_1
* cell instance sg13cmos5l_a21oi_1_142 r0 *1 0,0
Xsg13cmos5l_a21oi_1_142 \$666 \$2709 \$2961 VPWR VGND \$2730 sg13cmos5l_a21oi_1
* cell instance sg13cmos5l_a21oi_1_143 r0 *1 0,0
Xsg13cmos5l_a21oi_1_143 \$5418 \$5163 \$4979 VPWR VGND \$5164 sg13cmos5l_a21oi_1
* cell instance sg13cmos5l_a21oi_1_144 r0 *1 0,0
Xsg13cmos5l_a21oi_1_144 \$249 \$3744 \$3539 VPWR VGND \$3380 sg13cmos5l_a21oi_1
* cell instance sg13cmos5l_a21oi_1_145 r0 *1 0,0
Xsg13cmos5l_a21oi_1_145 \$929 \$3289 \$2963 VPWR VGND \$3160 sg13cmos5l_a21oi_1
* cell instance sg13cmos5l_a21oi_1_146 r0 *1 0,0
Xsg13cmos5l_a21oi_1_146 \$413 \$590 \$414 VPWR VGND \$542 sg13cmos5l_a21oi_1
* cell instance sg13cmos5l_a21oi_1_147 r0 *1 0,0
Xsg13cmos5l_a21oi_1_147 \$232 \$3744 \$3938 VPWR VGND \$4042 sg13cmos5l_a21oi_1
* cell instance sg13cmos5l_a21oi_1_148 r0 *1 0,0
Xsg13cmos5l_a21oi_1_148 \$5287 \$5168 \$5165 VPWR VGND \$5166 sg13cmos5l_a21oi_1
* cell instance sg13cmos5l_a21oi_1_149 r0 *1 0,0
Xsg13cmos5l_a21oi_1_149 \$666 \$1070 \$668 VPWR VGND \$667 sg13cmos5l_a21oi_1
* cell instance sg13cmos5l_a21oi_1_150 r0 *1 0,0
Xsg13cmos5l_a21oi_1_150 \$1081 \$1240 \$1238 VPWR VGND \$1239 sg13cmos5l_a21oi_1
* cell instance sg13cmos5l_a21oi_1_151 r0 *1 0,0
Xsg13cmos5l_a21oi_1_151 \$504 \$1084 \$1239 VPWR VGND \$1082 sg13cmos5l_a21oi_1
* cell instance sg13cmos5l_a21oi_1_152 r0 *1 0,0
Xsg13cmos5l_a21oi_1_152 \$666 \$2967 \$3164 VPWR VGND \$3163 sg13cmos5l_a21oi_1
* cell instance sg13cmos5l_a21oi_1_153 r0 *1 0,0
Xsg13cmos5l_a21oi_1_153 \$4125 \$4979 \$4980 VPWR VGND \$5168 sg13cmos5l_a21oi_1
* cell instance sg13cmos5l_a21oi_1_154 r0 *1 0,0
Xsg13cmos5l_a21oi_1_154 \$1084 \$956 \$1747 VPWR VGND \$1812 sg13cmos5l_a21oi_1
* cell instance sg13cmos5l_a21oi_1_155 r0 *1 0,0
Xsg13cmos5l_a21oi_1_155 \$2356 \$1808 \$2349 VPWR VGND \$2354 sg13cmos5l_a21oi_1
* cell instance sg13cmos5l_a21oi_1_156 r0 *1 0,0
Xsg13cmos5l_a21oi_1_156 \$228 \$1244 \$1086 VPWR VGND \$1087 sg13cmos5l_a21oi_1
* cell instance sg13cmos5l_a21oi_1_157 r0 *1 0,0
Xsg13cmos5l_a21oi_1_157 \$1357 \$2165 \$2163 VPWR VGND \$2164 sg13cmos5l_a21oi_1
* cell instance sg13cmos5l_a21oi_1_158 r0 *1 0,0
Xsg13cmos5l_a21oi_1_158 \$1357 \$2878 \$2526 VPWR VGND \$2740 sg13cmos5l_a21oi_1
* cell instance sg13cmos5l_a21oi_1_159 r0 *1 0,0
Xsg13cmos5l_a21oi_1_159 \$4986 \$4849 \$5083 VPWR VGND \$4984 sg13cmos5l_a21oi_1
* cell instance sg13cmos5l_a21oi_1_160 r0 *1 0,0
Xsg13cmos5l_a21oi_1_160 \$1357 \$1420 \$1246 VPWR VGND \$1292 sg13cmos5l_a21oi_1
* cell instance sg13cmos5l_a21oi_1_161 r0 *1 0,0
Xsg13cmos5l_a21oi_1_161 \$666 \$1794 \$2528 VPWR VGND \$2527 sg13cmos5l_a21oi_1
* cell instance sg13cmos5l_a21oi_1_162 r0 *1 0,0
Xsg13cmos5l_a21oi_1_162 \$189 \$3949 \$3947 VPWR VGND \$3943 sg13cmos5l_a21oi_1
* cell instance sg13cmos5l_a21oi_1_163 r0 *1 0,0
Xsg13cmos5l_a21oi_1_163 \$504 \$1515 \$1247 VPWR VGND \$1517 sg13cmos5l_a21oi_1
* cell instance sg13cmos5l_a21oi_1_164 r0 *1 0,0
Xsg13cmos5l_a21oi_1_164 \$413 \$1817 \$1738 VPWR VGND \$1818 sg13cmos5l_a21oi_1
* cell instance sg13cmos5l_a21oi_1_165 r0 *1 0,0
Xsg13cmos5l_a21oi_1_165 \$5645 \$5796 \$4986 VPWR VGND \$2101 sg13cmos5l_a21oi_1
* cell instance sg13cmos5l_a21oi_1_166 r0 *1 0,0
Xsg13cmos5l_a21oi_1_166 \$2001 \$1244 \$2003 VPWR VGND \$2005 sg13cmos5l_a21oi_1
* cell instance sg13cmos5l_a21oi_1_167 r0 *1 0,0
Xsg13cmos5l_a21oi_1_167 \$4991 \$4993 \$4989 VPWR VGND \$4990 sg13cmos5l_a21oi_1
* cell instance sg13cmos5l_a21oi_1_168 r0 *1 0,0
Xsg13cmos5l_a21oi_1_168 \$504 \$1801 \$1819 VPWR VGND \$1824 sg13cmos5l_a21oi_1
* cell instance sg13cmos5l_a21oi_1_169 r0 *1 0,0
Xsg13cmos5l_a21oi_1_169 \$3189 \$3 \$3956 VPWR VGND \$4133 sg13cmos5l_a21oi_1
* cell instance sg13cmos5l_a21oi_1_170 r0 *1 0,0
Xsg13cmos5l_a21oi_1_170 \$1362 \$1244 \$1252 VPWR VGND \$1361 sg13cmos5l_a21oi_1
* cell instance sg13cmos5l_a21oi_1_171 r0 *1 0,0
Xsg13cmos5l_a21oi_1_171 \$5418 \$5163 \$4988 VPWR VGND \$5308 sg13cmos5l_a21oi_1
* cell instance sg13cmos5l_a21oi_1_172 r0 *1 0,0
Xsg13cmos5l_a21oi_1_172 \$82 \$1244 \$971 VPWR VGND \$970 sg13cmos5l_a21oi_1
* cell instance sg13cmos5l_a21oi_1_173 r0 *1 0,0
Xsg13cmos5l_a21oi_1_173 \$2985 \$3400 \$3399 VPWR VGND \$3552 sg13cmos5l_a21oi_1
* cell instance sg13cmos5l_a21oi_1_174 r0 *1 0,0
Xsg13cmos5l_a21oi_1_174 \$2985 \$3563 \$3672 VPWR VGND \$3385 sg13cmos5l_a21oi_1
* cell instance sg13cmos5l_a21oi_1_175 r0 *1 0,0
Xsg13cmos5l_a21oi_1_175 \$2985 \$2987 \$2984 VPWR VGND \$2986 sg13cmos5l_a21oi_1
* cell instance sg13cmos5l_a21oi_1_176 r0 *1 0,0
Xsg13cmos5l_a21oi_1_176 \$3189 \$2466 \$3957 VPWR VGND \$3764 sg13cmos5l_a21oi_1
* cell instance sg13cmos5l_a21oi_1_177 r0 *1 0,0
Xsg13cmos5l_a21oi_1_177 \$3023 \$4979 \$4859 VPWR VGND \$4993 sg13cmos5l_a21oi_1
* cell instance sg13cmos5l_a21oi_1_178 r0 *1 0,0
Xsg13cmos5l_a21oi_1_178 \$4991 \$5685 \$5900 VPWR VGND \$5901 sg13cmos5l_a21oi_1
* cell instance sg13cmos5l_a21oi_1_179 r0 *1 0,0
Xsg13cmos5l_a21oi_1_179 \$4991 \$5310 \$5306 VPWR VGND \$5311 sg13cmos5l_a21oi_1
* cell instance sg13cmos5l_a21oi_1_180 r0 *1 0,0
Xsg13cmos5l_a21oi_1_180 \$5083 \$5305 \$5531 VPWR VGND \$5532 sg13cmos5l_a21oi_1
* cell instance sg13cmos5l_a21oi_1_181 r0 *1 0,0
Xsg13cmos5l_a21oi_1_181 \$5316 \$5532 \$5313 VPWR VGND \$5314 sg13cmos5l_a21oi_1
* cell instance sg13cmos5l_a21oi_1_182 r0 *1 0,0
Xsg13cmos5l_a21oi_1_182 \$2378 \$2195 \$1845 VPWR VGND \$2024 sg13cmos5l_a21oi_1
* cell instance sg13cmos5l_a21oi_1_183 r0 *1 0,0
Xsg13cmos5l_a21oi_1_183 \$2194 \$2195 \$1845 VPWR VGND \$1840 sg13cmos5l_a21oi_1
* cell instance sg13cmos5l_a21oi_1_184 r0 *1 0,0
Xsg13cmos5l_a21oi_1_184 \$416 \$337 \$555 VPWR VGND \$544 sg13cmos5l_a21oi_1
* cell instance sg13cmos5l_a21oi_1_185 r0 *1 0,0
Xsg13cmos5l_a21oi_1_185 \$696 \$326 \$694 VPWR VGND \$693 sg13cmos5l_a21oi_1
* cell instance sg13cmos5l_a21oi_1_186 r0 *1 0,0
Xsg13cmos5l_a21oi_1_186 \$2198 \$2195 \$2197 VPWR VGND \$1856 sg13cmos5l_a21oi_1
* cell instance sg13cmos5l_a21oi_1_187 r0 *1 0,0
Xsg13cmos5l_a21oi_1_187 \$699 \$855 \$210 VPWR VGND \$851 sg13cmos5l_a21oi_1
* cell instance sg13cmos5l_a21oi_1_188 r0 *1 0,0
Xsg13cmos5l_a21oi_1_188 \$3020 \$2997 \$3196 VPWR VGND \$3198 sg13cmos5l_a21oi_1
* cell instance sg13cmos5l_a21oi_1_189 r0 *1 0,0
Xsg13cmos5l_a21oi_1_189 \$113 \$95 \$66 VPWR VGND \$419 sg13cmos5l_a21oi_1
* cell instance sg13cmos5l_a21oi_1_190 r0 *1 0,0
Xsg13cmos5l_a21oi_1_190 \$558 \$437 \$41 VPWR VGND \$561 sg13cmos5l_a21oi_1
* cell instance sg13cmos5l_a21oi_1_191 r0 *1 0,0
Xsg13cmos5l_a21oi_1_191 \$433 \$1263 \$333 VPWR VGND \$1262 sg13cmos5l_a21oi_1
* cell instance sg13cmos5l_a21oi_1_192 r0 *1 0,0
Xsg13cmos5l_a21oi_1_192 \$113 \$65 \$66 VPWR VGND \$860 sg13cmos5l_a21oi_1
* cell instance sg13cmos5l_a21oi_1_193 r0 *1 0,0
Xsg13cmos5l_a21oi_1_193 \$7 \$8 \$60 VPWR VGND \$5 sg13cmos5l_a21oi_1
* cell instance sg13cmos5l_a21oi_1_194 r0 *1 0,0
Xsg13cmos5l_a21oi_1_194 \$113 \$423 \$97 VPWR VGND \$328 sg13cmos5l_a21oi_1
* cell instance sg13cmos5l_a21oi_1_195 r0 *1 0,0
Xsg13cmos5l_a21oi_1_195 \$3202 \$3204 \$3197 VPWR VGND \$3200 sg13cmos5l_a21oi_1
* cell instance sg13cmos5l_a21oi_1_196 r0 *1 0,0
Xsg13cmos5l_a21oi_1_196 \$7 \$8 \$62 VPWR VGND \$12 sg13cmos5l_a21oi_1
* cell instance sg13cmos5l_a21oi_1_197 r0 *1 0,0
Xsg13cmos5l_a21oi_1_197 \$4337 \$4318 \$3573 VPWR VGND \$3961 sg13cmos5l_a21oi_1
* cell instance sg13cmos5l_a21oi_1_198 r0 *1 0,0
Xsg13cmos5l_a21oi_1_198 \$3592 \$3676 \$3591 VPWR VGND \$3588 sg13cmos5l_a21oi_1
* cell instance sg13cmos5l_a21oi_1_199 r0 *1 0,0
Xsg13cmos5l_a21oi_1_199 \$2573 \$2572 \$2284 VPWR VGND \$2570 sg13cmos5l_a21oi_1
* cell instance sg13cmos5l_a21oi_1_200 r0 *1 0,0
Xsg13cmos5l_a21oi_1_200 \$19 \$1130 \$988 VPWR VGND \$705 sg13cmos5l_a21oi_1
* cell instance sg13cmos5l_a21oi_1_201 r0 *1 0,0
Xsg13cmos5l_a21oi_1_201 \$60 \$105 \$97 VPWR VGND \$103 sg13cmos5l_a21oi_1
* cell instance sg13cmos5l_a21oi_1_202 r0 *1 0,0
Xsg13cmos5l_a21oi_1_202 \$1394 \$996 \$418 VPWR VGND \$1390 sg13cmos5l_a21oi_1
* cell instance sg13cmos5l_a21oi_1_203 r0 *1 0,0
Xsg13cmos5l_a21oi_1_203 \$4337 \$4876 \$4927 VPWR VGND \$4877 sg13cmos5l_a21oi_1
* cell instance sg13cmos5l_a21oi_1_204 r0 *1 0,0
Xsg13cmos5l_a21oi_1_204 \$1130 \$1166 \$994 VPWR VGND \$991 sg13cmos5l_a21oi_1
* cell instance sg13cmos5l_a21oi_1_205 r0 *1 0,0
Xsg13cmos5l_a21oi_1_205 \$5571 \$5569 \$5570 VPWR VGND \$5345 sg13cmos5l_a21oi_1
* cell instance sg13cmos5l_a21oi_1_206 r0 *1 0,0
Xsg13cmos5l_a21oi_1_206 \$21 \$114 \$109 VPWR VGND \$206 sg13cmos5l_a21oi_1
* cell instance sg13cmos5l_a21oi_1_207 r0 *1 0,0
Xsg13cmos5l_a21oi_1_207 \$1394 \$1133 \$210 VPWR VGND \$1555 sg13cmos5l_a21oi_1
* cell instance sg13cmos5l_a21oi_1_208 r0 *1 0,0
Xsg13cmos5l_a21oi_1_208 \$2997 \$3302 \$3022 VPWR VGND \$2218 sg13cmos5l_a21oi_1
* cell instance sg13cmos5l_a21oi_1_209 r0 *1 0,0
Xsg13cmos5l_a21oi_1_209 \$20 \$112 \$333 VPWR VGND \$110 sg13cmos5l_a21oi_1
* cell instance sg13cmos5l_a21oi_1_210 r0 *1 0,0
Xsg13cmos5l_a21oi_1_210 \$997 \$1135 \$418 VPWR VGND \$852 sg13cmos5l_a21oi_1
* cell instance sg13cmos5l_a21oi_1_211 r0 *1 0,0
Xsg13cmos5l_a21oi_1_211 \$4538 \$3490 \$4550 VPWR VGND \$4551 sg13cmos5l_a21oi_1
* cell instance sg13cmos5l_a21oi_1_212 r0 *1 0,0
Xsg13cmos5l_a21oi_1_212 \$1267 \$1263 \$1268 VPWR VGND \$1135 sg13cmos5l_a21oi_1
* cell instance sg13cmos5l_a21oi_1_213 r0 *1 0,0
Xsg13cmos5l_a21oi_1_213 \$3595 \$2669 \$3790 VPWR VGND \$3791 sg13cmos5l_a21oi_1
* cell instance sg13cmos5l_a21oi_1_214 r0 *1 0,0
Xsg13cmos5l_a21oi_1_214 \$3595 \$2669 \$4551 VPWR VGND \$4553 sg13cmos5l_a21oi_1
* cell instance sg13cmos5l_a21oi_1_215 r0 *1 0,0
Xsg13cmos5l_a21oi_1_215 \$2221 \$2770 \$3318 VPWR VGND \$2220 sg13cmos5l_a21oi_1
* cell instance sg13cmos5l_a21oi_1_216 r0 *1 0,0
Xsg13cmos5l_a21oi_1_216 \$4761 \$3490 \$3678 VPWR VGND \$3790 sg13cmos5l_a21oi_1
* cell instance sg13cmos5l_a21oi_1_217 r0 *1 0,0
Xsg13cmos5l_a21oi_1_217 \$1572 \$1400 \$1556 VPWR VGND \$1554 sg13cmos5l_a21oi_1
* cell instance sg13cmos5l_a21oi_1_218 r0 *1 0,0
Xsg13cmos5l_a21oi_1_218 \$2579 \$2384 \$3026 VPWR VGND \$1692 sg13cmos5l_a21oi_1
* cell instance sg13cmos5l_a21oi_1_219 r0 *1 0,0
Xsg13cmos5l_a21oi_1_219 \$997 \$1142 \$718 VPWR VGND \$1140 sg13cmos5l_a21oi_1
* cell instance sg13cmos5l_a21oi_1_220 r0 *1 0,0
Xsg13cmos5l_a21oi_1_220 \$15 \$29 \$93 VPWR VGND \$27 sg13cmos5l_a21oi_1
* cell instance sg13cmos5l_a21oi_1_221 r0 *1 0,0
Xsg13cmos5l_a21oi_1_221 \$4850 \$5033 \$3595 VPWR VGND \$5021 sg13cmos5l_a21oi_1
* cell instance sg13cmos5l_a21oi_1_222 r0 *1 0,0
Xsg13cmos5l_a21oi_1_222 \$5723 \$5732 \$5961 VPWR VGND \$5964 sg13cmos5l_a21oi_1
* cell instance sg13cmos5l_a21oi_1_223 r0 *1 0,0
Xsg13cmos5l_a21oi_1_223 \$75 \$65 \$1022 VPWR VGND \$1402 sg13cmos5l_a21oi_1
* cell instance sg13cmos5l_a21oi_1_224 r0 *1 0,0
Xsg13cmos5l_a21oi_1_224 \$721 \$601 \$718 VPWR VGND \$719 sg13cmos5l_a21oi_1
* cell instance sg13cmos5l_a21oi_1_225 r0 *1 0,0
Xsg13cmos5l_a21oi_1_225 \$2049 \$2384 \$1910 VPWR VGND \$1905 sg13cmos5l_a21oi_1
* cell instance sg13cmos5l_a21oi_1_226 r0 *1 0,0
Xsg13cmos5l_a21oi_1_226 \$26 \$33 \$30 VPWR VGND \$31 sg13cmos5l_a21oi_1
* cell instance sg13cmos5l_a21oi_1_227 r0 *1 0,0
Xsg13cmos5l_a21oi_1_227 \$2049 \$2211 \$2284 VPWR VGND \$2229 sg13cmos5l_a21oi_1
* cell instance sg13cmos5l_a21oi_1_228 r0 *1 0,0
Xsg13cmos5l_a21oi_1_228 \$342 \$1405 \$334 VPWR VGND \$1560 sg13cmos5l_a21oi_1
* cell instance sg13cmos5l_a21oi_1_229 r0 *1 0,0
Xsg13cmos5l_a21oi_1_229 \$75 \$23 \$67 VPWR VGND \$38 sg13cmos5l_a21oi_1
* cell instance sg13cmos5l_a21oi_1_230 r0 *1 0,0
Xsg13cmos5l_a21oi_1_230 \$433 \$444 \$220 VPWR VGND \$575 sg13cmos5l_a21oi_1
* cell instance sg13cmos5l_a21oi_1_231 r0 *1 0,0
Xsg13cmos5l_a21oi_1_231 \$3833 \$4550 \$3491 VPWR VGND \$3605 sg13cmos5l_a21oi_1
* cell instance sg13cmos5l_a21oi_1_232 r0 *1 0,0
Xsg13cmos5l_a21oi_1_232 \$1570 \$346 \$1576 VPWR VGND \$1569 sg13cmos5l_a21oi_1
* cell instance sg13cmos5l_a21oi_1_233 r0 *1 0,0
Xsg13cmos5l_a21oi_1_233 \$48 \$49 \$41 VPWR VGND \$46 sg13cmos5l_a21oi_1
* cell instance sg13cmos5l_a21oi_1_234 r0 *1 0,0
Xsg13cmos5l_a21oi_1_234 \$3031 \$3303 \$3030 VPWR VGND \$2893 sg13cmos5l_a21oi_1
* cell instance sg13cmos5l_a21oi_1_235 r0 *1 0,0
Xsg13cmos5l_a21oi_1_235 \$5204 \$5207 \$4185 VPWR VGND \$5024 sg13cmos5l_a21oi_1
* cell instance sg13cmos5l_a21oi_1_236 r0 *1 0,0
Xsg13cmos5l_a21oi_1_236 \$3223 \$3303 \$3220 VPWR VGND \$3221 sg13cmos5l_a21oi_1
* cell instance sg13cmos5l_a21oi_1_237 r0 *1 0,0
Xsg13cmos5l_a21oi_1_237 \$34 \$50 \$69 VPWR VGND \$49 sg13cmos5l_a21oi_1
* cell instance sg13cmos5l_a21oi_1_238 r0 *1 0,0
Xsg13cmos5l_a21oi_1_238 \$3484 \$3491 \$3605 VPWR VGND \$3424 sg13cmos5l_a21oi_1
* cell instance sg13cmos5l_a21oi_1_239 r0 *1 0,0
Xsg13cmos5l_a21oi_1_239 \$25 \$22 \$226 VPWR VGND \$224 sg13cmos5l_a21oi_1
* cell instance sg13cmos5l_a21oi_1_240 r0 *1 0,0
Xsg13cmos5l_a21oi_1_240 \$75 \$76 \$1003 VPWR VGND \$866 sg13cmos5l_a21oi_1
* cell instance sg13cmos5l_a21oi_1_241 r0 *1 0,0
Xsg13cmos5l_a21oi_1_241 \$1011 \$75 \$333 VPWR VGND \$1713 sg13cmos5l_a21oi_1
* cell instance sg13cmos5l_a21oi_1_242 r0 *1 0,0
Xsg13cmos5l_a21oi_1_242 \$76 \$204 \$707 VPWR VGND \$1014 sg13cmos5l_a21oi_1
* cell instance sg13cmos5l_a21oi_1_243 r0 *1 0,0
Xsg13cmos5l_a21oi_1_243 \$5025 \$5027 \$4345 VPWR VGND \$5029 sg13cmos5l_a21oi_1
* cell instance sg13cmos5l_a21oi_1_244 r0 *1 0,0
Xsg13cmos5l_a21oi_1_244 \$2801 \$3219 \$3416 VPWR VGND \$3431 sg13cmos5l_a21oi_1
* cell instance sg13cmos5l_a21oi_1_245 r0 *1 0,0
Xsg13cmos5l_a21oi_1_245 \$3492 \$3219 \$3416 VPWR VGND \$3610 sg13cmos5l_a21oi_1
* cell instance sg13cmos5l_a21oi_1_246 r0 *1 0,0
Xsg13cmos5l_a21oi_1_246 \$1281 \$1277 \$222 VPWR VGND \$1296 sg13cmos5l_a21oi_1
* cell instance sg13cmos5l_a21oi_1_247 r0 *1 0,0
Xsg13cmos5l_a21oi_1_247 \$5026 \$4883 \$5029 VPWR VGND \$5033 sg13cmos5l_a21oi_1
* cell instance sg13cmos5l_a21oi_1_248 r0 *1 0,0
Xsg13cmos5l_a21oi_1_248 \$4046 \$5028 \$5033 VPWR VGND \$5209 sg13cmos5l_a21oi_1
* cell instance sg13cmos5l_a21oi_1_249 r0 *1 0,0
Xsg13cmos5l_a21oi_1_249 \$5758 \$6172 \$6091 VPWR VGND \$5381 sg13cmos5l_a21oi_1
* cell instance sg13cmos5l_a21oi_1_250 r0 *1 0,0
Xsg13cmos5l_a21oi_1_250 \$5580 \$5385 \$5383 VPWR VGND \$5242 sg13cmos5l_a21oi_1
* cell instance sg13cmos5l_a21oi_1_251 r0 *1 0,0
Xsg13cmos5l_a21oi_1_251 \$5212 \$5769 \$6016 VPWR VGND \$6176 sg13cmos5l_a21oi_1
* cell instance sg13cmos5l_a21oi_1_252 r0 *1 0,0
Xsg13cmos5l_a21oi_1_252 \$2230 \$6789 \$9576 VPWR VGND \$9577 sg13cmos5l_a21oi_1
* cell instance sg13cmos5l_a21oi_1_253 r0 *1 0,0
Xsg13cmos5l_a21oi_1_253 \$3677 \$8447 \$8285 VPWR VGND \$8514 sg13cmos5l_a21oi_1
* cell instance sg13cmos5l_a21oi_1_254 r0 *1 0,0
Xsg13cmos5l_a21oi_1_254 \$6809 \$8447 \$10441 VPWR VGND \$10758
+ sg13cmos5l_a21oi_1
* cell instance sg13cmos5l_a21oi_1_255 r0 *1 0,0
Xsg13cmos5l_a21oi_1_255 \$3021 \$8447 \$7871 VPWR VGND \$8195 sg13cmos5l_a21oi_1
* cell instance sg13cmos5l_a21oi_1_256 r0 *1 0,0
Xsg13cmos5l_a21oi_1_256 \$5898 \$7225 \$7250 VPWR VGND \$7251 sg13cmos5l_a21oi_1
* cell instance sg13cmos5l_a21oi_1_257 r0 *1 0,0
Xsg13cmos5l_a21oi_1_257 \$3110 \$8447 \$9092 VPWR VGND \$9067 sg13cmos5l_a21oi_1
* cell instance sg13cmos5l_a21oi_1_258 r0 *1 0,0
Xsg13cmos5l_a21oi_1_258 \$4375 \$2803 \$4373 VPWR VGND \$4212 sg13cmos5l_a21oi_1
* cell instance sg13cmos5l_a21oi_1_259 r0 *1 0,0
Xsg13cmos5l_a21oi_1_259 \$5580 \$6178 \$5395 VPWR VGND \$5994 sg13cmos5l_a21oi_1
* cell instance sg13cmos5l_a21oi_1_260 r0 *1 0,0
Xsg13cmos5l_a21oi_1_260 \$2466 \$4884 \$5033 VPWR VGND \$5396 sg13cmos5l_a21oi_1
* cell instance sg13cmos5l_a21oi_1_261 r0 *1 0,0
Xsg13cmos5l_a21oi_1_261 \$4732 \$4379 \$4012 VPWR VGND \$5050 sg13cmos5l_a21oi_1
* cell instance sg13cmos5l_a21oi_1_262 r0 *1 0,0
Xsg13cmos5l_a21oi_1_262 \$5089 \$5055 \$5033 VPWR VGND \$5053 sg13cmos5l_a21oi_1
* cell instance sg13cmos5l_a21oi_1_263 r0 *1 0,0
Xsg13cmos5l_a21oi_1_263 \$5374 \$5784 \$5782 VPWR VGND \$5780 sg13cmos5l_a21oi_1
* cell instance sg13cmos5l_a21oi_1_264 r0 *1 0,0
Xsg13cmos5l_a21oi_1_264 \$6189 \$6415 \$6718 VPWR VGND \$6400 sg13cmos5l_a21oi_1
* cell instance sg13cmos5l_a21oi_1_265 r0 *1 0,0
Xsg13cmos5l_a21oi_1_265 \$5996 \$6394 \$6189 VPWR VGND \$6402 sg13cmos5l_a21oi_1
* cell instance sg13cmos5l_a21oi_1_266 r0 *1 0,0
Xsg13cmos5l_a21oi_1_266 \$3 \$4383 \$6402 VPWR VGND \$6405 sg13cmos5l_a21oi_1
* cell instance sg13cmos5l_a221oi_1_0 r0 *1 0,0
Xsg13cmos5l_a221oi_1_0 \$6417 \$6229 \$6735 \$6732 \$5841 VPWR VGND \$6730
+ sg13cmos5l_a221oi_1
* cell instance sg13cmos5l_a221oi_1_1 r0 *1 0,0
Xsg13cmos5l_a221oi_1_1 \$6039 \$5795 \$5867 \$6013 \$5077 VPWR VGND \$5859
+ sg13cmos5l_a221oi_1
* cell instance sg13cmos5l_a221oi_1_2 r0 *1 0,0
Xsg13cmos5l_a221oi_1_2 \$6851 \$5636 \$5795 \$6849 \$4270 VPWR VGND \$6432
+ sg13cmos5l_a221oi_1
* cell instance sg13cmos5l_a221oi_1_3 r0 *1 0,0
Xsg13cmos5l_a221oi_1_3 \$5611 \$5157 \$6251 \$6434 \$6248 VPWR VGND \$6247
+ sg13cmos5l_a221oi_1
* cell instance sg13cmos5l_a221oi_1_4 r0 *1 0,0
Xsg13cmos5l_a221oi_1_4 \$7901 \$5638 \$6251 \$8345 \$6905 VPWR VGND \$6254
+ sg13cmos5l_a221oi_1
* cell instance sg13cmos5l_a221oi_1_5 r0 *1 0,0
Xsg13cmos5l_a221oi_1_5 \$6442 \$4844 \$5638 \$6439 \$6437 VPWR VGND \$6433
+ sg13cmos5l_a221oi_1
* cell instance sg13cmos5l_a221oi_1_6 r0 *1 0,0
Xsg13cmos5l_a221oi_1_6 \$7904 \$5636 \$6251 \$8039 \$5150 VPWR VGND \$6049
+ sg13cmos5l_a221oi_1
* cell instance sg13cmos5l_a221oi_1_7 r0 *1 0,0
Xsg13cmos5l_a221oi_1_7 \$3916 \$4957 \$5157 \$4955 \$4037 VPWR VGND \$5078
+ sg13cmos5l_a221oi_1
* cell instance sg13cmos5l_a221oi_1_8 r0 *1 0,0
Xsg13cmos5l_a221oi_1_8 \$1784 \$1791 \$1623 \$1789 \$913 VPWR VGND \$1747
+ sg13cmos5l_a221oi_1
* cell instance sg13cmos5l_a221oi_1_9 r0 *1 0,0
Xsg13cmos5l_a221oi_1_9 \$1212 \$938 \$1976 \$2967 \$3140 VPWR VGND \$3287
+ sg13cmos5l_a221oi_1
* cell instance sg13cmos5l_a221oi_1_10 r0 *1 0,0
Xsg13cmos5l_a221oi_1_10 \$1976 \$3150 \$3357 \$3353 \$3149 VPWR VGND \$3358
+ sg13cmos5l_a221oi_1
* cell instance sg13cmos5l_a221oi_1_11 r0 *1 0,0
Xsg13cmos5l_a221oi_1_11 \$6448 \$4861 \$4097 \$6255 \$6087 VPWR VGND \$6298
+ sg13cmos5l_a221oi_1
* cell instance sg13cmos5l_a221oi_1_12 r0 *1 0,0
Xsg13cmos5l_a221oi_1_12 \$5893 \$4861 \$3737 \$6783 \$6014 VPWR VGND \$4248
+ sg13cmos5l_a221oi_1
* cell instance sg13cmos5l_a221oi_1_13 r0 *1 0,0
Xsg13cmos5l_a221oi_1_13 \$19613 \$4861 \$6092 \$19605 \$6785 VPWR VGND \$5755
+ sg13cmos5l_a221oi_1
* cell instance sg13cmos5l_a221oi_1_14 r0 *1 0,0
Xsg13cmos5l_a221oi_1_14 \$3953 \$3954 \$3952 \$2978 \$3949 VPWR VGND \$3947
+ sg13cmos5l_a221oi_1
* cell instance sg13cmos5l_a221oi_1_15 r0 *1 0,0
Xsg13cmos5l_a221oi_1_15 \$213 \$5 \$65 \$105 \$201 VPWR VGND \$987
+ sg13cmos5l_a221oi_1
* cell instance sg13cmos5l_a221oi_1_16 r0 *1 0,0
Xsg13cmos5l_a221oi_1_16 \$3591 \$2210 \$2208 \$4504 \$3588 VPWR VGND \$3675
+ sg13cmos5l_a221oi_1
* cell instance sg13cmos5l_a221oi_1_17 r0 *1 0,0
Xsg13cmos5l_a221oi_1_17 \$101 \$102 \$95 \$29 \$93 VPWR VGND \$4
+ sg13cmos5l_a221oi_1
* cell instance sg13cmos5l_a221oi_1_18 r0 *1 0,0
Xsg13cmos5l_a221oi_1_18 \$1876 \$2211 \$1930 \$2210 \$2205 VPWR VGND \$2209
+ sg13cmos5l_a221oi_1
* cell instance sg13cmos5l_a221oi_1_19 r0 *1 0,0
Xsg13cmos5l_a221oi_1_19 \$106 \$1555 \$1554 \$210 \$694 VPWR VGND \$1553
+ sg13cmos5l_a221oi_1
* cell instance sg13cmos5l_a221oi_1_20 r0 *1 0,0
Xsg13cmos5l_a221oi_1_20 \$2388 \$2887 \$2770 \$2567 \$2382 VPWR VGND \$2767
+ sg13cmos5l_a221oi_1
* cell instance sg13cmos5l_a221oi_1_21 r0 *1 0,0
Xsg13cmos5l_a221oi_1_21 \$210 \$710 \$564 \$341 \$694 VPWR VGND \$680
+ sg13cmos5l_a221oi_1
* cell instance sg13cmos5l_a221oi_1_22 r0 *1 0,0
Xsg13cmos5l_a221oi_1_22 \$2577 \$2770 \$2773 \$2887 \$3318 VPWR VGND \$2889
+ sg13cmos5l_a221oi_1
* cell instance sg13cmos5l_a221oi_1_23 r0 *1 0,0
Xsg13cmos5l_a221oi_1_23 \$1139 \$1028 \$434 \$1268 \$210 VPWR VGND \$1136
+ sg13cmos5l_a221oi_1
* cell instance sg13cmos5l_a221oi_1_24 r0 *1 0,0
Xsg13cmos5l_a221oi_1_24 \$702 \$72 \$61 \$113 \$21 VPWR VGND \$715
+ sg13cmos5l_a221oi_1
* cell instance sg13cmos5l_a221oi_1_25 r0 *1 0,0
Xsg13cmos5l_a221oi_1_25 \$50 \$109 \$119 \$21 \$334 VPWR VGND \$212
+ sg13cmos5l_a221oi_1
* cell instance sg13cmos5l_a221oi_1_26 r0 *1 0,0
Xsg13cmos5l_a221oi_1_26 \$728 \$437 \$594 \$455 \$222 VPWR VGND \$565
+ sg13cmos5l_a221oi_1
* cell instance sg13cmos5l_a221oi_1_27 r0 *1 0,0
Xsg13cmos5l_a221oi_1_27 \$2579 \$2211 \$2580 \$2210 \$2777 VPWR VGND \$2776
+ sg13cmos5l_a221oi_1
* cell instance sg13cmos5l_a221oi_1_28 r0 *1 0,0
Xsg13cmos5l_a221oi_1_28 \$4510 \$5033 \$5366 \$5201 \$4692 VPWR VGND \$4175
+ sg13cmos5l_a221oi_1
* cell instance sg13cmos5l_a221oi_1_29 r0 *1 0,0
Xsg13cmos5l_a221oi_1_29 \$2230 \$2231 \$2229 \$2228 \$2227 VPWR VGND \$1910
+ sg13cmos5l_a221oi_1
* cell instance sg13cmos5l_a221oi_1_30 r0 *1 0,0
Xsg13cmos5l_a221oi_1_30 \$2592 \$2211 \$2584 \$2210 \$2891 VPWR VGND \$2582
+ sg13cmos5l_a221oi_1
* cell instance sg13cmos5l_a221oi_1_31 r0 *1 0,0
Xsg13cmos5l_a221oi_1_31 \$2588 \$2211 \$3305 \$2210 \$3417 VPWR VGND \$3420
+ sg13cmos5l_a221oi_1
* cell instance sg13cmos5l_a221oi_1_32 r0 *1 0,0
Xsg13cmos5l_a221oi_1_32 \$718 \$703 \$722 \$739 \$864 VPWR VGND \$867
+ sg13cmos5l_a221oi_1
* cell instance sg13cmos5l_a221oi_1_33 r0 *1 0,0
Xsg13cmos5l_a221oi_1_33 \$1022 \$50 \$1006 \$1004 \$220 VPWR VGND \$870
+ sg13cmos5l_a221oi_1
* cell instance sg13cmos5l_a221oi_1_34 r0 *1 0,0
Xsg13cmos5l_a221oi_1_34 \$718 \$43 \$576 \$719 \$864 VPWR VGND \$724
+ sg13cmos5l_a221oi_1
* cell instance sg13cmos5l_a221oi_1_35 r0 *1 0,0
Xsg13cmos5l_a221oi_1_35 \$1395 \$1569 \$1563 \$1568 \$222 VPWR VGND \$1567
+ sg13cmos5l_a221oi_1
* cell instance sg13cmos5l_a221oi_1_36 r0 *1 0,0
Xsg13cmos5l_a221oi_1_36 \$861 \$1008 \$1148 \$728 \$718 VPWR VGND \$1145
+ sg13cmos5l_a221oi_1
* cell instance sg13cmos5l_a221oi_1_37 r0 *1 0,0
Xsg13cmos5l_a221oi_1_37 \$95 \$29 \$125 \$71 \$41 VPWR VGND \$122
+ sg13cmos5l_a221oi_1
* cell instance sg13cmos5l_a221oi_1_38 r0 *1 0,0
Xsg13cmos5l_a221oi_1_38 \$600 \$1154 \$1013 \$728 \$718 VPWR VGND \$1151
+ sg13cmos5l_a221oi_1
* cell instance sg13cmos5l_a221oi_1_39 r0 *1 0,0
Xsg13cmos5l_a221oi_1_39 \$5373 \$5089 \$4884 \$4046 \$5033 VPWR VGND \$5440
+ sg13cmos5l_a221oi_1
* cell instance sg13cmos5l_a221oi_1_40 r0 *1 0,0
Xsg13cmos5l_a221oi_1_40 \$1268 \$1407 \$447 \$222 \$1717 VPWR VGND \$1573
+ sg13cmos5l_a221oi_1
* cell instance sg13cmos5l_a221oi_1_41 r0 *1 0,0
Xsg13cmos5l_a221oi_1_41 \$5771 \$6169 \$5758 \$6377 \$6378 VPWR VGND \$5201
+ sg13cmos5l_a221oi_1
* cell instance sg13cmos5l_a221oi_1_42 r0 *1 0,0
Xsg13cmos5l_a221oi_1_42 \$3023 \$4884 \$5211 \$5089 \$5040 VPWR VGND \$5038
+ sg13cmos5l_a221oi_1
* cell instance sg13cmos5l_a221oi_1_43 r0 *1 0,0
Xsg13cmos5l_a221oi_1_43 \$5388 \$5763 \$5390 \$3023 \$5213 VPWR VGND \$5827
+ sg13cmos5l_a221oi_1
* cell instance sg13cmos5l_a221oi_1_44 r0 *1 0,0
Xsg13cmos5l_a221oi_1_44 \$4331 \$5033 \$4893 \$5049 \$4725 VPWR VGND \$4892
+ sg13cmos5l_a221oi_1
* cell instance sg13cmos5l_a221oi_1_45 r0 *1 0,0
Xsg13cmos5l_a221oi_1_45 \$5771 \$6711 \$6716 \$5758 \$6389 VPWR VGND \$4728
+ sg13cmos5l_a221oi_1
* cell instance sg13cmos5l_a221oi_1_46 r0 *1 0,0
Xsg13cmos5l_a221oi_1_46 \$3688 \$4359 \$2020 \$4015 \$4385 VPWR VGND \$4384
+ sg13cmos5l_a221oi_1
* cell instance sg13cmos5l_a22oi_1_0 r0 *1 0,0
Xsg13cmos5l_a22oi_1_0 \$8227 \$8133 \$8336 \$7843 VPWR VGND \$8228
+ sg13cmos5l_a22oi_1
* cell instance sg13cmos5l_a22oi_1_1 r0 *1 0,0
Xsg13cmos5l_a22oi_1_1 \$2119 \$1191 \$3131 \$3132 VPWR VGND \$3129
+ sg13cmos5l_a22oi_1
* cell instance sg13cmos5l_a22oi_1_2 r0 *1 0,0
Xsg13cmos5l_a22oi_1_2 \$5855 \$6037 \$6002 \$6035 VPWR VGND \$6033
+ sg13cmos5l_a22oi_1
* cell instance sg13cmos5l_a22oi_1_3 r0 *1 0,0
Xsg13cmos5l_a22oi_1_3 \$10134 \$8133 \$9325 \$7843 VPWR VGND \$9824
+ sg13cmos5l_a22oi_1
* cell instance sg13cmos5l_a22oi_1_4 r0 *1 0,0
Xsg13cmos5l_a22oi_1_4 \$906 \$1191 \$1184 \$1046 VPWR VGND \$1045
+ sg13cmos5l_a22oi_1
* cell instance sg13cmos5l_a22oi_1_5 r0 *1 0,0
Xsg13cmos5l_a22oi_1_5 \$1191 \$751 \$1768 \$1441 VPWR VGND \$1461
+ sg13cmos5l_a22oi_1
* cell instance sg13cmos5l_a22oi_1_6 r0 *1 0,0
Xsg13cmos5l_a22oi_1_6 \$9323 \$6251 \$5867 \$9143 VPWR VGND \$6980
+ sg13cmos5l_a22oi_1
* cell instance sg13cmos5l_a22oi_1_7 r0 *1 0,0
Xsg13cmos5l_a22oi_1_7 \$17273 \$5638 \$6251 \$10297 VPWR VGND \$6232
+ sg13cmos5l_a22oi_1
* cell instance sg13cmos5l_a22oi_1_8 r0 *1 0,0
Xsg13cmos5l_a22oi_1_8 \$2487 \$1209 \$2932 \$2925 VPWR VGND \$2934
+ sg13cmos5l_a22oi_1
* cell instance sg13cmos5l_a22oi_1_9 r0 *1 0,0
Xsg13cmos5l_a22oi_1_9 \$7541 \$5636 \$5795 \$7534 VPWR VGND \$6244
+ sg13cmos5l_a22oi_1
* cell instance sg13cmos5l_a22oi_1_10 r0 *1 0,0
Xsg13cmos5l_a22oi_1_10 \$9664 \$5636 \$5867 \$9328 VPWR VGND \$6252
+ sg13cmos5l_a22oi_1
* cell instance sg13cmos5l_a22oi_1_11 r0 *1 0,0
Xsg13cmos5l_a22oi_1_11 \$5633 \$5636 \$4957 \$2143 VPWR VGND \$5635
+ sg13cmos5l_a22oi_1
* cell instance sg13cmos5l_a22oi_1_12 r0 *1 0,0
Xsg13cmos5l_a22oi_1_12 \$7456 \$5795 \$5867 \$7542 VPWR VGND \$7501
+ sg13cmos5l_a22oi_1
* cell instance sg13cmos5l_a22oi_1_13 r0 *1 0,0
Xsg13cmos5l_a22oi_1_13 \$3717 \$4957 \$5638 \$5640 VPWR VGND \$5639
+ sg13cmos5l_a22oi_1
* cell instance sg13cmos5l_a22oi_1_14 r0 *1 0,0
Xsg13cmos5l_a22oi_1_14 \$1769 \$1209 \$2932 \$3513 VPWR VGND \$3520
+ sg13cmos5l_a22oi_1
* cell instance sg13cmos5l_a22oi_1_15 r0 *1 0,0
Xsg13cmos5l_a22oi_1_15 \$775 \$1207 \$1315 \$1441 VPWR VGND \$1316
+ sg13cmos5l_a22oi_1
* cell instance sg13cmos5l_a22oi_1_16 r0 *1 0,0
Xsg13cmos5l_a22oi_1_16 \$7457 \$5795 \$5867 \$7897 VPWR VGND \$6435
+ sg13cmos5l_a22oi_1
* cell instance sg13cmos5l_a22oi_1_17 r0 *1 0,0
Xsg13cmos5l_a22oi_1_17 \$10086 \$7895 \$9546 \$7843 VPWR VGND \$10223
+ sg13cmos5l_a22oi_1
* cell instance sg13cmos5l_a22oi_1_18 r0 *1 0,0
Xsg13cmos5l_a22oi_1_18 \$4275 \$938 \$2932 \$4271 VPWR VGND \$4277
+ sg13cmos5l_a22oi_1
* cell instance sg13cmos5l_a22oi_1_19 r0 *1 0,0
Xsg13cmos5l_a22oi_1_19 \$1191 \$1203 \$1184 \$915 VPWR VGND \$1049
+ sg13cmos5l_a22oi_1
* cell instance sg13cmos5l_a22oi_1_20 r0 *1 0,0
Xsg13cmos5l_a22oi_1_20 \$158 \$481 \$1315 \$4646 VPWR VGND \$1318
+ sg13cmos5l_a22oi_1
* cell instance sg13cmos5l_a22oi_1_21 r0 *1 0,0
Xsg13cmos5l_a22oi_1_21 \$10770 \$5636 \$6251 \$9504 VPWR VGND \$7324
+ sg13cmos5l_a22oi_1
* cell instance sg13cmos5l_a22oi_1_22 r0 *1 0,0
Xsg13cmos5l_a22oi_1_22 \$84 \$938 \$2932 \$3720 VPWR VGND \$3719
+ sg13cmos5l_a22oi_1
* cell instance sg13cmos5l_a22oi_1_23 r0 *1 0,0
Xsg13cmos5l_a22oi_1_23 \$478 \$481 \$1207 \$234 VPWR VGND \$480
+ sg13cmos5l_a22oi_1
* cell instance sg13cmos5l_a22oi_1_24 r0 *1 0,0
Xsg13cmos5l_a22oi_1_24 \$6425 \$5795 \$5157 \$5527 VPWR VGND \$6046
+ sg13cmos5l_a22oi_1
* cell instance sg13cmos5l_a22oi_1_25 r0 *1 0,0
Xsg13cmos5l_a22oi_1_25 \$3922 \$2875 \$4089 \$4772 VPWR VGND \$4087
+ sg13cmos5l_a22oi_1
* cell instance sg13cmos5l_a22oi_1_26 r0 *1 0,0
Xsg13cmos5l_a22oi_1_26 \$4794 \$4957 \$5795 \$5855 VPWR VGND \$5864
+ sg13cmos5l_a22oi_1
* cell instance sg13cmos5l_a22oi_1_27 r0 *1 0,0
Xsg13cmos5l_a22oi_1_27 \$245 \$1207 \$1204 \$1249 VPWR VGND \$1205
+ sg13cmos5l_a22oi_1
* cell instance sg13cmos5l_a22oi_1_28 r0 *1 0,0
Xsg13cmos5l_a22oi_1_28 \$1337 \$2875 \$2932 \$3320 VPWR VGND \$2703
+ sg13cmos5l_a22oi_1
* cell instance sg13cmos5l_a22oi_1_29 r0 *1 0,0
Xsg13cmos5l_a22oi_1_29 \$10138 \$7895 \$9086 \$7843 VPWR VGND \$10224
+ sg13cmos5l_a22oi_1
* cell instance sg13cmos5l_a22oi_1_30 r0 *1 0,0
Xsg13cmos5l_a22oi_1_30 \$6047 \$4844 \$5638 \$6775 VPWR VGND \$6256
+ sg13cmos5l_a22oi_1
* cell instance sg13cmos5l_a22oi_1_31 r0 *1 0,0
Xsg13cmos5l_a22oi_1_31 \$3544 \$2875 \$2932 \$3723 VPWR VGND \$3722
+ sg13cmos5l_a22oi_1
* cell instance sg13cmos5l_a22oi_1_32 r0 *1 0,0
Xsg13cmos5l_a22oi_1_32 \$4284 \$938 \$4089 \$4437 VPWR VGND \$4286
+ sg13cmos5l_a22oi_1
* cell instance sg13cmos5l_a22oi_1_33 r0 *1 0,0
Xsg13cmos5l_a22oi_1_33 \$388 \$481 \$1207 \$262 VPWR VGND \$389
+ sg13cmos5l_a22oi_1
* cell instance sg13cmos5l_a22oi_1_34 r0 *1 0,0
Xsg13cmos5l_a22oi_1_34 \$5865 \$5636 \$4957 \$3109 VPWR VGND \$5866
+ sg13cmos5l_a22oi_1
* cell instance sg13cmos5l_a22oi_1_35 r0 *1 0,0
Xsg13cmos5l_a22oi_1_35 \$1616 \$938 \$2875 \$2709 VPWR VGND \$2708
+ sg13cmos5l_a22oi_1
* cell instance sg13cmos5l_a22oi_1_36 r0 *1 0,0
Xsg13cmos5l_a22oi_1_36 \$6259 \$4844 \$5867 \$6260 VPWR VGND \$6257
+ sg13cmos5l_a22oi_1
* cell instance sg13cmos5l_a22oi_1_37 r0 *1 0,0
Xsg13cmos5l_a22oi_1_37 \$11218 \$5638 \$6251 \$10926 VPWR VGND \$5868
+ sg13cmos5l_a22oi_1
* cell instance sg13cmos5l_a22oi_1_38 r0 *1 0,0
Xsg13cmos5l_a22oi_1_38 \$8556 \$5638 \$5867 \$8539 VPWR VGND \$6780
+ sg13cmos5l_a22oi_1
* cell instance sg13cmos5l_a22oi_1_39 r0 *1 0,0
Xsg13cmos5l_a22oi_1_39 \$85 \$1207 \$1204 \$1253 VPWR VGND \$1206
+ sg13cmos5l_a22oi_1
* cell instance sg13cmos5l_a22oi_1_40 r0 *1 0,0
Xsg13cmos5l_a22oi_1_40 \$6915 \$4844 \$6251 \$9552 VPWR VGND \$6782
+ sg13cmos5l_a22oi_1
* cell instance sg13cmos5l_a22oi_1_41 r0 *1 0,0
Xsg13cmos5l_a22oi_1_41 \$5492 \$5157 \$1412 \$4671 VPWR VGND \$5493
+ sg13cmos5l_a22oi_1
* cell instance sg13cmos5l_a22oi_1_42 r0 *1 0,0
Xsg13cmos5l_a22oi_1_42 \$4841 \$5148 \$5145 \$5147 VPWR VGND \$5146
+ sg13cmos5l_a22oi_1
* cell instance sg13cmos5l_a22oi_1_43 r0 *1 0,0
Xsg13cmos5l_a22oi_1_43 \$5278 \$4844 \$4671 \$4291 VPWR VGND \$5280
+ sg13cmos5l_a22oi_1
* cell instance sg13cmos5l_a22oi_1_44 r0 *1 0,0
Xsg13cmos5l_a22oi_1_44 \$799 \$938 \$1209 \$756 VPWR VGND \$937
+ sg13cmos5l_a22oi_1
* cell instance sg13cmos5l_a22oi_1_45 r0 *1 0,0
Xsg13cmos5l_a22oi_1_45 \$1794 \$1204 \$1315 \$2678 VPWR VGND \$2325
+ sg13cmos5l_a22oi_1
* cell instance sg13cmos5l_a22oi_1_46 r0 *1 0,0
Xsg13cmos5l_a22oi_1_46 \$1515 \$1204 \$1315 \$2302 VPWR VGND \$2327
+ sg13cmos5l_a22oi_1
* cell instance sg13cmos5l_a22oi_1_47 r0 *1 0,0
Xsg13cmos5l_a22oi_1_47 \$5304 \$5157 \$5867 \$5873 VPWR VGND \$5875
+ sg13cmos5l_a22oi_1
* cell instance sg13cmos5l_a22oi_1_48 r0 *1 0,0
Xsg13cmos5l_a22oi_1_48 \$3353 \$1193 \$2313 \$1315 VPWR VGND \$2503
+ sg13cmos5l_a22oi_1
* cell instance sg13cmos5l_a22oi_1_49 r0 *1 0,0
Xsg13cmos5l_a22oi_1_49 \$1628 \$938 \$1976 \$1980 VPWR VGND \$1979
+ sg13cmos5l_a22oi_1
* cell instance sg13cmos5l_a22oi_1_50 r0 *1 0,0
Xsg13cmos5l_a22oi_1_50 \$1070 \$481 \$1207 \$1036 VPWR VGND \$1224
+ sg13cmos5l_a22oi_1
* cell instance sg13cmos5l_a22oi_1_51 r0 *1 0,0
Xsg13cmos5l_a22oi_1_51 \$1801 \$1204 \$1315 \$1920 VPWR VGND \$1982
+ sg13cmos5l_a22oi_1
* cell instance sg13cmos5l_a22oi_1_52 r0 *1 0,0
Xsg13cmos5l_a22oi_1_52 \$4976 \$4844 \$4671 \$1414 VPWR VGND \$5155
+ sg13cmos5l_a22oi_1
* cell instance sg13cmos5l_a22oi_1_53 r0 *1 0,0
Xsg13cmos5l_a22oi_1_53 \$190 \$481 \$1207 \$352 VPWR VGND \$519
+ sg13cmos5l_a22oi_1
* cell instance sg13cmos5l_a22oi_1_54 r0 *1 0,0
Xsg13cmos5l_a22oi_1_54 \$826 \$481 \$1204 \$1085 VPWR VGND \$1225
+ sg13cmos5l_a22oi_1
* cell instance sg13cmos5l_a22oi_1_55 r0 *1 0,0
Xsg13cmos5l_a22oi_1_55 \$3925 \$2875 \$4089 \$3927 VPWR VGND \$3924
+ sg13cmos5l_a22oi_1
* cell instance sg13cmos5l_a22oi_1_56 r0 *1 0,0
Xsg13cmos5l_a22oi_1_56 \$588 \$481 \$1207 \$353 VPWR VGND \$520
+ sg13cmos5l_a22oi_1
* cell instance sg13cmos5l_a22oi_1_57 r0 *1 0,0
Xsg13cmos5l_a22oi_1_57 \$3362 \$1209 \$1976 \$3533 VPWR VGND \$3487
+ sg13cmos5l_a22oi_1
* cell instance sg13cmos5l_a22oi_1_58 r0 *1 0,0
Xsg13cmos5l_a22oi_1_58 \$1417 \$1204 \$1315 \$1499 VPWR VGND \$1335
+ sg13cmos5l_a22oi_1
* cell instance sg13cmos5l_a22oi_1_59 r0 *1 0,0
Xsg13cmos5l_a22oi_1_59 \$2146 \$1209 \$1204 \$2147 VPWR VGND \$2282
+ sg13cmos5l_a22oi_1
* cell instance sg13cmos5l_a22oi_1_60 r0 *1 0,0
Xsg13cmos5l_a22oi_1_60 \$6071 \$4844 \$5157 \$5418 VPWR VGND \$6056
+ sg13cmos5l_a22oi_1
* cell instance sg13cmos5l_a22oi_1_61 r0 *1 0,0
Xsg13cmos5l_a22oi_1_61 \$5665 \$5668 \$5667 \$5287 VPWR VGND \$5663
+ sg13cmos5l_a22oi_1
* cell instance sg13cmos5l_a22oi_1_62 r0 *1 0,0
Xsg13cmos5l_a22oi_1_62 \$5449 \$5668 \$5670 \$5287 VPWR VGND \$5671
+ sg13cmos5l_a22oi_1
* cell instance sg13cmos5l_a22oi_1_63 r0 *1 0,0
Xsg13cmos5l_a22oi_1_63 \$12317 \$4861 \$6092 \$19616 VPWR VGND \$5646
+ sg13cmos5l_a22oi_1
* cell instance sg13cmos5l_a22oi_1_64 r0 *1 0,0
Xsg13cmos5l_a22oi_1_64 \$19622 \$4385 \$6092 \$19601 VPWR VGND \$5796
+ sg13cmos5l_a22oi_1
* cell instance sg13cmos5l_a22oi_1_65 r0 *1 0,0
Xsg13cmos5l_a22oi_1_65 \$19628 \$4861 \$6092 \$19608 VPWR VGND \$6301
+ sg13cmos5l_a22oi_1
* cell instance sg13cmos5l_a22oi_1_66 r0 *1 0,0
Xsg13cmos5l_a22oi_1_66 \$19629 \$4861 \$6092 \$19526 VPWR VGND \$3052
+ sg13cmos5l_a22oi_1
* cell instance sg13cmos5l_a22oi_1_67 r0 *1 0,0
Xsg13cmos5l_a22oi_1_67 \$3299 \$3571 \$3569 \$3570 VPWR VGND \$3563
+ sg13cmos5l_a22oi_1
* cell instance sg13cmos5l_a22oi_1_68 r0 *1 0,0
Xsg13cmos5l_a22oi_1_68 \$2754 \$1843 \$2543 \$2985 VPWR VGND \$2756
+ sg13cmos5l_a22oi_1
* cell instance sg13cmos5l_a22oi_1_69 r0 *1 0,0
Xsg13cmos5l_a22oi_1_69 \$3570 \$3405 \$3571 \$3550 VPWR VGND \$2987
+ sg13cmos5l_a22oi_1
* cell instance sg13cmos5l_a22oi_1_70 r0 *1 0,0
Xsg13cmos5l_a22oi_1_70 \$2545 \$2025 \$2546 \$2547 VPWR VGND \$2363
+ sg13cmos5l_a22oi_1
* cell instance sg13cmos5l_a22oi_1_71 r0 *1 0,0
Xsg13cmos5l_a22oi_1_71 \$3570 \$2996 \$4504 \$3571 VPWR VGND \$3400
+ sg13cmos5l_a22oi_1
* cell instance sg13cmos5l_a22oi_1_72 r0 *1 0,0
Xsg13cmos5l_a22oi_1_72 \$856 \$701 \$858 \$600 VPWR VGND \$855
+ sg13cmos5l_a22oi_1
* cell instance sg13cmos5l_a22oi_1_73 r0 *1 0,0
Xsg13cmos5l_a22oi_1_73 \$2567 \$2211 \$2208 \$2378 VPWR VGND \$2572
+ sg13cmos5l_a22oi_1
* cell instance sg13cmos5l_a22oi_1_74 r0 *1 0,0
Xsg13cmos5l_a22oi_1_74 \$3010 \$2211 \$2208 \$3777 VPWR VGND \$3204
+ sg13cmos5l_a22oi_1
* cell instance sg13cmos5l_a22oi_1_75 r0 *1 0,0
Xsg13cmos5l_a22oi_1_75 \$423 \$332 \$426 \$331 VPWR VGND \$427
+ sg13cmos5l_a22oi_1
* cell instance sg13cmos5l_a22oi_1_76 r0 *1 0,0
Xsg13cmos5l_a22oi_1_76 \$3021 \$2231 \$3020 \$3022 VPWR VGND \$3017
+ sg13cmos5l_a22oi_1
* cell instance sg13cmos5l_a22oi_1_77 r0 *1 0,0
Xsg13cmos5l_a22oi_1_77 \$105 \$95 \$29 \$115 VPWR VGND \$211 sg13cmos5l_a22oi_1
* cell instance sg13cmos5l_a22oi_1_78 r0 *1 0,0
Xsg13cmos5l_a22oi_1_78 \$50 \$29 \$866 \$702 VPWR VGND \$993 sg13cmos5l_a22oi_1
* cell instance sg13cmos5l_a22oi_1_79 r0 *1 0,0
Xsg13cmos5l_a22oi_1_79 \$2194 \$2208 \$2225 \$2210 VPWR VGND \$2228
+ sg13cmos5l_a22oi_1
* cell instance sg13cmos5l_a22oi_1_80 r0 *1 0,0
Xsg13cmos5l_a22oi_1_80 \$4692 \$4341 \$5023 \$5021 VPWR VGND \$3972
+ sg13cmos5l_a22oi_1
* cell instance sg13cmos5l_a22oi_1_81 r0 *1 0,0
Xsg13cmos5l_a22oi_1_81 \$428 \$1139 \$1276 \$600 VPWR VGND \$1277
+ sg13cmos5l_a22oi_1
* cell instance sg13cmos5l_a22oi_1_82 r0 *1 0,0
Xsg13cmos5l_a22oi_1_82 \$25 \$428 \$444 \$433 VPWR VGND \$570 sg13cmos5l_a22oi_1
* cell instance sg13cmos5l_a22oi_1_83 r0 *1 0,0
Xsg13cmos5l_a22oi_1_83 \$1002 \$1278 \$127 \$866 VPWR VGND \$1148
+ sg13cmos5l_a22oi_1
* cell instance sg13cmos5l_a22oi_1_84 r0 *1 0,0
Xsg13cmos5l_a22oi_1_84 \$871 \$1002 \$22 \$53 VPWR VGND \$727 sg13cmos5l_a22oi_1
* cell instance sg13cmos5l_a22oi_1_85 r0 *1 0,0
Xsg13cmos5l_a22oi_1_85 \$29 \$127 \$128 \$57 VPWR VGND \$131 sg13cmos5l_a22oi_1
* cell instance sg13cmos5l_a22oi_1_86 r0 *1 0,0
Xsg13cmos5l_a22oi_1_86 \$5089 \$3438 \$5028 \$4125 VPWR VGND \$4885
+ sg13cmos5l_a22oi_1
* cell instance sg13cmos5l_a22oi_1_87 r0 *1 0,0
Xsg13cmos5l_a22oi_1_87 \$4125 \$5373 \$3438 \$3312 VPWR VGND \$5767
+ sg13cmos5l_a22oi_1
* cell instance sg13cmos5l_a22oi_1_88 r0 *1 0,0
Xsg13cmos5l_a22oi_1_88 \$4681 \$6203 \$6382 \$5758 VPWR VGND \$5090
+ sg13cmos5l_a22oi_1
* cell instance sg13cmos5l_a22oi_1_89 r0 *1 0,0
Xsg13cmos5l_a22oi_1_89 \$6386 \$5756 \$5777 \$6708 VPWR VGND \$6702
+ sg13cmos5l_a22oi_1
* cell instance sg13cmos5l_a22oi_1_90 r0 *1 0,0
Xsg13cmos5l_a22oi_1_90 \$5050 \$4884 \$5046 \$5089 VPWR VGND \$5091
+ sg13cmos5l_a22oi_1
* cell instance sg13cmos5l_a22oi_1_91 r0 *1 0,0
Xsg13cmos5l_a22oi_1_91 \$2842 \$3620 \$3493 \$2843 VPWR VGND \$3685
+ sg13cmos5l_a22oi_1
* cell instance sg13cmos5l_a22oi_1_92 r0 *1 0,0
Xsg13cmos5l_a22oi_1_92 \$5771 \$6710 \$6713 \$5758 VPWR VGND \$5049
+ sg13cmos5l_a22oi_1
* cell instance sg13cmos5l_a22oi_1_93 r0 *1 0,0
Xsg13cmos5l_a22oi_1_93 \$5220 \$5028 \$4586 \$5089 VPWR VGND \$5221
+ sg13cmos5l_a22oi_1
* cell instance sg13cmos5l_a22oi_1_94 r0 *1 0,0
Xsg13cmos5l_a22oi_1_94 \$4375 \$4385 \$4585 \$4587 VPWR VGND \$4586
+ sg13cmos5l_a22oi_1
* cell instance sg13cmos5l_a22oi_1_95 r0 *1 0,0
Xsg13cmos5l_a22oi_1_95 \$3 \$4884 \$5028 \$5050 VPWR VGND \$5052
+ sg13cmos5l_a22oi_1
* cell instance sg13cmos5l_a22oi_1_96 r0 *1 0,0
Xsg13cmos5l_a22oi_1_96 \$2908 \$3620 \$3493 \$3314 VPWR VGND \$3452
+ sg13cmos5l_a22oi_1
* cell instance sg13cmos5l_a22oi_1_97 r0 *1 0,0
Xsg13cmos5l_a22oi_1_97 \$4377 \$3620 \$3493 \$4380 VPWR VGND \$4379
+ sg13cmos5l_a22oi_1
* cell instance sg13cmos5l_a22oi_1_98 r0 *1 0,0
Xsg13cmos5l_a22oi_1_98 \$4380 \$4773 \$2020 \$4377 VPWR VGND \$4587
+ sg13cmos5l_a22oi_1
* cell instance sg13cmos5l_a22oi_1_99 r0 *1 0,0
Xsg13cmos5l_a22oi_1_99 \$4015 \$3620 \$3493 \$4017 VPWR VGND \$4013
+ sg13cmos5l_a22oi_1
* cell instance sg13cmos5l_a22oi_1_100 r0 *1 0,0
Xsg13cmos5l_a22oi_1_100 \$4381 \$4385 \$4253 \$4384 VPWR VGND \$4383
+ sg13cmos5l_a22oi_1
* cell instance sg13cmos5l_a22oi_1_101 r0 *1 0,0
Xsg13cmos5l_a22oi_1_101 \$5399 \$4884 \$5028 \$2466 VPWR VGND \$5401
+ sg13cmos5l_a22oi_1
* cell instance sg13cmos5l_a22oi_1_102 r0 *1 0,0
Xsg13cmos5l_a22oi_1_102 \$4735 \$3976 \$2020 \$4738 VPWR VGND \$4737
+ sg13cmos5l_a22oi_1
* cell instance sg13cmos5l_a22oi_1_103 r0 *1 0,0
Xsg13cmos5l_a22oi_1_103 \$4900 \$4385 \$5058 \$4737 VPWR VGND \$5060
+ sg13cmos5l_a22oi_1
* cell instance sg13cmos5l_and2_1_0 r0 *1 0,0
Xsg13cmos5l_and2_1_0 \$4670 \$6032 VPWR VGND \$6024 sg13cmos5l_and2_1
* cell instance sg13cmos5l_and2_1_1 r0 *1 0,0
Xsg13cmos5l_and2_1_1 \$1766 \$1184 VPWR VGND \$1768 sg13cmos5l_and2_1
* cell instance sg13cmos5l_and2_1_2 r0 *1 0,0
Xsg13cmos5l_and2_1_2 \$4670 \$5795 VPWR VGND \$7323 sg13cmos5l_and2_1
* cell instance sg13cmos5l_and2_1_3 r0 *1 0,0
Xsg13cmos5l_and2_1_3 \$10923 \$5638 VPWR VGND \$6248 sg13cmos5l_and2_1
* cell instance sg13cmos5l_and2_1_4 r0 *1 0,0
Xsg13cmos5l_and2_1_4 \$5144 \$4670 VPWR VGND \$10746 sg13cmos5l_and2_1
* cell instance sg13cmos5l_and2_1_5 r0 *1 0,0
Xsg13cmos5l_and2_1_5 \$2135 \$2307 VPWR VGND \$2493 sg13cmos5l_and2_1
* cell instance sg13cmos5l_and2_1_6 r0 *1 0,0
Xsg13cmos5l_and2_1_6 \$4670 \$4830 VPWR VGND \$11305 sg13cmos5l_and2_1
* cell instance sg13cmos5l_and2_1_7 r0 *1 0,0
Xsg13cmos5l_and2_1_7 \$4841 \$4318 VPWR VGND \$5144 sg13cmos5l_and2_1
* cell instance sg13cmos5l_and2_1_8 r0 *1 0,0
Xsg13cmos5l_and2_1_8 \$4672 \$4318 VPWR VGND \$4957 sg13cmos5l_and2_1
* cell instance sg13cmos5l_and2_1_9 r0 *1 0,0
Xsg13cmos5l_and2_1_9 \$1979 \$3520 VPWR VGND \$3731 sg13cmos5l_and2_1
* cell instance sg13cmos5l_and2_1_10 r0 *1 0,0
Xsg13cmos5l_and2_1_10 \$4841 \$4757 VPWR VGND \$4830 sg13cmos5l_and2_1
* cell instance sg13cmos5l_and2_1_11 r0 *1 0,0
Xsg13cmos5l_and2_1_11 \$5322 \$5157 VPWR VGND \$6437 sg13cmos5l_and2_1
* cell instance sg13cmos5l_and2_1_12 r0 *1 0,0
Xsg13cmos5l_and2_1_12 \$3729 \$4092 VPWR VGND \$4293 sg13cmos5l_and2_1
* cell instance sg13cmos5l_and2_1_13 r0 *1 0,0
Xsg13cmos5l_and2_1_13 \$4672 \$4839 VPWR VGND \$5145 sg13cmos5l_and2_1
* cell instance sg13cmos5l_and2_1_14 r0 *1 0,0
Xsg13cmos5l_and2_1_14 \$4672 \$4757 VPWR VGND \$4671 sg13cmos5l_and2_1
* cell instance sg13cmos5l_and2_1_15 r0 *1 0,0
Xsg13cmos5l_and2_1_15 \$4093 \$4297 VPWR VGND \$1984 sg13cmos5l_and2_1
* cell instance sg13cmos5l_and2_1_16 r0 *1 0,0
Xsg13cmos5l_and2_1_16 \$4672 \$4676 VPWR VGND \$4297 sg13cmos5l_and2_1
* cell instance sg13cmos5l_and2_1_17 r0 *1 0,0
Xsg13cmos5l_and2_1_17 \$4841 \$4676 VPWR VGND \$4849 sg13cmos5l_and2_1
* cell instance sg13cmos5l_and2_1_18 r0 *1 0,0
Xsg13cmos5l_and2_1_18 \$5082 \$5304 VPWR VGND \$5163 sg13cmos5l_and2_1
* cell instance sg13cmos5l_and2_1_19 r0 *1 0,0
Xsg13cmos5l_and2_1_19 \$2197 \$2997 VPWR VGND \$3194 sg13cmos5l_and2_1
* cell instance sg13cmos5l_and2_1_20 r0 *1 0,0
Xsg13cmos5l_and2_1_20 \$60 \$62 VPWR VGND \$423 sg13cmos5l_and2_1
* cell instance sg13cmos5l_and2_1_21 r0 *1 0,0
Xsg13cmos5l_and2_1_21 \$7 \$8 VPWR VGND \$1689 sg13cmos5l_and2_1
* cell instance sg13cmos5l_and2_1_22 r0 *1 0,0
Xsg13cmos5l_and2_1_22 \$2106 \$2047 VPWR VGND \$1930 sg13cmos5l_and2_1
* cell instance sg13cmos5l_and2_1_23 r0 *1 0,0
Xsg13cmos5l_and2_1_23 \$3785 \$4538 VPWR VGND \$3303 sg13cmos5l_and2_1
* cell instance sg13cmos5l_and2_1_24 r0 *1 0,0
Xsg13cmos5l_and2_1_24 \$3595 \$3678 VPWR VGND \$2231 sg13cmos5l_and2_1
* cell instance sg13cmos5l_and2_1_25 r0 *1 0,0
Xsg13cmos5l_and2_1_25 \$436 \$29 VPWR VGND \$437 sg13cmos5l_and2_1
* cell instance sg13cmos5l_and2_1_26 r0 *1 0,0
Xsg13cmos5l_and2_1_26 \$728 \$1002 VPWR VGND \$1139 sg13cmos5l_and2_1
* cell instance sg13cmos5l_and2_1_27 r0 *1 0,0
Xsg13cmos5l_and2_1_27 \$2578 \$2583 VPWR VGND \$2584 sg13cmos5l_and2_1
* cell instance sg13cmos5l_and2_1_28 r0 *1 0,0
Xsg13cmos5l_and2_1_28 \$5970 \$6152 VPWR VGND \$5732 sg13cmos5l_and2_1
* cell instance sg13cmos5l_and2_1_29 r0 *1 0,0
Xsg13cmos5l_and2_1_29 \$1268 \$446 VPWR VGND \$455 sg13cmos5l_and2_1
* cell instance sg13cmos5l_and2_1_30 r0 *1 0,0
Xsg13cmos5l_and2_1_30 \$5758 \$6374 VPWR VGND \$6372 sg13cmos5l_and2_1
* cell instance sg13cmos5l_and2_1_31 r0 *1 0,0
Xsg13cmos5l_and2_1_31 \$57 \$128 VPWR VGND \$125 sg13cmos5l_and2_1
* cell instance sg13cmos5l_and2_1_32 r0 *1 0,0
Xsg13cmos5l_and2_1_32 \$5823 \$5769 VPWR VGND \$6172 sg13cmos5l_and2_1
* cell instance sg13cmos5l_and2_1_33 r0 *1 0,0
Xsg13cmos5l_and2_1_33 \$5388 \$5763 VPWR VGND \$5583 sg13cmos5l_and2_1
* cell instance sg13cmos5l_and2_1_34 r0 *1 0,0
Xsg13cmos5l_and2_1_34 \$2786 \$5211 VPWR VGND \$5386 sg13cmos5l_and2_1
* cell instance sg13cmos5l_and2_1_35 r0 *1 0,0
Xsg13cmos5l_and2_1_35 \$5771 \$6181 VPWR VGND \$5989 sg13cmos5l_and2_1
* cell instance sg13cmos5l_and2_1_36 r0 *1 0,0
Xsg13cmos5l_and2_1_36 \$6856 \$5974 VPWR VGND \$6859 sg13cmos5l_and2_1
* cell instance sg13cmos5l_and2_1_37 r0 *1 0,0
Xsg13cmos5l_and2_1_37 \$6393 \$6394 VPWR VGND \$6713 sg13cmos5l_and2_1
* cell instance sg13cmos5l_and3_1_0 r0 *1 0,0
Xsg13cmos5l_and3_1_0 \$4794 \$2312 \$1766 VPWR VGND \$1410 sg13cmos5l_and3_1
* cell instance sg13cmos5l_and3_1_1 r0 *1 0,0
Xsg13cmos5l_and3_1_1 \$645 \$4957 \$4093 VPWR VGND \$4485 sg13cmos5l_and3_1
* cell instance sg13cmos5l_and3_1_2 r0 *1 0,0
Xsg13cmos5l_and3_1_2 \$4337 \$4876 \$4863 VPWR VGND \$5188 sg13cmos5l_and3_1
* cell instance sg13cmos5l_and3_1_3 r0 *1 0,0
Xsg13cmos5l_and3_1_3 \$1823 \$2561 \$2382 VPWR VGND \$2384 sg13cmos5l_and3_1
* cell instance sg13cmos5l_and3_1_4 r0 *1 0,0
Xsg13cmos5l_and3_1_4 \$7 \$8 \$62 VPWR VGND \$68 sg13cmos5l_and3_1
* cell instance sg13cmos5l_and3_1_5 r0 *1 0,0
Xsg13cmos5l_and3_1_5 \$60 \$7 \$8 VPWR VGND \$10 sg13cmos5l_and3_1
* cell instance sg13cmos5l_and3_1_6 r0 *1 0,0
Xsg13cmos5l_and3_1_6 \$7 \$8 \$201 VPWR VGND \$204 sg13cmos5l_and3_1
* cell instance sg13cmos5l_and3_1_7 r0 *1 0,0
Xsg13cmos5l_and3_1_7 \$3595 \$4549 \$2669 VPWR VGND \$5884 sg13cmos5l_and3_1
* cell instance sg13cmos5l_and3_1_8 r0 *1 0,0
Xsg13cmos5l_and3_1_8 \$5996 \$6000 \$5600 VPWR VGND \$5778 sg13cmos5l_and3_1
* cell instance sg13cmos5l_and4_1_0 r0 *1 0,0
Xsg13cmos5l_and4_1_0 \$5480 \$6432 \$6433 \$6980 VPWR VGND \$6436
+ sg13cmos5l_and4_1
* cell instance sg13cmos5l_and4_1_1 r0 *1 0,0
Xsg13cmos5l_and4_1_1 \$6252 \$6046 \$6254 \$5642 VPWR VGND \$6255
+ sg13cmos5l_and4_1
* cell instance sg13cmos5l_and4_1_2 r0 *1 0,0
Xsg13cmos5l_and4_1_2 \$6780 \$5493 \$6777 \$6782 VPWR VGND \$6783
+ sg13cmos5l_and4_1
* cell instance sg13cmos5l_and4_1_3 r0 *1 0,0
Xsg13cmos5l_and4_1_3 \$2194 \$4331 \$2759 \$4332 VPWR VGND \$4672
+ sg13cmos5l_and4_1
* cell instance sg13cmos5l_and4_1_4 r0 *1 0,0
Xsg13cmos5l_and4_1_4 \$4841 \$4876 \$4681 \$4773 VPWR VGND \$4538
+ sg13cmos5l_and4_1
* cell instance sg13cmos5l_and4_1_5 r0 *1 0,0
Xsg13cmos5l_and4_1_5 \$5723 \$5961 \$5576 \$5732 VPWR VGND \$5569
+ sg13cmos5l_and4_1
* cell instance sg13cmos5l_and4_1_6 r0 *1 0,0
Xsg13cmos5l_and4_1_6 \$4046 \$5204 \$5438 \$3438 VPWR VGND \$5376
+ sg13cmos5l_and4_1
* cell instance sg13cmos5l_antennanp_0 r0 *1 0,0
Xsg13cmos5l_antennanp_0 \$6832 VPWR VGND sg13cmos5l_antennanp
* cell instance sg13cmos5l_antennanp_1 r0 *1 0,0
Xsg13cmos5l_antennanp_1 \$2230 VPWR VGND sg13cmos5l_antennanp
* cell instance sg13cmos5l_antennanp_2 r0 *1 0,0
Xsg13cmos5l_antennanp_2 \$1359 VPWR VGND sg13cmos5l_antennanp
* cell instance sg13cmos5l_antennanp_3 r0 *1 0,0
Xsg13cmos5l_antennanp_3 \$5682 VPWR VGND sg13cmos5l_antennanp
* cell instance sg13cmos5l_antennanp_4 r0 *1 0,0
Xsg13cmos5l_antennanp_4 \$6533 VPWR VGND sg13cmos5l_antennanp
* cell instance sg13cmos5l_buf_1_0 r0 *1 0,0
Xsg13cmos5l_buf_1_0 \$2298 VPWR VGND \$457 sg13cmos5l_buf_1
* cell instance sg13cmos5l_buf_1_1 r0 *1 0,0
Xsg13cmos5l_buf_1_1 \$5462 VPWR VGND \$2307 sg13cmos5l_buf_1
* cell instance sg13cmos5l_buf_1_2 r0 *1 0,0
Xsg13cmos5l_buf_1_2 \$5109 VPWR VGND \$1766 sg13cmos5l_buf_1
* cell instance sg13cmos5l_buf_1_3 r0 *1 0,0
Xsg13cmos5l_buf_1_3 \$2307 VPWR VGND \$913 sg13cmos5l_buf_1
* cell instance sg13cmos5l_buf_1_4 r0 *1 0,0
Xsg13cmos5l_buf_1_4 \$4265 VPWR VGND \$4256 sg13cmos5l_buf_1
* cell instance sg13cmos5l_buf_1_5 r0 *1 0,0
Xsg13cmos5l_buf_1_5 \$6428 VPWR VGND \$9083 sg13cmos5l_buf_1
* cell instance sg13cmos5l_buf_1_6 r0 *1 0,0
Xsg13cmos5l_buf_1_6 \$5114 VPWR VGND \$3109 sg13cmos5l_buf_1
* cell instance sg13cmos5l_buf_1_7 r0 *1 0,0
Xsg13cmos5l_buf_1_7 \$10746 VPWR VGND \$14404 sg13cmos5l_buf_1
* cell instance sg13cmos5l_buf_1_8 r0 *1 0,0
Xsg13cmos5l_buf_1_8 \$7323 VPWR VGND \$6018 sg13cmos5l_buf_1
* cell instance sg13cmos5l_buf_1_9 r0 *1 0,0
Xsg13cmos5l_buf_1_9 \$8538 VPWR VGND \$8133 sg13cmos5l_buf_1
* cell instance sg13cmos5l_buf_1_10 r0 *1 0,0
Xsg13cmos5l_buf_1_10 \$14413 VPWR VGND \$16428 sg13cmos5l_buf_1
* cell instance sg13cmos5l_buf_1_11 r0 *1 0,0
Xsg13cmos5l_buf_1_11 \$1040 VPWR VGND \$610 sg13cmos5l_buf_1
* cell instance sg13cmos5l_buf_1_12 r0 *1 0,0
Xsg13cmos5l_buf_1_12 \$7323 VPWR VGND \$7240 sg13cmos5l_buf_1
* cell instance sg13cmos5l_buf_1_13 r0 *1 0,0
Xsg13cmos5l_buf_1_13 \$5120 VPWR VGND \$4794 sg13cmos5l_buf_1
* cell instance sg13cmos5l_buf_1_14 r0 *1 0,0
Xsg13cmos5l_buf_1_14 \$6211 VPWR VGND \$7841 sg13cmos5l_buf_1
* cell instance sg13cmos5l_buf_1_15 r0 *1 0,0
Xsg13cmos5l_buf_1_15 \$1457 VPWR VGND \$1428 sg13cmos5l_buf_1
* cell instance sg13cmos5l_buf_1_16 r0 *1 0,0
Xsg13cmos5l_buf_1_16 \$4654 VPWR VGND \$4936 sg13cmos5l_buf_1
* cell instance sg13cmos5l_buf_1_17 r0 *1 0,0
Xsg13cmos5l_buf_1_17 \$786 VPWR VGND \$605 sg13cmos5l_buf_1
* cell instance sg13cmos5l_buf_1_18 r0 *1 0,0
Xsg13cmos5l_buf_1_18 \$1596 VPWR VGND \$2914 sg13cmos5l_buf_1
* cell instance sg13cmos5l_buf_1_19 r0 *1 0,0
Xsg13cmos5l_buf_1_19 \$4644 VPWR VGND \$4935 sg13cmos5l_buf_1
* cell instance sg13cmos5l_buf_1_20 r0 *1 0,0
Xsg13cmos5l_buf_1_20 \$5472 VPWR VGND \$4644 sg13cmos5l_buf_1
* cell instance sg13cmos5l_buf_1_21 r0 *1 0,0
Xsg13cmos5l_buf_1_21 \$13813 VPWR VGND \$17987 sg13cmos5l_buf_1
* cell instance sg13cmos5l_buf_1_22 r0 *1 0,0
Xsg13cmos5l_buf_1_22 \$3109 VPWR VGND \$1323 sg13cmos5l_buf_1
* cell instance sg13cmos5l_buf_1_23 r0 *1 0,0
Xsg13cmos5l_buf_1_23 \$4104 VPWR VGND \$4265 sg13cmos5l_buf_1
* cell instance sg13cmos5l_buf_1_24 r0 *1 0,0
Xsg13cmos5l_buf_1_24 \$3907 VPWR VGND \$1596 sg13cmos5l_buf_1
* cell instance sg13cmos5l_buf_1_25 r0 *1 0,0
Xsg13cmos5l_buf_1_25 \$4644 VPWR VGND \$5126 sg13cmos5l_buf_1
* cell instance sg13cmos5l_buf_1_26 r0 *1 0,0
Xsg13cmos5l_buf_1_26 \$1428 VPWR VGND \$138 sg13cmos5l_buf_1
* cell instance sg13cmos5l_buf_1_27 r0 *1 0,0
Xsg13cmos5l_buf_1_27 \$1040 VPWR VGND \$623 sg13cmos5l_buf_1
* cell instance sg13cmos5l_buf_1_28 r0 *1 0,0
Xsg13cmos5l_buf_1_28 \$929 VPWR VGND \$3325 sg13cmos5l_buf_1
* cell instance sg13cmos5l_buf_1_29 r0 *1 0,0
Xsg13cmos5l_buf_1_29 \$2700 VPWR VGND \$1040 sg13cmos5l_buf_1
* cell instance sg13cmos5l_buf_1_30 r0 *1 0,0
Xsg13cmos5l_buf_1_30 \$13813 VPWR VGND \$12308 sg13cmos5l_buf_1
* cell instance sg13cmos5l_buf_1_31 r0 *1 0,0
Xsg13cmos5l_buf_1_31 \$8563 VPWR VGND \$12206 sg13cmos5l_buf_1
* cell instance sg13cmos5l_buf_1_32 r0 *1 0,0
Xsg13cmos5l_buf_1_32 \$629 VPWR VGND \$613 sg13cmos5l_buf_1
* cell instance sg13cmos5l_buf_1_33 r0 *1 0,0
Xsg13cmos5l_buf_1_33 \$16437 VPWR VGND \$17275 sg13cmos5l_buf_1
* cell instance sg13cmos5l_buf_1_34 r0 *1 0,0
Xsg13cmos5l_buf_1_34 \$4794 VPWR VGND \$1076 sg13cmos5l_buf_1
* cell instance sg13cmos5l_buf_1_35 r0 *1 0,0
Xsg13cmos5l_buf_1_35 \$4644 VPWR VGND \$3498 sg13cmos5l_buf_1
* cell instance sg13cmos5l_buf_1_36 r0 *1 0,0
Xsg13cmos5l_buf_1_36 \$1076 VPWR VGND \$1201 sg13cmos5l_buf_1
* cell instance sg13cmos5l_buf_1_37 r0 *1 0,0
Xsg13cmos5l_buf_1_37 \$6428 VPWR VGND \$7535 sg13cmos5l_buf_1
* cell instance sg13cmos5l_buf_1_38 r0 *1 0,0
Xsg13cmos5l_buf_1_38 \$6428 VPWR VGND \$6430 sg13cmos5l_buf_1
* cell instance sg13cmos5l_buf_1_39 r0 *1 0,0
Xsg13cmos5l_buf_1_39 \$10746 VPWR VGND \$15156 sg13cmos5l_buf_1
* cell instance sg13cmos5l_buf_1_40 r0 *1 0,0
Xsg13cmos5l_buf_1_40 \$645 VPWR VGND \$2298 sg13cmos5l_buf_1
* cell instance sg13cmos5l_buf_1_41 r0 *1 0,0
Xsg13cmos5l_buf_1_41 \$2307 VPWR VGND \$876 sg13cmos5l_buf_1
* cell instance sg13cmos5l_buf_1_42 r0 *1 0,0
Xsg13cmos5l_buf_1_42 \$13813 VPWR VGND \$16432 sg13cmos5l_buf_1
* cell instance sg13cmos5l_buf_1_43 r0 *1 0,0
Xsg13cmos5l_buf_1_43 \$6005 VPWR VGND \$3717 sg13cmos5l_buf_1
* cell instance sg13cmos5l_buf_1_44 r0 *1 0,0
Xsg13cmos5l_buf_1_44 \$5266 VPWR VGND \$2135 sg13cmos5l_buf_1
* cell instance sg13cmos5l_buf_1_45 r0 *1 0,0
Xsg13cmos5l_buf_1_45 \$13813 VPWR VGND \$12832 sg13cmos5l_buf_1
* cell instance sg13cmos5l_buf_1_46 r0 *1 0,0
Xsg13cmos5l_buf_1_46 \$629 VPWR VGND \$1460 sg13cmos5l_buf_1
* cell instance sg13cmos5l_buf_1_47 r0 *1 0,0
Xsg13cmos5l_buf_1_47 \$11403 VPWR VGND \$13813 sg13cmos5l_buf_1
* cell instance sg13cmos5l_buf_1_48 r0 *1 0,0
Xsg13cmos5l_buf_1_48 \$6852 VPWR VGND \$6428 sg13cmos5l_buf_1
* cell instance sg13cmos5l_buf_1_49 r0 *1 0,0
Xsg13cmos5l_buf_1_49 \$2493 VPWR VGND \$1184 sg13cmos5l_buf_1
* cell instance sg13cmos5l_buf_1_50 r0 *1 0,0
Xsg13cmos5l_buf_1_50 \$3717 VPWR VGND \$2312 sg13cmos5l_buf_1
* cell instance sg13cmos5l_buf_1_51 r0 *1 0,0
Xsg13cmos5l_buf_1_51 \$929 VPWR VGND \$2120 sg13cmos5l_buf_1
* cell instance sg13cmos5l_buf_1_52 r0 *1 0,0
Xsg13cmos5l_buf_1_52 \$4089 VPWR VGND \$2932 sg13cmos5l_buf_1
* cell instance sg13cmos5l_buf_1_53 r0 *1 0,0
Xsg13cmos5l_buf_1_53 \$2493 VPWR VGND \$2311 sg13cmos5l_buf_1
* cell instance sg13cmos5l_buf_1_54 r0 *1 0,0
Xsg13cmos5l_buf_1_54 \$6211 VPWR VGND \$8041 sg13cmos5l_buf_1
* cell instance sg13cmos5l_buf_1_55 r0 *1 0,0
Xsg13cmos5l_buf_1_55 \$2965 VPWR VGND \$367 sg13cmos5l_buf_1
* cell instance sg13cmos5l_buf_1_56 r0 *1 0,0
Xsg13cmos5l_buf_1_56 \$4280 VPWR VGND \$1976 sg13cmos5l_buf_1
* cell instance sg13cmos5l_buf_1_57 r0 *1 0,0
Xsg13cmos5l_buf_1_57 \$11974 VPWR VGND \$11400 sg13cmos5l_buf_1
* cell instance sg13cmos5l_buf_1_58 r0 *1 0,0
Xsg13cmos5l_buf_1_58 \$1976 VPWR VGND \$2875 sg13cmos5l_buf_1
* cell instance sg13cmos5l_buf_1_59 r0 *1 0,0
Xsg13cmos5l_buf_1_59 \$13964 VPWR VGND \$17288 sg13cmos5l_buf_1
* cell instance sg13cmos5l_buf_1_60 r0 *1 0,0
Xsg13cmos5l_buf_1_60 \$11974 VPWR VGND \$11296 sg13cmos5l_buf_1
* cell instance sg13cmos5l_buf_1_61 r0 *1 0,0
Xsg13cmos5l_buf_1_61 \$1766 VPWR VGND \$1793 sg13cmos5l_buf_1
* cell instance sg13cmos5l_buf_1_62 r0 *1 0,0
Xsg13cmos5l_buf_1_62 \$8538 VPWR VGND \$7895 sg13cmos5l_buf_1
* cell instance sg13cmos5l_buf_1_63 r0 *1 0,0
Xsg13cmos5l_buf_1_63 \$4283 VPWR VGND \$270 sg13cmos5l_buf_1
* cell instance sg13cmos5l_buf_1_64 r0 *1 0,0
Xsg13cmos5l_buf_1_64 \$4830 VPWR VGND \$5638 sg13cmos5l_buf_1
* cell instance sg13cmos5l_buf_1_65 r0 *1 0,0
Xsg13cmos5l_buf_1_65 \$166 VPWR VGND \$240 sg13cmos5l_buf_1
* cell instance sg13cmos5l_buf_1_66 r0 *1 0,0
Xsg13cmos5l_buf_1_66 \$4485 VPWR VGND \$4654 sg13cmos5l_buf_1
* cell instance sg13cmos5l_buf_1_67 r0 *1 0,0
Xsg13cmos5l_buf_1_67 \$11403 VPWR VGND \$6852 sg13cmos5l_buf_1
* cell instance sg13cmos5l_buf_1_68 r0 *1 0,0
Xsg13cmos5l_buf_1_68 \$1315 VPWR VGND \$4089 sg13cmos5l_buf_1
* cell instance sg13cmos5l_buf_1_69 r0 *1 0,0
Xsg13cmos5l_buf_1_69 \$5144 VPWR VGND \$5636 sg13cmos5l_buf_1
* cell instance sg13cmos5l_buf_1_70 r0 *1 0,0
Xsg13cmos5l_buf_1_70 \$642 VPWR VGND \$1052 sg13cmos5l_buf_1
* cell instance sg13cmos5l_buf_1_71 r0 *1 0,0
Xsg13cmos5l_buf_1_71 \$2135 VPWR VGND \$1324 sg13cmos5l_buf_1
* cell instance sg13cmos5l_buf_1_72 r0 *1 0,0
Xsg13cmos5l_buf_1_72 \$2706 VPWR VGND \$938 sg13cmos5l_buf_1
* cell instance sg13cmos5l_buf_1_73 r0 *1 0,0
Xsg13cmos5l_buf_1_73 \$929 VPWR VGND \$629 sg13cmos5l_buf_1
* cell instance sg13cmos5l_buf_1_74 r0 *1 0,0
Xsg13cmos5l_buf_1_74 \$11305 VPWR VGND \$14413 sg13cmos5l_buf_1
* cell instance sg13cmos5l_buf_1_75 r0 *1 0,0
Xsg13cmos5l_buf_1_75 \$19480 VPWR VGND \$18974 sg13cmos5l_buf_1
* cell instance sg13cmos5l_buf_1_76 r0 *1 0,0
Xsg13cmos5l_buf_1_76 \$19480 VPWR VGND \$16435 sg13cmos5l_buf_1
* cell instance sg13cmos5l_buf_1_77 r0 *1 0,0
Xsg13cmos5l_buf_1_77 \$493 VPWR VGND \$2680 sg13cmos5l_buf_1
* cell instance sg13cmos5l_buf_1_78 r0 *1 0,0
Xsg13cmos5l_buf_1_78 \$4293 VPWR VGND \$1315 sg13cmos5l_buf_1
* cell instance sg13cmos5l_buf_1_79 r0 *1 0,0
Xsg13cmos5l_buf_1_79 \$4978 VPWR VGND \$16437 sg13cmos5l_buf_1
* cell instance sg13cmos5l_buf_1_80 r0 *1 0,0
Xsg13cmos5l_buf_1_80 \$1052 VPWR VGND \$786 sg13cmos5l_buf_1
* cell instance sg13cmos5l_buf_1_81 r0 *1 0,0
Xsg13cmos5l_buf_1_81 \$3109 VPWR VGND \$1929 sg13cmos5l_buf_1
* cell instance sg13cmos5l_buf_1_82 r0 *1 0,0
Xsg13cmos5l_buf_1_82 \$1209 VPWR VGND \$1207 sg13cmos5l_buf_1
* cell instance sg13cmos5l_buf_1_83 r0 *1 0,0
Xsg13cmos5l_buf_1_83 \$5682 VPWR VGND \$11974 sg13cmos5l_buf_1
* cell instance sg13cmos5l_buf_1_84 r0 *1 0,0
Xsg13cmos5l_buf_1_84 \$629 VPWR VGND \$632 sg13cmos5l_buf_1
* cell instance sg13cmos5l_buf_1_85 r0 *1 0,0
Xsg13cmos5l_buf_1_85 \$4482 VPWR VGND \$4092 sg13cmos5l_buf_1
* cell instance sg13cmos5l_buf_1_86 r0 *1 0,0
Xsg13cmos5l_buf_1_86 \$11403 VPWR VGND \$13964 sg13cmos5l_buf_1
* cell instance sg13cmos5l_buf_1_87 r0 *1 0,0
Xsg13cmos5l_buf_1_87 \$493 VPWR VGND \$458 sg13cmos5l_buf_1
* cell instance sg13cmos5l_buf_1_88 r0 *1 0,0
Xsg13cmos5l_buf_1_88 \$2501 VPWR VGND \$1209 sg13cmos5l_buf_1
* cell instance sg13cmos5l_buf_1_89 r0 *1 0,0
Xsg13cmos5l_buf_1_89 \$3733 VPWR VGND \$2935 sg13cmos5l_buf_1
* cell instance sg13cmos5l_buf_1_90 r0 *1 0,0
Xsg13cmos5l_buf_1_90 \$641 VPWR VGND \$645 sg13cmos5l_buf_1
* cell instance sg13cmos5l_buf_1_91 r0 *1 0,0
Xsg13cmos5l_buf_1_91 \$4832 VPWR VGND \$3352 sg13cmos5l_buf_1
* cell instance sg13cmos5l_buf_1_92 r0 *1 0,0
Xsg13cmos5l_buf_1_92 \$270 VPWR VGND \$267 sg13cmos5l_buf_1
* cell instance sg13cmos5l_buf_1_93 r0 *1 0,0
Xsg13cmos5l_buf_1_93 \$4666 VPWR VGND \$3353 sg13cmos5l_buf_1
* cell instance sg13cmos5l_buf_1_94 r0 *1 0,0
Xsg13cmos5l_buf_1_94 \$2141 VPWR VGND \$1068 sg13cmos5l_buf_1
* cell instance sg13cmos5l_buf_1_95 r0 *1 0,0
Xsg13cmos5l_buf_1_95 \$2143 VPWR VGND \$2141 sg13cmos5l_buf_1
* cell instance sg13cmos5l_buf_1_96 r0 *1 0,0
Xsg13cmos5l_buf_1_96 \$1976 VPWR VGND \$1204 sg13cmos5l_buf_1
* cell instance sg13cmos5l_buf_1_97 r0 *1 0,0
Xsg13cmos5l_buf_1_97 \$599 VPWR VGND \$598 sg13cmos5l_buf_1
* cell instance sg13cmos5l_buf_1_98 r0 *1 0,0
Xsg13cmos5l_buf_1_98 \$1797 VPWR VGND \$599 sg13cmos5l_buf_1
* cell instance sg13cmos5l_buf_1_99 r0 *1 0,0
Xsg13cmos5l_buf_1_99 \$2135 VPWR VGND \$1511 sg13cmos5l_buf_1
* cell instance sg13cmos5l_buf_1_100 r0 *1 0,0
Xsg13cmos5l_buf_1_100 \$4972 VPWR VGND \$3729 sg13cmos5l_buf_1
* cell instance sg13cmos5l_buf_1_101 r0 *1 0,0
Xsg13cmos5l_buf_1_101 \$4855 VPWR VGND \$19480 sg13cmos5l_buf_1
* cell instance sg13cmos5l_buf_1_102 r0 *1 0,0
Xsg13cmos5l_buf_1_102 \$1457 VPWR VGND \$801 sg13cmos5l_buf_1
* cell instance sg13cmos5l_buf_1_103 r0 *1 0,0
Xsg13cmos5l_buf_1_103 \$2112 VPWR VGND \$1457 sg13cmos5l_buf_1
* cell instance sg13cmos5l_buf_1_104 r0 *1 0,0
Xsg13cmos5l_buf_1_104 \$5083 VPWR VGND \$4844 sg13cmos5l_buf_1
* cell instance sg13cmos5l_buf_1_105 r0 *1 0,0
Xsg13cmos5l_buf_1_105 \$2001 VPWR VGND \$2281 sg13cmos5l_buf_1
* cell instance sg13cmos5l_buf_1_106 r0 *1 0,0
Xsg13cmos5l_buf_1_106 \$4863 VPWR VGND \$4670 sg13cmos5l_buf_1
* cell instance sg13cmos5l_buf_1_107 r0 *1 0,0
Xsg13cmos5l_buf_1_107 \$2112 VPWR VGND \$5472 sg13cmos5l_buf_1
* cell instance sg13cmos5l_buf_1_108 r0 *1 0,0
Xsg13cmos5l_buf_1_108 \$801 VPWR VGND \$161 sg13cmos5l_buf_1
* cell instance sg13cmos5l_buf_1_109 r0 *1 0,0
Xsg13cmos5l_buf_1_109 \$166 VPWR VGND \$287 sg13cmos5l_buf_1
* cell instance sg13cmos5l_buf_1_110 r0 *1 0,0
Xsg13cmos5l_buf_1_110 \$5472 VPWR VGND \$4471 sg13cmos5l_buf_1
* cell instance sg13cmos5l_buf_1_111 r0 *1 0,0
Xsg13cmos5l_buf_1_111 \$6601 VPWR VGND \$2112 sg13cmos5l_buf_1
* cell instance sg13cmos5l_buf_1_112 r0 *1 0,0
Xsg13cmos5l_buf_1_112 \$270 VPWR VGND \$192 sg13cmos5l_buf_1
* cell instance sg13cmos5l_buf_1_113 r0 *1 0,0
Xsg13cmos5l_buf_1_113 \$4849 VPWR VGND \$5157 sg13cmos5l_buf_1
* cell instance sg13cmos5l_buf_1_114 r0 *1 0,0
Xsg13cmos5l_buf_1_114 \$2112 VPWR VGND \$11403 sg13cmos5l_buf_1
* cell instance sg13cmos5l_buf_1_115 r0 *1 0,0
Xsg13cmos5l_buf_1_115 \$938 VPWR VGND \$481 sg13cmos5l_buf_1
* cell instance sg13cmos5l_buf_1_116 r0 *1 0,0
Xsg13cmos5l_buf_1_116 \$4310 VPWR VGND \$4104 sg13cmos5l_buf_1
* cell instance sg13cmos5l_buf_1_117 r0 *1 0,0
Xsg13cmos5l_buf_1_117 \$2347 VPWR VGND \$3744 sg13cmos5l_buf_1
* cell instance sg13cmos5l_buf_1_118 r0 *1 0,0
Xsg13cmos5l_buf_1_118 \$2725 VPWR VGND \$1787 sg13cmos5l_buf_1
* cell instance sg13cmos5l_buf_1_119 r0 *1 0,0
Xsg13cmos5l_buf_1_119 \$3677 VPWR VGND \$2725 sg13cmos5l_buf_1
* cell instance sg13cmos5l_buf_1_120 r0 *1 0,0
Xsg13cmos5l_buf_1_120 \$1645 VPWR VGND \$2724 sg13cmos5l_buf_1
* cell instance sg13cmos5l_buf_1_121 r0 *1 0,0
Xsg13cmos5l_buf_1_121 \$1645 VPWR VGND \$1230 sg13cmos5l_buf_1
* cell instance sg13cmos5l_buf_1_122 r0 *1 0,0
Xsg13cmos5l_buf_1_122 uio_in[6] VPWR VGND \$6086 sg13cmos5l_buf_1
* cell instance sg13cmos5l_buf_1_123 r0 *1 0,0
Xsg13cmos5l_buf_1_123 \$3550 VPWR VGND \$4678 sg13cmos5l_buf_1
* cell instance sg13cmos5l_buf_1_124 r0 *1 0,0
Xsg13cmos5l_buf_1_124 uio_in[5] VPWR VGND \$19601 sg13cmos5l_buf_1
* cell instance sg13cmos5l_buf_1_125 r0 *1 0,0
Xsg13cmos5l_buf_1_125 \$4509 VPWR VGND \$3550 sg13cmos5l_buf_1
* cell instance sg13cmos5l_buf_1_126 r0 *1 0,0
Xsg13cmos5l_buf_1_126 uio_in[7] VPWR VGND \$6061 sg13cmos5l_buf_1
* cell instance sg13cmos5l_buf_1_127 r0 *1 0,0
Xsg13cmos5l_buf_1_127 \$539 VPWR VGND \$232 sg13cmos5l_buf_1
* cell instance sg13cmos5l_buf_1_128 r0 *1 0,0
Xsg13cmos5l_buf_1_128 uio_in[4] VPWR VGND \$19605 sg13cmos5l_buf_1
* cell instance sg13cmos5l_buf_1_129 r0 *1 0,0
Xsg13cmos5l_buf_1_129 \$642 VPWR VGND \$666 sg13cmos5l_buf_1
* cell instance sg13cmos5l_buf_1_130 r0 *1 0,0
Xsg13cmos5l_buf_1_130 \$2524 VPWR VGND \$249 sg13cmos5l_buf_1
* cell instance sg13cmos5l_buf_1_131 r0 *1 0,0
Xsg13cmos5l_buf_1_131 \$1191 VPWR VGND \$1808 sg13cmos5l_buf_1
* cell instance sg13cmos5l_buf_1_132 r0 *1 0,0
Xsg13cmos5l_buf_1_132 \$3110 VPWR VGND \$2965 sg13cmos5l_buf_1
* cell instance sg13cmos5l_buf_1_133 r0 *1 0,0
Xsg13cmos5l_buf_1_133 \$1293 VPWR VGND \$1191 sg13cmos5l_buf_1
* cell instance sg13cmos5l_buf_1_134 r0 *1 0,0
Xsg13cmos5l_buf_1_134 uio_in[3] VPWR VGND \$19608 sg13cmos5l_buf_1
* cell instance sg13cmos5l_buf_1_135 r0 *1 0,0
Xsg13cmos5l_buf_1_135 uio_in[2] VPWR VGND \$6088 sg13cmos5l_buf_1
* cell instance sg13cmos5l_buf_1_136 r0 *1 0,0
Xsg13cmos5l_buf_1_136 \$2141 VPWR VGND \$956 sg13cmos5l_buf_1
* cell instance sg13cmos5l_buf_1_137 r0 *1 0,0
Xsg13cmos5l_buf_1_137 \$4853 VPWR VGND \$4979 sg13cmos5l_buf_1
* cell instance sg13cmos5l_buf_1_138 r0 *1 0,0
Xsg13cmos5l_buf_1_138 \$2736 VPWR VGND \$929 sg13cmos5l_buf_1
* cell instance sg13cmos5l_buf_1_139 r0 *1 0,0
Xsg13cmos5l_buf_1_139 uio_in[1] VPWR VGND \$19526 sg13cmos5l_buf_1
* cell instance sg13cmos5l_buf_1_140 r0 *1 0,0
Xsg13cmos5l_buf_1_140 \$3768 VPWR VGND \$3290 sg13cmos5l_buf_1
* cell instance sg13cmos5l_buf_1_141 r0 *1 0,0
Xsg13cmos5l_buf_1_141 \$409 VPWR VGND \$401 sg13cmos5l_buf_1
* cell instance sg13cmos5l_buf_1_142 r0 *1 0,0
Xsg13cmos5l_buf_1_142 \$2523 VPWR VGND \$2524 sg13cmos5l_buf_1
* cell instance sg13cmos5l_buf_1_143 r0 *1 0,0
Xsg13cmos5l_buf_1_143 \$3973 VPWR VGND \$4623 sg13cmos5l_buf_1
* cell instance sg13cmos5l_buf_1_144 r0 *1 0,0
Xsg13cmos5l_buf_1_144 \$1823 VPWR VGND \$541 sg13cmos5l_buf_1
* cell instance sg13cmos5l_buf_1_145 r0 *1 0,0
Xsg13cmos5l_buf_1_145 uio_in[0] VPWR VGND \$19616 sg13cmos5l_buf_1
* cell instance sg13cmos5l_buf_1_146 r0 *1 0,0
Xsg13cmos5l_buf_1_146 \$2974 VPWR VGND \$1823 sg13cmos5l_buf_1
* cell instance sg13cmos5l_buf_1_147 r0 *1 0,0
Xsg13cmos5l_buf_1_147 \$4043 VPWR VGND \$493 sg13cmos5l_buf_1
* cell instance sg13cmos5l_buf_1_148 r0 *1 0,0
Xsg13cmos5l_buf_1_148 \$493 VPWR VGND \$409 sg13cmos5l_buf_1
* cell instance sg13cmos5l_buf_1_149 r0 *1 0,0
Xsg13cmos5l_buf_1_149 \$666 VPWR VGND \$504 sg13cmos5l_buf_1
* cell instance sg13cmos5l_buf_1_150 r0 *1 0,0
Xsg13cmos5l_buf_1_150 \$951 VPWR VGND \$189 sg13cmos5l_buf_1
* cell instance sg13cmos5l_buf_1_151 r0 *1 0,0
Xsg13cmos5l_buf_1_151 \$1362 VPWR VGND \$951 sg13cmos5l_buf_1
* cell instance sg13cmos5l_buf_1_152 r0 *1 0,0
Xsg13cmos5l_buf_1_152 \$4854 VPWR VGND \$5083 sg13cmos5l_buf_1
* cell instance sg13cmos5l_buf_1_153 r0 *1 0,0
Xsg13cmos5l_buf_1_153 \$3290 VPWR VGND \$3388 sg13cmos5l_buf_1
* cell instance sg13cmos5l_buf_1_154 r0 *1 0,0
Xsg13cmos5l_buf_1_154 ui_in[7] VPWR VGND \$5684 sg13cmos5l_buf_1
* cell instance sg13cmos5l_buf_1_155 r0 *1 0,0
Xsg13cmos5l_buf_1_155 \$929 VPWR VGND \$1357 sg13cmos5l_buf_1
* cell instance sg13cmos5l_buf_1_156 r0 *1 0,0
Xsg13cmos5l_buf_1_156 \$178 VPWR VGND \$228 sg13cmos5l_buf_1
* cell instance sg13cmos5l_buf_1_157 r0 *1 0,0
Xsg13cmos5l_buf_1_157 \$56 VPWR VGND \$539 sg13cmos5l_buf_1
* cell instance sg13cmos5l_buf_1_158 r0 *1 0,0
Xsg13cmos5l_buf_1_158 \$969 VPWR VGND \$1502 sg13cmos5l_buf_1
* cell instance sg13cmos5l_buf_1_159 r0 *1 0,0
Xsg13cmos5l_buf_1_159 ui_in[6] VPWR VGND \$19617 sg13cmos5l_buf_1
* cell instance sg13cmos5l_buf_1_160 r0 *1 0,0
Xsg13cmos5l_buf_1_160 \$969 VPWR VGND \$312 sg13cmos5l_buf_1
* cell instance sg13cmos5l_buf_1_161 r0 *1 0,0
Xsg13cmos5l_buf_1_161 \$2230 VPWR VGND \$2001 sg13cmos5l_buf_1
* cell instance sg13cmos5l_buf_1_162 r0 *1 0,0
Xsg13cmos5l_buf_1_162 \$2347 VPWR VGND \$1244 sg13cmos5l_buf_1
* cell instance sg13cmos5l_buf_1_163 r0 *1 0,0
Xsg13cmos5l_buf_1_163 \$1359 VPWR VGND \$178 sg13cmos5l_buf_1
* cell instance sg13cmos5l_buf_1_164 r0 *1 0,0
Xsg13cmos5l_buf_1_164 \$807 VPWR VGND \$413 sg13cmos5l_buf_1
* cell instance sg13cmos5l_buf_1_165 r0 *1 0,0
Xsg13cmos5l_buf_1_165 \$1357 VPWR VGND \$807 sg13cmos5l_buf_1
* cell instance sg13cmos5l_buf_1_166 r0 *1 0,0
Xsg13cmos5l_buf_1_166 \$4150 VPWR VGND \$4517 sg13cmos5l_buf_1
* cell instance sg13cmos5l_buf_1_167 r0 *1 0,0
Xsg13cmos5l_buf_1_167 ui_in[5] VPWR VGND \$19622 sg13cmos5l_buf_1
* cell instance sg13cmos5l_buf_1_168 r0 *1 0,0
Xsg13cmos5l_buf_1_168 \$3567 VPWR VGND \$3189 sg13cmos5l_buf_1
* cell instance sg13cmos5l_buf_1_169 r0 *1 0,0
Xsg13cmos5l_buf_1_169 ui_in[4] VPWR VGND \$19613 sg13cmos5l_buf_1
* cell instance sg13cmos5l_buf_1_170 r0 *1 0,0
Xsg13cmos5l_buf_1_170 ui_in[3] VPWR VGND \$19628 sg13cmos5l_buf_1
* cell instance sg13cmos5l_buf_1_171 r0 *1 0,0
Xsg13cmos5l_buf_1_171 \$3021 VPWR VGND \$58 sg13cmos5l_buf_1
* cell instance sg13cmos5l_buf_1_172 r0 *1 0,0
Xsg13cmos5l_buf_1_172 \$58 VPWR VGND \$82 sg13cmos5l_buf_1
* cell instance sg13cmos5l_buf_1_173 r0 *1 0,0
Xsg13cmos5l_buf_1_173 \$1671 VPWR VGND \$1525 sg13cmos5l_buf_1
* cell instance sg13cmos5l_buf_1_174 r0 *1 0,0
Xsg13cmos5l_buf_1_174 ui_in[2] VPWR VGND \$6195 sg13cmos5l_buf_1
* cell instance sg13cmos5l_buf_1_175 r0 *1 0,0
Xsg13cmos5l_buf_1_175 ui_in[1] VPWR VGND \$19629 sg13cmos5l_buf_1
* cell instance sg13cmos5l_buf_1_176 r0 *1 0,0
Xsg13cmos5l_buf_1_176 \$4991 VPWR VGND \$5287 sg13cmos5l_buf_1
* cell instance sg13cmos5l_buf_1_177 r0 *1 0,0
Xsg13cmos5l_buf_1_177 \$969 VPWR VGND \$3768 sg13cmos5l_buf_1
* cell instance sg13cmos5l_buf_1_178 r0 *1 0,0
Xsg13cmos5l_buf_1_178 \$2112 VPWR VGND \$969 sg13cmos5l_buf_1
* cell instance sg13cmos5l_buf_1_179 r0 *1 0,0
Xsg13cmos5l_buf_1_179 ui_in[0] VPWR VGND \$12317 sg13cmos5l_buf_1
* cell instance sg13cmos5l_buf_1_180 r0 *1 0,0
Xsg13cmos5l_buf_1_180 rst_n VPWR VGND \$6601 sg13cmos5l_buf_1
* cell instance sg13cmos5l_buf_1_181 r0 *1 0,0
Xsg13cmos5l_buf_1_181 \$2197 VPWR VGND \$1845 sg13cmos5l_buf_1
* cell instance sg13cmos5l_buf_1_182 r0 *1 0,0
Xsg13cmos5l_buf_1_182 \$1894 VPWR VGND \$864 sg13cmos5l_buf_1
* cell instance sg13cmos5l_buf_1_183 r0 *1 0,0
Xsg13cmos5l_buf_1_183 \$2547 VPWR VGND \$2985 sg13cmos5l_buf_1
* cell instance sg13cmos5l_buf_1_184 r0 *1 0,0
Xsg13cmos5l_buf_1_184 \$683 VPWR VGND \$1671 sg13cmos5l_buf_1
* cell instance sg13cmos5l_buf_1_185 r0 *1 0,0
Xsg13cmos5l_buf_1_185 \$969 VPWR VGND \$683 sg13cmos5l_buf_1
* cell instance sg13cmos5l_buf_1_186 r0 *1 0,0
Xsg13cmos5l_buf_1_186 \$3973 VPWR VGND \$3772 sg13cmos5l_buf_1
* cell instance sg13cmos5l_buf_1_187 r0 *1 0,0
Xsg13cmos5l_buf_1_187 \$2197 VPWR VGND \$3570 sg13cmos5l_buf_1
* cell instance sg13cmos5l_buf_1_188 r0 *1 0,0
Xsg13cmos5l_buf_1_188 \$222 VPWR VGND \$210 sg13cmos5l_buf_1
* cell instance sg13cmos5l_buf_1_189 r0 *1 0,0
Xsg13cmos5l_buf_1_189 \$1547 VPWR VGND \$222 sg13cmos5l_buf_1
* cell instance sg13cmos5l_buf_1_190 r0 *1 0,0
Xsg13cmos5l_buf_1_190 \$5189 VPWR VGND \$4385 sg13cmos5l_buf_1
* cell instance sg13cmos5l_buf_1_191 r0 *1 0,0
Xsg13cmos5l_buf_1_191 \$1550 VPWR VGND \$418 sg13cmos5l_buf_1
* cell instance sg13cmos5l_buf_1_192 r0 *1 0,0
Xsg13cmos5l_buf_1_192 \$69 VPWR VGND \$558 sg13cmos5l_buf_1
* cell instance sg13cmos5l_buf_1_193 r0 *1 0,0
Xsg13cmos5l_buf_1_193 \$1863 VPWR VGND \$41 sg13cmos5l_buf_1
* cell instance sg13cmos5l_buf_1_194 r0 *1 0,0
Xsg13cmos5l_buf_1_194 \$3197 VPWR VGND \$2197 sg13cmos5l_buf_1
* cell instance sg13cmos5l_buf_1_195 r0 *1 0,0
Xsg13cmos5l_buf_1_195 \$2386 VPWR VGND \$3318 sg13cmos5l_buf_1
* cell instance sg13cmos5l_buf_1_196 r0 *1 0,0
Xsg13cmos5l_buf_1_196 \$4385 VPWR VGND \$4861 sg13cmos5l_buf_1
* cell instance sg13cmos5l_buf_1_197 r0 *1 0,0
Xsg13cmos5l_buf_1_197 \$3413 VPWR VGND \$3197 sg13cmos5l_buf_1
* cell instance sg13cmos5l_buf_1_198 r0 *1 0,0
Xsg13cmos5l_buf_1_198 \$1268 VPWR VGND \$330 sg13cmos5l_buf_1
* cell instance sg13cmos5l_buf_1_199 r0 *1 0,0
Xsg13cmos5l_buf_1_199 \$64 VPWR VGND \$69 sg13cmos5l_buf_1
* cell instance sg13cmos5l_buf_1_200 r0 *1 0,0
Xsg13cmos5l_buf_1_200 \$61 VPWR VGND \$65 sg13cmos5l_buf_1
* cell instance sg13cmos5l_buf_1_201 r0 *1 0,0
Xsg13cmos5l_buf_1_201 \$1386 VPWR VGND \$105 sg13cmos5l_buf_1
* cell instance sg13cmos5l_buf_1_202 r0 *1 0,0
Xsg13cmos5l_buf_1_202 \$1576 VPWR VGND \$1268 sg13cmos5l_buf_1
* cell instance sg13cmos5l_buf_1_203 r0 *1 0,0
Xsg13cmos5l_buf_1_203 \$1270 VPWR VGND \$333 sg13cmos5l_buf_1
* cell instance sg13cmos5l_buf_1_204 r0 *1 0,0
Xsg13cmos5l_buf_1_204 \$5952 VPWR VGND \$1870 sg13cmos5l_buf_1
* cell instance sg13cmos5l_buf_1_205 r0 *1 0,0
Xsg13cmos5l_buf_1_205 \$201 VPWR VGND \$97 sg13cmos5l_buf_1
* cell instance sg13cmos5l_buf_1_206 r0 *1 0,0
Xsg13cmos5l_buf_1_206 \$129 VPWR VGND \$113 sg13cmos5l_buf_1
* cell instance sg13cmos5l_buf_1_207 r0 *1 0,0
Xsg13cmos5l_buf_1_207 \$1689 VPWR VGND \$129 sg13cmos5l_buf_1
* cell instance sg13cmos5l_buf_1_208 r0 *1 0,0
Xsg13cmos5l_buf_1_208 \$1692 VPWR VGND \$66 sg13cmos5l_buf_1
* cell instance sg13cmos5l_buf_1_209 r0 *1 0,0
Xsg13cmos5l_buf_1_209 \$2460 VPWR VGND \$2669 sg13cmos5l_buf_1
* cell instance sg13cmos5l_buf_1_210 r0 *1 0,0
Xsg13cmos5l_buf_1_210 \$204 VPWR VGND \$29 sg13cmos5l_buf_1
* cell instance sg13cmos5l_buf_1_211 r0 *1 0,0
Xsg13cmos5l_buf_1_211 \$723 VPWR VGND \$201 sg13cmos5l_buf_1
* cell instance sg13cmos5l_buf_1_212 r0 *1 0,0
Xsg13cmos5l_buf_1_212 \$864 VPWR VGND \$694 sg13cmos5l_buf_1
* cell instance sg13cmos5l_buf_1_213 r0 *1 0,0
Xsg13cmos5l_buf_1_213 \$4150 VPWR VGND \$3971 sg13cmos5l_buf_1
* cell instance sg13cmos5l_buf_1_214 r0 *1 0,0
Xsg13cmos5l_buf_1_214 \$4151 VPWR VGND \$4337 sg13cmos5l_buf_1
* cell instance sg13cmos5l_buf_1_215 r0 *1 0,0
Xsg13cmos5l_buf_1_215 \$5564 VPWR VGND \$5334 sg13cmos5l_buf_1
* cell instance sg13cmos5l_buf_1_216 r0 *1 0,0
Xsg13cmos5l_buf_1_216 \$1027 VPWR VGND \$334 sg13cmos5l_buf_1
* cell instance sg13cmos5l_buf_1_217 r0 *1 0,0
Xsg13cmos5l_buf_1_217 \$3409 VPWR VGND \$3595 sg13cmos5l_buf_1
* cell instance sg13cmos5l_buf_1_218 r0 *1 0,0
Xsg13cmos5l_buf_1_218 \$5564 VPWR VGND \$5337 sg13cmos5l_buf_1
* cell instance sg13cmos5l_buf_1_219 r0 *1 0,0
Xsg13cmos5l_buf_1_219 \$2576 VPWR VGND \$2382 sg13cmos5l_buf_1
* cell instance sg13cmos5l_buf_1_220 r0 *1 0,0
Xsg13cmos5l_buf_1_220 \$4692 VPWR VGND \$3409 sg13cmos5l_buf_1
* cell instance sg13cmos5l_buf_1_221 r0 *1 0,0
Xsg13cmos5l_buf_1_221 \$5014 VPWR VGND \$4692 sg13cmos5l_buf_1
* cell instance sg13cmos5l_buf_1_222 r0 *1 0,0
Xsg13cmos5l_buf_1_222 \$5952 VPWR VGND \$3797 sg13cmos5l_buf_1
* cell instance sg13cmos5l_buf_1_223 r0 *1 0,0
Xsg13cmos5l_buf_1_223 \$6601 VPWR VGND \$3047 sg13cmos5l_buf_1
* cell instance sg13cmos5l_buf_1_224 r0 *1 0,0
Xsg13cmos5l_buf_1_224 \$201 VPWR VGND \$21 sg13cmos5l_buf_1
* cell instance sg13cmos5l_buf_1_225 r0 *1 0,0
Xsg13cmos5l_buf_1_225 \$4151 VPWR VGND \$4841 sg13cmos5l_buf_1
* cell instance sg13cmos5l_buf_1_226 r0 *1 0,0
Xsg13cmos5l_buf_1_226 \$3047 VPWR VGND \$5952 sg13cmos5l_buf_1
* cell instance sg13cmos5l_buf_1_227 r0 *1 0,0
Xsg13cmos5l_buf_1_227 \$1261 VPWR VGND \$93 sg13cmos5l_buf_1
* cell instance sg13cmos5l_buf_1_228 r0 *1 0,0
Xsg13cmos5l_buf_1_228 \$1022 VPWR VGND \$23 sg13cmos5l_buf_1
* cell instance sg13cmos5l_buf_1_229 r0 *1 0,0
Xsg13cmos5l_buf_1_229 \$3976 VPWR VGND \$5010 sg13cmos5l_buf_1
* cell instance sg13cmos5l_buf_1_230 r0 *1 0,0
Xsg13cmos5l_buf_1_230 \$5010 VPWR VGND \$4359 sg13cmos5l_buf_1
* cell instance sg13cmos5l_buf_1_231 r0 *1 0,0
Xsg13cmos5l_buf_1_231 \$213 VPWR VGND \$62 sg13cmos5l_buf_1
* cell instance sg13cmos5l_buf_1_232 r0 *1 0,0
Xsg13cmos5l_buf_1_232 \$1550 VPWR VGND \$718 sg13cmos5l_buf_1
* cell instance sg13cmos5l_buf_1_233 r0 *1 0,0
Xsg13cmos5l_buf_1_233 \$1692 VPWR VGND \$1022 sg13cmos5l_buf_1
* cell instance sg13cmos5l_buf_1_234 r0 *1 0,0
Xsg13cmos5l_buf_1_234 \$1386 VPWR VGND \$75 sg13cmos5l_buf_1
* cell instance sg13cmos5l_buf_1_235 r0 *1 0,0
Xsg13cmos5l_buf_1_235 \$5952 VPWR VGND \$3808 sg13cmos5l_buf_1
* cell instance sg13cmos5l_buf_1_236 r0 *1 0,0
Xsg13cmos5l_buf_1_236 \$418 VPWR VGND \$1579 sg13cmos5l_buf_1
* cell instance sg13cmos5l_buf_1_237 r0 *1 0,0
Xsg13cmos5l_buf_1_237 \$5973 VPWR VGND \$5564 sg13cmos5l_buf_1
* cell instance sg13cmos5l_buf_1_238 r0 *1 0,0
Xsg13cmos5l_buf_1_238 \$723 VPWR VGND \$1003 sg13cmos5l_buf_1
* cell instance sg13cmos5l_buf_1_239 r0 *1 0,0
Xsg13cmos5l_buf_1_239 \$4418 VPWR VGND \$4343 sg13cmos5l_buf_1
* cell instance sg13cmos5l_buf_1_240 r0 *1 0,0
Xsg13cmos5l_buf_1_240 \$573 VPWR VGND \$343 sg13cmos5l_buf_1
* cell instance sg13cmos5l_buf_1_241 r0 *1 0,0
Xsg13cmos5l_buf_1_241 \$3973 VPWR VGND \$4170 sg13cmos5l_buf_1
* cell instance sg13cmos5l_buf_1_242 r0 *1 0,0
Xsg13cmos5l_buf_1_242 \$1905 VPWR VGND \$1261 sg13cmos5l_buf_1
* cell instance sg13cmos5l_buf_1_243 r0 *1 0,0
Xsg13cmos5l_buf_1_243 \$5952 VPWR VGND \$2235 sg13cmos5l_buf_1
* cell instance sg13cmos5l_buf_1_244 r0 *1 0,0
Xsg13cmos5l_buf_1_244 \$1270 VPWR VGND \$220 sg13cmos5l_buf_1
* cell instance sg13cmos5l_buf_1_245 r0 *1 0,0
Xsg13cmos5l_buf_1_245 \$1261 VPWR VGND \$573 sg13cmos5l_buf_1
* cell instance sg13cmos5l_buf_1_246 r0 *1 0,0
Xsg13cmos5l_buf_1_246 \$3781 VPWR VGND \$3967 sg13cmos5l_buf_1
* cell instance sg13cmos5l_buf_1_247 r0 *1 0,0
Xsg13cmos5l_buf_1_247 \$3816 VPWR VGND \$3781 sg13cmos5l_buf_1
* cell instance sg13cmos5l_buf_1_248 r0 *1 0,0
Xsg13cmos5l_buf_1_248 \$4170 VPWR VGND \$3975 sg13cmos5l_buf_1
* cell instance sg13cmos5l_buf_1_249 r0 *1 0,0
Xsg13cmos5l_buf_1_249 \$4692 VPWR VGND \$3833 sg13cmos5l_buf_1
* cell instance sg13cmos5l_buf_1_250 r0 *1 0,0
Xsg13cmos5l_buf_1_250 \$723 VPWR VGND \$34 sg13cmos5l_buf_1
* cell instance sg13cmos5l_buf_1_251 r0 *1 0,0
Xsg13cmos5l_buf_1_251 \$60 VPWR VGND \$53 sg13cmos5l_buf_1
* cell instance sg13cmos5l_buf_1_252 r0 *1 0,0
Xsg13cmos5l_buf_1_252 \$2245 VPWR VGND \$1011 sg13cmos5l_buf_1
* cell instance sg13cmos5l_buf_1_253 r0 *1 0,0
Xsg13cmos5l_buf_1_253 \$2595 VPWR VGND \$213 sg13cmos5l_buf_1
* cell instance sg13cmos5l_buf_1_254 r0 *1 0,0
Xsg13cmos5l_buf_1_254 \$1011 VPWR VGND \$60 sg13cmos5l_buf_1
* cell instance sg13cmos5l_buf_1_255 r0 *1 0,0
Xsg13cmos5l_buf_1_255 \$213 VPWR VGND \$76 sg13cmos5l_buf_1
* cell instance sg13cmos5l_buf_1_256 r0 *1 0,0
Xsg13cmos5l_buf_1_256 \$4883 VPWR VGND \$4345 sg13cmos5l_buf_1
* cell instance sg13cmos5l_buf_1_257 r0 *1 0,0
Xsg13cmos5l_buf_1_257 \$4342 VPWR VGND \$4536 sg13cmos5l_buf_1
* cell instance sg13cmos5l_buf_1_258 r0 *1 0,0
Xsg13cmos5l_buf_1_258 \$76 VPWR VGND \$72 sg13cmos5l_buf_1
* cell instance sg13cmos5l_buf_1_259 r0 *1 0,0
Xsg13cmos5l_buf_1_259 \$3423 VPWR VGND \$2803 sg13cmos5l_buf_1
* cell instance sg13cmos5l_buf_1_260 r0 *1 0,0
Xsg13cmos5l_buf_1_260 \$5439 VPWR VGND \$5374 sg13cmos5l_buf_1
* cell instance sg13cmos5l_buf_1_261 r0 *1 0,0
Xsg13cmos5l_buf_1_261 \$2611 VPWR VGND \$2256 sg13cmos5l_buf_1
* cell instance sg13cmos5l_buf_1_262 r0 *1 0,0
Xsg13cmos5l_buf_1_262 \$2613 VPWR VGND \$1721 sg13cmos5l_buf_1
* cell instance sg13cmos5l_buf_1_263 r0 *1 0,0
Xsg13cmos5l_buf_1_263 \$3047 VPWR VGND \$2613 sg13cmos5l_buf_1
* cell instance sg13cmos5l_buf_1_264 r0 *1 0,0
Xsg13cmos5l_buf_1_264 \$4170 VPWR VGND \$3825 sg13cmos5l_buf_1
* cell instance sg13cmos5l_buf_1_265 r0 *1 0,0
Xsg13cmos5l_buf_1_265 \$3826 VPWR VGND \$3031 sg13cmos5l_buf_1
* cell instance sg13cmos5l_buf_1_266 r0 *1 0,0
Xsg13cmos5l_buf_1_266 \$4200 VPWR VGND \$1362 sg13cmos5l_buf_1
* cell instance sg13cmos5l_buf_1_267 r0 *1 0,0
Xsg13cmos5l_buf_1_267 \$2816 VPWR VGND \$2817 sg13cmos5l_buf_1
* cell instance sg13cmos5l_buf_1_268 r0 *1 0,0
Xsg13cmos5l_buf_1_268 \$2670 VPWR VGND \$2620 sg13cmos5l_buf_1
* cell instance sg13cmos5l_buf_1_269 r0 *1 0,0
Xsg13cmos5l_buf_1_269 \$5035 VPWR VGND \$4185 sg13cmos5l_buf_1
* cell instance sg13cmos5l_buf_1_270 r0 *1 0,0
Xsg13cmos5l_buf_1_270 \$3312 VPWR VGND \$4046 sg13cmos5l_buf_1
* cell instance sg13cmos5l_buf_1_271 r0 *1 0,0
Xsg13cmos5l_buf_1_271 \$3047 VPWR VGND \$3891 sg13cmos5l_buf_1
* cell instance sg13cmos5l_buf_1_272 r0 *1 0,0
Xsg13cmos5l_buf_1_272 \$3223 VPWR VGND \$3313 sg13cmos5l_buf_1
* cell instance sg13cmos5l_buf_1_273 r0 *1 0,0
Xsg13cmos5l_buf_1_273 \$8832 VPWR VGND \$6796 sg13cmos5l_buf_1
* cell instance sg13cmos5l_buf_1_274 r0 *1 0,0
Xsg13cmos5l_buf_1_274 \$3031 VPWR VGND \$3254 sg13cmos5l_buf_1
* cell instance sg13cmos5l_buf_1_275 r0 *1 0,0
Xsg13cmos5l_buf_1_275 \$5188 VPWR VGND \$6789 sg13cmos5l_buf_1
* cell instance sg13cmos5l_buf_1_276 r0 *1 0,0
Xsg13cmos5l_buf_1_276 \$3047 VPWR VGND \$8832 sg13cmos5l_buf_1
* cell instance sg13cmos5l_buf_1_277 r0 *1 0,0
Xsg13cmos5l_buf_1_277 \$7998 VPWR VGND \$8563 sg13cmos5l_buf_1
* cell instance sg13cmos5l_buf_1_278 r0 *1 0,0
Xsg13cmos5l_buf_1_278 \$4692 VPWR VGND \$4725 sg13cmos5l_buf_1
* cell instance sg13cmos5l_buf_1_279 r0 *1 0,0
Xsg13cmos5l_buf_1_279 \$6789 VPWR VGND \$8447 sg13cmos5l_buf_1
* cell instance sg13cmos5l_buf_1_280 r0 *1 0,0
Xsg13cmos5l_buf_1_280 \$3260 VPWR VGND \$1359 sg13cmos5l_buf_1
* cell instance sg13cmos5l_buf_1_281 r0 *1 0,0
Xsg13cmos5l_buf_1_281 \$5220 VPWR VGND \$3023 sg13cmos5l_buf_1
* cell instance sg13cmos5l_buf_1_282 r0 *1 0,0
Xsg13cmos5l_buf_1_282 \$5682 VPWR VGND \$5973 sg13cmos5l_buf_1
* cell instance sg13cmos5l_buf_1_283 r0 *1 0,0
Xsg13cmos5l_buf_1_283 \$8832 VPWR VGND \$6944 sg13cmos5l_buf_1
* cell instance sg13cmos5l_buf_1_284 r0 *1 0,0
Xsg13cmos5l_buf_1_284 \$3891 VPWR VGND \$3847 sg13cmos5l_buf_1
* cell instance sg13cmos5l_buf_1_285 r0 *1 0,0
Xsg13cmos5l_buf_1_285 \$5973 VPWR VGND \$6855 sg13cmos5l_buf_1
* cell instance sg13cmos5l_buf_1_286 r0 *1 0,0
Xsg13cmos5l_buf_1_286 \$3313 VPWR VGND \$3268 sg13cmos5l_buf_1
* cell instance sg13cmos5l_buf_1_287 r0 *1 0,0
Xsg13cmos5l_buf_1_287 \$4729 VPWR VGND \$2230 sg13cmos5l_buf_1
* cell instance sg13cmos5l_buf_1_288 r0 *1 0,0
Xsg13cmos5l_buf_1_288 \$8007 VPWR VGND \$5682 sg13cmos5l_buf_1
* cell instance sg13cmos5l_buf_1_289 r0 *1 0,0
Xsg13cmos5l_buf_1_289 \$4018 VPWR VGND \$3110 sg13cmos5l_buf_1
* cell instance sg13cmos5l_buf_1_290 r0 *1 0,0
Xsg13cmos5l_buf_1_290 \$3847 VPWR VGND \$3459 sg13cmos5l_buf_1
* cell instance sg13cmos5l_buf_1_291 r0 *1 0,0
Xsg13cmos5l_buf_1_291 \$5594 VPWR VGND \$3021 sg13cmos5l_buf_1
* cell instance sg13cmos5l_buf_4_0 r0 *1 0,0
Xsg13cmos5l_buf_4_0 \$9827 VPWR VGND \$6854 sg13cmos5l_buf_4
* cell instance sg13cmos5l_buf_4_1 r0 *1 0,0
Xsg13cmos5l_buf_4_1 \$7893 VPWR VGND \$6894 sg13cmos5l_buf_4
* cell instance sg13cmos5l_buf_4_2 r0 *1 0,0
Xsg13cmos5l_buf_4_2 \$9147 VPWR VGND \$6981 sg13cmos5l_buf_4
* cell instance sg13cmos5l_buf_4_3 r0 *1 0,0
Xsg13cmos5l_buf_4_3 \$7544 VPWR VGND \$6788 sg13cmos5l_buf_4
* cell instance sg13cmos5l_buf_4_4 r0 *1 0,0
Xsg13cmos5l_buf_4_4 \$7545 VPWR VGND \$6871 sg13cmos5l_buf_4
* cell instance sg13cmos5l_buf_4_5 r0 *1 0,0
Xsg13cmos5l_buf_4_5 \$7905 VPWR VGND \$6790 sg13cmos5l_buf_4
* cell instance sg13cmos5l_buf_4_6 r0 *1 0,0
Xsg13cmos5l_buf_4_6 \$10299 VPWR VGND \$6954 sg13cmos5l_buf_4
* cell instance sg13cmos5l_buf_4_7 r0 *1 0,0
Xsg13cmos5l_buf_4_7 \$7843 VPWR VGND \$7848 sg13cmos5l_buf_4
* cell instance sg13cmos5l_buf_4_8 r0 *1 0,0
Xsg13cmos5l_buf_4_8 \$9557 VPWR VGND \$6784 sg13cmos5l_buf_4
* cell instance sg13cmos5l_buf_4_9 r0 *1 0,0
Xsg13cmos5l_buf_4_9 \$6316 VPWR VGND \$6104 sg13cmos5l_buf_4
* cell instance sg13cmos5l_buf_4_10 r0 *1 0,0
Xsg13cmos5l_buf_4_10 \$6107 VPWR VGND \$6105 sg13cmos5l_buf_4
* cell instance sg13cmos5l_buf_4_11 r0 *1 0,0
Xsg13cmos5l_buf_4_11 \$5701 VPWR VGND \$5700 sg13cmos5l_buf_4
* cell instance sg13cmos5l_buf_4_12 r0 *1 0,0
Xsg13cmos5l_buf_4_12 \$5927 VPWR VGND \$5925 sg13cmos5l_buf_4
* cell instance sg13cmos5l_buf_4_13 r0 *1 0,0
Xsg13cmos5l_buf_4_13 \$5551 VPWR VGND \$5549 sg13cmos5l_buf_4
* cell instance sg13cmos5l_buf_4_14 r0 *1 0,0
Xsg13cmos5l_buf_4_14 \$6123 VPWR VGND \$6120 sg13cmos5l_buf_4
* cell instance sg13cmos5l_buf_4_15 r0 *1 0,0
Xsg13cmos5l_buf_4_15 \$5709 VPWR VGND \$5708 sg13cmos5l_buf_4
* cell instance sg13cmos5l_buf_4_16 r0 *1 0,0
Xsg13cmos5l_buf_4_16 \$5555 VPWR VGND \$5553 sg13cmos5l_buf_4
* cell instance sg13cmos5l_buf_4_17 r0 *1 0,0
Xsg13cmos5l_buf_4_17 \$5558 VPWR VGND \$5556 sg13cmos5l_buf_4
* cell instance sg13cmos5l_buf_4_18 r0 *1 0,0
Xsg13cmos5l_buf_4_18 \$6135 VPWR VGND \$6128 sg13cmos5l_buf_4
* cell instance sg13cmos5l_buf_4_19 r0 *1 0,0
Xsg13cmos5l_buf_4_19 \$6353 VPWR VGND \$6351 sg13cmos5l_buf_4
* cell instance sg13cmos5l_buf_4_20 r0 *1 0,0
Xsg13cmos5l_buf_4_20 \$6354 VPWR VGND \$6355 sg13cmos5l_buf_4
* cell instance sg13cmos5l_buf_4_21 r0 *1 0,0
Xsg13cmos5l_buf_4_21 \$6520 VPWR VGND \$6643 sg13cmos5l_buf_4
* cell instance sg13cmos5l_buf_4_22 r0 *1 0,0
Xsg13cmos5l_buf_4_22 \$8561 VPWR VGND \$7996 sg13cmos5l_buf_4
* cell instance sg13cmos5l_buf_4_23 r0 *1 0,0
Xsg13cmos5l_buf_4_23 \$8827 VPWR VGND \$7994 sg13cmos5l_buf_4
* cell instance sg13cmos5l_buf_4_24 r0 *1 0,0
Xsg13cmos5l_buf_4_24 \$9091 VPWR VGND \$8194 sg13cmos5l_buf_4
* cell instance sg13cmos5l_buf_4_25 r0 *1 0,0
Xsg13cmos5l_buf_4_25 \$9341 VPWR VGND \$8320 sg13cmos5l_buf_4
* cell instance sg13cmos5l_buf_4_26 r0 *1 0,0
Xsg13cmos5l_buf_4_26 \$8323 VPWR VGND \$7448 sg13cmos5l_buf_4
* cell instance sg13cmos5l_buf_8_0 r0 *1 0,0
Xsg13cmos5l_buf_8_0 \$387 VPWR VGND \$747 sg13cmos5l_buf_8
* cell instance sg13cmos5l_buf_8_1 r0 *1 0,0
Xsg13cmos5l_buf_8_1 \$6913 VPWR VGND \$6845 sg13cmos5l_buf_8
* cell instance sg13cmos5l_buf_8_2 r0 *1 0,0
Xsg13cmos5l_buf_8_2 \$387 VPWR VGND \$1771 sg13cmos5l_buf_8
* cell instance sg13cmos5l_buf_8_3 r0 *1 0,0
Xsg13cmos5l_buf_8_3 \$387 VPWR VGND \$5101 sg13cmos5l_buf_8
* cell instance sg13cmos5l_buf_8_4 r0 *1 0,0
Xsg13cmos5l_buf_8_4 \$6913 VPWR VGND \$12926 sg13cmos5l_buf_8
* cell instance sg13cmos5l_buf_8_5 r0 *1 0,0
Xsg13cmos5l_buf_8_5 \$6913 VPWR VGND \$17989 sg13cmos5l_buf_8
* cell instance sg13cmos5l_buf_8_6 r0 *1 0,0
Xsg13cmos5l_buf_8_6 \$10296 VPWR VGND \$11216 sg13cmos5l_buf_8
* cell instance sg13cmos5l_buf_8_7 r0 *1 0,0
Xsg13cmos5l_buf_8_7 \$6913 VPWR VGND \$10296 sg13cmos5l_buf_8
* cell instance sg13cmos5l_buf_8_8 r0 *1 0,0
Xsg13cmos5l_buf_8_8 \$135 VPWR VGND \$269 sg13cmos5l_buf_8
* cell instance sg13cmos5l_buf_8_9 r0 *1 0,0
Xsg13cmos5l_buf_8_9 \$387 VPWR VGND \$135 sg13cmos5l_buf_8
* cell instance sg13cmos5l_buf_8_10 r0 *1 0,0
Xsg13cmos5l_buf_8_10 \$6913 VPWR VGND \$6914 sg13cmos5l_buf_8
* cell instance sg13cmos5l_buf_8_11 r0 *1 0,0
Xsg13cmos5l_buf_8_11 \$4829 VPWR VGND \$6913 sg13cmos5l_buf_8
* cell instance sg13cmos5l_buf_8_12 r0 *1 0,0
Xsg13cmos5l_buf_8_12 \$6913 VPWR VGND \$16038 sg13cmos5l_buf_8
* cell instance sg13cmos5l_buf_8_13 r0 *1 0,0
Xsg13cmos5l_buf_8_13 \$4829 VPWR VGND \$387 sg13cmos5l_buf_8
* cell instance sg13cmos5l_buf_8_14 r0 *1 0,0
Xsg13cmos5l_buf_8_14 \$4674 VPWR VGND \$4307 sg13cmos5l_buf_8
* cell instance sg13cmos5l_buf_8_15 r0 *1 0,0
Xsg13cmos5l_buf_8_15 \$4307 VPWR VGND \$5285 sg13cmos5l_buf_8
* cell instance sg13cmos5l_buf_8_16 r0 *1 0,0
Xsg13cmos5l_buf_8_16 \$387 VPWR VGND \$5654 sg13cmos5l_buf_8
* cell instance sg13cmos5l_buf_8_17 r0 *1 0,0
Xsg13cmos5l_buf_8_17 \$387 VPWR VGND \$513 sg13cmos5l_buf_8
* cell instance sg13cmos5l_buf_8_18 r0 *1 0,0
Xsg13cmos5l_buf_8_18 \$1546 VPWR VGND \$1833 sg13cmos5l_buf_8
* cell instance sg13cmos5l_buf_8_19 r0 *1 0,0
Xsg13cmos5l_buf_8_19 \$6330 VPWR VGND \$6570 sg13cmos5l_buf_8
* cell instance sg13cmos5l_buf_8_20 r0 *1 0,0
Xsg13cmos5l_buf_8_20 clk VPWR VGND \$19638 sg13cmos5l_buf_8
* cell instance sg13cmos5l_buf_8_21 r0 *1 0,0
Xsg13cmos5l_buf_8_21 \$1546 VPWR VGND \$688 sg13cmos5l_buf_8
* cell instance sg13cmos5l_buf_8_22 r0 *1 0,0
Xsg13cmos5l_buf_8_22 \$19638 VPWR VGND \$6791 sg13cmos5l_buf_8
* cell instance sg13cmos5l_buf_8_23 r0 *1 0,0
Xsg13cmos5l_buf_8_23 \$6791 VPWR VGND \$6326 sg13cmos5l_buf_8
* cell instance sg13cmos5l_buf_8_24 r0 *1 0,0
Xsg13cmos5l_buf_8_24 \$6577 VPWR VGND \$4829 sg13cmos5l_buf_8
* cell instance sg13cmos5l_buf_8_25 r0 *1 0,0
Xsg13cmos5l_buf_8_25 \$6326 VPWR VGND \$6330 sg13cmos5l_buf_8
* cell instance sg13cmos5l_buf_8_26 r0 *1 0,0
Xsg13cmos5l_buf_8_26 \$3181 VPWR VGND \$4543 sg13cmos5l_buf_8
* cell instance sg13cmos5l_buf_8_27 r0 *1 0,0
Xsg13cmos5l_buf_8_27 \$4674 VPWR VGND \$3181 sg13cmos5l_buf_8
* cell instance sg13cmos5l_buf_8_28 r0 *1 0,0
Xsg13cmos5l_buf_8_28 clk VPWR VGND \$6577 sg13cmos5l_buf_8
* cell instance sg13cmos5l_buf_8_29 r0 *1 0,0
Xsg13cmos5l_buf_8_29 \$4674 VPWR VGND \$6340 sg13cmos5l_buf_8
* cell instance sg13cmos5l_buf_8_30 r0 *1 0,0
Xsg13cmos5l_buf_8_30 \$4829 VPWR VGND \$4674 sg13cmos5l_buf_8
* cell instance sg13cmos5l_buf_8_31 r0 *1 0,0
Xsg13cmos5l_buf_8_31 \$4674 VPWR VGND \$1871 sg13cmos5l_buf_8
* cell instance sg13cmos5l_buf_8_32 r0 *1 0,0
Xsg13cmos5l_buf_8_32 \$1546 VPWR VGND \$2789 sg13cmos5l_buf_8
* cell instance sg13cmos5l_buf_8_33 r0 *1 0,0
Xsg13cmos5l_buf_8_33 \$4829 VPWR VGND \$1546 sg13cmos5l_buf_8
* cell instance sg13cmos5l_buf_8_34 r0 *1 0,0
Xsg13cmos5l_buf_8_34 \$4674 VPWR VGND \$5361 sg13cmos5l_buf_8
* cell instance sg13cmos5l_buf_8_35 r0 *1 0,0
Xsg13cmos5l_buf_8_35 \$1546 VPWR VGND \$1726 sg13cmos5l_buf_8
* cell instance sg13cmos5l_buf_8_36 r0 *1 0,0
Xsg13cmos5l_buf_8_36 \$1546 VPWR VGND \$2270 sg13cmos5l_buf_8
* cell instance sg13cmos5l_buf_8_37 r0 *1 0,0
Xsg13cmos5l_buf_8_37 \$4674 VPWR VGND \$8197 sg13cmos5l_buf_8
* cell instance sg13cmos5l_buf_8_38 r0 *1 0,0
Xsg13cmos5l_buf_8_38 \$1546 VPWR VGND \$3838 sg13cmos5l_buf_8
* cell instance sg13cmos5l_decap_4_0 r0 *1 0,0
Xsg13cmos5l_decap_4_0 VPWR VGND sg13cmos5l_decap_4
* cell instance sg13cmos5l_decap_4_1 r0 *1 0,0
Xsg13cmos5l_decap_4_1 VPWR VGND sg13cmos5l_decap_4
* cell instance sg13cmos5l_decap_4_2 r0 *1 0,0
Xsg13cmos5l_decap_4_2 VPWR VGND sg13cmos5l_decap_4
* cell instance sg13cmos5l_decap_4_3 r0 *1 0,0
Xsg13cmos5l_decap_4_3 VPWR VGND sg13cmos5l_decap_4
* cell instance sg13cmos5l_decap_4_4 r0 *1 0,0
Xsg13cmos5l_decap_4_4 VPWR VGND sg13cmos5l_decap_4
* cell instance sg13cmos5l_decap_4_5 r0 *1 0,0
Xsg13cmos5l_decap_4_5 VPWR VGND sg13cmos5l_decap_4
* cell instance sg13cmos5l_decap_4_6 r0 *1 0,0
Xsg13cmos5l_decap_4_6 VPWR VGND sg13cmos5l_decap_4
* cell instance sg13cmos5l_decap_4_7 r0 *1 0,0
Xsg13cmos5l_decap_4_7 VPWR VGND sg13cmos5l_decap_4
* cell instance sg13cmos5l_decap_4_8 r0 *1 0,0
Xsg13cmos5l_decap_4_8 VPWR VGND sg13cmos5l_decap_4
* cell instance sg13cmos5l_decap_4_9 r0 *1 0,0
Xsg13cmos5l_decap_4_9 VPWR VGND sg13cmos5l_decap_4
* cell instance sg13cmos5l_decap_4_10 r0 *1 0,0
Xsg13cmos5l_decap_4_10 VPWR VGND sg13cmos5l_decap_4
* cell instance sg13cmos5l_decap_4_11 r0 *1 0,0
Xsg13cmos5l_decap_4_11 VPWR VGND sg13cmos5l_decap_4
* cell instance sg13cmos5l_decap_4_12 r0 *1 0,0
Xsg13cmos5l_decap_4_12 VPWR VGND sg13cmos5l_decap_4
* cell instance sg13cmos5l_decap_4_13 r0 *1 0,0
Xsg13cmos5l_decap_4_13 VPWR VGND sg13cmos5l_decap_4
* cell instance sg13cmos5l_decap_4_14 r0 *1 0,0
Xsg13cmos5l_decap_4_14 VPWR VGND sg13cmos5l_decap_4
* cell instance sg13cmos5l_decap_4_15 r0 *1 0,0
Xsg13cmos5l_decap_4_15 VPWR VGND sg13cmos5l_decap_4
* cell instance sg13cmos5l_decap_4_16 r0 *1 0,0
Xsg13cmos5l_decap_4_16 VPWR VGND sg13cmos5l_decap_4
* cell instance sg13cmos5l_decap_4_17 r0 *1 0,0
Xsg13cmos5l_decap_4_17 VPWR VGND sg13cmos5l_decap_4
* cell instance sg13cmos5l_decap_4_18 r0 *1 0,0
Xsg13cmos5l_decap_4_18 VPWR VGND sg13cmos5l_decap_4
* cell instance sg13cmos5l_decap_4_19 r0 *1 0,0
Xsg13cmos5l_decap_4_19 VPWR VGND sg13cmos5l_decap_4
* cell instance sg13cmos5l_decap_4_20 r0 *1 0,0
Xsg13cmos5l_decap_4_20 VPWR VGND sg13cmos5l_decap_4
* cell instance sg13cmos5l_decap_4_21 r0 *1 0,0
Xsg13cmos5l_decap_4_21 VPWR VGND sg13cmos5l_decap_4
* cell instance sg13cmos5l_decap_4_22 r0 *1 0,0
Xsg13cmos5l_decap_4_22 VPWR VGND sg13cmos5l_decap_4
* cell instance sg13cmos5l_decap_4_23 r0 *1 0,0
Xsg13cmos5l_decap_4_23 VPWR VGND sg13cmos5l_decap_4
* cell instance sg13cmos5l_decap_4_24 r0 *1 0,0
Xsg13cmos5l_decap_4_24 VPWR VGND sg13cmos5l_decap_4
* cell instance sg13cmos5l_decap_4_25 r0 *1 0,0
Xsg13cmos5l_decap_4_25 VPWR VGND sg13cmos5l_decap_4
* cell instance sg13cmos5l_decap_4_26 r0 *1 0,0
Xsg13cmos5l_decap_4_26 VPWR VGND sg13cmos5l_decap_4
* cell instance sg13cmos5l_decap_4_27 r0 *1 0,0
Xsg13cmos5l_decap_4_27 VPWR VGND sg13cmos5l_decap_4
* cell instance sg13cmos5l_decap_4_28 r0 *1 0,0
Xsg13cmos5l_decap_4_28 VPWR VGND sg13cmos5l_decap_4
* cell instance sg13cmos5l_decap_4_29 r0 *1 0,0
Xsg13cmos5l_decap_4_29 VPWR VGND sg13cmos5l_decap_4
* cell instance sg13cmos5l_decap_4_30 r0 *1 0,0
Xsg13cmos5l_decap_4_30 VPWR VGND sg13cmos5l_decap_4
* cell instance sg13cmos5l_decap_4_31 r0 *1 0,0
Xsg13cmos5l_decap_4_31 VPWR VGND sg13cmos5l_decap_4
* cell instance sg13cmos5l_decap_4_32 r0 *1 0,0
Xsg13cmos5l_decap_4_32 VPWR VGND sg13cmos5l_decap_4
* cell instance sg13cmos5l_decap_4_33 r0 *1 0,0
Xsg13cmos5l_decap_4_33 VPWR VGND sg13cmos5l_decap_4
* cell instance sg13cmos5l_decap_4_34 r0 *1 0,0
Xsg13cmos5l_decap_4_34 VPWR VGND sg13cmos5l_decap_4
* cell instance sg13cmos5l_decap_4_35 r0 *1 0,0
Xsg13cmos5l_decap_4_35 VPWR VGND sg13cmos5l_decap_4
* cell instance sg13cmos5l_decap_4_36 r0 *1 0,0
Xsg13cmos5l_decap_4_36 VPWR VGND sg13cmos5l_decap_4
* cell instance sg13cmos5l_decap_4_37 r0 *1 0,0
Xsg13cmos5l_decap_4_37 VPWR VGND sg13cmos5l_decap_4
* cell instance sg13cmos5l_decap_4_38 r0 *1 0,0
Xsg13cmos5l_decap_4_38 VPWR VGND sg13cmos5l_decap_4
* cell instance sg13cmos5l_decap_4_39 r0 *1 0,0
Xsg13cmos5l_decap_4_39 VPWR VGND sg13cmos5l_decap_4
* cell instance sg13cmos5l_decap_4_40 r0 *1 0,0
Xsg13cmos5l_decap_4_40 VPWR VGND sg13cmos5l_decap_4
* cell instance sg13cmos5l_decap_4_41 r0 *1 0,0
Xsg13cmos5l_decap_4_41 VPWR VGND sg13cmos5l_decap_4
* cell instance sg13cmos5l_decap_4_42 r0 *1 0,0
Xsg13cmos5l_decap_4_42 VPWR VGND sg13cmos5l_decap_4
* cell instance sg13cmos5l_decap_4_43 r0 *1 0,0
Xsg13cmos5l_decap_4_43 VPWR VGND sg13cmos5l_decap_4
* cell instance sg13cmos5l_decap_4_44 r0 *1 0,0
Xsg13cmos5l_decap_4_44 VPWR VGND sg13cmos5l_decap_4
* cell instance sg13cmos5l_decap_4_45 r0 *1 0,0
Xsg13cmos5l_decap_4_45 VPWR VGND sg13cmos5l_decap_4
* cell instance sg13cmos5l_decap_4_46 r0 *1 0,0
Xsg13cmos5l_decap_4_46 VPWR VGND sg13cmos5l_decap_4
* cell instance sg13cmos5l_decap_4_47 r0 *1 0,0
Xsg13cmos5l_decap_4_47 VPWR VGND sg13cmos5l_decap_4
* cell instance sg13cmos5l_decap_4_48 r0 *1 0,0
Xsg13cmos5l_decap_4_48 VPWR VGND sg13cmos5l_decap_4
* cell instance sg13cmos5l_decap_4_49 r0 *1 0,0
Xsg13cmos5l_decap_4_49 VPWR VGND sg13cmos5l_decap_4
* cell instance sg13cmos5l_decap_4_50 r0 *1 0,0
Xsg13cmos5l_decap_4_50 VPWR VGND sg13cmos5l_decap_4
* cell instance sg13cmos5l_decap_4_51 r0 *1 0,0
Xsg13cmos5l_decap_4_51 VPWR VGND sg13cmos5l_decap_4
* cell instance sg13cmos5l_decap_4_52 r0 *1 0,0
Xsg13cmos5l_decap_4_52 VPWR VGND sg13cmos5l_decap_4
* cell instance sg13cmos5l_decap_4_53 r0 *1 0,0
Xsg13cmos5l_decap_4_53 VPWR VGND sg13cmos5l_decap_4
* cell instance sg13cmos5l_decap_4_54 r0 *1 0,0
Xsg13cmos5l_decap_4_54 VPWR VGND sg13cmos5l_decap_4
* cell instance sg13cmos5l_decap_4_55 r0 *1 0,0
Xsg13cmos5l_decap_4_55 VPWR VGND sg13cmos5l_decap_4
* cell instance sg13cmos5l_decap_4_56 r0 *1 0,0
Xsg13cmos5l_decap_4_56 VPWR VGND sg13cmos5l_decap_4
* cell instance sg13cmos5l_decap_4_57 r0 *1 0,0
Xsg13cmos5l_decap_4_57 VPWR VGND sg13cmos5l_decap_4
* cell instance sg13cmos5l_decap_4_58 r0 *1 0,0
Xsg13cmos5l_decap_4_58 VPWR VGND sg13cmos5l_decap_4
* cell instance sg13cmos5l_decap_4_59 r0 *1 0,0
Xsg13cmos5l_decap_4_59 VPWR VGND sg13cmos5l_decap_4
* cell instance sg13cmos5l_decap_4_60 r0 *1 0,0
Xsg13cmos5l_decap_4_60 VPWR VGND sg13cmos5l_decap_4
* cell instance sg13cmos5l_decap_4_61 r0 *1 0,0
Xsg13cmos5l_decap_4_61 VPWR VGND sg13cmos5l_decap_4
* cell instance sg13cmos5l_decap_4_62 r0 *1 0,0
Xsg13cmos5l_decap_4_62 VPWR VGND sg13cmos5l_decap_4
* cell instance sg13cmos5l_decap_4_63 r0 *1 0,0
Xsg13cmos5l_decap_4_63 VPWR VGND sg13cmos5l_decap_4
* cell instance sg13cmos5l_decap_4_64 r0 *1 0,0
Xsg13cmos5l_decap_4_64 VPWR VGND sg13cmos5l_decap_4
* cell instance sg13cmos5l_decap_4_65 r0 *1 0,0
Xsg13cmos5l_decap_4_65 VPWR VGND sg13cmos5l_decap_4
* cell instance sg13cmos5l_decap_4_66 r0 *1 0,0
Xsg13cmos5l_decap_4_66 VPWR VGND sg13cmos5l_decap_4
* cell instance sg13cmos5l_decap_4_67 r0 *1 0,0
Xsg13cmos5l_decap_4_67 VPWR VGND sg13cmos5l_decap_4
* cell instance sg13cmos5l_decap_4_68 r0 *1 0,0
Xsg13cmos5l_decap_4_68 VPWR VGND sg13cmos5l_decap_4
* cell instance sg13cmos5l_decap_4_69 r0 *1 0,0
Xsg13cmos5l_decap_4_69 VPWR VGND sg13cmos5l_decap_4
* cell instance sg13cmos5l_decap_4_70 r0 *1 0,0
Xsg13cmos5l_decap_4_70 VPWR VGND sg13cmos5l_decap_4
* cell instance sg13cmos5l_decap_4_71 r0 *1 0,0
Xsg13cmos5l_decap_4_71 VPWR VGND sg13cmos5l_decap_4
* cell instance sg13cmos5l_decap_4_72 r0 *1 0,0
Xsg13cmos5l_decap_4_72 VPWR VGND sg13cmos5l_decap_4
* cell instance sg13cmos5l_decap_4_73 r0 *1 0,0
Xsg13cmos5l_decap_4_73 VPWR VGND sg13cmos5l_decap_4
* cell instance sg13cmos5l_decap_4_74 r0 *1 0,0
Xsg13cmos5l_decap_4_74 VPWR VGND sg13cmos5l_decap_4
* cell instance sg13cmos5l_decap_4_75 r0 *1 0,0
Xsg13cmos5l_decap_4_75 VPWR VGND sg13cmos5l_decap_4
* cell instance sg13cmos5l_decap_4_76 r0 *1 0,0
Xsg13cmos5l_decap_4_76 VPWR VGND sg13cmos5l_decap_4
* cell instance sg13cmos5l_decap_4_77 r0 *1 0,0
Xsg13cmos5l_decap_4_77 VPWR VGND sg13cmos5l_decap_4
* cell instance sg13cmos5l_decap_4_78 r0 *1 0,0
Xsg13cmos5l_decap_4_78 VPWR VGND sg13cmos5l_decap_4
* cell instance sg13cmos5l_decap_4_79 r0 *1 0,0
Xsg13cmos5l_decap_4_79 VPWR VGND sg13cmos5l_decap_4
* cell instance sg13cmos5l_decap_4_80 r0 *1 0,0
Xsg13cmos5l_decap_4_80 VPWR VGND sg13cmos5l_decap_4
* cell instance sg13cmos5l_decap_4_81 r0 *1 0,0
Xsg13cmos5l_decap_4_81 VPWR VGND sg13cmos5l_decap_4
* cell instance sg13cmos5l_decap_4_82 r0 *1 0,0
Xsg13cmos5l_decap_4_82 VPWR VGND sg13cmos5l_decap_4
* cell instance sg13cmos5l_decap_4_83 r0 *1 0,0
Xsg13cmos5l_decap_4_83 VPWR VGND sg13cmos5l_decap_4
* cell instance sg13cmos5l_decap_4_84 r0 *1 0,0
Xsg13cmos5l_decap_4_84 VPWR VGND sg13cmos5l_decap_4
* cell instance sg13cmos5l_decap_4_85 r0 *1 0,0
Xsg13cmos5l_decap_4_85 VPWR VGND sg13cmos5l_decap_4
* cell instance sg13cmos5l_decap_4_86 r0 *1 0,0
Xsg13cmos5l_decap_4_86 VPWR VGND sg13cmos5l_decap_4
* cell instance sg13cmos5l_decap_4_87 r0 *1 0,0
Xsg13cmos5l_decap_4_87 VPWR VGND sg13cmos5l_decap_4
* cell instance sg13cmos5l_decap_4_88 r0 *1 0,0
Xsg13cmos5l_decap_4_88 VPWR VGND sg13cmos5l_decap_4
* cell instance sg13cmos5l_decap_4_89 r0 *1 0,0
Xsg13cmos5l_decap_4_89 VPWR VGND sg13cmos5l_decap_4
* cell instance sg13cmos5l_decap_4_90 r0 *1 0,0
Xsg13cmos5l_decap_4_90 VPWR VGND sg13cmos5l_decap_4
* cell instance sg13cmos5l_decap_4_91 r0 *1 0,0
Xsg13cmos5l_decap_4_91 VPWR VGND sg13cmos5l_decap_4
* cell instance sg13cmos5l_decap_4_92 r0 *1 0,0
Xsg13cmos5l_decap_4_92 VPWR VGND sg13cmos5l_decap_4
* cell instance sg13cmos5l_decap_4_93 r0 *1 0,0
Xsg13cmos5l_decap_4_93 VPWR VGND sg13cmos5l_decap_4
* cell instance sg13cmos5l_decap_4_94 r0 *1 0,0
Xsg13cmos5l_decap_4_94 VPWR VGND sg13cmos5l_decap_4
* cell instance sg13cmos5l_decap_4_95 r0 *1 0,0
Xsg13cmos5l_decap_4_95 VPWR VGND sg13cmos5l_decap_4
* cell instance sg13cmos5l_decap_4_96 r0 *1 0,0
Xsg13cmos5l_decap_4_96 VPWR VGND sg13cmos5l_decap_4
* cell instance sg13cmos5l_decap_4_97 r0 *1 0,0
Xsg13cmos5l_decap_4_97 VPWR VGND sg13cmos5l_decap_4
* cell instance sg13cmos5l_decap_4_98 r0 *1 0,0
Xsg13cmos5l_decap_4_98 VPWR VGND sg13cmos5l_decap_4
* cell instance sg13cmos5l_decap_4_99 r0 *1 0,0
Xsg13cmos5l_decap_4_99 VPWR VGND sg13cmos5l_decap_4
* cell instance sg13cmos5l_decap_4_100 r0 *1 0,0
Xsg13cmos5l_decap_4_100 VPWR VGND sg13cmos5l_decap_4
* cell instance sg13cmos5l_decap_4_101 r0 *1 0,0
Xsg13cmos5l_decap_4_101 VPWR VGND sg13cmos5l_decap_4
* cell instance sg13cmos5l_decap_4_102 r0 *1 0,0
Xsg13cmos5l_decap_4_102 VPWR VGND sg13cmos5l_decap_4
* cell instance sg13cmos5l_decap_4_103 r0 *1 0,0
Xsg13cmos5l_decap_4_103 VPWR VGND sg13cmos5l_decap_4
* cell instance sg13cmos5l_decap_4_104 r0 *1 0,0
Xsg13cmos5l_decap_4_104 VPWR VGND sg13cmos5l_decap_4
* cell instance sg13cmos5l_decap_4_105 r0 *1 0,0
Xsg13cmos5l_decap_4_105 VPWR VGND sg13cmos5l_decap_4
* cell instance sg13cmos5l_decap_4_106 r0 *1 0,0
Xsg13cmos5l_decap_4_106 VPWR VGND sg13cmos5l_decap_4
* cell instance sg13cmos5l_decap_4_107 r0 *1 0,0
Xsg13cmos5l_decap_4_107 VPWR VGND sg13cmos5l_decap_4
* cell instance sg13cmos5l_decap_4_108 r0 *1 0,0
Xsg13cmos5l_decap_4_108 VPWR VGND sg13cmos5l_decap_4
* cell instance sg13cmos5l_decap_4_109 r0 *1 0,0
Xsg13cmos5l_decap_4_109 VPWR VGND sg13cmos5l_decap_4
* cell instance sg13cmos5l_decap_4_110 r0 *1 0,0
Xsg13cmos5l_decap_4_110 VPWR VGND sg13cmos5l_decap_4
* cell instance sg13cmos5l_decap_4_111 r0 *1 0,0
Xsg13cmos5l_decap_4_111 VPWR VGND sg13cmos5l_decap_4
* cell instance sg13cmos5l_decap_4_112 r0 *1 0,0
Xsg13cmos5l_decap_4_112 VPWR VGND sg13cmos5l_decap_4
* cell instance sg13cmos5l_decap_4_113 r0 *1 0,0
Xsg13cmos5l_decap_4_113 VPWR VGND sg13cmos5l_decap_4
* cell instance sg13cmos5l_decap_4_114 r0 *1 0,0
Xsg13cmos5l_decap_4_114 VPWR VGND sg13cmos5l_decap_4
* cell instance sg13cmos5l_decap_4_115 r0 *1 0,0
Xsg13cmos5l_decap_4_115 VPWR VGND sg13cmos5l_decap_4
* cell instance sg13cmos5l_decap_4_116 r0 *1 0,0
Xsg13cmos5l_decap_4_116 VPWR VGND sg13cmos5l_decap_4
* cell instance sg13cmos5l_decap_4_117 r0 *1 0,0
Xsg13cmos5l_decap_4_117 VPWR VGND sg13cmos5l_decap_4
* cell instance sg13cmos5l_decap_4_118 r0 *1 0,0
Xsg13cmos5l_decap_4_118 VPWR VGND sg13cmos5l_decap_4
* cell instance sg13cmos5l_decap_4_119 r0 *1 0,0
Xsg13cmos5l_decap_4_119 VPWR VGND sg13cmos5l_decap_4
* cell instance sg13cmos5l_decap_4_120 r0 *1 0,0
Xsg13cmos5l_decap_4_120 VPWR VGND sg13cmos5l_decap_4
* cell instance sg13cmos5l_decap_4_121 r0 *1 0,0
Xsg13cmos5l_decap_4_121 VPWR VGND sg13cmos5l_decap_4
* cell instance sg13cmos5l_decap_4_122 r0 *1 0,0
Xsg13cmos5l_decap_4_122 VPWR VGND sg13cmos5l_decap_4
* cell instance sg13cmos5l_decap_4_123 r0 *1 0,0
Xsg13cmos5l_decap_4_123 VPWR VGND sg13cmos5l_decap_4
* cell instance sg13cmos5l_decap_4_124 r0 *1 0,0
Xsg13cmos5l_decap_4_124 VPWR VGND sg13cmos5l_decap_4
* cell instance sg13cmos5l_decap_4_125 r0 *1 0,0
Xsg13cmos5l_decap_4_125 VPWR VGND sg13cmos5l_decap_4
* cell instance sg13cmos5l_decap_4_126 r0 *1 0,0
Xsg13cmos5l_decap_4_126 VPWR VGND sg13cmos5l_decap_4
* cell instance sg13cmos5l_decap_4_127 r0 *1 0,0
Xsg13cmos5l_decap_4_127 VPWR VGND sg13cmos5l_decap_4
* cell instance sg13cmos5l_decap_4_128 r0 *1 0,0
Xsg13cmos5l_decap_4_128 VPWR VGND sg13cmos5l_decap_4
* cell instance sg13cmos5l_decap_4_129 r0 *1 0,0
Xsg13cmos5l_decap_4_129 VPWR VGND sg13cmos5l_decap_4
* cell instance sg13cmos5l_decap_4_130 r0 *1 0,0
Xsg13cmos5l_decap_4_130 VPWR VGND sg13cmos5l_decap_4
* cell instance sg13cmos5l_decap_4_131 r0 *1 0,0
Xsg13cmos5l_decap_4_131 VPWR VGND sg13cmos5l_decap_4
* cell instance sg13cmos5l_decap_4_132 r0 *1 0,0
Xsg13cmos5l_decap_4_132 VPWR VGND sg13cmos5l_decap_4
* cell instance sg13cmos5l_decap_4_133 r0 *1 0,0
Xsg13cmos5l_decap_4_133 VPWR VGND sg13cmos5l_decap_4
* cell instance sg13cmos5l_decap_4_134 r0 *1 0,0
Xsg13cmos5l_decap_4_134 VPWR VGND sg13cmos5l_decap_4
* cell instance sg13cmos5l_decap_4_135 r0 *1 0,0
Xsg13cmos5l_decap_4_135 VPWR VGND sg13cmos5l_decap_4
* cell instance sg13cmos5l_decap_4_136 r0 *1 0,0
Xsg13cmos5l_decap_4_136 VPWR VGND sg13cmos5l_decap_4
* cell instance sg13cmos5l_decap_4_137 r0 *1 0,0
Xsg13cmos5l_decap_4_137 VPWR VGND sg13cmos5l_decap_4
* cell instance sg13cmos5l_decap_4_138 r0 *1 0,0
Xsg13cmos5l_decap_4_138 VPWR VGND sg13cmos5l_decap_4
* cell instance sg13cmos5l_decap_4_139 r0 *1 0,0
Xsg13cmos5l_decap_4_139 VPWR VGND sg13cmos5l_decap_4
* cell instance sg13cmos5l_decap_4_140 r0 *1 0,0
Xsg13cmos5l_decap_4_140 VPWR VGND sg13cmos5l_decap_4
* cell instance sg13cmos5l_decap_4_141 r0 *1 0,0
Xsg13cmos5l_decap_4_141 VPWR VGND sg13cmos5l_decap_4
* cell instance sg13cmos5l_decap_4_142 r0 *1 0,0
Xsg13cmos5l_decap_4_142 VPWR VGND sg13cmos5l_decap_4
* cell instance sg13cmos5l_decap_4_143 r0 *1 0,0
Xsg13cmos5l_decap_4_143 VPWR VGND sg13cmos5l_decap_4
* cell instance sg13cmos5l_decap_4_144 r0 *1 0,0
Xsg13cmos5l_decap_4_144 VPWR VGND sg13cmos5l_decap_4
* cell instance sg13cmos5l_decap_4_145 r0 *1 0,0
Xsg13cmos5l_decap_4_145 VPWR VGND sg13cmos5l_decap_4
* cell instance sg13cmos5l_decap_4_146 r0 *1 0,0
Xsg13cmos5l_decap_4_146 VPWR VGND sg13cmos5l_decap_4
* cell instance sg13cmos5l_decap_4_147 r0 *1 0,0
Xsg13cmos5l_decap_4_147 VPWR VGND sg13cmos5l_decap_4
* cell instance sg13cmos5l_decap_4_148 r0 *1 0,0
Xsg13cmos5l_decap_4_148 VPWR VGND sg13cmos5l_decap_4
* cell instance sg13cmos5l_decap_4_149 r0 *1 0,0
Xsg13cmos5l_decap_4_149 VPWR VGND sg13cmos5l_decap_4
* cell instance sg13cmos5l_decap_4_150 r0 *1 0,0
Xsg13cmos5l_decap_4_150 VPWR VGND sg13cmos5l_decap_4
* cell instance sg13cmos5l_decap_4_151 r0 *1 0,0
Xsg13cmos5l_decap_4_151 VPWR VGND sg13cmos5l_decap_4
* cell instance sg13cmos5l_decap_4_152 r0 *1 0,0
Xsg13cmos5l_decap_4_152 VPWR VGND sg13cmos5l_decap_4
* cell instance sg13cmos5l_decap_4_153 r0 *1 0,0
Xsg13cmos5l_decap_4_153 VPWR VGND sg13cmos5l_decap_4
* cell instance sg13cmos5l_decap_4_154 r0 *1 0,0
Xsg13cmos5l_decap_4_154 VPWR VGND sg13cmos5l_decap_4
* cell instance sg13cmos5l_decap_4_155 r0 *1 0,0
Xsg13cmos5l_decap_4_155 VPWR VGND sg13cmos5l_decap_4
* cell instance sg13cmos5l_decap_4_156 r0 *1 0,0
Xsg13cmos5l_decap_4_156 VPWR VGND sg13cmos5l_decap_4
* cell instance sg13cmos5l_decap_4_157 r0 *1 0,0
Xsg13cmos5l_decap_4_157 VPWR VGND sg13cmos5l_decap_4
* cell instance sg13cmos5l_decap_4_158 r0 *1 0,0
Xsg13cmos5l_decap_4_158 VPWR VGND sg13cmos5l_decap_4
* cell instance sg13cmos5l_decap_4_159 r0 *1 0,0
Xsg13cmos5l_decap_4_159 VPWR VGND sg13cmos5l_decap_4
* cell instance sg13cmos5l_decap_4_160 r0 *1 0,0
Xsg13cmos5l_decap_4_160 VPWR VGND sg13cmos5l_decap_4
* cell instance sg13cmos5l_decap_4_161 r0 *1 0,0
Xsg13cmos5l_decap_4_161 VPWR VGND sg13cmos5l_decap_4
* cell instance sg13cmos5l_decap_4_162 r0 *1 0,0
Xsg13cmos5l_decap_4_162 VPWR VGND sg13cmos5l_decap_4
* cell instance sg13cmos5l_decap_4_163 r0 *1 0,0
Xsg13cmos5l_decap_4_163 VPWR VGND sg13cmos5l_decap_4
* cell instance sg13cmos5l_decap_4_164 r0 *1 0,0
Xsg13cmos5l_decap_4_164 VPWR VGND sg13cmos5l_decap_4
* cell instance sg13cmos5l_decap_4_165 r0 *1 0,0
Xsg13cmos5l_decap_4_165 VPWR VGND sg13cmos5l_decap_4
* cell instance sg13cmos5l_decap_4_166 r0 *1 0,0
Xsg13cmos5l_decap_4_166 VPWR VGND sg13cmos5l_decap_4
* cell instance sg13cmos5l_decap_4_167 r0 *1 0,0
Xsg13cmos5l_decap_4_167 VPWR VGND sg13cmos5l_decap_4
* cell instance sg13cmos5l_decap_4_168 r0 *1 0,0
Xsg13cmos5l_decap_4_168 VPWR VGND sg13cmos5l_decap_4
* cell instance sg13cmos5l_decap_4_169 r0 *1 0,0
Xsg13cmos5l_decap_4_169 VPWR VGND sg13cmos5l_decap_4
* cell instance sg13cmos5l_decap_4_170 r0 *1 0,0
Xsg13cmos5l_decap_4_170 VPWR VGND sg13cmos5l_decap_4
* cell instance sg13cmos5l_decap_4_171 r0 *1 0,0
Xsg13cmos5l_decap_4_171 VPWR VGND sg13cmos5l_decap_4
* cell instance sg13cmos5l_decap_4_172 r0 *1 0,0
Xsg13cmos5l_decap_4_172 VPWR VGND sg13cmos5l_decap_4
* cell instance sg13cmos5l_decap_4_173 r0 *1 0,0
Xsg13cmos5l_decap_4_173 VPWR VGND sg13cmos5l_decap_4
* cell instance sg13cmos5l_decap_4_174 r0 *1 0,0
Xsg13cmos5l_decap_4_174 VPWR VGND sg13cmos5l_decap_4
* cell instance sg13cmos5l_decap_4_175 r0 *1 0,0
Xsg13cmos5l_decap_4_175 VPWR VGND sg13cmos5l_decap_4
* cell instance sg13cmos5l_decap_4_176 r0 *1 0,0
Xsg13cmos5l_decap_4_176 VPWR VGND sg13cmos5l_decap_4
* cell instance sg13cmos5l_decap_4_177 r0 *1 0,0
Xsg13cmos5l_decap_4_177 VPWR VGND sg13cmos5l_decap_4
* cell instance sg13cmos5l_decap_4_178 r0 *1 0,0
Xsg13cmos5l_decap_4_178 VPWR VGND sg13cmos5l_decap_4
* cell instance sg13cmos5l_decap_4_179 r0 *1 0,0
Xsg13cmos5l_decap_4_179 VPWR VGND sg13cmos5l_decap_4
* cell instance sg13cmos5l_decap_4_180 r0 *1 0,0
Xsg13cmos5l_decap_4_180 VPWR VGND sg13cmos5l_decap_4
* cell instance sg13cmos5l_decap_4_181 r0 *1 0,0
Xsg13cmos5l_decap_4_181 VPWR VGND sg13cmos5l_decap_4
* cell instance sg13cmos5l_decap_4_182 r0 *1 0,0
Xsg13cmos5l_decap_4_182 VPWR VGND sg13cmos5l_decap_4
* cell instance sg13cmos5l_decap_4_183 r0 *1 0,0
Xsg13cmos5l_decap_4_183 VPWR VGND sg13cmos5l_decap_4
* cell instance sg13cmos5l_decap_4_184 r0 *1 0,0
Xsg13cmos5l_decap_4_184 VPWR VGND sg13cmos5l_decap_4
* cell instance sg13cmos5l_decap_4_185 r0 *1 0,0
Xsg13cmos5l_decap_4_185 VPWR VGND sg13cmos5l_decap_4
* cell instance sg13cmos5l_decap_4_186 r0 *1 0,0
Xsg13cmos5l_decap_4_186 VPWR VGND sg13cmos5l_decap_4
* cell instance sg13cmos5l_decap_4_187 r0 *1 0,0
Xsg13cmos5l_decap_4_187 VPWR VGND sg13cmos5l_decap_4
* cell instance sg13cmos5l_decap_4_188 r0 *1 0,0
Xsg13cmos5l_decap_4_188 VPWR VGND sg13cmos5l_decap_4
* cell instance sg13cmos5l_decap_4_189 r0 *1 0,0
Xsg13cmos5l_decap_4_189 VPWR VGND sg13cmos5l_decap_4
* cell instance sg13cmos5l_decap_4_190 r0 *1 0,0
Xsg13cmos5l_decap_4_190 VPWR VGND sg13cmos5l_decap_4
* cell instance sg13cmos5l_decap_4_191 r0 *1 0,0
Xsg13cmos5l_decap_4_191 VPWR VGND sg13cmos5l_decap_4
* cell instance sg13cmos5l_decap_4_192 r0 *1 0,0
Xsg13cmos5l_decap_4_192 VPWR VGND sg13cmos5l_decap_4
* cell instance sg13cmos5l_decap_4_193 r0 *1 0,0
Xsg13cmos5l_decap_4_193 VPWR VGND sg13cmos5l_decap_4
* cell instance sg13cmos5l_decap_4_194 r0 *1 0,0
Xsg13cmos5l_decap_4_194 VPWR VGND sg13cmos5l_decap_4
* cell instance sg13cmos5l_decap_4_195 r0 *1 0,0
Xsg13cmos5l_decap_4_195 VPWR VGND sg13cmos5l_decap_4
* cell instance sg13cmos5l_decap_4_196 r0 *1 0,0
Xsg13cmos5l_decap_4_196 VPWR VGND sg13cmos5l_decap_4
* cell instance sg13cmos5l_decap_4_197 r0 *1 0,0
Xsg13cmos5l_decap_4_197 VPWR VGND sg13cmos5l_decap_4
* cell instance sg13cmos5l_decap_4_198 r0 *1 0,0
Xsg13cmos5l_decap_4_198 VPWR VGND sg13cmos5l_decap_4
* cell instance sg13cmos5l_decap_4_199 r0 *1 0,0
Xsg13cmos5l_decap_4_199 VPWR VGND sg13cmos5l_decap_4
* cell instance sg13cmos5l_decap_4_200 r0 *1 0,0
Xsg13cmos5l_decap_4_200 VPWR VGND sg13cmos5l_decap_4
* cell instance sg13cmos5l_decap_4_201 r0 *1 0,0
Xsg13cmos5l_decap_4_201 VPWR VGND sg13cmos5l_decap_4
* cell instance sg13cmos5l_decap_4_202 r0 *1 0,0
Xsg13cmos5l_decap_4_202 VPWR VGND sg13cmos5l_decap_4
* cell instance sg13cmos5l_decap_4_203 r0 *1 0,0
Xsg13cmos5l_decap_4_203 VPWR VGND sg13cmos5l_decap_4
* cell instance sg13cmos5l_decap_4_204 r0 *1 0,0
Xsg13cmos5l_decap_4_204 VPWR VGND sg13cmos5l_decap_4
* cell instance sg13cmos5l_decap_4_205 r0 *1 0,0
Xsg13cmos5l_decap_4_205 VPWR VGND sg13cmos5l_decap_4
* cell instance sg13cmos5l_decap_4_206 r0 *1 0,0
Xsg13cmos5l_decap_4_206 VPWR VGND sg13cmos5l_decap_4
* cell instance sg13cmos5l_decap_4_207 r0 *1 0,0
Xsg13cmos5l_decap_4_207 VPWR VGND sg13cmos5l_decap_4
* cell instance sg13cmos5l_decap_4_208 r0 *1 0,0
Xsg13cmos5l_decap_4_208 VPWR VGND sg13cmos5l_decap_4
* cell instance sg13cmos5l_decap_4_209 r0 *1 0,0
Xsg13cmos5l_decap_4_209 VPWR VGND sg13cmos5l_decap_4
* cell instance sg13cmos5l_decap_4_210 r0 *1 0,0
Xsg13cmos5l_decap_4_210 VPWR VGND sg13cmos5l_decap_4
* cell instance sg13cmos5l_decap_4_211 r0 *1 0,0
Xsg13cmos5l_decap_4_211 VPWR VGND sg13cmos5l_decap_4
* cell instance sg13cmos5l_decap_4_212 r0 *1 0,0
Xsg13cmos5l_decap_4_212 VPWR VGND sg13cmos5l_decap_4
* cell instance sg13cmos5l_decap_4_213 r0 *1 0,0
Xsg13cmos5l_decap_4_213 VPWR VGND sg13cmos5l_decap_4
* cell instance sg13cmos5l_decap_4_214 r0 *1 0,0
Xsg13cmos5l_decap_4_214 VPWR VGND sg13cmos5l_decap_4
* cell instance sg13cmos5l_decap_4_215 r0 *1 0,0
Xsg13cmos5l_decap_4_215 VPWR VGND sg13cmos5l_decap_4
* cell instance sg13cmos5l_decap_4_216 r0 *1 0,0
Xsg13cmos5l_decap_4_216 VPWR VGND sg13cmos5l_decap_4
* cell instance sg13cmos5l_decap_4_217 r0 *1 0,0
Xsg13cmos5l_decap_4_217 VPWR VGND sg13cmos5l_decap_4
* cell instance sg13cmos5l_decap_4_218 r0 *1 0,0
Xsg13cmos5l_decap_4_218 VPWR VGND sg13cmos5l_decap_4
* cell instance sg13cmos5l_decap_4_219 r0 *1 0,0
Xsg13cmos5l_decap_4_219 VPWR VGND sg13cmos5l_decap_4
* cell instance sg13cmos5l_decap_4_220 r0 *1 0,0
Xsg13cmos5l_decap_4_220 VPWR VGND sg13cmos5l_decap_4
* cell instance sg13cmos5l_decap_4_221 r0 *1 0,0
Xsg13cmos5l_decap_4_221 VPWR VGND sg13cmos5l_decap_4
* cell instance sg13cmos5l_decap_4_222 r0 *1 0,0
Xsg13cmos5l_decap_4_222 VPWR VGND sg13cmos5l_decap_4
* cell instance sg13cmos5l_decap_4_223 r0 *1 0,0
Xsg13cmos5l_decap_4_223 VPWR VGND sg13cmos5l_decap_4
* cell instance sg13cmos5l_decap_4_224 r0 *1 0,0
Xsg13cmos5l_decap_4_224 VPWR VGND sg13cmos5l_decap_4
* cell instance sg13cmos5l_decap_4_225 r0 *1 0,0
Xsg13cmos5l_decap_4_225 VPWR VGND sg13cmos5l_decap_4
* cell instance sg13cmos5l_decap_4_226 r0 *1 0,0
Xsg13cmos5l_decap_4_226 VPWR VGND sg13cmos5l_decap_4
* cell instance sg13cmos5l_decap_4_227 r0 *1 0,0
Xsg13cmos5l_decap_4_227 VPWR VGND sg13cmos5l_decap_4
* cell instance sg13cmos5l_decap_4_228 r0 *1 0,0
Xsg13cmos5l_decap_4_228 VPWR VGND sg13cmos5l_decap_4
* cell instance sg13cmos5l_decap_4_229 r0 *1 0,0
Xsg13cmos5l_decap_4_229 VPWR VGND sg13cmos5l_decap_4
* cell instance sg13cmos5l_decap_4_230 r0 *1 0,0
Xsg13cmos5l_decap_4_230 VPWR VGND sg13cmos5l_decap_4
* cell instance sg13cmos5l_decap_4_231 r0 *1 0,0
Xsg13cmos5l_decap_4_231 VPWR VGND sg13cmos5l_decap_4
* cell instance sg13cmos5l_decap_4_232 r0 *1 0,0
Xsg13cmos5l_decap_4_232 VPWR VGND sg13cmos5l_decap_4
* cell instance sg13cmos5l_decap_4_233 r0 *1 0,0
Xsg13cmos5l_decap_4_233 VPWR VGND sg13cmos5l_decap_4
* cell instance sg13cmos5l_decap_4_234 r0 *1 0,0
Xsg13cmos5l_decap_4_234 VPWR VGND sg13cmos5l_decap_4
* cell instance sg13cmos5l_decap_4_235 r0 *1 0,0
Xsg13cmos5l_decap_4_235 VPWR VGND sg13cmos5l_decap_4
* cell instance sg13cmos5l_decap_4_236 r0 *1 0,0
Xsg13cmos5l_decap_4_236 VPWR VGND sg13cmos5l_decap_4
* cell instance sg13cmos5l_decap_4_237 r0 *1 0,0
Xsg13cmos5l_decap_4_237 VPWR VGND sg13cmos5l_decap_4
* cell instance sg13cmos5l_decap_4_238 r0 *1 0,0
Xsg13cmos5l_decap_4_238 VPWR VGND sg13cmos5l_decap_4
* cell instance sg13cmos5l_decap_4_239 r0 *1 0,0
Xsg13cmos5l_decap_4_239 VPWR VGND sg13cmos5l_decap_4
* cell instance sg13cmos5l_decap_4_240 r0 *1 0,0
Xsg13cmos5l_decap_4_240 VPWR VGND sg13cmos5l_decap_4
* cell instance sg13cmos5l_decap_4_241 r0 *1 0,0
Xsg13cmos5l_decap_4_241 VPWR VGND sg13cmos5l_decap_4
* cell instance sg13cmos5l_decap_4_242 r0 *1 0,0
Xsg13cmos5l_decap_4_242 VPWR VGND sg13cmos5l_decap_4
* cell instance sg13cmos5l_decap_4_243 r0 *1 0,0
Xsg13cmos5l_decap_4_243 VPWR VGND sg13cmos5l_decap_4
* cell instance sg13cmos5l_decap_4_244 r0 *1 0,0
Xsg13cmos5l_decap_4_244 VPWR VGND sg13cmos5l_decap_4
* cell instance sg13cmos5l_decap_4_245 r0 *1 0,0
Xsg13cmos5l_decap_4_245 VPWR VGND sg13cmos5l_decap_4
* cell instance sg13cmos5l_decap_4_246 r0 *1 0,0
Xsg13cmos5l_decap_4_246 VPWR VGND sg13cmos5l_decap_4
* cell instance sg13cmos5l_decap_4_247 r0 *1 0,0
Xsg13cmos5l_decap_4_247 VPWR VGND sg13cmos5l_decap_4
* cell instance sg13cmos5l_decap_4_248 r0 *1 0,0
Xsg13cmos5l_decap_4_248 VPWR VGND sg13cmos5l_decap_4
* cell instance sg13cmos5l_decap_4_249 r0 *1 0,0
Xsg13cmos5l_decap_4_249 VPWR VGND sg13cmos5l_decap_4
* cell instance sg13cmos5l_decap_4_250 r0 *1 0,0
Xsg13cmos5l_decap_4_250 VPWR VGND sg13cmos5l_decap_4
* cell instance sg13cmos5l_decap_4_251 r0 *1 0,0
Xsg13cmos5l_decap_4_251 VPWR VGND sg13cmos5l_decap_4
* cell instance sg13cmos5l_decap_4_252 r0 *1 0,0
Xsg13cmos5l_decap_4_252 VPWR VGND sg13cmos5l_decap_4
* cell instance sg13cmos5l_decap_4_253 r0 *1 0,0
Xsg13cmos5l_decap_4_253 VPWR VGND sg13cmos5l_decap_4
* cell instance sg13cmos5l_decap_4_254 r0 *1 0,0
Xsg13cmos5l_decap_4_254 VPWR VGND sg13cmos5l_decap_4
* cell instance sg13cmos5l_decap_4_255 r0 *1 0,0
Xsg13cmos5l_decap_4_255 VPWR VGND sg13cmos5l_decap_4
* cell instance sg13cmos5l_decap_4_256 r0 *1 0,0
Xsg13cmos5l_decap_4_256 VPWR VGND sg13cmos5l_decap_4
* cell instance sg13cmos5l_decap_4_257 r0 *1 0,0
Xsg13cmos5l_decap_4_257 VPWR VGND sg13cmos5l_decap_4
* cell instance sg13cmos5l_decap_4_258 r0 *1 0,0
Xsg13cmos5l_decap_4_258 VPWR VGND sg13cmos5l_decap_4
* cell instance sg13cmos5l_decap_4_259 r0 *1 0,0
Xsg13cmos5l_decap_4_259 VPWR VGND sg13cmos5l_decap_4
* cell instance sg13cmos5l_decap_4_260 r0 *1 0,0
Xsg13cmos5l_decap_4_260 VPWR VGND sg13cmos5l_decap_4
* cell instance sg13cmos5l_decap_4_261 r0 *1 0,0
Xsg13cmos5l_decap_4_261 VPWR VGND sg13cmos5l_decap_4
* cell instance sg13cmos5l_decap_4_262 r0 *1 0,0
Xsg13cmos5l_decap_4_262 VPWR VGND sg13cmos5l_decap_4
* cell instance sg13cmos5l_decap_4_263 r0 *1 0,0
Xsg13cmos5l_decap_4_263 VPWR VGND sg13cmos5l_decap_4
* cell instance sg13cmos5l_decap_4_264 r0 *1 0,0
Xsg13cmos5l_decap_4_264 VPWR VGND sg13cmos5l_decap_4
* cell instance sg13cmos5l_decap_4_265 r0 *1 0,0
Xsg13cmos5l_decap_4_265 VPWR VGND sg13cmos5l_decap_4
* cell instance sg13cmos5l_decap_4_266 r0 *1 0,0
Xsg13cmos5l_decap_4_266 VPWR VGND sg13cmos5l_decap_4
* cell instance sg13cmos5l_decap_4_267 r0 *1 0,0
Xsg13cmos5l_decap_4_267 VPWR VGND sg13cmos5l_decap_4
* cell instance sg13cmos5l_decap_4_268 r0 *1 0,0
Xsg13cmos5l_decap_4_268 VPWR VGND sg13cmos5l_decap_4
* cell instance sg13cmos5l_decap_4_269 r0 *1 0,0
Xsg13cmos5l_decap_4_269 VPWR VGND sg13cmos5l_decap_4
* cell instance sg13cmos5l_decap_4_270 r0 *1 0,0
Xsg13cmos5l_decap_4_270 VPWR VGND sg13cmos5l_decap_4
* cell instance sg13cmos5l_decap_4_271 r0 *1 0,0
Xsg13cmos5l_decap_4_271 VPWR VGND sg13cmos5l_decap_4
* cell instance sg13cmos5l_decap_4_272 r0 *1 0,0
Xsg13cmos5l_decap_4_272 VPWR VGND sg13cmos5l_decap_4
* cell instance sg13cmos5l_decap_4_273 r0 *1 0,0
Xsg13cmos5l_decap_4_273 VPWR VGND sg13cmos5l_decap_4
* cell instance sg13cmos5l_decap_4_274 r0 *1 0,0
Xsg13cmos5l_decap_4_274 VPWR VGND sg13cmos5l_decap_4
* cell instance sg13cmos5l_decap_4_275 r0 *1 0,0
Xsg13cmos5l_decap_4_275 VPWR VGND sg13cmos5l_decap_4
* cell instance sg13cmos5l_decap_4_276 r0 *1 0,0
Xsg13cmos5l_decap_4_276 VPWR VGND sg13cmos5l_decap_4
* cell instance sg13cmos5l_decap_4_277 r0 *1 0,0
Xsg13cmos5l_decap_4_277 VPWR VGND sg13cmos5l_decap_4
* cell instance sg13cmos5l_decap_4_278 r0 *1 0,0
Xsg13cmos5l_decap_4_278 VPWR VGND sg13cmos5l_decap_4
* cell instance sg13cmos5l_decap_4_279 r0 *1 0,0
Xsg13cmos5l_decap_4_279 VPWR VGND sg13cmos5l_decap_4
* cell instance sg13cmos5l_decap_4_280 r0 *1 0,0
Xsg13cmos5l_decap_4_280 VPWR VGND sg13cmos5l_decap_4
* cell instance sg13cmos5l_decap_4_281 r0 *1 0,0
Xsg13cmos5l_decap_4_281 VPWR VGND sg13cmos5l_decap_4
* cell instance sg13cmos5l_decap_4_282 r0 *1 0,0
Xsg13cmos5l_decap_4_282 VPWR VGND sg13cmos5l_decap_4
* cell instance sg13cmos5l_decap_4_283 r0 *1 0,0
Xsg13cmos5l_decap_4_283 VPWR VGND sg13cmos5l_decap_4
* cell instance sg13cmos5l_decap_4_284 r0 *1 0,0
Xsg13cmos5l_decap_4_284 VPWR VGND sg13cmos5l_decap_4
* cell instance sg13cmos5l_decap_4_285 r0 *1 0,0
Xsg13cmos5l_decap_4_285 VPWR VGND sg13cmos5l_decap_4
* cell instance sg13cmos5l_decap_4_286 r0 *1 0,0
Xsg13cmos5l_decap_4_286 VPWR VGND sg13cmos5l_decap_4
* cell instance sg13cmos5l_decap_4_287 r0 *1 0,0
Xsg13cmos5l_decap_4_287 VPWR VGND sg13cmos5l_decap_4
* cell instance sg13cmos5l_decap_4_288 r0 *1 0,0
Xsg13cmos5l_decap_4_288 VPWR VGND sg13cmos5l_decap_4
* cell instance sg13cmos5l_decap_4_289 r0 *1 0,0
Xsg13cmos5l_decap_4_289 VPWR VGND sg13cmos5l_decap_4
* cell instance sg13cmos5l_decap_4_290 r0 *1 0,0
Xsg13cmos5l_decap_4_290 VPWR VGND sg13cmos5l_decap_4
* cell instance sg13cmos5l_decap_4_291 r0 *1 0,0
Xsg13cmos5l_decap_4_291 VPWR VGND sg13cmos5l_decap_4
* cell instance sg13cmos5l_decap_4_292 r0 *1 0,0
Xsg13cmos5l_decap_4_292 VPWR VGND sg13cmos5l_decap_4
* cell instance sg13cmos5l_decap_4_293 r0 *1 0,0
Xsg13cmos5l_decap_4_293 VPWR VGND sg13cmos5l_decap_4
* cell instance sg13cmos5l_decap_4_294 r0 *1 0,0
Xsg13cmos5l_decap_4_294 VPWR VGND sg13cmos5l_decap_4
* cell instance sg13cmos5l_decap_4_295 r0 *1 0,0
Xsg13cmos5l_decap_4_295 VPWR VGND sg13cmos5l_decap_4
* cell instance sg13cmos5l_decap_4_296 r0 *1 0,0
Xsg13cmos5l_decap_4_296 VPWR VGND sg13cmos5l_decap_4
* cell instance sg13cmos5l_decap_4_297 r0 *1 0,0
Xsg13cmos5l_decap_4_297 VPWR VGND sg13cmos5l_decap_4
* cell instance sg13cmos5l_decap_4_298 r0 *1 0,0
Xsg13cmos5l_decap_4_298 VPWR VGND sg13cmos5l_decap_4
* cell instance sg13cmos5l_decap_4_299 r0 *1 0,0
Xsg13cmos5l_decap_4_299 VPWR VGND sg13cmos5l_decap_4
* cell instance sg13cmos5l_decap_4_300 r0 *1 0,0
Xsg13cmos5l_decap_4_300 VPWR VGND sg13cmos5l_decap_4
* cell instance sg13cmos5l_decap_4_301 r0 *1 0,0
Xsg13cmos5l_decap_4_301 VPWR VGND sg13cmos5l_decap_4
* cell instance sg13cmos5l_decap_4_302 r0 *1 0,0
Xsg13cmos5l_decap_4_302 VPWR VGND sg13cmos5l_decap_4
* cell instance sg13cmos5l_decap_4_303 r0 *1 0,0
Xsg13cmos5l_decap_4_303 VPWR VGND sg13cmos5l_decap_4
* cell instance sg13cmos5l_decap_4_304 r0 *1 0,0
Xsg13cmos5l_decap_4_304 VPWR VGND sg13cmos5l_decap_4
* cell instance sg13cmos5l_decap_4_305 r0 *1 0,0
Xsg13cmos5l_decap_4_305 VPWR VGND sg13cmos5l_decap_4
* cell instance sg13cmos5l_decap_4_306 r0 *1 0,0
Xsg13cmos5l_decap_4_306 VPWR VGND sg13cmos5l_decap_4
* cell instance sg13cmos5l_decap_4_307 r0 *1 0,0
Xsg13cmos5l_decap_4_307 VPWR VGND sg13cmos5l_decap_4
* cell instance sg13cmos5l_decap_4_308 r0 *1 0,0
Xsg13cmos5l_decap_4_308 VPWR VGND sg13cmos5l_decap_4
* cell instance sg13cmos5l_decap_4_309 r0 *1 0,0
Xsg13cmos5l_decap_4_309 VPWR VGND sg13cmos5l_decap_4
* cell instance sg13cmos5l_decap_4_310 r0 *1 0,0
Xsg13cmos5l_decap_4_310 VPWR VGND sg13cmos5l_decap_4
* cell instance sg13cmos5l_decap_4_311 r0 *1 0,0
Xsg13cmos5l_decap_4_311 VPWR VGND sg13cmos5l_decap_4
* cell instance sg13cmos5l_decap_4_312 r0 *1 0,0
Xsg13cmos5l_decap_4_312 VPWR VGND sg13cmos5l_decap_4
* cell instance sg13cmos5l_decap_4_313 r0 *1 0,0
Xsg13cmos5l_decap_4_313 VPWR VGND sg13cmos5l_decap_4
* cell instance sg13cmos5l_decap_4_314 r0 *1 0,0
Xsg13cmos5l_decap_4_314 VPWR VGND sg13cmos5l_decap_4
* cell instance sg13cmos5l_decap_4_315 r0 *1 0,0
Xsg13cmos5l_decap_4_315 VPWR VGND sg13cmos5l_decap_4
* cell instance sg13cmos5l_decap_4_316 r0 *1 0,0
Xsg13cmos5l_decap_4_316 VPWR VGND sg13cmos5l_decap_4
* cell instance sg13cmos5l_decap_4_317 r0 *1 0,0
Xsg13cmos5l_decap_4_317 VPWR VGND sg13cmos5l_decap_4
* cell instance sg13cmos5l_decap_4_318 r0 *1 0,0
Xsg13cmos5l_decap_4_318 VPWR VGND sg13cmos5l_decap_4
* cell instance sg13cmos5l_decap_4_319 r0 *1 0,0
Xsg13cmos5l_decap_4_319 VPWR VGND sg13cmos5l_decap_4
* cell instance sg13cmos5l_decap_4_320 r0 *1 0,0
Xsg13cmos5l_decap_4_320 VPWR VGND sg13cmos5l_decap_4
* cell instance sg13cmos5l_decap_4_321 r0 *1 0,0
Xsg13cmos5l_decap_4_321 VPWR VGND sg13cmos5l_decap_4
* cell instance sg13cmos5l_decap_4_322 r0 *1 0,0
Xsg13cmos5l_decap_4_322 VPWR VGND sg13cmos5l_decap_4
* cell instance sg13cmos5l_decap_4_323 r0 *1 0,0
Xsg13cmos5l_decap_4_323 VPWR VGND sg13cmos5l_decap_4
* cell instance sg13cmos5l_decap_4_324 r0 *1 0,0
Xsg13cmos5l_decap_4_324 VPWR VGND sg13cmos5l_decap_4
* cell instance sg13cmos5l_decap_4_325 r0 *1 0,0
Xsg13cmos5l_decap_4_325 VPWR VGND sg13cmos5l_decap_4
* cell instance sg13cmos5l_decap_4_326 r0 *1 0,0
Xsg13cmos5l_decap_4_326 VPWR VGND sg13cmos5l_decap_4
* cell instance sg13cmos5l_decap_4_327 r0 *1 0,0
Xsg13cmos5l_decap_4_327 VPWR VGND sg13cmos5l_decap_4
* cell instance sg13cmos5l_decap_4_328 r0 *1 0,0
Xsg13cmos5l_decap_4_328 VPWR VGND sg13cmos5l_decap_4
* cell instance sg13cmos5l_decap_4_329 r0 *1 0,0
Xsg13cmos5l_decap_4_329 VPWR VGND sg13cmos5l_decap_4
* cell instance sg13cmos5l_decap_4_330 r0 *1 0,0
Xsg13cmos5l_decap_4_330 VPWR VGND sg13cmos5l_decap_4
* cell instance sg13cmos5l_decap_4_331 r0 *1 0,0
Xsg13cmos5l_decap_4_331 VPWR VGND sg13cmos5l_decap_4
* cell instance sg13cmos5l_decap_4_332 r0 *1 0,0
Xsg13cmos5l_decap_4_332 VPWR VGND sg13cmos5l_decap_4
* cell instance sg13cmos5l_decap_4_333 r0 *1 0,0
Xsg13cmos5l_decap_4_333 VPWR VGND sg13cmos5l_decap_4
* cell instance sg13cmos5l_decap_4_334 r0 *1 0,0
Xsg13cmos5l_decap_4_334 VPWR VGND sg13cmos5l_decap_4
* cell instance sg13cmos5l_decap_4_335 r0 *1 0,0
Xsg13cmos5l_decap_4_335 VPWR VGND sg13cmos5l_decap_4
* cell instance sg13cmos5l_decap_4_336 r0 *1 0,0
Xsg13cmos5l_decap_4_336 VPWR VGND sg13cmos5l_decap_4
* cell instance sg13cmos5l_decap_4_337 r0 *1 0,0
Xsg13cmos5l_decap_4_337 VPWR VGND sg13cmos5l_decap_4
* cell instance sg13cmos5l_decap_4_338 r0 *1 0,0
Xsg13cmos5l_decap_4_338 VPWR VGND sg13cmos5l_decap_4
* cell instance sg13cmos5l_decap_4_339 r0 *1 0,0
Xsg13cmos5l_decap_4_339 VPWR VGND sg13cmos5l_decap_4
* cell instance sg13cmos5l_decap_4_340 r0 *1 0,0
Xsg13cmos5l_decap_4_340 VPWR VGND sg13cmos5l_decap_4
* cell instance sg13cmos5l_decap_4_341 r0 *1 0,0
Xsg13cmos5l_decap_4_341 VPWR VGND sg13cmos5l_decap_4
* cell instance sg13cmos5l_decap_4_342 r0 *1 0,0
Xsg13cmos5l_decap_4_342 VPWR VGND sg13cmos5l_decap_4
* cell instance sg13cmos5l_decap_4_343 r0 *1 0,0
Xsg13cmos5l_decap_4_343 VPWR VGND sg13cmos5l_decap_4
* cell instance sg13cmos5l_decap_4_344 r0 *1 0,0
Xsg13cmos5l_decap_4_344 VPWR VGND sg13cmos5l_decap_4
* cell instance sg13cmos5l_decap_4_345 r0 *1 0,0
Xsg13cmos5l_decap_4_345 VPWR VGND sg13cmos5l_decap_4
* cell instance sg13cmos5l_decap_4_346 r0 *1 0,0
Xsg13cmos5l_decap_4_346 VPWR VGND sg13cmos5l_decap_4
* cell instance sg13cmos5l_decap_4_347 r0 *1 0,0
Xsg13cmos5l_decap_4_347 VPWR VGND sg13cmos5l_decap_4
* cell instance sg13cmos5l_decap_4_348 r0 *1 0,0
Xsg13cmos5l_decap_4_348 VPWR VGND sg13cmos5l_decap_4
* cell instance sg13cmos5l_decap_4_349 r0 *1 0,0
Xsg13cmos5l_decap_4_349 VPWR VGND sg13cmos5l_decap_4
* cell instance sg13cmos5l_decap_4_350 r0 *1 0,0
Xsg13cmos5l_decap_4_350 VPWR VGND sg13cmos5l_decap_4
* cell instance sg13cmos5l_decap_4_351 r0 *1 0,0
Xsg13cmos5l_decap_4_351 VPWR VGND sg13cmos5l_decap_4
* cell instance sg13cmos5l_decap_4_352 r0 *1 0,0
Xsg13cmos5l_decap_4_352 VPWR VGND sg13cmos5l_decap_4
* cell instance sg13cmos5l_decap_4_353 r0 *1 0,0
Xsg13cmos5l_decap_4_353 VPWR VGND sg13cmos5l_decap_4
* cell instance sg13cmos5l_decap_4_354 r0 *1 0,0
Xsg13cmos5l_decap_4_354 VPWR VGND sg13cmos5l_decap_4
* cell instance sg13cmos5l_decap_4_355 r0 *1 0,0
Xsg13cmos5l_decap_4_355 VPWR VGND sg13cmos5l_decap_4
* cell instance sg13cmos5l_decap_4_356 r0 *1 0,0
Xsg13cmos5l_decap_4_356 VPWR VGND sg13cmos5l_decap_4
* cell instance sg13cmos5l_decap_4_357 r0 *1 0,0
Xsg13cmos5l_decap_4_357 VPWR VGND sg13cmos5l_decap_4
* cell instance sg13cmos5l_decap_4_358 r0 *1 0,0
Xsg13cmos5l_decap_4_358 VPWR VGND sg13cmos5l_decap_4
* cell instance sg13cmos5l_decap_4_359 r0 *1 0,0
Xsg13cmos5l_decap_4_359 VPWR VGND sg13cmos5l_decap_4
* cell instance sg13cmos5l_decap_4_360 r0 *1 0,0
Xsg13cmos5l_decap_4_360 VPWR VGND sg13cmos5l_decap_4
* cell instance sg13cmos5l_decap_4_361 r0 *1 0,0
Xsg13cmos5l_decap_4_361 VPWR VGND sg13cmos5l_decap_4
* cell instance sg13cmos5l_decap_4_362 r0 *1 0,0
Xsg13cmos5l_decap_4_362 VPWR VGND sg13cmos5l_decap_4
* cell instance sg13cmos5l_decap_4_363 r0 *1 0,0
Xsg13cmos5l_decap_4_363 VPWR VGND sg13cmos5l_decap_4
* cell instance sg13cmos5l_decap_4_364 r0 *1 0,0
Xsg13cmos5l_decap_4_364 VPWR VGND sg13cmos5l_decap_4
* cell instance sg13cmos5l_decap_4_365 r0 *1 0,0
Xsg13cmos5l_decap_4_365 VPWR VGND sg13cmos5l_decap_4
* cell instance sg13cmos5l_decap_4_366 r0 *1 0,0
Xsg13cmos5l_decap_4_366 VPWR VGND sg13cmos5l_decap_4
* cell instance sg13cmos5l_decap_4_367 r0 *1 0,0
Xsg13cmos5l_decap_4_367 VPWR VGND sg13cmos5l_decap_4
* cell instance sg13cmos5l_decap_4_368 r0 *1 0,0
Xsg13cmos5l_decap_4_368 VPWR VGND sg13cmos5l_decap_4
* cell instance sg13cmos5l_decap_4_369 r0 *1 0,0
Xsg13cmos5l_decap_4_369 VPWR VGND sg13cmos5l_decap_4
* cell instance sg13cmos5l_decap_4_370 r0 *1 0,0
Xsg13cmos5l_decap_4_370 VPWR VGND sg13cmos5l_decap_4
* cell instance sg13cmos5l_decap_4_371 r0 *1 0,0
Xsg13cmos5l_decap_4_371 VPWR VGND sg13cmos5l_decap_4
* cell instance sg13cmos5l_decap_4_372 r0 *1 0,0
Xsg13cmos5l_decap_4_372 VPWR VGND sg13cmos5l_decap_4
* cell instance sg13cmos5l_decap_4_373 r0 *1 0,0
Xsg13cmos5l_decap_4_373 VPWR VGND sg13cmos5l_decap_4
* cell instance sg13cmos5l_decap_4_374 r0 *1 0,0
Xsg13cmos5l_decap_4_374 VPWR VGND sg13cmos5l_decap_4
* cell instance sg13cmos5l_decap_4_375 r0 *1 0,0
Xsg13cmos5l_decap_4_375 VPWR VGND sg13cmos5l_decap_4
* cell instance sg13cmos5l_decap_4_376 r0 *1 0,0
Xsg13cmos5l_decap_4_376 VPWR VGND sg13cmos5l_decap_4
* cell instance sg13cmos5l_decap_4_377 r0 *1 0,0
Xsg13cmos5l_decap_4_377 VPWR VGND sg13cmos5l_decap_4
* cell instance sg13cmos5l_decap_4_378 r0 *1 0,0
Xsg13cmos5l_decap_4_378 VPWR VGND sg13cmos5l_decap_4
* cell instance sg13cmos5l_decap_4_379 r0 *1 0,0
Xsg13cmos5l_decap_4_379 VPWR VGND sg13cmos5l_decap_4
* cell instance sg13cmos5l_decap_4_380 r0 *1 0,0
Xsg13cmos5l_decap_4_380 VPWR VGND sg13cmos5l_decap_4
* cell instance sg13cmos5l_decap_4_381 r0 *1 0,0
Xsg13cmos5l_decap_4_381 VPWR VGND sg13cmos5l_decap_4
* cell instance sg13cmos5l_decap_4_382 r0 *1 0,0
Xsg13cmos5l_decap_4_382 VPWR VGND sg13cmos5l_decap_4
* cell instance sg13cmos5l_decap_4_383 r0 *1 0,0
Xsg13cmos5l_decap_4_383 VPWR VGND sg13cmos5l_decap_4
* cell instance sg13cmos5l_decap_4_384 r0 *1 0,0
Xsg13cmos5l_decap_4_384 VPWR VGND sg13cmos5l_decap_4
* cell instance sg13cmos5l_decap_4_385 r0 *1 0,0
Xsg13cmos5l_decap_4_385 VPWR VGND sg13cmos5l_decap_4
* cell instance sg13cmos5l_decap_4_386 r0 *1 0,0
Xsg13cmos5l_decap_4_386 VPWR VGND sg13cmos5l_decap_4
* cell instance sg13cmos5l_decap_4_387 r0 *1 0,0
Xsg13cmos5l_decap_4_387 VPWR VGND sg13cmos5l_decap_4
* cell instance sg13cmos5l_decap_4_388 r0 *1 0,0
Xsg13cmos5l_decap_4_388 VPWR VGND sg13cmos5l_decap_4
* cell instance sg13cmos5l_decap_4_389 r0 *1 0,0
Xsg13cmos5l_decap_4_389 VPWR VGND sg13cmos5l_decap_4
* cell instance sg13cmos5l_decap_4_390 r0 *1 0,0
Xsg13cmos5l_decap_4_390 VPWR VGND sg13cmos5l_decap_4
* cell instance sg13cmos5l_decap_4_391 r0 *1 0,0
Xsg13cmos5l_decap_4_391 VPWR VGND sg13cmos5l_decap_4
* cell instance sg13cmos5l_decap_4_392 r0 *1 0,0
Xsg13cmos5l_decap_4_392 VPWR VGND sg13cmos5l_decap_4
* cell instance sg13cmos5l_decap_4_393 r0 *1 0,0
Xsg13cmos5l_decap_4_393 VPWR VGND sg13cmos5l_decap_4
* cell instance sg13cmos5l_decap_4_394 r0 *1 0,0
Xsg13cmos5l_decap_4_394 VPWR VGND sg13cmos5l_decap_4
* cell instance sg13cmos5l_decap_4_395 r0 *1 0,0
Xsg13cmos5l_decap_4_395 VPWR VGND sg13cmos5l_decap_4
* cell instance sg13cmos5l_decap_4_396 r0 *1 0,0
Xsg13cmos5l_decap_4_396 VPWR VGND sg13cmos5l_decap_4
* cell instance sg13cmos5l_decap_4_397 r0 *1 0,0
Xsg13cmos5l_decap_4_397 VPWR VGND sg13cmos5l_decap_4
* cell instance sg13cmos5l_decap_4_398 r0 *1 0,0
Xsg13cmos5l_decap_4_398 VPWR VGND sg13cmos5l_decap_4
* cell instance sg13cmos5l_decap_4_399 r0 *1 0,0
Xsg13cmos5l_decap_4_399 VPWR VGND sg13cmos5l_decap_4
* cell instance sg13cmos5l_decap_4_400 r0 *1 0,0
Xsg13cmos5l_decap_4_400 VPWR VGND sg13cmos5l_decap_4
* cell instance sg13cmos5l_decap_4_401 r0 *1 0,0
Xsg13cmos5l_decap_4_401 VPWR VGND sg13cmos5l_decap_4
* cell instance sg13cmos5l_decap_4_402 r0 *1 0,0
Xsg13cmos5l_decap_4_402 VPWR VGND sg13cmos5l_decap_4
* cell instance sg13cmos5l_decap_4_403 r0 *1 0,0
Xsg13cmos5l_decap_4_403 VPWR VGND sg13cmos5l_decap_4
* cell instance sg13cmos5l_decap_4_404 r0 *1 0,0
Xsg13cmos5l_decap_4_404 VPWR VGND sg13cmos5l_decap_4
* cell instance sg13cmos5l_decap_4_405 r0 *1 0,0
Xsg13cmos5l_decap_4_405 VPWR VGND sg13cmos5l_decap_4
* cell instance sg13cmos5l_decap_4_406 r0 *1 0,0
Xsg13cmos5l_decap_4_406 VPWR VGND sg13cmos5l_decap_4
* cell instance sg13cmos5l_decap_4_407 r0 *1 0,0
Xsg13cmos5l_decap_4_407 VPWR VGND sg13cmos5l_decap_4
* cell instance sg13cmos5l_decap_4_408 r0 *1 0,0
Xsg13cmos5l_decap_4_408 VPWR VGND sg13cmos5l_decap_4
* cell instance sg13cmos5l_decap_4_409 r0 *1 0,0
Xsg13cmos5l_decap_4_409 VPWR VGND sg13cmos5l_decap_4
* cell instance sg13cmos5l_decap_4_410 r0 *1 0,0
Xsg13cmos5l_decap_4_410 VPWR VGND sg13cmos5l_decap_4
* cell instance sg13cmos5l_decap_4_411 r0 *1 0,0
Xsg13cmos5l_decap_4_411 VPWR VGND sg13cmos5l_decap_4
* cell instance sg13cmos5l_decap_4_412 r0 *1 0,0
Xsg13cmos5l_decap_4_412 VPWR VGND sg13cmos5l_decap_4
* cell instance sg13cmos5l_decap_4_413 r0 *1 0,0
Xsg13cmos5l_decap_4_413 VPWR VGND sg13cmos5l_decap_4
* cell instance sg13cmos5l_decap_4_414 r0 *1 0,0
Xsg13cmos5l_decap_4_414 VPWR VGND sg13cmos5l_decap_4
* cell instance sg13cmos5l_decap_4_415 r0 *1 0,0
Xsg13cmos5l_decap_4_415 VPWR VGND sg13cmos5l_decap_4
* cell instance sg13cmos5l_decap_4_416 r0 *1 0,0
Xsg13cmos5l_decap_4_416 VPWR VGND sg13cmos5l_decap_4
* cell instance sg13cmos5l_decap_4_417 r0 *1 0,0
Xsg13cmos5l_decap_4_417 VPWR VGND sg13cmos5l_decap_4
* cell instance sg13cmos5l_decap_4_418 r0 *1 0,0
Xsg13cmos5l_decap_4_418 VPWR VGND sg13cmos5l_decap_4
* cell instance sg13cmos5l_decap_4_419 r0 *1 0,0
Xsg13cmos5l_decap_4_419 VPWR VGND sg13cmos5l_decap_4
* cell instance sg13cmos5l_decap_4_420 r0 *1 0,0
Xsg13cmos5l_decap_4_420 VPWR VGND sg13cmos5l_decap_4
* cell instance sg13cmos5l_decap_4_421 r0 *1 0,0
Xsg13cmos5l_decap_4_421 VPWR VGND sg13cmos5l_decap_4
* cell instance sg13cmos5l_decap_4_422 r0 *1 0,0
Xsg13cmos5l_decap_4_422 VPWR VGND sg13cmos5l_decap_4
* cell instance sg13cmos5l_decap_4_423 r0 *1 0,0
Xsg13cmos5l_decap_4_423 VPWR VGND sg13cmos5l_decap_4
* cell instance sg13cmos5l_decap_4_424 r0 *1 0,0
Xsg13cmos5l_decap_4_424 VPWR VGND sg13cmos5l_decap_4
* cell instance sg13cmos5l_decap_4_425 r0 *1 0,0
Xsg13cmos5l_decap_4_425 VPWR VGND sg13cmos5l_decap_4
* cell instance sg13cmos5l_decap_4_426 r0 *1 0,0
Xsg13cmos5l_decap_4_426 VPWR VGND sg13cmos5l_decap_4
* cell instance sg13cmos5l_decap_4_427 r0 *1 0,0
Xsg13cmos5l_decap_4_427 VPWR VGND sg13cmos5l_decap_4
* cell instance sg13cmos5l_decap_4_428 r0 *1 0,0
Xsg13cmos5l_decap_4_428 VPWR VGND sg13cmos5l_decap_4
* cell instance sg13cmos5l_decap_4_429 r0 *1 0,0
Xsg13cmos5l_decap_4_429 VPWR VGND sg13cmos5l_decap_4
* cell instance sg13cmos5l_decap_4_430 r0 *1 0,0
Xsg13cmos5l_decap_4_430 VPWR VGND sg13cmos5l_decap_4
* cell instance sg13cmos5l_decap_4_431 r0 *1 0,0
Xsg13cmos5l_decap_4_431 VPWR VGND sg13cmos5l_decap_4
* cell instance sg13cmos5l_decap_4_432 r0 *1 0,0
Xsg13cmos5l_decap_4_432 VPWR VGND sg13cmos5l_decap_4
* cell instance sg13cmos5l_decap_4_433 r0 *1 0,0
Xsg13cmos5l_decap_4_433 VPWR VGND sg13cmos5l_decap_4
* cell instance sg13cmos5l_decap_4_434 r0 *1 0,0
Xsg13cmos5l_decap_4_434 VPWR VGND sg13cmos5l_decap_4
* cell instance sg13cmos5l_decap_4_435 r0 *1 0,0
Xsg13cmos5l_decap_4_435 VPWR VGND sg13cmos5l_decap_4
* cell instance sg13cmos5l_decap_4_436 r0 *1 0,0
Xsg13cmos5l_decap_4_436 VPWR VGND sg13cmos5l_decap_4
* cell instance sg13cmos5l_decap_4_437 r0 *1 0,0
Xsg13cmos5l_decap_4_437 VPWR VGND sg13cmos5l_decap_4
* cell instance sg13cmos5l_decap_4_438 r0 *1 0,0
Xsg13cmos5l_decap_4_438 VPWR VGND sg13cmos5l_decap_4
* cell instance sg13cmos5l_decap_4_439 r0 *1 0,0
Xsg13cmos5l_decap_4_439 VPWR VGND sg13cmos5l_decap_4
* cell instance sg13cmos5l_decap_4_440 r0 *1 0,0
Xsg13cmos5l_decap_4_440 VPWR VGND sg13cmos5l_decap_4
* cell instance sg13cmos5l_decap_4_441 r0 *1 0,0
Xsg13cmos5l_decap_4_441 VPWR VGND sg13cmos5l_decap_4
* cell instance sg13cmos5l_decap_4_442 r0 *1 0,0
Xsg13cmos5l_decap_4_442 VPWR VGND sg13cmos5l_decap_4
* cell instance sg13cmos5l_decap_4_443 r0 *1 0,0
Xsg13cmos5l_decap_4_443 VPWR VGND sg13cmos5l_decap_4
* cell instance sg13cmos5l_decap_4_444 r0 *1 0,0
Xsg13cmos5l_decap_4_444 VPWR VGND sg13cmos5l_decap_4
* cell instance sg13cmos5l_decap_4_445 r0 *1 0,0
Xsg13cmos5l_decap_4_445 VPWR VGND sg13cmos5l_decap_4
* cell instance sg13cmos5l_decap_4_446 r0 *1 0,0
Xsg13cmos5l_decap_4_446 VPWR VGND sg13cmos5l_decap_4
* cell instance sg13cmos5l_decap_4_447 r0 *1 0,0
Xsg13cmos5l_decap_4_447 VPWR VGND sg13cmos5l_decap_4
* cell instance sg13cmos5l_decap_4_448 r0 *1 0,0
Xsg13cmos5l_decap_4_448 VPWR VGND sg13cmos5l_decap_4
* cell instance sg13cmos5l_decap_4_449 r0 *1 0,0
Xsg13cmos5l_decap_4_449 VPWR VGND sg13cmos5l_decap_4
* cell instance sg13cmos5l_decap_4_450 r0 *1 0,0
Xsg13cmos5l_decap_4_450 VPWR VGND sg13cmos5l_decap_4
* cell instance sg13cmos5l_decap_4_451 r0 *1 0,0
Xsg13cmos5l_decap_4_451 VPWR VGND sg13cmos5l_decap_4
* cell instance sg13cmos5l_decap_4_452 r0 *1 0,0
Xsg13cmos5l_decap_4_452 VPWR VGND sg13cmos5l_decap_4
* cell instance sg13cmos5l_decap_4_453 r0 *1 0,0
Xsg13cmos5l_decap_4_453 VPWR VGND sg13cmos5l_decap_4
* cell instance sg13cmos5l_decap_4_454 r0 *1 0,0
Xsg13cmos5l_decap_4_454 VPWR VGND sg13cmos5l_decap_4
* cell instance sg13cmos5l_decap_4_455 r0 *1 0,0
Xsg13cmos5l_decap_4_455 VPWR VGND sg13cmos5l_decap_4
* cell instance sg13cmos5l_decap_4_456 r0 *1 0,0
Xsg13cmos5l_decap_4_456 VPWR VGND sg13cmos5l_decap_4
* cell instance sg13cmos5l_decap_4_457 r0 *1 0,0
Xsg13cmos5l_decap_4_457 VPWR VGND sg13cmos5l_decap_4
* cell instance sg13cmos5l_decap_4_458 r0 *1 0,0
Xsg13cmos5l_decap_4_458 VPWR VGND sg13cmos5l_decap_4
* cell instance sg13cmos5l_decap_4_459 r0 *1 0,0
Xsg13cmos5l_decap_4_459 VPWR VGND sg13cmos5l_decap_4
* cell instance sg13cmos5l_decap_4_460 r0 *1 0,0
Xsg13cmos5l_decap_4_460 VPWR VGND sg13cmos5l_decap_4
* cell instance sg13cmos5l_decap_4_461 r0 *1 0,0
Xsg13cmos5l_decap_4_461 VPWR VGND sg13cmos5l_decap_4
* cell instance sg13cmos5l_decap_4_462 r0 *1 0,0
Xsg13cmos5l_decap_4_462 VPWR VGND sg13cmos5l_decap_4
* cell instance sg13cmos5l_decap_4_463 r0 *1 0,0
Xsg13cmos5l_decap_4_463 VPWR VGND sg13cmos5l_decap_4
* cell instance sg13cmos5l_decap_4_464 r0 *1 0,0
Xsg13cmos5l_decap_4_464 VPWR VGND sg13cmos5l_decap_4
* cell instance sg13cmos5l_decap_4_465 r0 *1 0,0
Xsg13cmos5l_decap_4_465 VPWR VGND sg13cmos5l_decap_4
* cell instance sg13cmos5l_decap_4_466 r0 *1 0,0
Xsg13cmos5l_decap_4_466 VPWR VGND sg13cmos5l_decap_4
* cell instance sg13cmos5l_decap_4_467 r0 *1 0,0
Xsg13cmos5l_decap_4_467 VPWR VGND sg13cmos5l_decap_4
* cell instance sg13cmos5l_decap_4_468 r0 *1 0,0
Xsg13cmos5l_decap_4_468 VPWR VGND sg13cmos5l_decap_4
* cell instance sg13cmos5l_decap_4_469 r0 *1 0,0
Xsg13cmos5l_decap_4_469 VPWR VGND sg13cmos5l_decap_4
* cell instance sg13cmos5l_decap_4_470 r0 *1 0,0
Xsg13cmos5l_decap_4_470 VPWR VGND sg13cmos5l_decap_4
* cell instance sg13cmos5l_decap_4_471 r0 *1 0,0
Xsg13cmos5l_decap_4_471 VPWR VGND sg13cmos5l_decap_4
* cell instance sg13cmos5l_decap_4_472 r0 *1 0,0
Xsg13cmos5l_decap_4_472 VPWR VGND sg13cmos5l_decap_4
* cell instance sg13cmos5l_decap_4_473 r0 *1 0,0
Xsg13cmos5l_decap_4_473 VPWR VGND sg13cmos5l_decap_4
* cell instance sg13cmos5l_decap_4_474 r0 *1 0,0
Xsg13cmos5l_decap_4_474 VPWR VGND sg13cmos5l_decap_4
* cell instance sg13cmos5l_decap_4_475 r0 *1 0,0
Xsg13cmos5l_decap_4_475 VPWR VGND sg13cmos5l_decap_4
* cell instance sg13cmos5l_decap_4_476 r0 *1 0,0
Xsg13cmos5l_decap_4_476 VPWR VGND sg13cmos5l_decap_4
* cell instance sg13cmos5l_decap_4_477 r0 *1 0,0
Xsg13cmos5l_decap_4_477 VPWR VGND sg13cmos5l_decap_4
* cell instance sg13cmos5l_decap_4_478 r0 *1 0,0
Xsg13cmos5l_decap_4_478 VPWR VGND sg13cmos5l_decap_4
* cell instance sg13cmos5l_decap_4_479 r0 *1 0,0
Xsg13cmos5l_decap_4_479 VPWR VGND sg13cmos5l_decap_4
* cell instance sg13cmos5l_decap_4_480 r0 *1 0,0
Xsg13cmos5l_decap_4_480 VPWR VGND sg13cmos5l_decap_4
* cell instance sg13cmos5l_decap_4_481 r0 *1 0,0
Xsg13cmos5l_decap_4_481 VPWR VGND sg13cmos5l_decap_4
* cell instance sg13cmos5l_decap_4_482 r0 *1 0,0
Xsg13cmos5l_decap_4_482 VPWR VGND sg13cmos5l_decap_4
* cell instance sg13cmos5l_decap_4_483 r0 *1 0,0
Xsg13cmos5l_decap_4_483 VPWR VGND sg13cmos5l_decap_4
* cell instance sg13cmos5l_decap_4_484 r0 *1 0,0
Xsg13cmos5l_decap_4_484 VPWR VGND sg13cmos5l_decap_4
* cell instance sg13cmos5l_decap_4_485 r0 *1 0,0
Xsg13cmos5l_decap_4_485 VPWR VGND sg13cmos5l_decap_4
* cell instance sg13cmos5l_decap_4_486 r0 *1 0,0
Xsg13cmos5l_decap_4_486 VPWR VGND sg13cmos5l_decap_4
* cell instance sg13cmos5l_decap_4_487 r0 *1 0,0
Xsg13cmos5l_decap_4_487 VPWR VGND sg13cmos5l_decap_4
* cell instance sg13cmos5l_decap_4_488 r0 *1 0,0
Xsg13cmos5l_decap_4_488 VPWR VGND sg13cmos5l_decap_4
* cell instance sg13cmos5l_decap_4_489 r0 *1 0,0
Xsg13cmos5l_decap_4_489 VPWR VGND sg13cmos5l_decap_4
* cell instance sg13cmos5l_decap_4_490 r0 *1 0,0
Xsg13cmos5l_decap_4_490 VPWR VGND sg13cmos5l_decap_4
* cell instance sg13cmos5l_decap_4_491 r0 *1 0,0
Xsg13cmos5l_decap_4_491 VPWR VGND sg13cmos5l_decap_4
* cell instance sg13cmos5l_decap_4_492 r0 *1 0,0
Xsg13cmos5l_decap_4_492 VPWR VGND sg13cmos5l_decap_4
* cell instance sg13cmos5l_decap_4_493 r0 *1 0,0
Xsg13cmos5l_decap_4_493 VPWR VGND sg13cmos5l_decap_4
* cell instance sg13cmos5l_decap_4_494 r0 *1 0,0
Xsg13cmos5l_decap_4_494 VPWR VGND sg13cmos5l_decap_4
* cell instance sg13cmos5l_decap_4_495 r0 *1 0,0
Xsg13cmos5l_decap_4_495 VPWR VGND sg13cmos5l_decap_4
* cell instance sg13cmos5l_decap_4_496 r0 *1 0,0
Xsg13cmos5l_decap_4_496 VPWR VGND sg13cmos5l_decap_4
* cell instance sg13cmos5l_decap_4_497 r0 *1 0,0
Xsg13cmos5l_decap_4_497 VPWR VGND sg13cmos5l_decap_4
* cell instance sg13cmos5l_decap_4_498 r0 *1 0,0
Xsg13cmos5l_decap_4_498 VPWR VGND sg13cmos5l_decap_4
* cell instance sg13cmos5l_decap_4_499 r0 *1 0,0
Xsg13cmos5l_decap_4_499 VPWR VGND sg13cmos5l_decap_4
* cell instance sg13cmos5l_decap_4_500 r0 *1 0,0
Xsg13cmos5l_decap_4_500 VPWR VGND sg13cmos5l_decap_4
* cell instance sg13cmos5l_decap_4_501 r0 *1 0,0
Xsg13cmos5l_decap_4_501 VPWR VGND sg13cmos5l_decap_4
* cell instance sg13cmos5l_decap_4_502 r0 *1 0,0
Xsg13cmos5l_decap_4_502 VPWR VGND sg13cmos5l_decap_4
* cell instance sg13cmos5l_decap_4_503 r0 *1 0,0
Xsg13cmos5l_decap_4_503 VPWR VGND sg13cmos5l_decap_4
* cell instance sg13cmos5l_decap_4_504 r0 *1 0,0
Xsg13cmos5l_decap_4_504 VPWR VGND sg13cmos5l_decap_4
* cell instance sg13cmos5l_decap_4_505 r0 *1 0,0
Xsg13cmos5l_decap_4_505 VPWR VGND sg13cmos5l_decap_4
* cell instance sg13cmos5l_decap_4_506 r0 *1 0,0
Xsg13cmos5l_decap_4_506 VPWR VGND sg13cmos5l_decap_4
* cell instance sg13cmos5l_decap_4_507 r0 *1 0,0
Xsg13cmos5l_decap_4_507 VPWR VGND sg13cmos5l_decap_4
* cell instance sg13cmos5l_decap_4_508 r0 *1 0,0
Xsg13cmos5l_decap_4_508 VPWR VGND sg13cmos5l_decap_4
* cell instance sg13cmos5l_decap_4_509 r0 *1 0,0
Xsg13cmos5l_decap_4_509 VPWR VGND sg13cmos5l_decap_4
* cell instance sg13cmos5l_decap_4_510 r0 *1 0,0
Xsg13cmos5l_decap_4_510 VPWR VGND sg13cmos5l_decap_4
* cell instance sg13cmos5l_decap_4_511 r0 *1 0,0
Xsg13cmos5l_decap_4_511 VPWR VGND sg13cmos5l_decap_4
* cell instance sg13cmos5l_decap_4_512 r0 *1 0,0
Xsg13cmos5l_decap_4_512 VPWR VGND sg13cmos5l_decap_4
* cell instance sg13cmos5l_decap_4_513 r0 *1 0,0
Xsg13cmos5l_decap_4_513 VPWR VGND sg13cmos5l_decap_4
* cell instance sg13cmos5l_decap_4_514 r0 *1 0,0
Xsg13cmos5l_decap_4_514 VPWR VGND sg13cmos5l_decap_4
* cell instance sg13cmos5l_decap_4_515 r0 *1 0,0
Xsg13cmos5l_decap_4_515 VPWR VGND sg13cmos5l_decap_4
* cell instance sg13cmos5l_decap_4_516 r0 *1 0,0
Xsg13cmos5l_decap_4_516 VPWR VGND sg13cmos5l_decap_4
* cell instance sg13cmos5l_decap_4_517 r0 *1 0,0
Xsg13cmos5l_decap_4_517 VPWR VGND sg13cmos5l_decap_4
* cell instance sg13cmos5l_decap_4_518 r0 *1 0,0
Xsg13cmos5l_decap_4_518 VPWR VGND sg13cmos5l_decap_4
* cell instance sg13cmos5l_decap_4_519 r0 *1 0,0
Xsg13cmos5l_decap_4_519 VPWR VGND sg13cmos5l_decap_4
* cell instance sg13cmos5l_decap_4_520 r0 *1 0,0
Xsg13cmos5l_decap_4_520 VPWR VGND sg13cmos5l_decap_4
* cell instance sg13cmos5l_decap_4_521 r0 *1 0,0
Xsg13cmos5l_decap_4_521 VPWR VGND sg13cmos5l_decap_4
* cell instance sg13cmos5l_decap_4_522 r0 *1 0,0
Xsg13cmos5l_decap_4_522 VPWR VGND sg13cmos5l_decap_4
* cell instance sg13cmos5l_decap_4_523 r0 *1 0,0
Xsg13cmos5l_decap_4_523 VPWR VGND sg13cmos5l_decap_4
* cell instance sg13cmos5l_decap_4_524 r0 *1 0,0
Xsg13cmos5l_decap_4_524 VPWR VGND sg13cmos5l_decap_4
* cell instance sg13cmos5l_decap_4_525 r0 *1 0,0
Xsg13cmos5l_decap_4_525 VPWR VGND sg13cmos5l_decap_4
* cell instance sg13cmos5l_decap_4_526 r0 *1 0,0
Xsg13cmos5l_decap_4_526 VPWR VGND sg13cmos5l_decap_4
* cell instance sg13cmos5l_decap_4_527 r0 *1 0,0
Xsg13cmos5l_decap_4_527 VPWR VGND sg13cmos5l_decap_4
* cell instance sg13cmos5l_decap_4_528 r0 *1 0,0
Xsg13cmos5l_decap_4_528 VPWR VGND sg13cmos5l_decap_4
* cell instance sg13cmos5l_decap_4_529 r0 *1 0,0
Xsg13cmos5l_decap_4_529 VPWR VGND sg13cmos5l_decap_4
* cell instance sg13cmos5l_decap_4_530 r0 *1 0,0
Xsg13cmos5l_decap_4_530 VPWR VGND sg13cmos5l_decap_4
* cell instance sg13cmos5l_decap_4_531 r0 *1 0,0
Xsg13cmos5l_decap_4_531 VPWR VGND sg13cmos5l_decap_4
* cell instance sg13cmos5l_decap_4_532 r0 *1 0,0
Xsg13cmos5l_decap_4_532 VPWR VGND sg13cmos5l_decap_4
* cell instance sg13cmos5l_decap_4_533 r0 *1 0,0
Xsg13cmos5l_decap_4_533 VPWR VGND sg13cmos5l_decap_4
* cell instance sg13cmos5l_decap_4_534 r0 *1 0,0
Xsg13cmos5l_decap_4_534 VPWR VGND sg13cmos5l_decap_4
* cell instance sg13cmos5l_decap_4_535 r0 *1 0,0
Xsg13cmos5l_decap_4_535 VPWR VGND sg13cmos5l_decap_4
* cell instance sg13cmos5l_decap_4_536 r0 *1 0,0
Xsg13cmos5l_decap_4_536 VPWR VGND sg13cmos5l_decap_4
* cell instance sg13cmos5l_decap_4_537 r0 *1 0,0
Xsg13cmos5l_decap_4_537 VPWR VGND sg13cmos5l_decap_4
* cell instance sg13cmos5l_decap_4_538 r0 *1 0,0
Xsg13cmos5l_decap_4_538 VPWR VGND sg13cmos5l_decap_4
* cell instance sg13cmos5l_decap_4_539 r0 *1 0,0
Xsg13cmos5l_decap_4_539 VPWR VGND sg13cmos5l_decap_4
* cell instance sg13cmos5l_decap_4_540 r0 *1 0,0
Xsg13cmos5l_decap_4_540 VPWR VGND sg13cmos5l_decap_4
* cell instance sg13cmos5l_decap_8_0 r0 *1 0,0
Xsg13cmos5l_decap_8_0 VPWR VGND sg13cmos5l_decap_8
* cell instance sg13cmos5l_decap_8_1 r0 *1 0,0
Xsg13cmos5l_decap_8_1 VPWR VGND sg13cmos5l_decap_8
* cell instance sg13cmos5l_decap_8_2 r0 *1 0,0
Xsg13cmos5l_decap_8_2 VPWR VGND sg13cmos5l_decap_8
* cell instance sg13cmos5l_decap_8_3 r0 *1 0,0
Xsg13cmos5l_decap_8_3 VPWR VGND sg13cmos5l_decap_8
* cell instance sg13cmos5l_decap_8_4 r0 *1 0,0
Xsg13cmos5l_decap_8_4 VPWR VGND sg13cmos5l_decap_8
* cell instance sg13cmos5l_decap_8_5 r0 *1 0,0
Xsg13cmos5l_decap_8_5 VPWR VGND sg13cmos5l_decap_8
* cell instance sg13cmos5l_decap_8_6 r0 *1 0,0
Xsg13cmos5l_decap_8_6 VPWR VGND sg13cmos5l_decap_8
* cell instance sg13cmos5l_decap_8_7 r0 *1 0,0
Xsg13cmos5l_decap_8_7 VPWR VGND sg13cmos5l_decap_8
* cell instance sg13cmos5l_decap_8_8 r0 *1 0,0
Xsg13cmos5l_decap_8_8 VPWR VGND sg13cmos5l_decap_8
* cell instance sg13cmos5l_decap_8_9 r0 *1 0,0
Xsg13cmos5l_decap_8_9 VPWR VGND sg13cmos5l_decap_8
* cell instance sg13cmos5l_decap_8_10 r0 *1 0,0
Xsg13cmos5l_decap_8_10 VPWR VGND sg13cmos5l_decap_8
* cell instance sg13cmos5l_decap_8_11 r0 *1 0,0
Xsg13cmos5l_decap_8_11 VPWR VGND sg13cmos5l_decap_8
* cell instance sg13cmos5l_decap_8_12 r0 *1 0,0
Xsg13cmos5l_decap_8_12 VPWR VGND sg13cmos5l_decap_8
* cell instance sg13cmos5l_decap_8_13 r0 *1 0,0
Xsg13cmos5l_decap_8_13 VPWR VGND sg13cmos5l_decap_8
* cell instance sg13cmos5l_decap_8_14 r0 *1 0,0
Xsg13cmos5l_decap_8_14 VPWR VGND sg13cmos5l_decap_8
* cell instance sg13cmos5l_decap_8_15 r0 *1 0,0
Xsg13cmos5l_decap_8_15 VPWR VGND sg13cmos5l_decap_8
* cell instance sg13cmos5l_decap_8_16 r0 *1 0,0
Xsg13cmos5l_decap_8_16 VPWR VGND sg13cmos5l_decap_8
* cell instance sg13cmos5l_decap_8_17 r0 *1 0,0
Xsg13cmos5l_decap_8_17 VPWR VGND sg13cmos5l_decap_8
* cell instance sg13cmos5l_decap_8_18 r0 *1 0,0
Xsg13cmos5l_decap_8_18 VPWR VGND sg13cmos5l_decap_8
* cell instance sg13cmos5l_decap_8_19 r0 *1 0,0
Xsg13cmos5l_decap_8_19 VPWR VGND sg13cmos5l_decap_8
* cell instance sg13cmos5l_decap_8_20 r0 *1 0,0
Xsg13cmos5l_decap_8_20 VPWR VGND sg13cmos5l_decap_8
* cell instance sg13cmos5l_decap_8_21 r0 *1 0,0
Xsg13cmos5l_decap_8_21 VPWR VGND sg13cmos5l_decap_8
* cell instance sg13cmos5l_decap_8_22 r0 *1 0,0
Xsg13cmos5l_decap_8_22 VPWR VGND sg13cmos5l_decap_8
* cell instance sg13cmos5l_decap_8_23 r0 *1 0,0
Xsg13cmos5l_decap_8_23 VPWR VGND sg13cmos5l_decap_8
* cell instance sg13cmos5l_decap_8_24 r0 *1 0,0
Xsg13cmos5l_decap_8_24 VPWR VGND sg13cmos5l_decap_8
* cell instance sg13cmos5l_decap_8_25 r0 *1 0,0
Xsg13cmos5l_decap_8_25 VPWR VGND sg13cmos5l_decap_8
* cell instance sg13cmos5l_decap_8_26 r0 *1 0,0
Xsg13cmos5l_decap_8_26 VPWR VGND sg13cmos5l_decap_8
* cell instance sg13cmos5l_decap_8_27 r0 *1 0,0
Xsg13cmos5l_decap_8_27 VPWR VGND sg13cmos5l_decap_8
* cell instance sg13cmos5l_decap_8_28 r0 *1 0,0
Xsg13cmos5l_decap_8_28 VPWR VGND sg13cmos5l_decap_8
* cell instance sg13cmos5l_decap_8_29 r0 *1 0,0
Xsg13cmos5l_decap_8_29 VPWR VGND sg13cmos5l_decap_8
* cell instance sg13cmos5l_decap_8_30 r0 *1 0,0
Xsg13cmos5l_decap_8_30 VPWR VGND sg13cmos5l_decap_8
* cell instance sg13cmos5l_decap_8_31 r0 *1 0,0
Xsg13cmos5l_decap_8_31 VPWR VGND sg13cmos5l_decap_8
* cell instance sg13cmos5l_decap_8_32 r0 *1 0,0
Xsg13cmos5l_decap_8_32 VPWR VGND sg13cmos5l_decap_8
* cell instance sg13cmos5l_decap_8_33 r0 *1 0,0
Xsg13cmos5l_decap_8_33 VPWR VGND sg13cmos5l_decap_8
* cell instance sg13cmos5l_decap_8_34 r0 *1 0,0
Xsg13cmos5l_decap_8_34 VPWR VGND sg13cmos5l_decap_8
* cell instance sg13cmos5l_decap_8_35 r0 *1 0,0
Xsg13cmos5l_decap_8_35 VPWR VGND sg13cmos5l_decap_8
* cell instance sg13cmos5l_decap_8_36 r0 *1 0,0
Xsg13cmos5l_decap_8_36 VPWR VGND sg13cmos5l_decap_8
* cell instance sg13cmos5l_decap_8_37 r0 *1 0,0
Xsg13cmos5l_decap_8_37 VPWR VGND sg13cmos5l_decap_8
* cell instance sg13cmos5l_decap_8_38 r0 *1 0,0
Xsg13cmos5l_decap_8_38 VPWR VGND sg13cmos5l_decap_8
* cell instance sg13cmos5l_decap_8_39 r0 *1 0,0
Xsg13cmos5l_decap_8_39 VPWR VGND sg13cmos5l_decap_8
* cell instance sg13cmos5l_decap_8_40 r0 *1 0,0
Xsg13cmos5l_decap_8_40 VPWR VGND sg13cmos5l_decap_8
* cell instance sg13cmos5l_decap_8_41 r0 *1 0,0
Xsg13cmos5l_decap_8_41 VPWR VGND sg13cmos5l_decap_8
* cell instance sg13cmos5l_decap_8_42 r0 *1 0,0
Xsg13cmos5l_decap_8_42 VPWR VGND sg13cmos5l_decap_8
* cell instance sg13cmos5l_decap_8_43 r0 *1 0,0
Xsg13cmos5l_decap_8_43 VPWR VGND sg13cmos5l_decap_8
* cell instance sg13cmos5l_decap_8_44 r0 *1 0,0
Xsg13cmos5l_decap_8_44 VPWR VGND sg13cmos5l_decap_8
* cell instance sg13cmos5l_decap_8_45 r0 *1 0,0
Xsg13cmos5l_decap_8_45 VPWR VGND sg13cmos5l_decap_8
* cell instance sg13cmos5l_decap_8_46 r0 *1 0,0
Xsg13cmos5l_decap_8_46 VPWR VGND sg13cmos5l_decap_8
* cell instance sg13cmos5l_decap_8_47 r0 *1 0,0
Xsg13cmos5l_decap_8_47 VPWR VGND sg13cmos5l_decap_8
* cell instance sg13cmos5l_decap_8_48 r0 *1 0,0
Xsg13cmos5l_decap_8_48 VPWR VGND sg13cmos5l_decap_8
* cell instance sg13cmos5l_decap_8_49 r0 *1 0,0
Xsg13cmos5l_decap_8_49 VPWR VGND sg13cmos5l_decap_8
* cell instance sg13cmos5l_decap_8_50 r0 *1 0,0
Xsg13cmos5l_decap_8_50 VPWR VGND sg13cmos5l_decap_8
* cell instance sg13cmos5l_decap_8_51 r0 *1 0,0
Xsg13cmos5l_decap_8_51 VPWR VGND sg13cmos5l_decap_8
* cell instance sg13cmos5l_decap_8_52 r0 *1 0,0
Xsg13cmos5l_decap_8_52 VPWR VGND sg13cmos5l_decap_8
* cell instance sg13cmos5l_decap_8_53 r0 *1 0,0
Xsg13cmos5l_decap_8_53 VPWR VGND sg13cmos5l_decap_8
* cell instance sg13cmos5l_decap_8_54 r0 *1 0,0
Xsg13cmos5l_decap_8_54 VPWR VGND sg13cmos5l_decap_8
* cell instance sg13cmos5l_decap_8_55 r0 *1 0,0
Xsg13cmos5l_decap_8_55 VPWR VGND sg13cmos5l_decap_8
* cell instance sg13cmos5l_decap_8_56 r0 *1 0,0
Xsg13cmos5l_decap_8_56 VPWR VGND sg13cmos5l_decap_8
* cell instance sg13cmos5l_decap_8_57 r0 *1 0,0
Xsg13cmos5l_decap_8_57 VPWR VGND sg13cmos5l_decap_8
* cell instance sg13cmos5l_decap_8_58 r0 *1 0,0
Xsg13cmos5l_decap_8_58 VPWR VGND sg13cmos5l_decap_8
* cell instance sg13cmos5l_decap_8_59 r0 *1 0,0
Xsg13cmos5l_decap_8_59 VPWR VGND sg13cmos5l_decap_8
* cell instance sg13cmos5l_decap_8_60 r0 *1 0,0
Xsg13cmos5l_decap_8_60 VPWR VGND sg13cmos5l_decap_8
* cell instance sg13cmos5l_decap_8_61 r0 *1 0,0
Xsg13cmos5l_decap_8_61 VPWR VGND sg13cmos5l_decap_8
* cell instance sg13cmos5l_decap_8_62 r0 *1 0,0
Xsg13cmos5l_decap_8_62 VPWR VGND sg13cmos5l_decap_8
* cell instance sg13cmos5l_decap_8_63 r0 *1 0,0
Xsg13cmos5l_decap_8_63 VPWR VGND sg13cmos5l_decap_8
* cell instance sg13cmos5l_decap_8_64 r0 *1 0,0
Xsg13cmos5l_decap_8_64 VPWR VGND sg13cmos5l_decap_8
* cell instance sg13cmos5l_decap_8_65 r0 *1 0,0
Xsg13cmos5l_decap_8_65 VPWR VGND sg13cmos5l_decap_8
* cell instance sg13cmos5l_decap_8_66 r0 *1 0,0
Xsg13cmos5l_decap_8_66 VPWR VGND sg13cmos5l_decap_8
* cell instance sg13cmos5l_decap_8_67 r0 *1 0,0
Xsg13cmos5l_decap_8_67 VPWR VGND sg13cmos5l_decap_8
* cell instance sg13cmos5l_decap_8_68 r0 *1 0,0
Xsg13cmos5l_decap_8_68 VPWR VGND sg13cmos5l_decap_8
* cell instance sg13cmos5l_decap_8_69 r0 *1 0,0
Xsg13cmos5l_decap_8_69 VPWR VGND sg13cmos5l_decap_8
* cell instance sg13cmos5l_decap_8_70 r0 *1 0,0
Xsg13cmos5l_decap_8_70 VPWR VGND sg13cmos5l_decap_8
* cell instance sg13cmos5l_decap_8_71 r0 *1 0,0
Xsg13cmos5l_decap_8_71 VPWR VGND sg13cmos5l_decap_8
* cell instance sg13cmos5l_decap_8_72 r0 *1 0,0
Xsg13cmos5l_decap_8_72 VPWR VGND sg13cmos5l_decap_8
* cell instance sg13cmos5l_decap_8_73 r0 *1 0,0
Xsg13cmos5l_decap_8_73 VPWR VGND sg13cmos5l_decap_8
* cell instance sg13cmos5l_decap_8_74 r0 *1 0,0
Xsg13cmos5l_decap_8_74 VPWR VGND sg13cmos5l_decap_8
* cell instance sg13cmos5l_decap_8_75 r0 *1 0,0
Xsg13cmos5l_decap_8_75 VPWR VGND sg13cmos5l_decap_8
* cell instance sg13cmos5l_decap_8_76 r0 *1 0,0
Xsg13cmos5l_decap_8_76 VPWR VGND sg13cmos5l_decap_8
* cell instance sg13cmos5l_decap_8_77 r0 *1 0,0
Xsg13cmos5l_decap_8_77 VPWR VGND sg13cmos5l_decap_8
* cell instance sg13cmos5l_decap_8_78 r0 *1 0,0
Xsg13cmos5l_decap_8_78 VPWR VGND sg13cmos5l_decap_8
* cell instance sg13cmos5l_decap_8_79 r0 *1 0,0
Xsg13cmos5l_decap_8_79 VPWR VGND sg13cmos5l_decap_8
* cell instance sg13cmos5l_decap_8_80 r0 *1 0,0
Xsg13cmos5l_decap_8_80 VPWR VGND sg13cmos5l_decap_8
* cell instance sg13cmos5l_decap_8_81 r0 *1 0,0
Xsg13cmos5l_decap_8_81 VPWR VGND sg13cmos5l_decap_8
* cell instance sg13cmos5l_decap_8_82 r0 *1 0,0
Xsg13cmos5l_decap_8_82 VPWR VGND sg13cmos5l_decap_8
* cell instance sg13cmos5l_decap_8_83 r0 *1 0,0
Xsg13cmos5l_decap_8_83 VPWR VGND sg13cmos5l_decap_8
* cell instance sg13cmos5l_decap_8_84 r0 *1 0,0
Xsg13cmos5l_decap_8_84 VPWR VGND sg13cmos5l_decap_8
* cell instance sg13cmos5l_decap_8_85 r0 *1 0,0
Xsg13cmos5l_decap_8_85 VPWR VGND sg13cmos5l_decap_8
* cell instance sg13cmos5l_decap_8_86 r0 *1 0,0
Xsg13cmos5l_decap_8_86 VPWR VGND sg13cmos5l_decap_8
* cell instance sg13cmos5l_decap_8_87 r0 *1 0,0
Xsg13cmos5l_decap_8_87 VPWR VGND sg13cmos5l_decap_8
* cell instance sg13cmos5l_decap_8_88 r0 *1 0,0
Xsg13cmos5l_decap_8_88 VPWR VGND sg13cmos5l_decap_8
* cell instance sg13cmos5l_decap_8_89 r0 *1 0,0
Xsg13cmos5l_decap_8_89 VPWR VGND sg13cmos5l_decap_8
* cell instance sg13cmos5l_decap_8_90 r0 *1 0,0
Xsg13cmos5l_decap_8_90 VPWR VGND sg13cmos5l_decap_8
* cell instance sg13cmos5l_decap_8_91 r0 *1 0,0
Xsg13cmos5l_decap_8_91 VPWR VGND sg13cmos5l_decap_8
* cell instance sg13cmos5l_decap_8_92 r0 *1 0,0
Xsg13cmos5l_decap_8_92 VPWR VGND sg13cmos5l_decap_8
* cell instance sg13cmos5l_decap_8_93 r0 *1 0,0
Xsg13cmos5l_decap_8_93 VPWR VGND sg13cmos5l_decap_8
* cell instance sg13cmos5l_decap_8_94 r0 *1 0,0
Xsg13cmos5l_decap_8_94 VPWR VGND sg13cmos5l_decap_8
* cell instance sg13cmos5l_decap_8_95 r0 *1 0,0
Xsg13cmos5l_decap_8_95 VPWR VGND sg13cmos5l_decap_8
* cell instance sg13cmos5l_decap_8_96 r0 *1 0,0
Xsg13cmos5l_decap_8_96 VPWR VGND sg13cmos5l_decap_8
* cell instance sg13cmos5l_decap_8_97 r0 *1 0,0
Xsg13cmos5l_decap_8_97 VPWR VGND sg13cmos5l_decap_8
* cell instance sg13cmos5l_decap_8_98 r0 *1 0,0
Xsg13cmos5l_decap_8_98 VPWR VGND sg13cmos5l_decap_8
* cell instance sg13cmos5l_decap_8_99 r0 *1 0,0
Xsg13cmos5l_decap_8_99 VPWR VGND sg13cmos5l_decap_8
* cell instance sg13cmos5l_decap_8_100 r0 *1 0,0
Xsg13cmos5l_decap_8_100 VPWR VGND sg13cmos5l_decap_8
* cell instance sg13cmos5l_decap_8_101 r0 *1 0,0
Xsg13cmos5l_decap_8_101 VPWR VGND sg13cmos5l_decap_8
* cell instance sg13cmos5l_decap_8_102 r0 *1 0,0
Xsg13cmos5l_decap_8_102 VPWR VGND sg13cmos5l_decap_8
* cell instance sg13cmos5l_decap_8_103 r0 *1 0,0
Xsg13cmos5l_decap_8_103 VPWR VGND sg13cmos5l_decap_8
* cell instance sg13cmos5l_decap_8_104 r0 *1 0,0
Xsg13cmos5l_decap_8_104 VPWR VGND sg13cmos5l_decap_8
* cell instance sg13cmos5l_decap_8_105 r0 *1 0,0
Xsg13cmos5l_decap_8_105 VPWR VGND sg13cmos5l_decap_8
* cell instance sg13cmos5l_decap_8_106 r0 *1 0,0
Xsg13cmos5l_decap_8_106 VPWR VGND sg13cmos5l_decap_8
* cell instance sg13cmos5l_decap_8_107 r0 *1 0,0
Xsg13cmos5l_decap_8_107 VPWR VGND sg13cmos5l_decap_8
* cell instance sg13cmos5l_decap_8_108 r0 *1 0,0
Xsg13cmos5l_decap_8_108 VPWR VGND sg13cmos5l_decap_8
* cell instance sg13cmos5l_decap_8_109 r0 *1 0,0
Xsg13cmos5l_decap_8_109 VPWR VGND sg13cmos5l_decap_8
* cell instance sg13cmos5l_decap_8_110 r0 *1 0,0
Xsg13cmos5l_decap_8_110 VPWR VGND sg13cmos5l_decap_8
* cell instance sg13cmos5l_decap_8_111 r0 *1 0,0
Xsg13cmos5l_decap_8_111 VPWR VGND sg13cmos5l_decap_8
* cell instance sg13cmos5l_decap_8_112 r0 *1 0,0
Xsg13cmos5l_decap_8_112 VPWR VGND sg13cmos5l_decap_8
* cell instance sg13cmos5l_decap_8_113 r0 *1 0,0
Xsg13cmos5l_decap_8_113 VPWR VGND sg13cmos5l_decap_8
* cell instance sg13cmos5l_decap_8_114 r0 *1 0,0
Xsg13cmos5l_decap_8_114 VPWR VGND sg13cmos5l_decap_8
* cell instance sg13cmos5l_decap_8_115 r0 *1 0,0
Xsg13cmos5l_decap_8_115 VPWR VGND sg13cmos5l_decap_8
* cell instance sg13cmos5l_decap_8_116 r0 *1 0,0
Xsg13cmos5l_decap_8_116 VPWR VGND sg13cmos5l_decap_8
* cell instance sg13cmos5l_decap_8_117 r0 *1 0,0
Xsg13cmos5l_decap_8_117 VPWR VGND sg13cmos5l_decap_8
* cell instance sg13cmos5l_decap_8_118 r0 *1 0,0
Xsg13cmos5l_decap_8_118 VPWR VGND sg13cmos5l_decap_8
* cell instance sg13cmos5l_decap_8_119 r0 *1 0,0
Xsg13cmos5l_decap_8_119 VPWR VGND sg13cmos5l_decap_8
* cell instance sg13cmos5l_decap_8_120 r0 *1 0,0
Xsg13cmos5l_decap_8_120 VPWR VGND sg13cmos5l_decap_8
* cell instance sg13cmos5l_decap_8_121 r0 *1 0,0
Xsg13cmos5l_decap_8_121 VPWR VGND sg13cmos5l_decap_8
* cell instance sg13cmos5l_decap_8_122 r0 *1 0,0
Xsg13cmos5l_decap_8_122 VPWR VGND sg13cmos5l_decap_8
* cell instance sg13cmos5l_decap_8_123 r0 *1 0,0
Xsg13cmos5l_decap_8_123 VPWR VGND sg13cmos5l_decap_8
* cell instance sg13cmos5l_decap_8_124 r0 *1 0,0
Xsg13cmos5l_decap_8_124 VPWR VGND sg13cmos5l_decap_8
* cell instance sg13cmos5l_decap_8_125 r0 *1 0,0
Xsg13cmos5l_decap_8_125 VPWR VGND sg13cmos5l_decap_8
* cell instance sg13cmos5l_decap_8_126 r0 *1 0,0
Xsg13cmos5l_decap_8_126 VPWR VGND sg13cmos5l_decap_8
* cell instance sg13cmos5l_decap_8_127 r0 *1 0,0
Xsg13cmos5l_decap_8_127 VPWR VGND sg13cmos5l_decap_8
* cell instance sg13cmos5l_decap_8_128 r0 *1 0,0
Xsg13cmos5l_decap_8_128 VPWR VGND sg13cmos5l_decap_8
* cell instance sg13cmos5l_decap_8_129 r0 *1 0,0
Xsg13cmos5l_decap_8_129 VPWR VGND sg13cmos5l_decap_8
* cell instance sg13cmos5l_decap_8_130 r0 *1 0,0
Xsg13cmos5l_decap_8_130 VPWR VGND sg13cmos5l_decap_8
* cell instance sg13cmos5l_decap_8_131 r0 *1 0,0
Xsg13cmos5l_decap_8_131 VPWR VGND sg13cmos5l_decap_8
* cell instance sg13cmos5l_decap_8_132 r0 *1 0,0
Xsg13cmos5l_decap_8_132 VPWR VGND sg13cmos5l_decap_8
* cell instance sg13cmos5l_decap_8_133 r0 *1 0,0
Xsg13cmos5l_decap_8_133 VPWR VGND sg13cmos5l_decap_8
* cell instance sg13cmos5l_decap_8_134 r0 *1 0,0
Xsg13cmos5l_decap_8_134 VPWR VGND sg13cmos5l_decap_8
* cell instance sg13cmos5l_decap_8_135 r0 *1 0,0
Xsg13cmos5l_decap_8_135 VPWR VGND sg13cmos5l_decap_8
* cell instance sg13cmos5l_decap_8_136 r0 *1 0,0
Xsg13cmos5l_decap_8_136 VPWR VGND sg13cmos5l_decap_8
* cell instance sg13cmos5l_decap_8_137 r0 *1 0,0
Xsg13cmos5l_decap_8_137 VPWR VGND sg13cmos5l_decap_8
* cell instance sg13cmos5l_decap_8_138 r0 *1 0,0
Xsg13cmos5l_decap_8_138 VPWR VGND sg13cmos5l_decap_8
* cell instance sg13cmos5l_decap_8_139 r0 *1 0,0
Xsg13cmos5l_decap_8_139 VPWR VGND sg13cmos5l_decap_8
* cell instance sg13cmos5l_decap_8_140 r0 *1 0,0
Xsg13cmos5l_decap_8_140 VPWR VGND sg13cmos5l_decap_8
* cell instance sg13cmos5l_decap_8_141 r0 *1 0,0
Xsg13cmos5l_decap_8_141 VPWR VGND sg13cmos5l_decap_8
* cell instance sg13cmos5l_decap_8_142 r0 *1 0,0
Xsg13cmos5l_decap_8_142 VPWR VGND sg13cmos5l_decap_8
* cell instance sg13cmos5l_decap_8_143 r0 *1 0,0
Xsg13cmos5l_decap_8_143 VPWR VGND sg13cmos5l_decap_8
* cell instance sg13cmos5l_decap_8_144 r0 *1 0,0
Xsg13cmos5l_decap_8_144 VPWR VGND sg13cmos5l_decap_8
* cell instance sg13cmos5l_decap_8_145 r0 *1 0,0
Xsg13cmos5l_decap_8_145 VPWR VGND sg13cmos5l_decap_8
* cell instance sg13cmos5l_decap_8_146 r0 *1 0,0
Xsg13cmos5l_decap_8_146 VPWR VGND sg13cmos5l_decap_8
* cell instance sg13cmos5l_decap_8_147 r0 *1 0,0
Xsg13cmos5l_decap_8_147 VPWR VGND sg13cmos5l_decap_8
* cell instance sg13cmos5l_decap_8_148 r0 *1 0,0
Xsg13cmos5l_decap_8_148 VPWR VGND sg13cmos5l_decap_8
* cell instance sg13cmos5l_decap_8_149 r0 *1 0,0
Xsg13cmos5l_decap_8_149 VPWR VGND sg13cmos5l_decap_8
* cell instance sg13cmos5l_decap_8_150 r0 *1 0,0
Xsg13cmos5l_decap_8_150 VPWR VGND sg13cmos5l_decap_8
* cell instance sg13cmos5l_decap_8_151 r0 *1 0,0
Xsg13cmos5l_decap_8_151 VPWR VGND sg13cmos5l_decap_8
* cell instance sg13cmos5l_decap_8_152 r0 *1 0,0
Xsg13cmos5l_decap_8_152 VPWR VGND sg13cmos5l_decap_8
* cell instance sg13cmos5l_decap_8_153 r0 *1 0,0
Xsg13cmos5l_decap_8_153 VPWR VGND sg13cmos5l_decap_8
* cell instance sg13cmos5l_decap_8_154 r0 *1 0,0
Xsg13cmos5l_decap_8_154 VPWR VGND sg13cmos5l_decap_8
* cell instance sg13cmos5l_decap_8_155 r0 *1 0,0
Xsg13cmos5l_decap_8_155 VPWR VGND sg13cmos5l_decap_8
* cell instance sg13cmos5l_decap_8_156 r0 *1 0,0
Xsg13cmos5l_decap_8_156 VPWR VGND sg13cmos5l_decap_8
* cell instance sg13cmos5l_decap_8_157 r0 *1 0,0
Xsg13cmos5l_decap_8_157 VPWR VGND sg13cmos5l_decap_8
* cell instance sg13cmos5l_decap_8_158 r0 *1 0,0
Xsg13cmos5l_decap_8_158 VPWR VGND sg13cmos5l_decap_8
* cell instance sg13cmos5l_decap_8_159 r0 *1 0,0
Xsg13cmos5l_decap_8_159 VPWR VGND sg13cmos5l_decap_8
* cell instance sg13cmos5l_decap_8_160 r0 *1 0,0
Xsg13cmos5l_decap_8_160 VPWR VGND sg13cmos5l_decap_8
* cell instance sg13cmos5l_decap_8_161 r0 *1 0,0
Xsg13cmos5l_decap_8_161 VPWR VGND sg13cmos5l_decap_8
* cell instance sg13cmos5l_decap_8_162 r0 *1 0,0
Xsg13cmos5l_decap_8_162 VPWR VGND sg13cmos5l_decap_8
* cell instance sg13cmos5l_decap_8_163 r0 *1 0,0
Xsg13cmos5l_decap_8_163 VPWR VGND sg13cmos5l_decap_8
* cell instance sg13cmos5l_decap_8_164 r0 *1 0,0
Xsg13cmos5l_decap_8_164 VPWR VGND sg13cmos5l_decap_8
* cell instance sg13cmos5l_decap_8_165 r0 *1 0,0
Xsg13cmos5l_decap_8_165 VPWR VGND sg13cmos5l_decap_8
* cell instance sg13cmos5l_decap_8_166 r0 *1 0,0
Xsg13cmos5l_decap_8_166 VPWR VGND sg13cmos5l_decap_8
* cell instance sg13cmos5l_decap_8_167 r0 *1 0,0
Xsg13cmos5l_decap_8_167 VPWR VGND sg13cmos5l_decap_8
* cell instance sg13cmos5l_decap_8_168 r0 *1 0,0
Xsg13cmos5l_decap_8_168 VPWR VGND sg13cmos5l_decap_8
* cell instance sg13cmos5l_decap_8_169 r0 *1 0,0
Xsg13cmos5l_decap_8_169 VPWR VGND sg13cmos5l_decap_8
* cell instance sg13cmos5l_decap_8_170 r0 *1 0,0
Xsg13cmos5l_decap_8_170 VPWR VGND sg13cmos5l_decap_8
* cell instance sg13cmos5l_decap_8_171 r0 *1 0,0
Xsg13cmos5l_decap_8_171 VPWR VGND sg13cmos5l_decap_8
* cell instance sg13cmos5l_decap_8_172 r0 *1 0,0
Xsg13cmos5l_decap_8_172 VPWR VGND sg13cmos5l_decap_8
* cell instance sg13cmos5l_decap_8_173 r0 *1 0,0
Xsg13cmos5l_decap_8_173 VPWR VGND sg13cmos5l_decap_8
* cell instance sg13cmos5l_decap_8_174 r0 *1 0,0
Xsg13cmos5l_decap_8_174 VPWR VGND sg13cmos5l_decap_8
* cell instance sg13cmos5l_decap_8_175 r0 *1 0,0
Xsg13cmos5l_decap_8_175 VPWR VGND sg13cmos5l_decap_8
* cell instance sg13cmos5l_decap_8_176 r0 *1 0,0
Xsg13cmos5l_decap_8_176 VPWR VGND sg13cmos5l_decap_8
* cell instance sg13cmos5l_decap_8_177 r0 *1 0,0
Xsg13cmos5l_decap_8_177 VPWR VGND sg13cmos5l_decap_8
* cell instance sg13cmos5l_decap_8_178 r0 *1 0,0
Xsg13cmos5l_decap_8_178 VPWR VGND sg13cmos5l_decap_8
* cell instance sg13cmos5l_decap_8_179 r0 *1 0,0
Xsg13cmos5l_decap_8_179 VPWR VGND sg13cmos5l_decap_8
* cell instance sg13cmos5l_decap_8_180 r0 *1 0,0
Xsg13cmos5l_decap_8_180 VPWR VGND sg13cmos5l_decap_8
* cell instance sg13cmos5l_decap_8_181 r0 *1 0,0
Xsg13cmos5l_decap_8_181 VPWR VGND sg13cmos5l_decap_8
* cell instance sg13cmos5l_decap_8_182 r0 *1 0,0
Xsg13cmos5l_decap_8_182 VPWR VGND sg13cmos5l_decap_8
* cell instance sg13cmos5l_decap_8_183 r0 *1 0,0
Xsg13cmos5l_decap_8_183 VPWR VGND sg13cmos5l_decap_8
* cell instance sg13cmos5l_decap_8_184 r0 *1 0,0
Xsg13cmos5l_decap_8_184 VPWR VGND sg13cmos5l_decap_8
* cell instance sg13cmos5l_decap_8_185 r0 *1 0,0
Xsg13cmos5l_decap_8_185 VPWR VGND sg13cmos5l_decap_8
* cell instance sg13cmos5l_decap_8_186 r0 *1 0,0
Xsg13cmos5l_decap_8_186 VPWR VGND sg13cmos5l_decap_8
* cell instance sg13cmos5l_decap_8_187 r0 *1 0,0
Xsg13cmos5l_decap_8_187 VPWR VGND sg13cmos5l_decap_8
* cell instance sg13cmos5l_decap_8_188 r0 *1 0,0
Xsg13cmos5l_decap_8_188 VPWR VGND sg13cmos5l_decap_8
* cell instance sg13cmos5l_decap_8_189 r0 *1 0,0
Xsg13cmos5l_decap_8_189 VPWR VGND sg13cmos5l_decap_8
* cell instance sg13cmos5l_decap_8_190 r0 *1 0,0
Xsg13cmos5l_decap_8_190 VPWR VGND sg13cmos5l_decap_8
* cell instance sg13cmos5l_decap_8_191 r0 *1 0,0
Xsg13cmos5l_decap_8_191 VPWR VGND sg13cmos5l_decap_8
* cell instance sg13cmos5l_decap_8_192 r0 *1 0,0
Xsg13cmos5l_decap_8_192 VPWR VGND sg13cmos5l_decap_8
* cell instance sg13cmos5l_decap_8_193 r0 *1 0,0
Xsg13cmos5l_decap_8_193 VPWR VGND sg13cmos5l_decap_8
* cell instance sg13cmos5l_decap_8_194 r0 *1 0,0
Xsg13cmos5l_decap_8_194 VPWR VGND sg13cmos5l_decap_8
* cell instance sg13cmos5l_decap_8_195 r0 *1 0,0
Xsg13cmos5l_decap_8_195 VPWR VGND sg13cmos5l_decap_8
* cell instance sg13cmos5l_decap_8_196 r0 *1 0,0
Xsg13cmos5l_decap_8_196 VPWR VGND sg13cmos5l_decap_8
* cell instance sg13cmos5l_decap_8_197 r0 *1 0,0
Xsg13cmos5l_decap_8_197 VPWR VGND sg13cmos5l_decap_8
* cell instance sg13cmos5l_decap_8_198 r0 *1 0,0
Xsg13cmos5l_decap_8_198 VPWR VGND sg13cmos5l_decap_8
* cell instance sg13cmos5l_decap_8_199 r0 *1 0,0
Xsg13cmos5l_decap_8_199 VPWR VGND sg13cmos5l_decap_8
* cell instance sg13cmos5l_decap_8_200 r0 *1 0,0
Xsg13cmos5l_decap_8_200 VPWR VGND sg13cmos5l_decap_8
* cell instance sg13cmos5l_decap_8_201 r0 *1 0,0
Xsg13cmos5l_decap_8_201 VPWR VGND sg13cmos5l_decap_8
* cell instance sg13cmos5l_decap_8_202 r0 *1 0,0
Xsg13cmos5l_decap_8_202 VPWR VGND sg13cmos5l_decap_8
* cell instance sg13cmos5l_decap_8_203 r0 *1 0,0
Xsg13cmos5l_decap_8_203 VPWR VGND sg13cmos5l_decap_8
* cell instance sg13cmos5l_decap_8_204 r0 *1 0,0
Xsg13cmos5l_decap_8_204 VPWR VGND sg13cmos5l_decap_8
* cell instance sg13cmos5l_decap_8_205 r0 *1 0,0
Xsg13cmos5l_decap_8_205 VPWR VGND sg13cmos5l_decap_8
* cell instance sg13cmos5l_decap_8_206 r0 *1 0,0
Xsg13cmos5l_decap_8_206 VPWR VGND sg13cmos5l_decap_8
* cell instance sg13cmos5l_decap_8_207 r0 *1 0,0
Xsg13cmos5l_decap_8_207 VPWR VGND sg13cmos5l_decap_8
* cell instance sg13cmos5l_decap_8_208 r0 *1 0,0
Xsg13cmos5l_decap_8_208 VPWR VGND sg13cmos5l_decap_8
* cell instance sg13cmos5l_decap_8_209 r0 *1 0,0
Xsg13cmos5l_decap_8_209 VPWR VGND sg13cmos5l_decap_8
* cell instance sg13cmos5l_decap_8_210 r0 *1 0,0
Xsg13cmos5l_decap_8_210 VPWR VGND sg13cmos5l_decap_8
* cell instance sg13cmos5l_decap_8_211 r0 *1 0,0
Xsg13cmos5l_decap_8_211 VPWR VGND sg13cmos5l_decap_8
* cell instance sg13cmos5l_decap_8_212 r0 *1 0,0
Xsg13cmos5l_decap_8_212 VPWR VGND sg13cmos5l_decap_8
* cell instance sg13cmos5l_decap_8_213 r0 *1 0,0
Xsg13cmos5l_decap_8_213 VPWR VGND sg13cmos5l_decap_8
* cell instance sg13cmos5l_decap_8_214 r0 *1 0,0
Xsg13cmos5l_decap_8_214 VPWR VGND sg13cmos5l_decap_8
* cell instance sg13cmos5l_decap_8_215 r0 *1 0,0
Xsg13cmos5l_decap_8_215 VPWR VGND sg13cmos5l_decap_8
* cell instance sg13cmos5l_decap_8_216 r0 *1 0,0
Xsg13cmos5l_decap_8_216 VPWR VGND sg13cmos5l_decap_8
* cell instance sg13cmos5l_decap_8_217 r0 *1 0,0
Xsg13cmos5l_decap_8_217 VPWR VGND sg13cmos5l_decap_8
* cell instance sg13cmos5l_decap_8_218 r0 *1 0,0
Xsg13cmos5l_decap_8_218 VPWR VGND sg13cmos5l_decap_8
* cell instance sg13cmos5l_decap_8_219 r0 *1 0,0
Xsg13cmos5l_decap_8_219 VPWR VGND sg13cmos5l_decap_8
* cell instance sg13cmos5l_decap_8_220 r0 *1 0,0
Xsg13cmos5l_decap_8_220 VPWR VGND sg13cmos5l_decap_8
* cell instance sg13cmos5l_decap_8_221 r0 *1 0,0
Xsg13cmos5l_decap_8_221 VPWR VGND sg13cmos5l_decap_8
* cell instance sg13cmos5l_decap_8_222 r0 *1 0,0
Xsg13cmos5l_decap_8_222 VPWR VGND sg13cmos5l_decap_8
* cell instance sg13cmos5l_decap_8_223 r0 *1 0,0
Xsg13cmos5l_decap_8_223 VPWR VGND sg13cmos5l_decap_8
* cell instance sg13cmos5l_decap_8_224 r0 *1 0,0
Xsg13cmos5l_decap_8_224 VPWR VGND sg13cmos5l_decap_8
* cell instance sg13cmos5l_decap_8_225 r0 *1 0,0
Xsg13cmos5l_decap_8_225 VPWR VGND sg13cmos5l_decap_8
* cell instance sg13cmos5l_decap_8_226 r0 *1 0,0
Xsg13cmos5l_decap_8_226 VPWR VGND sg13cmos5l_decap_8
* cell instance sg13cmos5l_decap_8_227 r0 *1 0,0
Xsg13cmos5l_decap_8_227 VPWR VGND sg13cmos5l_decap_8
* cell instance sg13cmos5l_decap_8_228 r0 *1 0,0
Xsg13cmos5l_decap_8_228 VPWR VGND sg13cmos5l_decap_8
* cell instance sg13cmos5l_decap_8_229 r0 *1 0,0
Xsg13cmos5l_decap_8_229 VPWR VGND sg13cmos5l_decap_8
* cell instance sg13cmos5l_decap_8_230 r0 *1 0,0
Xsg13cmos5l_decap_8_230 VPWR VGND sg13cmos5l_decap_8
* cell instance sg13cmos5l_decap_8_231 r0 *1 0,0
Xsg13cmos5l_decap_8_231 VPWR VGND sg13cmos5l_decap_8
* cell instance sg13cmos5l_decap_8_232 r0 *1 0,0
Xsg13cmos5l_decap_8_232 VPWR VGND sg13cmos5l_decap_8
* cell instance sg13cmos5l_decap_8_233 r0 *1 0,0
Xsg13cmos5l_decap_8_233 VPWR VGND sg13cmos5l_decap_8
* cell instance sg13cmos5l_decap_8_234 r0 *1 0,0
Xsg13cmos5l_decap_8_234 VPWR VGND sg13cmos5l_decap_8
* cell instance sg13cmos5l_decap_8_235 r0 *1 0,0
Xsg13cmos5l_decap_8_235 VPWR VGND sg13cmos5l_decap_8
* cell instance sg13cmos5l_decap_8_236 r0 *1 0,0
Xsg13cmos5l_decap_8_236 VPWR VGND sg13cmos5l_decap_8
* cell instance sg13cmos5l_decap_8_237 r0 *1 0,0
Xsg13cmos5l_decap_8_237 VPWR VGND sg13cmos5l_decap_8
* cell instance sg13cmos5l_decap_8_238 r0 *1 0,0
Xsg13cmos5l_decap_8_238 VPWR VGND sg13cmos5l_decap_8
* cell instance sg13cmos5l_decap_8_239 r0 *1 0,0
Xsg13cmos5l_decap_8_239 VPWR VGND sg13cmos5l_decap_8
* cell instance sg13cmos5l_decap_8_240 r0 *1 0,0
Xsg13cmos5l_decap_8_240 VPWR VGND sg13cmos5l_decap_8
* cell instance sg13cmos5l_decap_8_241 r0 *1 0,0
Xsg13cmos5l_decap_8_241 VPWR VGND sg13cmos5l_decap_8
* cell instance sg13cmos5l_decap_8_242 r0 *1 0,0
Xsg13cmos5l_decap_8_242 VPWR VGND sg13cmos5l_decap_8
* cell instance sg13cmos5l_decap_8_243 r0 *1 0,0
Xsg13cmos5l_decap_8_243 VPWR VGND sg13cmos5l_decap_8
* cell instance sg13cmos5l_decap_8_244 r0 *1 0,0
Xsg13cmos5l_decap_8_244 VPWR VGND sg13cmos5l_decap_8
* cell instance sg13cmos5l_decap_8_245 r0 *1 0,0
Xsg13cmos5l_decap_8_245 VPWR VGND sg13cmos5l_decap_8
* cell instance sg13cmos5l_decap_8_246 r0 *1 0,0
Xsg13cmos5l_decap_8_246 VPWR VGND sg13cmos5l_decap_8
* cell instance sg13cmos5l_decap_8_247 r0 *1 0,0
Xsg13cmos5l_decap_8_247 VPWR VGND sg13cmos5l_decap_8
* cell instance sg13cmos5l_decap_8_248 r0 *1 0,0
Xsg13cmos5l_decap_8_248 VPWR VGND sg13cmos5l_decap_8
* cell instance sg13cmos5l_decap_8_249 r0 *1 0,0
Xsg13cmos5l_decap_8_249 VPWR VGND sg13cmos5l_decap_8
* cell instance sg13cmos5l_decap_8_250 r0 *1 0,0
Xsg13cmos5l_decap_8_250 VPWR VGND sg13cmos5l_decap_8
* cell instance sg13cmos5l_decap_8_251 r0 *1 0,0
Xsg13cmos5l_decap_8_251 VPWR VGND sg13cmos5l_decap_8
* cell instance sg13cmos5l_decap_8_252 r0 *1 0,0
Xsg13cmos5l_decap_8_252 VPWR VGND sg13cmos5l_decap_8
* cell instance sg13cmos5l_decap_8_253 r0 *1 0,0
Xsg13cmos5l_decap_8_253 VPWR VGND sg13cmos5l_decap_8
* cell instance sg13cmos5l_decap_8_254 r0 *1 0,0
Xsg13cmos5l_decap_8_254 VPWR VGND sg13cmos5l_decap_8
* cell instance sg13cmos5l_decap_8_255 r0 *1 0,0
Xsg13cmos5l_decap_8_255 VPWR VGND sg13cmos5l_decap_8
* cell instance sg13cmos5l_decap_8_256 r0 *1 0,0
Xsg13cmos5l_decap_8_256 VPWR VGND sg13cmos5l_decap_8
* cell instance sg13cmos5l_decap_8_257 r0 *1 0,0
Xsg13cmos5l_decap_8_257 VPWR VGND sg13cmos5l_decap_8
* cell instance sg13cmos5l_decap_8_258 r0 *1 0,0
Xsg13cmos5l_decap_8_258 VPWR VGND sg13cmos5l_decap_8
* cell instance sg13cmos5l_decap_8_259 r0 *1 0,0
Xsg13cmos5l_decap_8_259 VPWR VGND sg13cmos5l_decap_8
* cell instance sg13cmos5l_decap_8_260 r0 *1 0,0
Xsg13cmos5l_decap_8_260 VPWR VGND sg13cmos5l_decap_8
* cell instance sg13cmos5l_decap_8_261 r0 *1 0,0
Xsg13cmos5l_decap_8_261 VPWR VGND sg13cmos5l_decap_8
* cell instance sg13cmos5l_decap_8_262 r0 *1 0,0
Xsg13cmos5l_decap_8_262 VPWR VGND sg13cmos5l_decap_8
* cell instance sg13cmos5l_decap_8_263 r0 *1 0,0
Xsg13cmos5l_decap_8_263 VPWR VGND sg13cmos5l_decap_8
* cell instance sg13cmos5l_decap_8_264 r0 *1 0,0
Xsg13cmos5l_decap_8_264 VPWR VGND sg13cmos5l_decap_8
* cell instance sg13cmos5l_decap_8_265 r0 *1 0,0
Xsg13cmos5l_decap_8_265 VPWR VGND sg13cmos5l_decap_8
* cell instance sg13cmos5l_decap_8_266 r0 *1 0,0
Xsg13cmos5l_decap_8_266 VPWR VGND sg13cmos5l_decap_8
* cell instance sg13cmos5l_decap_8_267 r0 *1 0,0
Xsg13cmos5l_decap_8_267 VPWR VGND sg13cmos5l_decap_8
* cell instance sg13cmos5l_decap_8_268 r0 *1 0,0
Xsg13cmos5l_decap_8_268 VPWR VGND sg13cmos5l_decap_8
* cell instance sg13cmos5l_decap_8_269 r0 *1 0,0
Xsg13cmos5l_decap_8_269 VPWR VGND sg13cmos5l_decap_8
* cell instance sg13cmos5l_decap_8_270 r0 *1 0,0
Xsg13cmos5l_decap_8_270 VPWR VGND sg13cmos5l_decap_8
* cell instance sg13cmos5l_decap_8_271 r0 *1 0,0
Xsg13cmos5l_decap_8_271 VPWR VGND sg13cmos5l_decap_8
* cell instance sg13cmos5l_decap_8_272 r0 *1 0,0
Xsg13cmos5l_decap_8_272 VPWR VGND sg13cmos5l_decap_8
* cell instance sg13cmos5l_decap_8_273 r0 *1 0,0
Xsg13cmos5l_decap_8_273 VPWR VGND sg13cmos5l_decap_8
* cell instance sg13cmos5l_decap_8_274 r0 *1 0,0
Xsg13cmos5l_decap_8_274 VPWR VGND sg13cmos5l_decap_8
* cell instance sg13cmos5l_decap_8_275 r0 *1 0,0
Xsg13cmos5l_decap_8_275 VPWR VGND sg13cmos5l_decap_8
* cell instance sg13cmos5l_decap_8_276 r0 *1 0,0
Xsg13cmos5l_decap_8_276 VPWR VGND sg13cmos5l_decap_8
* cell instance sg13cmos5l_decap_8_277 r0 *1 0,0
Xsg13cmos5l_decap_8_277 VPWR VGND sg13cmos5l_decap_8
* cell instance sg13cmos5l_decap_8_278 r0 *1 0,0
Xsg13cmos5l_decap_8_278 VPWR VGND sg13cmos5l_decap_8
* cell instance sg13cmos5l_decap_8_279 r0 *1 0,0
Xsg13cmos5l_decap_8_279 VPWR VGND sg13cmos5l_decap_8
* cell instance sg13cmos5l_decap_8_280 r0 *1 0,0
Xsg13cmos5l_decap_8_280 VPWR VGND sg13cmos5l_decap_8
* cell instance sg13cmos5l_decap_8_281 r0 *1 0,0
Xsg13cmos5l_decap_8_281 VPWR VGND sg13cmos5l_decap_8
* cell instance sg13cmos5l_decap_8_282 r0 *1 0,0
Xsg13cmos5l_decap_8_282 VPWR VGND sg13cmos5l_decap_8
* cell instance sg13cmos5l_decap_8_283 r0 *1 0,0
Xsg13cmos5l_decap_8_283 VPWR VGND sg13cmos5l_decap_8
* cell instance sg13cmos5l_decap_8_284 r0 *1 0,0
Xsg13cmos5l_decap_8_284 VPWR VGND sg13cmos5l_decap_8
* cell instance sg13cmos5l_decap_8_285 r0 *1 0,0
Xsg13cmos5l_decap_8_285 VPWR VGND sg13cmos5l_decap_8
* cell instance sg13cmos5l_decap_8_286 r0 *1 0,0
Xsg13cmos5l_decap_8_286 VPWR VGND sg13cmos5l_decap_8
* cell instance sg13cmos5l_decap_8_287 r0 *1 0,0
Xsg13cmos5l_decap_8_287 VPWR VGND sg13cmos5l_decap_8
* cell instance sg13cmos5l_decap_8_288 r0 *1 0,0
Xsg13cmos5l_decap_8_288 VPWR VGND sg13cmos5l_decap_8
* cell instance sg13cmos5l_decap_8_289 r0 *1 0,0
Xsg13cmos5l_decap_8_289 VPWR VGND sg13cmos5l_decap_8
* cell instance sg13cmos5l_decap_8_290 r0 *1 0,0
Xsg13cmos5l_decap_8_290 VPWR VGND sg13cmos5l_decap_8
* cell instance sg13cmos5l_decap_8_291 r0 *1 0,0
Xsg13cmos5l_decap_8_291 VPWR VGND sg13cmos5l_decap_8
* cell instance sg13cmos5l_decap_8_292 r0 *1 0,0
Xsg13cmos5l_decap_8_292 VPWR VGND sg13cmos5l_decap_8
* cell instance sg13cmos5l_decap_8_293 r0 *1 0,0
Xsg13cmos5l_decap_8_293 VPWR VGND sg13cmos5l_decap_8
* cell instance sg13cmos5l_decap_8_294 r0 *1 0,0
Xsg13cmos5l_decap_8_294 VPWR VGND sg13cmos5l_decap_8
* cell instance sg13cmos5l_decap_8_295 r0 *1 0,0
Xsg13cmos5l_decap_8_295 VPWR VGND sg13cmos5l_decap_8
* cell instance sg13cmos5l_decap_8_296 r0 *1 0,0
Xsg13cmos5l_decap_8_296 VPWR VGND sg13cmos5l_decap_8
* cell instance sg13cmos5l_decap_8_297 r0 *1 0,0
Xsg13cmos5l_decap_8_297 VPWR VGND sg13cmos5l_decap_8
* cell instance sg13cmos5l_decap_8_298 r0 *1 0,0
Xsg13cmos5l_decap_8_298 VPWR VGND sg13cmos5l_decap_8
* cell instance sg13cmos5l_decap_8_299 r0 *1 0,0
Xsg13cmos5l_decap_8_299 VPWR VGND sg13cmos5l_decap_8
* cell instance sg13cmos5l_decap_8_300 r0 *1 0,0
Xsg13cmos5l_decap_8_300 VPWR VGND sg13cmos5l_decap_8
* cell instance sg13cmos5l_decap_8_301 r0 *1 0,0
Xsg13cmos5l_decap_8_301 VPWR VGND sg13cmos5l_decap_8
* cell instance sg13cmos5l_decap_8_302 r0 *1 0,0
Xsg13cmos5l_decap_8_302 VPWR VGND sg13cmos5l_decap_8
* cell instance sg13cmos5l_decap_8_303 r0 *1 0,0
Xsg13cmos5l_decap_8_303 VPWR VGND sg13cmos5l_decap_8
* cell instance sg13cmos5l_decap_8_304 r0 *1 0,0
Xsg13cmos5l_decap_8_304 VPWR VGND sg13cmos5l_decap_8
* cell instance sg13cmos5l_decap_8_305 r0 *1 0,0
Xsg13cmos5l_decap_8_305 VPWR VGND sg13cmos5l_decap_8
* cell instance sg13cmos5l_decap_8_306 r0 *1 0,0
Xsg13cmos5l_decap_8_306 VPWR VGND sg13cmos5l_decap_8
* cell instance sg13cmos5l_decap_8_307 r0 *1 0,0
Xsg13cmos5l_decap_8_307 VPWR VGND sg13cmos5l_decap_8
* cell instance sg13cmos5l_decap_8_308 r0 *1 0,0
Xsg13cmos5l_decap_8_308 VPWR VGND sg13cmos5l_decap_8
* cell instance sg13cmos5l_decap_8_309 r0 *1 0,0
Xsg13cmos5l_decap_8_309 VPWR VGND sg13cmos5l_decap_8
* cell instance sg13cmos5l_decap_8_310 r0 *1 0,0
Xsg13cmos5l_decap_8_310 VPWR VGND sg13cmos5l_decap_8
* cell instance sg13cmos5l_decap_8_311 r0 *1 0,0
Xsg13cmos5l_decap_8_311 VPWR VGND sg13cmos5l_decap_8
* cell instance sg13cmos5l_decap_8_312 r0 *1 0,0
Xsg13cmos5l_decap_8_312 VPWR VGND sg13cmos5l_decap_8
* cell instance sg13cmos5l_decap_8_313 r0 *1 0,0
Xsg13cmos5l_decap_8_313 VPWR VGND sg13cmos5l_decap_8
* cell instance sg13cmos5l_decap_8_314 r0 *1 0,0
Xsg13cmos5l_decap_8_314 VPWR VGND sg13cmos5l_decap_8
* cell instance sg13cmos5l_decap_8_315 r0 *1 0,0
Xsg13cmos5l_decap_8_315 VPWR VGND sg13cmos5l_decap_8
* cell instance sg13cmos5l_decap_8_316 r0 *1 0,0
Xsg13cmos5l_decap_8_316 VPWR VGND sg13cmos5l_decap_8
* cell instance sg13cmos5l_decap_8_317 r0 *1 0,0
Xsg13cmos5l_decap_8_317 VPWR VGND sg13cmos5l_decap_8
* cell instance sg13cmos5l_decap_8_318 r0 *1 0,0
Xsg13cmos5l_decap_8_318 VPWR VGND sg13cmos5l_decap_8
* cell instance sg13cmos5l_decap_8_319 r0 *1 0,0
Xsg13cmos5l_decap_8_319 VPWR VGND sg13cmos5l_decap_8
* cell instance sg13cmos5l_decap_8_320 r0 *1 0,0
Xsg13cmos5l_decap_8_320 VPWR VGND sg13cmos5l_decap_8
* cell instance sg13cmos5l_decap_8_321 r0 *1 0,0
Xsg13cmos5l_decap_8_321 VPWR VGND sg13cmos5l_decap_8
* cell instance sg13cmos5l_decap_8_322 r0 *1 0,0
Xsg13cmos5l_decap_8_322 VPWR VGND sg13cmos5l_decap_8
* cell instance sg13cmos5l_decap_8_323 r0 *1 0,0
Xsg13cmos5l_decap_8_323 VPWR VGND sg13cmos5l_decap_8
* cell instance sg13cmos5l_decap_8_324 r0 *1 0,0
Xsg13cmos5l_decap_8_324 VPWR VGND sg13cmos5l_decap_8
* cell instance sg13cmos5l_decap_8_325 r0 *1 0,0
Xsg13cmos5l_decap_8_325 VPWR VGND sg13cmos5l_decap_8
* cell instance sg13cmos5l_decap_8_326 r0 *1 0,0
Xsg13cmos5l_decap_8_326 VPWR VGND sg13cmos5l_decap_8
* cell instance sg13cmos5l_decap_8_327 r0 *1 0,0
Xsg13cmos5l_decap_8_327 VPWR VGND sg13cmos5l_decap_8
* cell instance sg13cmos5l_decap_8_328 r0 *1 0,0
Xsg13cmos5l_decap_8_328 VPWR VGND sg13cmos5l_decap_8
* cell instance sg13cmos5l_decap_8_329 r0 *1 0,0
Xsg13cmos5l_decap_8_329 VPWR VGND sg13cmos5l_decap_8
* cell instance sg13cmos5l_decap_8_330 r0 *1 0,0
Xsg13cmos5l_decap_8_330 VPWR VGND sg13cmos5l_decap_8
* cell instance sg13cmos5l_decap_8_331 r0 *1 0,0
Xsg13cmos5l_decap_8_331 VPWR VGND sg13cmos5l_decap_8
* cell instance sg13cmos5l_decap_8_332 r0 *1 0,0
Xsg13cmos5l_decap_8_332 VPWR VGND sg13cmos5l_decap_8
* cell instance sg13cmos5l_decap_8_333 r0 *1 0,0
Xsg13cmos5l_decap_8_333 VPWR VGND sg13cmos5l_decap_8
* cell instance sg13cmos5l_decap_8_334 r0 *1 0,0
Xsg13cmos5l_decap_8_334 VPWR VGND sg13cmos5l_decap_8
* cell instance sg13cmos5l_decap_8_335 r0 *1 0,0
Xsg13cmos5l_decap_8_335 VPWR VGND sg13cmos5l_decap_8
* cell instance sg13cmos5l_decap_8_336 r0 *1 0,0
Xsg13cmos5l_decap_8_336 VPWR VGND sg13cmos5l_decap_8
* cell instance sg13cmos5l_decap_8_337 r0 *1 0,0
Xsg13cmos5l_decap_8_337 VPWR VGND sg13cmos5l_decap_8
* cell instance sg13cmos5l_decap_8_338 r0 *1 0,0
Xsg13cmos5l_decap_8_338 VPWR VGND sg13cmos5l_decap_8
* cell instance sg13cmos5l_decap_8_339 r0 *1 0,0
Xsg13cmos5l_decap_8_339 VPWR VGND sg13cmos5l_decap_8
* cell instance sg13cmos5l_decap_8_340 r0 *1 0,0
Xsg13cmos5l_decap_8_340 VPWR VGND sg13cmos5l_decap_8
* cell instance sg13cmos5l_decap_8_341 r0 *1 0,0
Xsg13cmos5l_decap_8_341 VPWR VGND sg13cmos5l_decap_8
* cell instance sg13cmos5l_decap_8_342 r0 *1 0,0
Xsg13cmos5l_decap_8_342 VPWR VGND sg13cmos5l_decap_8
* cell instance sg13cmos5l_decap_8_343 r0 *1 0,0
Xsg13cmos5l_decap_8_343 VPWR VGND sg13cmos5l_decap_8
* cell instance sg13cmos5l_decap_8_344 r0 *1 0,0
Xsg13cmos5l_decap_8_344 VPWR VGND sg13cmos5l_decap_8
* cell instance sg13cmos5l_decap_8_345 r0 *1 0,0
Xsg13cmos5l_decap_8_345 VPWR VGND sg13cmos5l_decap_8
* cell instance sg13cmos5l_decap_8_346 r0 *1 0,0
Xsg13cmos5l_decap_8_346 VPWR VGND sg13cmos5l_decap_8
* cell instance sg13cmos5l_decap_8_347 r0 *1 0,0
Xsg13cmos5l_decap_8_347 VPWR VGND sg13cmos5l_decap_8
* cell instance sg13cmos5l_decap_8_348 r0 *1 0,0
Xsg13cmos5l_decap_8_348 VPWR VGND sg13cmos5l_decap_8
* cell instance sg13cmos5l_decap_8_349 r0 *1 0,0
Xsg13cmos5l_decap_8_349 VPWR VGND sg13cmos5l_decap_8
* cell instance sg13cmos5l_decap_8_350 r0 *1 0,0
Xsg13cmos5l_decap_8_350 VPWR VGND sg13cmos5l_decap_8
* cell instance sg13cmos5l_decap_8_351 r0 *1 0,0
Xsg13cmos5l_decap_8_351 VPWR VGND sg13cmos5l_decap_8
* cell instance sg13cmos5l_decap_8_352 r0 *1 0,0
Xsg13cmos5l_decap_8_352 VPWR VGND sg13cmos5l_decap_8
* cell instance sg13cmos5l_decap_8_353 r0 *1 0,0
Xsg13cmos5l_decap_8_353 VPWR VGND sg13cmos5l_decap_8
* cell instance sg13cmos5l_decap_8_354 r0 *1 0,0
Xsg13cmos5l_decap_8_354 VPWR VGND sg13cmos5l_decap_8
* cell instance sg13cmos5l_decap_8_355 r0 *1 0,0
Xsg13cmos5l_decap_8_355 VPWR VGND sg13cmos5l_decap_8
* cell instance sg13cmos5l_decap_8_356 r0 *1 0,0
Xsg13cmos5l_decap_8_356 VPWR VGND sg13cmos5l_decap_8
* cell instance sg13cmos5l_decap_8_357 r0 *1 0,0
Xsg13cmos5l_decap_8_357 VPWR VGND sg13cmos5l_decap_8
* cell instance sg13cmos5l_decap_8_358 r0 *1 0,0
Xsg13cmos5l_decap_8_358 VPWR VGND sg13cmos5l_decap_8
* cell instance sg13cmos5l_decap_8_359 r0 *1 0,0
Xsg13cmos5l_decap_8_359 VPWR VGND sg13cmos5l_decap_8
* cell instance sg13cmos5l_decap_8_360 r0 *1 0,0
Xsg13cmos5l_decap_8_360 VPWR VGND sg13cmos5l_decap_8
* cell instance sg13cmos5l_decap_8_361 r0 *1 0,0
Xsg13cmos5l_decap_8_361 VPWR VGND sg13cmos5l_decap_8
* cell instance sg13cmos5l_decap_8_362 r0 *1 0,0
Xsg13cmos5l_decap_8_362 VPWR VGND sg13cmos5l_decap_8
* cell instance sg13cmos5l_decap_8_363 r0 *1 0,0
Xsg13cmos5l_decap_8_363 VPWR VGND sg13cmos5l_decap_8
* cell instance sg13cmos5l_decap_8_364 r0 *1 0,0
Xsg13cmos5l_decap_8_364 VPWR VGND sg13cmos5l_decap_8
* cell instance sg13cmos5l_decap_8_365 r0 *1 0,0
Xsg13cmos5l_decap_8_365 VPWR VGND sg13cmos5l_decap_8
* cell instance sg13cmos5l_decap_8_366 r0 *1 0,0
Xsg13cmos5l_decap_8_366 VPWR VGND sg13cmos5l_decap_8
* cell instance sg13cmos5l_decap_8_367 r0 *1 0,0
Xsg13cmos5l_decap_8_367 VPWR VGND sg13cmos5l_decap_8
* cell instance sg13cmos5l_decap_8_368 r0 *1 0,0
Xsg13cmos5l_decap_8_368 VPWR VGND sg13cmos5l_decap_8
* cell instance sg13cmos5l_decap_8_369 r0 *1 0,0
Xsg13cmos5l_decap_8_369 VPWR VGND sg13cmos5l_decap_8
* cell instance sg13cmos5l_decap_8_370 r0 *1 0,0
Xsg13cmos5l_decap_8_370 VPWR VGND sg13cmos5l_decap_8
* cell instance sg13cmos5l_decap_8_371 r0 *1 0,0
Xsg13cmos5l_decap_8_371 VPWR VGND sg13cmos5l_decap_8
* cell instance sg13cmos5l_decap_8_372 r0 *1 0,0
Xsg13cmos5l_decap_8_372 VPWR VGND sg13cmos5l_decap_8
* cell instance sg13cmos5l_decap_8_373 r0 *1 0,0
Xsg13cmos5l_decap_8_373 VPWR VGND sg13cmos5l_decap_8
* cell instance sg13cmos5l_decap_8_374 r0 *1 0,0
Xsg13cmos5l_decap_8_374 VPWR VGND sg13cmos5l_decap_8
* cell instance sg13cmos5l_decap_8_375 r0 *1 0,0
Xsg13cmos5l_decap_8_375 VPWR VGND sg13cmos5l_decap_8
* cell instance sg13cmos5l_decap_8_376 r0 *1 0,0
Xsg13cmos5l_decap_8_376 VPWR VGND sg13cmos5l_decap_8
* cell instance sg13cmos5l_decap_8_377 r0 *1 0,0
Xsg13cmos5l_decap_8_377 VPWR VGND sg13cmos5l_decap_8
* cell instance sg13cmos5l_decap_8_378 r0 *1 0,0
Xsg13cmos5l_decap_8_378 VPWR VGND sg13cmos5l_decap_8
* cell instance sg13cmos5l_decap_8_379 r0 *1 0,0
Xsg13cmos5l_decap_8_379 VPWR VGND sg13cmos5l_decap_8
* cell instance sg13cmos5l_decap_8_380 r0 *1 0,0
Xsg13cmos5l_decap_8_380 VPWR VGND sg13cmos5l_decap_8
* cell instance sg13cmos5l_decap_8_381 r0 *1 0,0
Xsg13cmos5l_decap_8_381 VPWR VGND sg13cmos5l_decap_8
* cell instance sg13cmos5l_decap_8_382 r0 *1 0,0
Xsg13cmos5l_decap_8_382 VPWR VGND sg13cmos5l_decap_8
* cell instance sg13cmos5l_decap_8_383 r0 *1 0,0
Xsg13cmos5l_decap_8_383 VPWR VGND sg13cmos5l_decap_8
* cell instance sg13cmos5l_decap_8_384 r0 *1 0,0
Xsg13cmos5l_decap_8_384 VPWR VGND sg13cmos5l_decap_8
* cell instance sg13cmos5l_decap_8_385 r0 *1 0,0
Xsg13cmos5l_decap_8_385 VPWR VGND sg13cmos5l_decap_8
* cell instance sg13cmos5l_decap_8_386 r0 *1 0,0
Xsg13cmos5l_decap_8_386 VPWR VGND sg13cmos5l_decap_8
* cell instance sg13cmos5l_decap_8_387 r0 *1 0,0
Xsg13cmos5l_decap_8_387 VPWR VGND sg13cmos5l_decap_8
* cell instance sg13cmos5l_decap_8_388 r0 *1 0,0
Xsg13cmos5l_decap_8_388 VPWR VGND sg13cmos5l_decap_8
* cell instance sg13cmos5l_decap_8_389 r0 *1 0,0
Xsg13cmos5l_decap_8_389 VPWR VGND sg13cmos5l_decap_8
* cell instance sg13cmos5l_decap_8_390 r0 *1 0,0
Xsg13cmos5l_decap_8_390 VPWR VGND sg13cmos5l_decap_8
* cell instance sg13cmos5l_decap_8_391 r0 *1 0,0
Xsg13cmos5l_decap_8_391 VPWR VGND sg13cmos5l_decap_8
* cell instance sg13cmos5l_decap_8_392 r0 *1 0,0
Xsg13cmos5l_decap_8_392 VPWR VGND sg13cmos5l_decap_8
* cell instance sg13cmos5l_decap_8_393 r0 *1 0,0
Xsg13cmos5l_decap_8_393 VPWR VGND sg13cmos5l_decap_8
* cell instance sg13cmos5l_decap_8_394 r0 *1 0,0
Xsg13cmos5l_decap_8_394 VPWR VGND sg13cmos5l_decap_8
* cell instance sg13cmos5l_decap_8_395 r0 *1 0,0
Xsg13cmos5l_decap_8_395 VPWR VGND sg13cmos5l_decap_8
* cell instance sg13cmos5l_decap_8_396 r0 *1 0,0
Xsg13cmos5l_decap_8_396 VPWR VGND sg13cmos5l_decap_8
* cell instance sg13cmos5l_decap_8_397 r0 *1 0,0
Xsg13cmos5l_decap_8_397 VPWR VGND sg13cmos5l_decap_8
* cell instance sg13cmos5l_decap_8_398 r0 *1 0,0
Xsg13cmos5l_decap_8_398 VPWR VGND sg13cmos5l_decap_8
* cell instance sg13cmos5l_decap_8_399 r0 *1 0,0
Xsg13cmos5l_decap_8_399 VPWR VGND sg13cmos5l_decap_8
* cell instance sg13cmos5l_decap_8_400 r0 *1 0,0
Xsg13cmos5l_decap_8_400 VPWR VGND sg13cmos5l_decap_8
* cell instance sg13cmos5l_decap_8_401 r0 *1 0,0
Xsg13cmos5l_decap_8_401 VPWR VGND sg13cmos5l_decap_8
* cell instance sg13cmos5l_decap_8_402 r0 *1 0,0
Xsg13cmos5l_decap_8_402 VPWR VGND sg13cmos5l_decap_8
* cell instance sg13cmos5l_decap_8_403 r0 *1 0,0
Xsg13cmos5l_decap_8_403 VPWR VGND sg13cmos5l_decap_8
* cell instance sg13cmos5l_decap_8_404 r0 *1 0,0
Xsg13cmos5l_decap_8_404 VPWR VGND sg13cmos5l_decap_8
* cell instance sg13cmos5l_decap_8_405 r0 *1 0,0
Xsg13cmos5l_decap_8_405 VPWR VGND sg13cmos5l_decap_8
* cell instance sg13cmos5l_decap_8_406 r0 *1 0,0
Xsg13cmos5l_decap_8_406 VPWR VGND sg13cmos5l_decap_8
* cell instance sg13cmos5l_decap_8_407 r0 *1 0,0
Xsg13cmos5l_decap_8_407 VPWR VGND sg13cmos5l_decap_8
* cell instance sg13cmos5l_decap_8_408 r0 *1 0,0
Xsg13cmos5l_decap_8_408 VPWR VGND sg13cmos5l_decap_8
* cell instance sg13cmos5l_decap_8_409 r0 *1 0,0
Xsg13cmos5l_decap_8_409 VPWR VGND sg13cmos5l_decap_8
* cell instance sg13cmos5l_decap_8_410 r0 *1 0,0
Xsg13cmos5l_decap_8_410 VPWR VGND sg13cmos5l_decap_8
* cell instance sg13cmos5l_decap_8_411 r0 *1 0,0
Xsg13cmos5l_decap_8_411 VPWR VGND sg13cmos5l_decap_8
* cell instance sg13cmos5l_decap_8_412 r0 *1 0,0
Xsg13cmos5l_decap_8_412 VPWR VGND sg13cmos5l_decap_8
* cell instance sg13cmos5l_decap_8_413 r0 *1 0,0
Xsg13cmos5l_decap_8_413 VPWR VGND sg13cmos5l_decap_8
* cell instance sg13cmos5l_decap_8_414 r0 *1 0,0
Xsg13cmos5l_decap_8_414 VPWR VGND sg13cmos5l_decap_8
* cell instance sg13cmos5l_decap_8_415 r0 *1 0,0
Xsg13cmos5l_decap_8_415 VPWR VGND sg13cmos5l_decap_8
* cell instance sg13cmos5l_decap_8_416 r0 *1 0,0
Xsg13cmos5l_decap_8_416 VPWR VGND sg13cmos5l_decap_8
* cell instance sg13cmos5l_decap_8_417 r0 *1 0,0
Xsg13cmos5l_decap_8_417 VPWR VGND sg13cmos5l_decap_8
* cell instance sg13cmos5l_decap_8_418 r0 *1 0,0
Xsg13cmos5l_decap_8_418 VPWR VGND sg13cmos5l_decap_8
* cell instance sg13cmos5l_decap_8_419 r0 *1 0,0
Xsg13cmos5l_decap_8_419 VPWR VGND sg13cmos5l_decap_8
* cell instance sg13cmos5l_decap_8_420 r0 *1 0,0
Xsg13cmos5l_decap_8_420 VPWR VGND sg13cmos5l_decap_8
* cell instance sg13cmos5l_decap_8_421 r0 *1 0,0
Xsg13cmos5l_decap_8_421 VPWR VGND sg13cmos5l_decap_8
* cell instance sg13cmos5l_decap_8_422 r0 *1 0,0
Xsg13cmos5l_decap_8_422 VPWR VGND sg13cmos5l_decap_8
* cell instance sg13cmos5l_decap_8_423 r0 *1 0,0
Xsg13cmos5l_decap_8_423 VPWR VGND sg13cmos5l_decap_8
* cell instance sg13cmos5l_decap_8_424 r0 *1 0,0
Xsg13cmos5l_decap_8_424 VPWR VGND sg13cmos5l_decap_8
* cell instance sg13cmos5l_decap_8_425 r0 *1 0,0
Xsg13cmos5l_decap_8_425 VPWR VGND sg13cmos5l_decap_8
* cell instance sg13cmos5l_decap_8_426 r0 *1 0,0
Xsg13cmos5l_decap_8_426 VPWR VGND sg13cmos5l_decap_8
* cell instance sg13cmos5l_decap_8_427 r0 *1 0,0
Xsg13cmos5l_decap_8_427 VPWR VGND sg13cmos5l_decap_8
* cell instance sg13cmos5l_decap_8_428 r0 *1 0,0
Xsg13cmos5l_decap_8_428 VPWR VGND sg13cmos5l_decap_8
* cell instance sg13cmos5l_decap_8_429 r0 *1 0,0
Xsg13cmos5l_decap_8_429 VPWR VGND sg13cmos5l_decap_8
* cell instance sg13cmos5l_decap_8_430 r0 *1 0,0
Xsg13cmos5l_decap_8_430 VPWR VGND sg13cmos5l_decap_8
* cell instance sg13cmos5l_decap_8_431 r0 *1 0,0
Xsg13cmos5l_decap_8_431 VPWR VGND sg13cmos5l_decap_8
* cell instance sg13cmos5l_decap_8_432 r0 *1 0,0
Xsg13cmos5l_decap_8_432 VPWR VGND sg13cmos5l_decap_8
* cell instance sg13cmos5l_decap_8_433 r0 *1 0,0
Xsg13cmos5l_decap_8_433 VPWR VGND sg13cmos5l_decap_8
* cell instance sg13cmos5l_decap_8_434 r0 *1 0,0
Xsg13cmos5l_decap_8_434 VPWR VGND sg13cmos5l_decap_8
* cell instance sg13cmos5l_decap_8_435 r0 *1 0,0
Xsg13cmos5l_decap_8_435 VPWR VGND sg13cmos5l_decap_8
* cell instance sg13cmos5l_decap_8_436 r0 *1 0,0
Xsg13cmos5l_decap_8_436 VPWR VGND sg13cmos5l_decap_8
* cell instance sg13cmos5l_decap_8_437 r0 *1 0,0
Xsg13cmos5l_decap_8_437 VPWR VGND sg13cmos5l_decap_8
* cell instance sg13cmos5l_decap_8_438 r0 *1 0,0
Xsg13cmos5l_decap_8_438 VPWR VGND sg13cmos5l_decap_8
* cell instance sg13cmos5l_decap_8_439 r0 *1 0,0
Xsg13cmos5l_decap_8_439 VPWR VGND sg13cmos5l_decap_8
* cell instance sg13cmos5l_decap_8_440 r0 *1 0,0
Xsg13cmos5l_decap_8_440 VPWR VGND sg13cmos5l_decap_8
* cell instance sg13cmos5l_decap_8_441 r0 *1 0,0
Xsg13cmos5l_decap_8_441 VPWR VGND sg13cmos5l_decap_8
* cell instance sg13cmos5l_decap_8_442 r0 *1 0,0
Xsg13cmos5l_decap_8_442 VPWR VGND sg13cmos5l_decap_8
* cell instance sg13cmos5l_decap_8_443 r0 *1 0,0
Xsg13cmos5l_decap_8_443 VPWR VGND sg13cmos5l_decap_8
* cell instance sg13cmos5l_decap_8_444 r0 *1 0,0
Xsg13cmos5l_decap_8_444 VPWR VGND sg13cmos5l_decap_8
* cell instance sg13cmos5l_decap_8_445 r0 *1 0,0
Xsg13cmos5l_decap_8_445 VPWR VGND sg13cmos5l_decap_8
* cell instance sg13cmos5l_decap_8_446 r0 *1 0,0
Xsg13cmos5l_decap_8_446 VPWR VGND sg13cmos5l_decap_8
* cell instance sg13cmos5l_decap_8_447 r0 *1 0,0
Xsg13cmos5l_decap_8_447 VPWR VGND sg13cmos5l_decap_8
* cell instance sg13cmos5l_decap_8_448 r0 *1 0,0
Xsg13cmos5l_decap_8_448 VPWR VGND sg13cmos5l_decap_8
* cell instance sg13cmos5l_decap_8_449 r0 *1 0,0
Xsg13cmos5l_decap_8_449 VPWR VGND sg13cmos5l_decap_8
* cell instance sg13cmos5l_decap_8_450 r0 *1 0,0
Xsg13cmos5l_decap_8_450 VPWR VGND sg13cmos5l_decap_8
* cell instance sg13cmos5l_decap_8_451 r0 *1 0,0
Xsg13cmos5l_decap_8_451 VPWR VGND sg13cmos5l_decap_8
* cell instance sg13cmos5l_decap_8_452 r0 *1 0,0
Xsg13cmos5l_decap_8_452 VPWR VGND sg13cmos5l_decap_8
* cell instance sg13cmos5l_decap_8_453 r0 *1 0,0
Xsg13cmos5l_decap_8_453 VPWR VGND sg13cmos5l_decap_8
* cell instance sg13cmos5l_decap_8_454 r0 *1 0,0
Xsg13cmos5l_decap_8_454 VPWR VGND sg13cmos5l_decap_8
* cell instance sg13cmos5l_decap_8_455 r0 *1 0,0
Xsg13cmos5l_decap_8_455 VPWR VGND sg13cmos5l_decap_8
* cell instance sg13cmos5l_decap_8_456 r0 *1 0,0
Xsg13cmos5l_decap_8_456 VPWR VGND sg13cmos5l_decap_8
* cell instance sg13cmos5l_decap_8_457 r0 *1 0,0
Xsg13cmos5l_decap_8_457 VPWR VGND sg13cmos5l_decap_8
* cell instance sg13cmos5l_decap_8_458 r0 *1 0,0
Xsg13cmos5l_decap_8_458 VPWR VGND sg13cmos5l_decap_8
* cell instance sg13cmos5l_decap_8_459 r0 *1 0,0
Xsg13cmos5l_decap_8_459 VPWR VGND sg13cmos5l_decap_8
* cell instance sg13cmos5l_decap_8_460 r0 *1 0,0
Xsg13cmos5l_decap_8_460 VPWR VGND sg13cmos5l_decap_8
* cell instance sg13cmos5l_decap_8_461 r0 *1 0,0
Xsg13cmos5l_decap_8_461 VPWR VGND sg13cmos5l_decap_8
* cell instance sg13cmos5l_decap_8_462 r0 *1 0,0
Xsg13cmos5l_decap_8_462 VPWR VGND sg13cmos5l_decap_8
* cell instance sg13cmos5l_decap_8_463 r0 *1 0,0
Xsg13cmos5l_decap_8_463 VPWR VGND sg13cmos5l_decap_8
* cell instance sg13cmos5l_decap_8_464 r0 *1 0,0
Xsg13cmos5l_decap_8_464 VPWR VGND sg13cmos5l_decap_8
* cell instance sg13cmos5l_decap_8_465 r0 *1 0,0
Xsg13cmos5l_decap_8_465 VPWR VGND sg13cmos5l_decap_8
* cell instance sg13cmos5l_decap_8_466 r0 *1 0,0
Xsg13cmos5l_decap_8_466 VPWR VGND sg13cmos5l_decap_8
* cell instance sg13cmos5l_decap_8_467 r0 *1 0,0
Xsg13cmos5l_decap_8_467 VPWR VGND sg13cmos5l_decap_8
* cell instance sg13cmos5l_decap_8_468 r0 *1 0,0
Xsg13cmos5l_decap_8_468 VPWR VGND sg13cmos5l_decap_8
* cell instance sg13cmos5l_decap_8_469 r0 *1 0,0
Xsg13cmos5l_decap_8_469 VPWR VGND sg13cmos5l_decap_8
* cell instance sg13cmos5l_decap_8_470 r0 *1 0,0
Xsg13cmos5l_decap_8_470 VPWR VGND sg13cmos5l_decap_8
* cell instance sg13cmos5l_decap_8_471 r0 *1 0,0
Xsg13cmos5l_decap_8_471 VPWR VGND sg13cmos5l_decap_8
* cell instance sg13cmos5l_decap_8_472 r0 *1 0,0
Xsg13cmos5l_decap_8_472 VPWR VGND sg13cmos5l_decap_8
* cell instance sg13cmos5l_decap_8_473 r0 *1 0,0
Xsg13cmos5l_decap_8_473 VPWR VGND sg13cmos5l_decap_8
* cell instance sg13cmos5l_decap_8_474 r0 *1 0,0
Xsg13cmos5l_decap_8_474 VPWR VGND sg13cmos5l_decap_8
* cell instance sg13cmos5l_decap_8_475 r0 *1 0,0
Xsg13cmos5l_decap_8_475 VPWR VGND sg13cmos5l_decap_8
* cell instance sg13cmos5l_decap_8_476 r0 *1 0,0
Xsg13cmos5l_decap_8_476 VPWR VGND sg13cmos5l_decap_8
* cell instance sg13cmos5l_decap_8_477 r0 *1 0,0
Xsg13cmos5l_decap_8_477 VPWR VGND sg13cmos5l_decap_8
* cell instance sg13cmos5l_decap_8_478 r0 *1 0,0
Xsg13cmos5l_decap_8_478 VPWR VGND sg13cmos5l_decap_8
* cell instance sg13cmos5l_decap_8_479 r0 *1 0,0
Xsg13cmos5l_decap_8_479 VPWR VGND sg13cmos5l_decap_8
* cell instance sg13cmos5l_decap_8_480 r0 *1 0,0
Xsg13cmos5l_decap_8_480 VPWR VGND sg13cmos5l_decap_8
* cell instance sg13cmos5l_decap_8_481 r0 *1 0,0
Xsg13cmos5l_decap_8_481 VPWR VGND sg13cmos5l_decap_8
* cell instance sg13cmos5l_decap_8_482 r0 *1 0,0
Xsg13cmos5l_decap_8_482 VPWR VGND sg13cmos5l_decap_8
* cell instance sg13cmos5l_decap_8_483 r0 *1 0,0
Xsg13cmos5l_decap_8_483 VPWR VGND sg13cmos5l_decap_8
* cell instance sg13cmos5l_decap_8_484 r0 *1 0,0
Xsg13cmos5l_decap_8_484 VPWR VGND sg13cmos5l_decap_8
* cell instance sg13cmos5l_decap_8_485 r0 *1 0,0
Xsg13cmos5l_decap_8_485 VPWR VGND sg13cmos5l_decap_8
* cell instance sg13cmos5l_decap_8_486 r0 *1 0,0
Xsg13cmos5l_decap_8_486 VPWR VGND sg13cmos5l_decap_8
* cell instance sg13cmos5l_decap_8_487 r0 *1 0,0
Xsg13cmos5l_decap_8_487 VPWR VGND sg13cmos5l_decap_8
* cell instance sg13cmos5l_decap_8_488 r0 *1 0,0
Xsg13cmos5l_decap_8_488 VPWR VGND sg13cmos5l_decap_8
* cell instance sg13cmos5l_decap_8_489 r0 *1 0,0
Xsg13cmos5l_decap_8_489 VPWR VGND sg13cmos5l_decap_8
* cell instance sg13cmos5l_decap_8_490 r0 *1 0,0
Xsg13cmos5l_decap_8_490 VPWR VGND sg13cmos5l_decap_8
* cell instance sg13cmos5l_decap_8_491 r0 *1 0,0
Xsg13cmos5l_decap_8_491 VPWR VGND sg13cmos5l_decap_8
* cell instance sg13cmos5l_decap_8_492 r0 *1 0,0
Xsg13cmos5l_decap_8_492 VPWR VGND sg13cmos5l_decap_8
* cell instance sg13cmos5l_decap_8_493 r0 *1 0,0
Xsg13cmos5l_decap_8_493 VPWR VGND sg13cmos5l_decap_8
* cell instance sg13cmos5l_decap_8_494 r0 *1 0,0
Xsg13cmos5l_decap_8_494 VPWR VGND sg13cmos5l_decap_8
* cell instance sg13cmos5l_decap_8_495 r0 *1 0,0
Xsg13cmos5l_decap_8_495 VPWR VGND sg13cmos5l_decap_8
* cell instance sg13cmos5l_decap_8_496 r0 *1 0,0
Xsg13cmos5l_decap_8_496 VPWR VGND sg13cmos5l_decap_8
* cell instance sg13cmos5l_decap_8_497 r0 *1 0,0
Xsg13cmos5l_decap_8_497 VPWR VGND sg13cmos5l_decap_8
* cell instance sg13cmos5l_decap_8_498 r0 *1 0,0
Xsg13cmos5l_decap_8_498 VPWR VGND sg13cmos5l_decap_8
* cell instance sg13cmos5l_decap_8_499 r0 *1 0,0
Xsg13cmos5l_decap_8_499 VPWR VGND sg13cmos5l_decap_8
* cell instance sg13cmos5l_decap_8_500 r0 *1 0,0
Xsg13cmos5l_decap_8_500 VPWR VGND sg13cmos5l_decap_8
* cell instance sg13cmos5l_decap_8_501 r0 *1 0,0
Xsg13cmos5l_decap_8_501 VPWR VGND sg13cmos5l_decap_8
* cell instance sg13cmos5l_decap_8_502 r0 *1 0,0
Xsg13cmos5l_decap_8_502 VPWR VGND sg13cmos5l_decap_8
* cell instance sg13cmos5l_decap_8_503 r0 *1 0,0
Xsg13cmos5l_decap_8_503 VPWR VGND sg13cmos5l_decap_8
* cell instance sg13cmos5l_decap_8_504 r0 *1 0,0
Xsg13cmos5l_decap_8_504 VPWR VGND sg13cmos5l_decap_8
* cell instance sg13cmos5l_decap_8_505 r0 *1 0,0
Xsg13cmos5l_decap_8_505 VPWR VGND sg13cmos5l_decap_8
* cell instance sg13cmos5l_decap_8_506 r0 *1 0,0
Xsg13cmos5l_decap_8_506 VPWR VGND sg13cmos5l_decap_8
* cell instance sg13cmos5l_decap_8_507 r0 *1 0,0
Xsg13cmos5l_decap_8_507 VPWR VGND sg13cmos5l_decap_8
* cell instance sg13cmos5l_decap_8_508 r0 *1 0,0
Xsg13cmos5l_decap_8_508 VPWR VGND sg13cmos5l_decap_8
* cell instance sg13cmos5l_decap_8_509 r0 *1 0,0
Xsg13cmos5l_decap_8_509 VPWR VGND sg13cmos5l_decap_8
* cell instance sg13cmos5l_decap_8_510 r0 *1 0,0
Xsg13cmos5l_decap_8_510 VPWR VGND sg13cmos5l_decap_8
* cell instance sg13cmos5l_decap_8_511 r0 *1 0,0
Xsg13cmos5l_decap_8_511 VPWR VGND sg13cmos5l_decap_8
* cell instance sg13cmos5l_decap_8_512 r0 *1 0,0
Xsg13cmos5l_decap_8_512 VPWR VGND sg13cmos5l_decap_8
* cell instance sg13cmos5l_decap_8_513 r0 *1 0,0
Xsg13cmos5l_decap_8_513 VPWR VGND sg13cmos5l_decap_8
* cell instance sg13cmos5l_decap_8_514 r0 *1 0,0
Xsg13cmos5l_decap_8_514 VPWR VGND sg13cmos5l_decap_8
* cell instance sg13cmos5l_decap_8_515 r0 *1 0,0
Xsg13cmos5l_decap_8_515 VPWR VGND sg13cmos5l_decap_8
* cell instance sg13cmos5l_decap_8_516 r0 *1 0,0
Xsg13cmos5l_decap_8_516 VPWR VGND sg13cmos5l_decap_8
* cell instance sg13cmos5l_decap_8_517 r0 *1 0,0
Xsg13cmos5l_decap_8_517 VPWR VGND sg13cmos5l_decap_8
* cell instance sg13cmos5l_decap_8_518 r0 *1 0,0
Xsg13cmos5l_decap_8_518 VPWR VGND sg13cmos5l_decap_8
* cell instance sg13cmos5l_decap_8_519 r0 *1 0,0
Xsg13cmos5l_decap_8_519 VPWR VGND sg13cmos5l_decap_8
* cell instance sg13cmos5l_decap_8_520 r0 *1 0,0
Xsg13cmos5l_decap_8_520 VPWR VGND sg13cmos5l_decap_8
* cell instance sg13cmos5l_decap_8_521 r0 *1 0,0
Xsg13cmos5l_decap_8_521 VPWR VGND sg13cmos5l_decap_8
* cell instance sg13cmos5l_decap_8_522 r0 *1 0,0
Xsg13cmos5l_decap_8_522 VPWR VGND sg13cmos5l_decap_8
* cell instance sg13cmos5l_decap_8_523 r0 *1 0,0
Xsg13cmos5l_decap_8_523 VPWR VGND sg13cmos5l_decap_8
* cell instance sg13cmos5l_decap_8_524 r0 *1 0,0
Xsg13cmos5l_decap_8_524 VPWR VGND sg13cmos5l_decap_8
* cell instance sg13cmos5l_decap_8_525 r0 *1 0,0
Xsg13cmos5l_decap_8_525 VPWR VGND sg13cmos5l_decap_8
* cell instance sg13cmos5l_decap_8_526 r0 *1 0,0
Xsg13cmos5l_decap_8_526 VPWR VGND sg13cmos5l_decap_8
* cell instance sg13cmos5l_decap_8_527 r0 *1 0,0
Xsg13cmos5l_decap_8_527 VPWR VGND sg13cmos5l_decap_8
* cell instance sg13cmos5l_decap_8_528 r0 *1 0,0
Xsg13cmos5l_decap_8_528 VPWR VGND sg13cmos5l_decap_8
* cell instance sg13cmos5l_decap_8_529 r0 *1 0,0
Xsg13cmos5l_decap_8_529 VPWR VGND sg13cmos5l_decap_8
* cell instance sg13cmos5l_decap_8_530 r0 *1 0,0
Xsg13cmos5l_decap_8_530 VPWR VGND sg13cmos5l_decap_8
* cell instance sg13cmos5l_decap_8_531 r0 *1 0,0
Xsg13cmos5l_decap_8_531 VPWR VGND sg13cmos5l_decap_8
* cell instance sg13cmos5l_decap_8_532 r0 *1 0,0
Xsg13cmos5l_decap_8_532 VPWR VGND sg13cmos5l_decap_8
* cell instance sg13cmos5l_decap_8_533 r0 *1 0,0
Xsg13cmos5l_decap_8_533 VPWR VGND sg13cmos5l_decap_8
* cell instance sg13cmos5l_decap_8_534 r0 *1 0,0
Xsg13cmos5l_decap_8_534 VPWR VGND sg13cmos5l_decap_8
* cell instance sg13cmos5l_decap_8_535 r0 *1 0,0
Xsg13cmos5l_decap_8_535 VPWR VGND sg13cmos5l_decap_8
* cell instance sg13cmos5l_decap_8_536 r0 *1 0,0
Xsg13cmos5l_decap_8_536 VPWR VGND sg13cmos5l_decap_8
* cell instance sg13cmos5l_decap_8_537 r0 *1 0,0
Xsg13cmos5l_decap_8_537 VPWR VGND sg13cmos5l_decap_8
* cell instance sg13cmos5l_decap_8_538 r0 *1 0,0
Xsg13cmos5l_decap_8_538 VPWR VGND sg13cmos5l_decap_8
* cell instance sg13cmos5l_decap_8_539 r0 *1 0,0
Xsg13cmos5l_decap_8_539 VPWR VGND sg13cmos5l_decap_8
* cell instance sg13cmos5l_decap_8_540 r0 *1 0,0
Xsg13cmos5l_decap_8_540 VPWR VGND sg13cmos5l_decap_8
* cell instance sg13cmos5l_decap_8_541 r0 *1 0,0
Xsg13cmos5l_decap_8_541 VPWR VGND sg13cmos5l_decap_8
* cell instance sg13cmos5l_decap_8_542 r0 *1 0,0
Xsg13cmos5l_decap_8_542 VPWR VGND sg13cmos5l_decap_8
* cell instance sg13cmos5l_decap_8_543 r0 *1 0,0
Xsg13cmos5l_decap_8_543 VPWR VGND sg13cmos5l_decap_8
* cell instance sg13cmos5l_decap_8_544 r0 *1 0,0
Xsg13cmos5l_decap_8_544 VPWR VGND sg13cmos5l_decap_8
* cell instance sg13cmos5l_decap_8_545 r0 *1 0,0
Xsg13cmos5l_decap_8_545 VPWR VGND sg13cmos5l_decap_8
* cell instance sg13cmos5l_decap_8_546 r0 *1 0,0
Xsg13cmos5l_decap_8_546 VPWR VGND sg13cmos5l_decap_8
* cell instance sg13cmos5l_decap_8_547 r0 *1 0,0
Xsg13cmos5l_decap_8_547 VPWR VGND sg13cmos5l_decap_8
* cell instance sg13cmos5l_decap_8_548 r0 *1 0,0
Xsg13cmos5l_decap_8_548 VPWR VGND sg13cmos5l_decap_8
* cell instance sg13cmos5l_decap_8_549 r0 *1 0,0
Xsg13cmos5l_decap_8_549 VPWR VGND sg13cmos5l_decap_8
* cell instance sg13cmos5l_decap_8_550 r0 *1 0,0
Xsg13cmos5l_decap_8_550 VPWR VGND sg13cmos5l_decap_8
* cell instance sg13cmos5l_decap_8_551 r0 *1 0,0
Xsg13cmos5l_decap_8_551 VPWR VGND sg13cmos5l_decap_8
* cell instance sg13cmos5l_decap_8_552 r0 *1 0,0
Xsg13cmos5l_decap_8_552 VPWR VGND sg13cmos5l_decap_8
* cell instance sg13cmos5l_decap_8_553 r0 *1 0,0
Xsg13cmos5l_decap_8_553 VPWR VGND sg13cmos5l_decap_8
* cell instance sg13cmos5l_decap_8_554 r0 *1 0,0
Xsg13cmos5l_decap_8_554 VPWR VGND sg13cmos5l_decap_8
* cell instance sg13cmos5l_decap_8_555 r0 *1 0,0
Xsg13cmos5l_decap_8_555 VPWR VGND sg13cmos5l_decap_8
* cell instance sg13cmos5l_decap_8_556 r0 *1 0,0
Xsg13cmos5l_decap_8_556 VPWR VGND sg13cmos5l_decap_8
* cell instance sg13cmos5l_decap_8_557 r0 *1 0,0
Xsg13cmos5l_decap_8_557 VPWR VGND sg13cmos5l_decap_8
* cell instance sg13cmos5l_decap_8_558 r0 *1 0,0
Xsg13cmos5l_decap_8_558 VPWR VGND sg13cmos5l_decap_8
* cell instance sg13cmos5l_decap_8_559 r0 *1 0,0
Xsg13cmos5l_decap_8_559 VPWR VGND sg13cmos5l_decap_8
* cell instance sg13cmos5l_decap_8_560 r0 *1 0,0
Xsg13cmos5l_decap_8_560 VPWR VGND sg13cmos5l_decap_8
* cell instance sg13cmos5l_decap_8_561 r0 *1 0,0
Xsg13cmos5l_decap_8_561 VPWR VGND sg13cmos5l_decap_8
* cell instance sg13cmos5l_decap_8_562 r0 *1 0,0
Xsg13cmos5l_decap_8_562 VPWR VGND sg13cmos5l_decap_8
* cell instance sg13cmos5l_decap_8_563 r0 *1 0,0
Xsg13cmos5l_decap_8_563 VPWR VGND sg13cmos5l_decap_8
* cell instance sg13cmos5l_decap_8_564 r0 *1 0,0
Xsg13cmos5l_decap_8_564 VPWR VGND sg13cmos5l_decap_8
* cell instance sg13cmos5l_decap_8_565 r0 *1 0,0
Xsg13cmos5l_decap_8_565 VPWR VGND sg13cmos5l_decap_8
* cell instance sg13cmos5l_decap_8_566 r0 *1 0,0
Xsg13cmos5l_decap_8_566 VPWR VGND sg13cmos5l_decap_8
* cell instance sg13cmos5l_decap_8_567 r0 *1 0,0
Xsg13cmos5l_decap_8_567 VPWR VGND sg13cmos5l_decap_8
* cell instance sg13cmos5l_decap_8_568 r0 *1 0,0
Xsg13cmos5l_decap_8_568 VPWR VGND sg13cmos5l_decap_8
* cell instance sg13cmos5l_decap_8_569 r0 *1 0,0
Xsg13cmos5l_decap_8_569 VPWR VGND sg13cmos5l_decap_8
* cell instance sg13cmos5l_decap_8_570 r0 *1 0,0
Xsg13cmos5l_decap_8_570 VPWR VGND sg13cmos5l_decap_8
* cell instance sg13cmos5l_decap_8_571 r0 *1 0,0
Xsg13cmos5l_decap_8_571 VPWR VGND sg13cmos5l_decap_8
* cell instance sg13cmos5l_decap_8_572 r0 *1 0,0
Xsg13cmos5l_decap_8_572 VPWR VGND sg13cmos5l_decap_8
* cell instance sg13cmos5l_decap_8_573 r0 *1 0,0
Xsg13cmos5l_decap_8_573 VPWR VGND sg13cmos5l_decap_8
* cell instance sg13cmos5l_decap_8_574 r0 *1 0,0
Xsg13cmos5l_decap_8_574 VPWR VGND sg13cmos5l_decap_8
* cell instance sg13cmos5l_decap_8_575 r0 *1 0,0
Xsg13cmos5l_decap_8_575 VPWR VGND sg13cmos5l_decap_8
* cell instance sg13cmos5l_decap_8_576 r0 *1 0,0
Xsg13cmos5l_decap_8_576 VPWR VGND sg13cmos5l_decap_8
* cell instance sg13cmos5l_decap_8_577 r0 *1 0,0
Xsg13cmos5l_decap_8_577 VPWR VGND sg13cmos5l_decap_8
* cell instance sg13cmos5l_decap_8_578 r0 *1 0,0
Xsg13cmos5l_decap_8_578 VPWR VGND sg13cmos5l_decap_8
* cell instance sg13cmos5l_decap_8_579 r0 *1 0,0
Xsg13cmos5l_decap_8_579 VPWR VGND sg13cmos5l_decap_8
* cell instance sg13cmos5l_decap_8_580 r0 *1 0,0
Xsg13cmos5l_decap_8_580 VPWR VGND sg13cmos5l_decap_8
* cell instance sg13cmos5l_decap_8_581 r0 *1 0,0
Xsg13cmos5l_decap_8_581 VPWR VGND sg13cmos5l_decap_8
* cell instance sg13cmos5l_decap_8_582 r0 *1 0,0
Xsg13cmos5l_decap_8_582 VPWR VGND sg13cmos5l_decap_8
* cell instance sg13cmos5l_decap_8_583 r0 *1 0,0
Xsg13cmos5l_decap_8_583 VPWR VGND sg13cmos5l_decap_8
* cell instance sg13cmos5l_decap_8_584 r0 *1 0,0
Xsg13cmos5l_decap_8_584 VPWR VGND sg13cmos5l_decap_8
* cell instance sg13cmos5l_decap_8_585 r0 *1 0,0
Xsg13cmos5l_decap_8_585 VPWR VGND sg13cmos5l_decap_8
* cell instance sg13cmos5l_decap_8_586 r0 *1 0,0
Xsg13cmos5l_decap_8_586 VPWR VGND sg13cmos5l_decap_8
* cell instance sg13cmos5l_decap_8_587 r0 *1 0,0
Xsg13cmos5l_decap_8_587 VPWR VGND sg13cmos5l_decap_8
* cell instance sg13cmos5l_decap_8_588 r0 *1 0,0
Xsg13cmos5l_decap_8_588 VPWR VGND sg13cmos5l_decap_8
* cell instance sg13cmos5l_decap_8_589 r0 *1 0,0
Xsg13cmos5l_decap_8_589 VPWR VGND sg13cmos5l_decap_8
* cell instance sg13cmos5l_decap_8_590 r0 *1 0,0
Xsg13cmos5l_decap_8_590 VPWR VGND sg13cmos5l_decap_8
* cell instance sg13cmos5l_decap_8_591 r0 *1 0,0
Xsg13cmos5l_decap_8_591 VPWR VGND sg13cmos5l_decap_8
* cell instance sg13cmos5l_decap_8_592 r0 *1 0,0
Xsg13cmos5l_decap_8_592 VPWR VGND sg13cmos5l_decap_8
* cell instance sg13cmos5l_decap_8_593 r0 *1 0,0
Xsg13cmos5l_decap_8_593 VPWR VGND sg13cmos5l_decap_8
* cell instance sg13cmos5l_decap_8_594 r0 *1 0,0
Xsg13cmos5l_decap_8_594 VPWR VGND sg13cmos5l_decap_8
* cell instance sg13cmos5l_decap_8_595 r0 *1 0,0
Xsg13cmos5l_decap_8_595 VPWR VGND sg13cmos5l_decap_8
* cell instance sg13cmos5l_decap_8_596 r0 *1 0,0
Xsg13cmos5l_decap_8_596 VPWR VGND sg13cmos5l_decap_8
* cell instance sg13cmos5l_decap_8_597 r0 *1 0,0
Xsg13cmos5l_decap_8_597 VPWR VGND sg13cmos5l_decap_8
* cell instance sg13cmos5l_decap_8_598 r0 *1 0,0
Xsg13cmos5l_decap_8_598 VPWR VGND sg13cmos5l_decap_8
* cell instance sg13cmos5l_decap_8_599 r0 *1 0,0
Xsg13cmos5l_decap_8_599 VPWR VGND sg13cmos5l_decap_8
* cell instance sg13cmos5l_decap_8_600 r0 *1 0,0
Xsg13cmos5l_decap_8_600 VPWR VGND sg13cmos5l_decap_8
* cell instance sg13cmos5l_decap_8_601 r0 *1 0,0
Xsg13cmos5l_decap_8_601 VPWR VGND sg13cmos5l_decap_8
* cell instance sg13cmos5l_decap_8_602 r0 *1 0,0
Xsg13cmos5l_decap_8_602 VPWR VGND sg13cmos5l_decap_8
* cell instance sg13cmos5l_decap_8_603 r0 *1 0,0
Xsg13cmos5l_decap_8_603 VPWR VGND sg13cmos5l_decap_8
* cell instance sg13cmos5l_decap_8_604 r0 *1 0,0
Xsg13cmos5l_decap_8_604 VPWR VGND sg13cmos5l_decap_8
* cell instance sg13cmos5l_decap_8_605 r0 *1 0,0
Xsg13cmos5l_decap_8_605 VPWR VGND sg13cmos5l_decap_8
* cell instance sg13cmos5l_decap_8_606 r0 *1 0,0
Xsg13cmos5l_decap_8_606 VPWR VGND sg13cmos5l_decap_8
* cell instance sg13cmos5l_decap_8_607 r0 *1 0,0
Xsg13cmos5l_decap_8_607 VPWR VGND sg13cmos5l_decap_8
* cell instance sg13cmos5l_decap_8_608 r0 *1 0,0
Xsg13cmos5l_decap_8_608 VPWR VGND sg13cmos5l_decap_8
* cell instance sg13cmos5l_decap_8_609 r0 *1 0,0
Xsg13cmos5l_decap_8_609 VPWR VGND sg13cmos5l_decap_8
* cell instance sg13cmos5l_decap_8_610 r0 *1 0,0
Xsg13cmos5l_decap_8_610 VPWR VGND sg13cmos5l_decap_8
* cell instance sg13cmos5l_decap_8_611 r0 *1 0,0
Xsg13cmos5l_decap_8_611 VPWR VGND sg13cmos5l_decap_8
* cell instance sg13cmos5l_decap_8_612 r0 *1 0,0
Xsg13cmos5l_decap_8_612 VPWR VGND sg13cmos5l_decap_8
* cell instance sg13cmos5l_decap_8_613 r0 *1 0,0
Xsg13cmos5l_decap_8_613 VPWR VGND sg13cmos5l_decap_8
* cell instance sg13cmos5l_decap_8_614 r0 *1 0,0
Xsg13cmos5l_decap_8_614 VPWR VGND sg13cmos5l_decap_8
* cell instance sg13cmos5l_decap_8_615 r0 *1 0,0
Xsg13cmos5l_decap_8_615 VPWR VGND sg13cmos5l_decap_8
* cell instance sg13cmos5l_decap_8_616 r0 *1 0,0
Xsg13cmos5l_decap_8_616 VPWR VGND sg13cmos5l_decap_8
* cell instance sg13cmos5l_decap_8_617 r0 *1 0,0
Xsg13cmos5l_decap_8_617 VPWR VGND sg13cmos5l_decap_8
* cell instance sg13cmos5l_decap_8_618 r0 *1 0,0
Xsg13cmos5l_decap_8_618 VPWR VGND sg13cmos5l_decap_8
* cell instance sg13cmos5l_decap_8_619 r0 *1 0,0
Xsg13cmos5l_decap_8_619 VPWR VGND sg13cmos5l_decap_8
* cell instance sg13cmos5l_decap_8_620 r0 *1 0,0
Xsg13cmos5l_decap_8_620 VPWR VGND sg13cmos5l_decap_8
* cell instance sg13cmos5l_decap_8_621 r0 *1 0,0
Xsg13cmos5l_decap_8_621 VPWR VGND sg13cmos5l_decap_8
* cell instance sg13cmos5l_decap_8_622 r0 *1 0,0
Xsg13cmos5l_decap_8_622 VPWR VGND sg13cmos5l_decap_8
* cell instance sg13cmos5l_decap_8_623 r0 *1 0,0
Xsg13cmos5l_decap_8_623 VPWR VGND sg13cmos5l_decap_8
* cell instance sg13cmos5l_decap_8_624 r0 *1 0,0
Xsg13cmos5l_decap_8_624 VPWR VGND sg13cmos5l_decap_8
* cell instance sg13cmos5l_decap_8_625 r0 *1 0,0
Xsg13cmos5l_decap_8_625 VPWR VGND sg13cmos5l_decap_8
* cell instance sg13cmos5l_decap_8_626 r0 *1 0,0
Xsg13cmos5l_decap_8_626 VPWR VGND sg13cmos5l_decap_8
* cell instance sg13cmos5l_decap_8_627 r0 *1 0,0
Xsg13cmos5l_decap_8_627 VPWR VGND sg13cmos5l_decap_8
* cell instance sg13cmos5l_decap_8_628 r0 *1 0,0
Xsg13cmos5l_decap_8_628 VPWR VGND sg13cmos5l_decap_8
* cell instance sg13cmos5l_decap_8_629 r0 *1 0,0
Xsg13cmos5l_decap_8_629 VPWR VGND sg13cmos5l_decap_8
* cell instance sg13cmos5l_decap_8_630 r0 *1 0,0
Xsg13cmos5l_decap_8_630 VPWR VGND sg13cmos5l_decap_8
* cell instance sg13cmos5l_decap_8_631 r0 *1 0,0
Xsg13cmos5l_decap_8_631 VPWR VGND sg13cmos5l_decap_8
* cell instance sg13cmos5l_decap_8_632 r0 *1 0,0
Xsg13cmos5l_decap_8_632 VPWR VGND sg13cmos5l_decap_8
* cell instance sg13cmos5l_decap_8_633 r0 *1 0,0
Xsg13cmos5l_decap_8_633 VPWR VGND sg13cmos5l_decap_8
* cell instance sg13cmos5l_decap_8_634 r0 *1 0,0
Xsg13cmos5l_decap_8_634 VPWR VGND sg13cmos5l_decap_8
* cell instance sg13cmos5l_decap_8_635 r0 *1 0,0
Xsg13cmos5l_decap_8_635 VPWR VGND sg13cmos5l_decap_8
* cell instance sg13cmos5l_decap_8_636 r0 *1 0,0
Xsg13cmos5l_decap_8_636 VPWR VGND sg13cmos5l_decap_8
* cell instance sg13cmos5l_decap_8_637 r0 *1 0,0
Xsg13cmos5l_decap_8_637 VPWR VGND sg13cmos5l_decap_8
* cell instance sg13cmos5l_decap_8_638 r0 *1 0,0
Xsg13cmos5l_decap_8_638 VPWR VGND sg13cmos5l_decap_8
* cell instance sg13cmos5l_decap_8_639 r0 *1 0,0
Xsg13cmos5l_decap_8_639 VPWR VGND sg13cmos5l_decap_8
* cell instance sg13cmos5l_decap_8_640 r0 *1 0,0
Xsg13cmos5l_decap_8_640 VPWR VGND sg13cmos5l_decap_8
* cell instance sg13cmos5l_decap_8_641 r0 *1 0,0
Xsg13cmos5l_decap_8_641 VPWR VGND sg13cmos5l_decap_8
* cell instance sg13cmos5l_decap_8_642 r0 *1 0,0
Xsg13cmos5l_decap_8_642 VPWR VGND sg13cmos5l_decap_8
* cell instance sg13cmos5l_decap_8_643 r0 *1 0,0
Xsg13cmos5l_decap_8_643 VPWR VGND sg13cmos5l_decap_8
* cell instance sg13cmos5l_decap_8_644 r0 *1 0,0
Xsg13cmos5l_decap_8_644 VPWR VGND sg13cmos5l_decap_8
* cell instance sg13cmos5l_decap_8_645 r0 *1 0,0
Xsg13cmos5l_decap_8_645 VPWR VGND sg13cmos5l_decap_8
* cell instance sg13cmos5l_decap_8_646 r0 *1 0,0
Xsg13cmos5l_decap_8_646 VPWR VGND sg13cmos5l_decap_8
* cell instance sg13cmos5l_decap_8_647 r0 *1 0,0
Xsg13cmos5l_decap_8_647 VPWR VGND sg13cmos5l_decap_8
* cell instance sg13cmos5l_decap_8_648 r0 *1 0,0
Xsg13cmos5l_decap_8_648 VPWR VGND sg13cmos5l_decap_8
* cell instance sg13cmos5l_decap_8_649 r0 *1 0,0
Xsg13cmos5l_decap_8_649 VPWR VGND sg13cmos5l_decap_8
* cell instance sg13cmos5l_decap_8_650 r0 *1 0,0
Xsg13cmos5l_decap_8_650 VPWR VGND sg13cmos5l_decap_8
* cell instance sg13cmos5l_decap_8_651 r0 *1 0,0
Xsg13cmos5l_decap_8_651 VPWR VGND sg13cmos5l_decap_8
* cell instance sg13cmos5l_decap_8_652 r0 *1 0,0
Xsg13cmos5l_decap_8_652 VPWR VGND sg13cmos5l_decap_8
* cell instance sg13cmos5l_decap_8_653 r0 *1 0,0
Xsg13cmos5l_decap_8_653 VPWR VGND sg13cmos5l_decap_8
* cell instance sg13cmos5l_decap_8_654 r0 *1 0,0
Xsg13cmos5l_decap_8_654 VPWR VGND sg13cmos5l_decap_8
* cell instance sg13cmos5l_decap_8_655 r0 *1 0,0
Xsg13cmos5l_decap_8_655 VPWR VGND sg13cmos5l_decap_8
* cell instance sg13cmos5l_decap_8_656 r0 *1 0,0
Xsg13cmos5l_decap_8_656 VPWR VGND sg13cmos5l_decap_8
* cell instance sg13cmos5l_decap_8_657 r0 *1 0,0
Xsg13cmos5l_decap_8_657 VPWR VGND sg13cmos5l_decap_8
* cell instance sg13cmos5l_decap_8_658 r0 *1 0,0
Xsg13cmos5l_decap_8_658 VPWR VGND sg13cmos5l_decap_8
* cell instance sg13cmos5l_decap_8_659 r0 *1 0,0
Xsg13cmos5l_decap_8_659 VPWR VGND sg13cmos5l_decap_8
* cell instance sg13cmos5l_decap_8_660 r0 *1 0,0
Xsg13cmos5l_decap_8_660 VPWR VGND sg13cmos5l_decap_8
* cell instance sg13cmos5l_decap_8_661 r0 *1 0,0
Xsg13cmos5l_decap_8_661 VPWR VGND sg13cmos5l_decap_8
* cell instance sg13cmos5l_decap_8_662 r0 *1 0,0
Xsg13cmos5l_decap_8_662 VPWR VGND sg13cmos5l_decap_8
* cell instance sg13cmos5l_decap_8_663 r0 *1 0,0
Xsg13cmos5l_decap_8_663 VPWR VGND sg13cmos5l_decap_8
* cell instance sg13cmos5l_decap_8_664 r0 *1 0,0
Xsg13cmos5l_decap_8_664 VPWR VGND sg13cmos5l_decap_8
* cell instance sg13cmos5l_decap_8_665 r0 *1 0,0
Xsg13cmos5l_decap_8_665 VPWR VGND sg13cmos5l_decap_8
* cell instance sg13cmos5l_decap_8_666 r0 *1 0,0
Xsg13cmos5l_decap_8_666 VPWR VGND sg13cmos5l_decap_8
* cell instance sg13cmos5l_decap_8_667 r0 *1 0,0
Xsg13cmos5l_decap_8_667 VPWR VGND sg13cmos5l_decap_8
* cell instance sg13cmos5l_decap_8_668 r0 *1 0,0
Xsg13cmos5l_decap_8_668 VPWR VGND sg13cmos5l_decap_8
* cell instance sg13cmos5l_decap_8_669 r0 *1 0,0
Xsg13cmos5l_decap_8_669 VPWR VGND sg13cmos5l_decap_8
* cell instance sg13cmos5l_decap_8_670 r0 *1 0,0
Xsg13cmos5l_decap_8_670 VPWR VGND sg13cmos5l_decap_8
* cell instance sg13cmos5l_decap_8_671 r0 *1 0,0
Xsg13cmos5l_decap_8_671 VPWR VGND sg13cmos5l_decap_8
* cell instance sg13cmos5l_decap_8_672 r0 *1 0,0
Xsg13cmos5l_decap_8_672 VPWR VGND sg13cmos5l_decap_8
* cell instance sg13cmos5l_decap_8_673 r0 *1 0,0
Xsg13cmos5l_decap_8_673 VPWR VGND sg13cmos5l_decap_8
* cell instance sg13cmos5l_decap_8_674 r0 *1 0,0
Xsg13cmos5l_decap_8_674 VPWR VGND sg13cmos5l_decap_8
* cell instance sg13cmos5l_decap_8_675 r0 *1 0,0
Xsg13cmos5l_decap_8_675 VPWR VGND sg13cmos5l_decap_8
* cell instance sg13cmos5l_decap_8_676 r0 *1 0,0
Xsg13cmos5l_decap_8_676 VPWR VGND sg13cmos5l_decap_8
* cell instance sg13cmos5l_decap_8_677 r0 *1 0,0
Xsg13cmos5l_decap_8_677 VPWR VGND sg13cmos5l_decap_8
* cell instance sg13cmos5l_decap_8_678 r0 *1 0,0
Xsg13cmos5l_decap_8_678 VPWR VGND sg13cmos5l_decap_8
* cell instance sg13cmos5l_decap_8_679 r0 *1 0,0
Xsg13cmos5l_decap_8_679 VPWR VGND sg13cmos5l_decap_8
* cell instance sg13cmos5l_decap_8_680 r0 *1 0,0
Xsg13cmos5l_decap_8_680 VPWR VGND sg13cmos5l_decap_8
* cell instance sg13cmos5l_decap_8_681 r0 *1 0,0
Xsg13cmos5l_decap_8_681 VPWR VGND sg13cmos5l_decap_8
* cell instance sg13cmos5l_decap_8_682 r0 *1 0,0
Xsg13cmos5l_decap_8_682 VPWR VGND sg13cmos5l_decap_8
* cell instance sg13cmos5l_decap_8_683 r0 *1 0,0
Xsg13cmos5l_decap_8_683 VPWR VGND sg13cmos5l_decap_8
* cell instance sg13cmos5l_decap_8_684 r0 *1 0,0
Xsg13cmos5l_decap_8_684 VPWR VGND sg13cmos5l_decap_8
* cell instance sg13cmos5l_decap_8_685 r0 *1 0,0
Xsg13cmos5l_decap_8_685 VPWR VGND sg13cmos5l_decap_8
* cell instance sg13cmos5l_decap_8_686 r0 *1 0,0
Xsg13cmos5l_decap_8_686 VPWR VGND sg13cmos5l_decap_8
* cell instance sg13cmos5l_decap_8_687 r0 *1 0,0
Xsg13cmos5l_decap_8_687 VPWR VGND sg13cmos5l_decap_8
* cell instance sg13cmos5l_decap_8_688 r0 *1 0,0
Xsg13cmos5l_decap_8_688 VPWR VGND sg13cmos5l_decap_8
* cell instance sg13cmos5l_decap_8_689 r0 *1 0,0
Xsg13cmos5l_decap_8_689 VPWR VGND sg13cmos5l_decap_8
* cell instance sg13cmos5l_decap_8_690 r0 *1 0,0
Xsg13cmos5l_decap_8_690 VPWR VGND sg13cmos5l_decap_8
* cell instance sg13cmos5l_decap_8_691 r0 *1 0,0
Xsg13cmos5l_decap_8_691 VPWR VGND sg13cmos5l_decap_8
* cell instance sg13cmos5l_decap_8_692 r0 *1 0,0
Xsg13cmos5l_decap_8_692 VPWR VGND sg13cmos5l_decap_8
* cell instance sg13cmos5l_decap_8_693 r0 *1 0,0
Xsg13cmos5l_decap_8_693 VPWR VGND sg13cmos5l_decap_8
* cell instance sg13cmos5l_decap_8_694 r0 *1 0,0
Xsg13cmos5l_decap_8_694 VPWR VGND sg13cmos5l_decap_8
* cell instance sg13cmos5l_decap_8_695 r0 *1 0,0
Xsg13cmos5l_decap_8_695 VPWR VGND sg13cmos5l_decap_8
* cell instance sg13cmos5l_decap_8_696 r0 *1 0,0
Xsg13cmos5l_decap_8_696 VPWR VGND sg13cmos5l_decap_8
* cell instance sg13cmos5l_decap_8_697 r0 *1 0,0
Xsg13cmos5l_decap_8_697 VPWR VGND sg13cmos5l_decap_8
* cell instance sg13cmos5l_decap_8_698 r0 *1 0,0
Xsg13cmos5l_decap_8_698 VPWR VGND sg13cmos5l_decap_8
* cell instance sg13cmos5l_decap_8_699 r0 *1 0,0
Xsg13cmos5l_decap_8_699 VPWR VGND sg13cmos5l_decap_8
* cell instance sg13cmos5l_decap_8_700 r0 *1 0,0
Xsg13cmos5l_decap_8_700 VPWR VGND sg13cmos5l_decap_8
* cell instance sg13cmos5l_decap_8_701 r0 *1 0,0
Xsg13cmos5l_decap_8_701 VPWR VGND sg13cmos5l_decap_8
* cell instance sg13cmos5l_decap_8_702 r0 *1 0,0
Xsg13cmos5l_decap_8_702 VPWR VGND sg13cmos5l_decap_8
* cell instance sg13cmos5l_decap_8_703 r0 *1 0,0
Xsg13cmos5l_decap_8_703 VPWR VGND sg13cmos5l_decap_8
* cell instance sg13cmos5l_decap_8_704 r0 *1 0,0
Xsg13cmos5l_decap_8_704 VPWR VGND sg13cmos5l_decap_8
* cell instance sg13cmos5l_decap_8_705 r0 *1 0,0
Xsg13cmos5l_decap_8_705 VPWR VGND sg13cmos5l_decap_8
* cell instance sg13cmos5l_decap_8_706 r0 *1 0,0
Xsg13cmos5l_decap_8_706 VPWR VGND sg13cmos5l_decap_8
* cell instance sg13cmos5l_decap_8_707 r0 *1 0,0
Xsg13cmos5l_decap_8_707 VPWR VGND sg13cmos5l_decap_8
* cell instance sg13cmos5l_decap_8_708 r0 *1 0,0
Xsg13cmos5l_decap_8_708 VPWR VGND sg13cmos5l_decap_8
* cell instance sg13cmos5l_decap_8_709 r0 *1 0,0
Xsg13cmos5l_decap_8_709 VPWR VGND sg13cmos5l_decap_8
* cell instance sg13cmos5l_decap_8_710 r0 *1 0,0
Xsg13cmos5l_decap_8_710 VPWR VGND sg13cmos5l_decap_8
* cell instance sg13cmos5l_decap_8_711 r0 *1 0,0
Xsg13cmos5l_decap_8_711 VPWR VGND sg13cmos5l_decap_8
* cell instance sg13cmos5l_decap_8_712 r0 *1 0,0
Xsg13cmos5l_decap_8_712 VPWR VGND sg13cmos5l_decap_8
* cell instance sg13cmos5l_decap_8_713 r0 *1 0,0
Xsg13cmos5l_decap_8_713 VPWR VGND sg13cmos5l_decap_8
* cell instance sg13cmos5l_decap_8_714 r0 *1 0,0
Xsg13cmos5l_decap_8_714 VPWR VGND sg13cmos5l_decap_8
* cell instance sg13cmos5l_decap_8_715 r0 *1 0,0
Xsg13cmos5l_decap_8_715 VPWR VGND sg13cmos5l_decap_8
* cell instance sg13cmos5l_decap_8_716 r0 *1 0,0
Xsg13cmos5l_decap_8_716 VPWR VGND sg13cmos5l_decap_8
* cell instance sg13cmos5l_decap_8_717 r0 *1 0,0
Xsg13cmos5l_decap_8_717 VPWR VGND sg13cmos5l_decap_8
* cell instance sg13cmos5l_decap_8_718 r0 *1 0,0
Xsg13cmos5l_decap_8_718 VPWR VGND sg13cmos5l_decap_8
* cell instance sg13cmos5l_decap_8_719 r0 *1 0,0
Xsg13cmos5l_decap_8_719 VPWR VGND sg13cmos5l_decap_8
* cell instance sg13cmos5l_decap_8_720 r0 *1 0,0
Xsg13cmos5l_decap_8_720 VPWR VGND sg13cmos5l_decap_8
* cell instance sg13cmos5l_decap_8_721 r0 *1 0,0
Xsg13cmos5l_decap_8_721 VPWR VGND sg13cmos5l_decap_8
* cell instance sg13cmos5l_decap_8_722 r0 *1 0,0
Xsg13cmos5l_decap_8_722 VPWR VGND sg13cmos5l_decap_8
* cell instance sg13cmos5l_decap_8_723 r0 *1 0,0
Xsg13cmos5l_decap_8_723 VPWR VGND sg13cmos5l_decap_8
* cell instance sg13cmos5l_decap_8_724 r0 *1 0,0
Xsg13cmos5l_decap_8_724 VPWR VGND sg13cmos5l_decap_8
* cell instance sg13cmos5l_decap_8_725 r0 *1 0,0
Xsg13cmos5l_decap_8_725 VPWR VGND sg13cmos5l_decap_8
* cell instance sg13cmos5l_decap_8_726 r0 *1 0,0
Xsg13cmos5l_decap_8_726 VPWR VGND sg13cmos5l_decap_8
* cell instance sg13cmos5l_decap_8_727 r0 *1 0,0
Xsg13cmos5l_decap_8_727 VPWR VGND sg13cmos5l_decap_8
* cell instance sg13cmos5l_decap_8_728 r0 *1 0,0
Xsg13cmos5l_decap_8_728 VPWR VGND sg13cmos5l_decap_8
* cell instance sg13cmos5l_decap_8_729 r0 *1 0,0
Xsg13cmos5l_decap_8_729 VPWR VGND sg13cmos5l_decap_8
* cell instance sg13cmos5l_decap_8_730 r0 *1 0,0
Xsg13cmos5l_decap_8_730 VPWR VGND sg13cmos5l_decap_8
* cell instance sg13cmos5l_decap_8_731 r0 *1 0,0
Xsg13cmos5l_decap_8_731 VPWR VGND sg13cmos5l_decap_8
* cell instance sg13cmos5l_decap_8_732 r0 *1 0,0
Xsg13cmos5l_decap_8_732 VPWR VGND sg13cmos5l_decap_8
* cell instance sg13cmos5l_decap_8_733 r0 *1 0,0
Xsg13cmos5l_decap_8_733 VPWR VGND sg13cmos5l_decap_8
* cell instance sg13cmos5l_decap_8_734 r0 *1 0,0
Xsg13cmos5l_decap_8_734 VPWR VGND sg13cmos5l_decap_8
* cell instance sg13cmos5l_decap_8_735 r0 *1 0,0
Xsg13cmos5l_decap_8_735 VPWR VGND sg13cmos5l_decap_8
* cell instance sg13cmos5l_decap_8_736 r0 *1 0,0
Xsg13cmos5l_decap_8_736 VPWR VGND sg13cmos5l_decap_8
* cell instance sg13cmos5l_decap_8_737 r0 *1 0,0
Xsg13cmos5l_decap_8_737 VPWR VGND sg13cmos5l_decap_8
* cell instance sg13cmos5l_decap_8_738 r0 *1 0,0
Xsg13cmos5l_decap_8_738 VPWR VGND sg13cmos5l_decap_8
* cell instance sg13cmos5l_decap_8_739 r0 *1 0,0
Xsg13cmos5l_decap_8_739 VPWR VGND sg13cmos5l_decap_8
* cell instance sg13cmos5l_decap_8_740 r0 *1 0,0
Xsg13cmos5l_decap_8_740 VPWR VGND sg13cmos5l_decap_8
* cell instance sg13cmos5l_decap_8_741 r0 *1 0,0
Xsg13cmos5l_decap_8_741 VPWR VGND sg13cmos5l_decap_8
* cell instance sg13cmos5l_decap_8_742 r0 *1 0,0
Xsg13cmos5l_decap_8_742 VPWR VGND sg13cmos5l_decap_8
* cell instance sg13cmos5l_decap_8_743 r0 *1 0,0
Xsg13cmos5l_decap_8_743 VPWR VGND sg13cmos5l_decap_8
* cell instance sg13cmos5l_decap_8_744 r0 *1 0,0
Xsg13cmos5l_decap_8_744 VPWR VGND sg13cmos5l_decap_8
* cell instance sg13cmos5l_decap_8_745 r0 *1 0,0
Xsg13cmos5l_decap_8_745 VPWR VGND sg13cmos5l_decap_8
* cell instance sg13cmos5l_decap_8_746 r0 *1 0,0
Xsg13cmos5l_decap_8_746 VPWR VGND sg13cmos5l_decap_8
* cell instance sg13cmos5l_decap_8_747 r0 *1 0,0
Xsg13cmos5l_decap_8_747 VPWR VGND sg13cmos5l_decap_8
* cell instance sg13cmos5l_decap_8_748 r0 *1 0,0
Xsg13cmos5l_decap_8_748 VPWR VGND sg13cmos5l_decap_8
* cell instance sg13cmos5l_decap_8_749 r0 *1 0,0
Xsg13cmos5l_decap_8_749 VPWR VGND sg13cmos5l_decap_8
* cell instance sg13cmos5l_decap_8_750 r0 *1 0,0
Xsg13cmos5l_decap_8_750 VPWR VGND sg13cmos5l_decap_8
* cell instance sg13cmos5l_decap_8_751 r0 *1 0,0
Xsg13cmos5l_decap_8_751 VPWR VGND sg13cmos5l_decap_8
* cell instance sg13cmos5l_decap_8_752 r0 *1 0,0
Xsg13cmos5l_decap_8_752 VPWR VGND sg13cmos5l_decap_8
* cell instance sg13cmos5l_decap_8_753 r0 *1 0,0
Xsg13cmos5l_decap_8_753 VPWR VGND sg13cmos5l_decap_8
* cell instance sg13cmos5l_decap_8_754 r0 *1 0,0
Xsg13cmos5l_decap_8_754 VPWR VGND sg13cmos5l_decap_8
* cell instance sg13cmos5l_decap_8_755 r0 *1 0,0
Xsg13cmos5l_decap_8_755 VPWR VGND sg13cmos5l_decap_8
* cell instance sg13cmos5l_decap_8_756 r0 *1 0,0
Xsg13cmos5l_decap_8_756 VPWR VGND sg13cmos5l_decap_8
* cell instance sg13cmos5l_decap_8_757 r0 *1 0,0
Xsg13cmos5l_decap_8_757 VPWR VGND sg13cmos5l_decap_8
* cell instance sg13cmos5l_decap_8_758 r0 *1 0,0
Xsg13cmos5l_decap_8_758 VPWR VGND sg13cmos5l_decap_8
* cell instance sg13cmos5l_decap_8_759 r0 *1 0,0
Xsg13cmos5l_decap_8_759 VPWR VGND sg13cmos5l_decap_8
* cell instance sg13cmos5l_decap_8_760 r0 *1 0,0
Xsg13cmos5l_decap_8_760 VPWR VGND sg13cmos5l_decap_8
* cell instance sg13cmos5l_decap_8_761 r0 *1 0,0
Xsg13cmos5l_decap_8_761 VPWR VGND sg13cmos5l_decap_8
* cell instance sg13cmos5l_decap_8_762 r0 *1 0,0
Xsg13cmos5l_decap_8_762 VPWR VGND sg13cmos5l_decap_8
* cell instance sg13cmos5l_decap_8_763 r0 *1 0,0
Xsg13cmos5l_decap_8_763 VPWR VGND sg13cmos5l_decap_8
* cell instance sg13cmos5l_decap_8_764 r0 *1 0,0
Xsg13cmos5l_decap_8_764 VPWR VGND sg13cmos5l_decap_8
* cell instance sg13cmos5l_decap_8_765 r0 *1 0,0
Xsg13cmos5l_decap_8_765 VPWR VGND sg13cmos5l_decap_8
* cell instance sg13cmos5l_decap_8_766 r0 *1 0,0
Xsg13cmos5l_decap_8_766 VPWR VGND sg13cmos5l_decap_8
* cell instance sg13cmos5l_decap_8_767 r0 *1 0,0
Xsg13cmos5l_decap_8_767 VPWR VGND sg13cmos5l_decap_8
* cell instance sg13cmos5l_decap_8_768 r0 *1 0,0
Xsg13cmos5l_decap_8_768 VPWR VGND sg13cmos5l_decap_8
* cell instance sg13cmos5l_decap_8_769 r0 *1 0,0
Xsg13cmos5l_decap_8_769 VPWR VGND sg13cmos5l_decap_8
* cell instance sg13cmos5l_decap_8_770 r0 *1 0,0
Xsg13cmos5l_decap_8_770 VPWR VGND sg13cmos5l_decap_8
* cell instance sg13cmos5l_decap_8_771 r0 *1 0,0
Xsg13cmos5l_decap_8_771 VPWR VGND sg13cmos5l_decap_8
* cell instance sg13cmos5l_decap_8_772 r0 *1 0,0
Xsg13cmos5l_decap_8_772 VPWR VGND sg13cmos5l_decap_8
* cell instance sg13cmos5l_decap_8_773 r0 *1 0,0
Xsg13cmos5l_decap_8_773 VPWR VGND sg13cmos5l_decap_8
* cell instance sg13cmos5l_decap_8_774 r0 *1 0,0
Xsg13cmos5l_decap_8_774 VPWR VGND sg13cmos5l_decap_8
* cell instance sg13cmos5l_decap_8_775 r0 *1 0,0
Xsg13cmos5l_decap_8_775 VPWR VGND sg13cmos5l_decap_8
* cell instance sg13cmos5l_decap_8_776 r0 *1 0,0
Xsg13cmos5l_decap_8_776 VPWR VGND sg13cmos5l_decap_8
* cell instance sg13cmos5l_decap_8_777 r0 *1 0,0
Xsg13cmos5l_decap_8_777 VPWR VGND sg13cmos5l_decap_8
* cell instance sg13cmos5l_decap_8_778 r0 *1 0,0
Xsg13cmos5l_decap_8_778 VPWR VGND sg13cmos5l_decap_8
* cell instance sg13cmos5l_decap_8_779 r0 *1 0,0
Xsg13cmos5l_decap_8_779 VPWR VGND sg13cmos5l_decap_8
* cell instance sg13cmos5l_decap_8_780 r0 *1 0,0
Xsg13cmos5l_decap_8_780 VPWR VGND sg13cmos5l_decap_8
* cell instance sg13cmos5l_decap_8_781 r0 *1 0,0
Xsg13cmos5l_decap_8_781 VPWR VGND sg13cmos5l_decap_8
* cell instance sg13cmos5l_decap_8_782 r0 *1 0,0
Xsg13cmos5l_decap_8_782 VPWR VGND sg13cmos5l_decap_8
* cell instance sg13cmos5l_decap_8_783 r0 *1 0,0
Xsg13cmos5l_decap_8_783 VPWR VGND sg13cmos5l_decap_8
* cell instance sg13cmos5l_decap_8_784 r0 *1 0,0
Xsg13cmos5l_decap_8_784 VPWR VGND sg13cmos5l_decap_8
* cell instance sg13cmos5l_decap_8_785 r0 *1 0,0
Xsg13cmos5l_decap_8_785 VPWR VGND sg13cmos5l_decap_8
* cell instance sg13cmos5l_decap_8_786 r0 *1 0,0
Xsg13cmos5l_decap_8_786 VPWR VGND sg13cmos5l_decap_8
* cell instance sg13cmos5l_decap_8_787 r0 *1 0,0
Xsg13cmos5l_decap_8_787 VPWR VGND sg13cmos5l_decap_8
* cell instance sg13cmos5l_decap_8_788 r0 *1 0,0
Xsg13cmos5l_decap_8_788 VPWR VGND sg13cmos5l_decap_8
* cell instance sg13cmos5l_decap_8_789 r0 *1 0,0
Xsg13cmos5l_decap_8_789 VPWR VGND sg13cmos5l_decap_8
* cell instance sg13cmos5l_decap_8_790 r0 *1 0,0
Xsg13cmos5l_decap_8_790 VPWR VGND sg13cmos5l_decap_8
* cell instance sg13cmos5l_decap_8_791 r0 *1 0,0
Xsg13cmos5l_decap_8_791 VPWR VGND sg13cmos5l_decap_8
* cell instance sg13cmos5l_decap_8_792 r0 *1 0,0
Xsg13cmos5l_decap_8_792 VPWR VGND sg13cmos5l_decap_8
* cell instance sg13cmos5l_decap_8_793 r0 *1 0,0
Xsg13cmos5l_decap_8_793 VPWR VGND sg13cmos5l_decap_8
* cell instance sg13cmos5l_decap_8_794 r0 *1 0,0
Xsg13cmos5l_decap_8_794 VPWR VGND sg13cmos5l_decap_8
* cell instance sg13cmos5l_decap_8_795 r0 *1 0,0
Xsg13cmos5l_decap_8_795 VPWR VGND sg13cmos5l_decap_8
* cell instance sg13cmos5l_decap_8_796 r0 *1 0,0
Xsg13cmos5l_decap_8_796 VPWR VGND sg13cmos5l_decap_8
* cell instance sg13cmos5l_decap_8_797 r0 *1 0,0
Xsg13cmos5l_decap_8_797 VPWR VGND sg13cmos5l_decap_8
* cell instance sg13cmos5l_decap_8_798 r0 *1 0,0
Xsg13cmos5l_decap_8_798 VPWR VGND sg13cmos5l_decap_8
* cell instance sg13cmos5l_decap_8_799 r0 *1 0,0
Xsg13cmos5l_decap_8_799 VPWR VGND sg13cmos5l_decap_8
* cell instance sg13cmos5l_decap_8_800 r0 *1 0,0
Xsg13cmos5l_decap_8_800 VPWR VGND sg13cmos5l_decap_8
* cell instance sg13cmos5l_decap_8_801 r0 *1 0,0
Xsg13cmos5l_decap_8_801 VPWR VGND sg13cmos5l_decap_8
* cell instance sg13cmos5l_decap_8_802 r0 *1 0,0
Xsg13cmos5l_decap_8_802 VPWR VGND sg13cmos5l_decap_8
* cell instance sg13cmos5l_decap_8_803 r0 *1 0,0
Xsg13cmos5l_decap_8_803 VPWR VGND sg13cmos5l_decap_8
* cell instance sg13cmos5l_decap_8_804 r0 *1 0,0
Xsg13cmos5l_decap_8_804 VPWR VGND sg13cmos5l_decap_8
* cell instance sg13cmos5l_decap_8_805 r0 *1 0,0
Xsg13cmos5l_decap_8_805 VPWR VGND sg13cmos5l_decap_8
* cell instance sg13cmos5l_decap_8_806 r0 *1 0,0
Xsg13cmos5l_decap_8_806 VPWR VGND sg13cmos5l_decap_8
* cell instance sg13cmos5l_decap_8_807 r0 *1 0,0
Xsg13cmos5l_decap_8_807 VPWR VGND sg13cmos5l_decap_8
* cell instance sg13cmos5l_decap_8_808 r0 *1 0,0
Xsg13cmos5l_decap_8_808 VPWR VGND sg13cmos5l_decap_8
* cell instance sg13cmos5l_decap_8_809 r0 *1 0,0
Xsg13cmos5l_decap_8_809 VPWR VGND sg13cmos5l_decap_8
* cell instance sg13cmos5l_decap_8_810 r0 *1 0,0
Xsg13cmos5l_decap_8_810 VPWR VGND sg13cmos5l_decap_8
* cell instance sg13cmos5l_decap_8_811 r0 *1 0,0
Xsg13cmos5l_decap_8_811 VPWR VGND sg13cmos5l_decap_8
* cell instance sg13cmos5l_decap_8_812 r0 *1 0,0
Xsg13cmos5l_decap_8_812 VPWR VGND sg13cmos5l_decap_8
* cell instance sg13cmos5l_decap_8_813 r0 *1 0,0
Xsg13cmos5l_decap_8_813 VPWR VGND sg13cmos5l_decap_8
* cell instance sg13cmos5l_decap_8_814 r0 *1 0,0
Xsg13cmos5l_decap_8_814 VPWR VGND sg13cmos5l_decap_8
* cell instance sg13cmos5l_decap_8_815 r0 *1 0,0
Xsg13cmos5l_decap_8_815 VPWR VGND sg13cmos5l_decap_8
* cell instance sg13cmos5l_decap_8_816 r0 *1 0,0
Xsg13cmos5l_decap_8_816 VPWR VGND sg13cmos5l_decap_8
* cell instance sg13cmos5l_decap_8_817 r0 *1 0,0
Xsg13cmos5l_decap_8_817 VPWR VGND sg13cmos5l_decap_8
* cell instance sg13cmos5l_decap_8_818 r0 *1 0,0
Xsg13cmos5l_decap_8_818 VPWR VGND sg13cmos5l_decap_8
* cell instance sg13cmos5l_decap_8_819 r0 *1 0,0
Xsg13cmos5l_decap_8_819 VPWR VGND sg13cmos5l_decap_8
* cell instance sg13cmos5l_decap_8_820 r0 *1 0,0
Xsg13cmos5l_decap_8_820 VPWR VGND sg13cmos5l_decap_8
* cell instance sg13cmos5l_decap_8_821 r0 *1 0,0
Xsg13cmos5l_decap_8_821 VPWR VGND sg13cmos5l_decap_8
* cell instance sg13cmos5l_decap_8_822 r0 *1 0,0
Xsg13cmos5l_decap_8_822 VPWR VGND sg13cmos5l_decap_8
* cell instance sg13cmos5l_decap_8_823 r0 *1 0,0
Xsg13cmos5l_decap_8_823 VPWR VGND sg13cmos5l_decap_8
* cell instance sg13cmos5l_decap_8_824 r0 *1 0,0
Xsg13cmos5l_decap_8_824 VPWR VGND sg13cmos5l_decap_8
* cell instance sg13cmos5l_decap_8_825 r0 *1 0,0
Xsg13cmos5l_decap_8_825 VPWR VGND sg13cmos5l_decap_8
* cell instance sg13cmos5l_decap_8_826 r0 *1 0,0
Xsg13cmos5l_decap_8_826 VPWR VGND sg13cmos5l_decap_8
* cell instance sg13cmos5l_decap_8_827 r0 *1 0,0
Xsg13cmos5l_decap_8_827 VPWR VGND sg13cmos5l_decap_8
* cell instance sg13cmos5l_decap_8_828 r0 *1 0,0
Xsg13cmos5l_decap_8_828 VPWR VGND sg13cmos5l_decap_8
* cell instance sg13cmos5l_decap_8_829 r0 *1 0,0
Xsg13cmos5l_decap_8_829 VPWR VGND sg13cmos5l_decap_8
* cell instance sg13cmos5l_decap_8_830 r0 *1 0,0
Xsg13cmos5l_decap_8_830 VPWR VGND sg13cmos5l_decap_8
* cell instance sg13cmos5l_decap_8_831 r0 *1 0,0
Xsg13cmos5l_decap_8_831 VPWR VGND sg13cmos5l_decap_8
* cell instance sg13cmos5l_decap_8_832 r0 *1 0,0
Xsg13cmos5l_decap_8_832 VPWR VGND sg13cmos5l_decap_8
* cell instance sg13cmos5l_decap_8_833 r0 *1 0,0
Xsg13cmos5l_decap_8_833 VPWR VGND sg13cmos5l_decap_8
* cell instance sg13cmos5l_decap_8_834 r0 *1 0,0
Xsg13cmos5l_decap_8_834 VPWR VGND sg13cmos5l_decap_8
* cell instance sg13cmos5l_decap_8_835 r0 *1 0,0
Xsg13cmos5l_decap_8_835 VPWR VGND sg13cmos5l_decap_8
* cell instance sg13cmos5l_decap_8_836 r0 *1 0,0
Xsg13cmos5l_decap_8_836 VPWR VGND sg13cmos5l_decap_8
* cell instance sg13cmos5l_decap_8_837 r0 *1 0,0
Xsg13cmos5l_decap_8_837 VPWR VGND sg13cmos5l_decap_8
* cell instance sg13cmos5l_decap_8_838 r0 *1 0,0
Xsg13cmos5l_decap_8_838 VPWR VGND sg13cmos5l_decap_8
* cell instance sg13cmos5l_decap_8_839 r0 *1 0,0
Xsg13cmos5l_decap_8_839 VPWR VGND sg13cmos5l_decap_8
* cell instance sg13cmos5l_decap_8_840 r0 *1 0,0
Xsg13cmos5l_decap_8_840 VPWR VGND sg13cmos5l_decap_8
* cell instance sg13cmos5l_decap_8_841 r0 *1 0,0
Xsg13cmos5l_decap_8_841 VPWR VGND sg13cmos5l_decap_8
* cell instance sg13cmos5l_decap_8_842 r0 *1 0,0
Xsg13cmos5l_decap_8_842 VPWR VGND sg13cmos5l_decap_8
* cell instance sg13cmos5l_decap_8_843 r0 *1 0,0
Xsg13cmos5l_decap_8_843 VPWR VGND sg13cmos5l_decap_8
* cell instance sg13cmos5l_decap_8_844 r0 *1 0,0
Xsg13cmos5l_decap_8_844 VPWR VGND sg13cmos5l_decap_8
* cell instance sg13cmos5l_decap_8_845 r0 *1 0,0
Xsg13cmos5l_decap_8_845 VPWR VGND sg13cmos5l_decap_8
* cell instance sg13cmos5l_decap_8_846 r0 *1 0,0
Xsg13cmos5l_decap_8_846 VPWR VGND sg13cmos5l_decap_8
* cell instance sg13cmos5l_decap_8_847 r0 *1 0,0
Xsg13cmos5l_decap_8_847 VPWR VGND sg13cmos5l_decap_8
* cell instance sg13cmos5l_decap_8_848 r0 *1 0,0
Xsg13cmos5l_decap_8_848 VPWR VGND sg13cmos5l_decap_8
* cell instance sg13cmos5l_decap_8_849 r0 *1 0,0
Xsg13cmos5l_decap_8_849 VPWR VGND sg13cmos5l_decap_8
* cell instance sg13cmos5l_decap_8_850 r0 *1 0,0
Xsg13cmos5l_decap_8_850 VPWR VGND sg13cmos5l_decap_8
* cell instance sg13cmos5l_decap_8_851 r0 *1 0,0
Xsg13cmos5l_decap_8_851 VPWR VGND sg13cmos5l_decap_8
* cell instance sg13cmos5l_decap_8_852 r0 *1 0,0
Xsg13cmos5l_decap_8_852 VPWR VGND sg13cmos5l_decap_8
* cell instance sg13cmos5l_decap_8_853 r0 *1 0,0
Xsg13cmos5l_decap_8_853 VPWR VGND sg13cmos5l_decap_8
* cell instance sg13cmos5l_decap_8_854 r0 *1 0,0
Xsg13cmos5l_decap_8_854 VPWR VGND sg13cmos5l_decap_8
* cell instance sg13cmos5l_decap_8_855 r0 *1 0,0
Xsg13cmos5l_decap_8_855 VPWR VGND sg13cmos5l_decap_8
* cell instance sg13cmos5l_decap_8_856 r0 *1 0,0
Xsg13cmos5l_decap_8_856 VPWR VGND sg13cmos5l_decap_8
* cell instance sg13cmos5l_decap_8_857 r0 *1 0,0
Xsg13cmos5l_decap_8_857 VPWR VGND sg13cmos5l_decap_8
* cell instance sg13cmos5l_decap_8_858 r0 *1 0,0
Xsg13cmos5l_decap_8_858 VPWR VGND sg13cmos5l_decap_8
* cell instance sg13cmos5l_decap_8_859 r0 *1 0,0
Xsg13cmos5l_decap_8_859 VPWR VGND sg13cmos5l_decap_8
* cell instance sg13cmos5l_decap_8_860 r0 *1 0,0
Xsg13cmos5l_decap_8_860 VPWR VGND sg13cmos5l_decap_8
* cell instance sg13cmos5l_decap_8_861 r0 *1 0,0
Xsg13cmos5l_decap_8_861 VPWR VGND sg13cmos5l_decap_8
* cell instance sg13cmos5l_decap_8_862 r0 *1 0,0
Xsg13cmos5l_decap_8_862 VPWR VGND sg13cmos5l_decap_8
* cell instance sg13cmos5l_decap_8_863 r0 *1 0,0
Xsg13cmos5l_decap_8_863 VPWR VGND sg13cmos5l_decap_8
* cell instance sg13cmos5l_decap_8_864 r0 *1 0,0
Xsg13cmos5l_decap_8_864 VPWR VGND sg13cmos5l_decap_8
* cell instance sg13cmos5l_decap_8_865 r0 *1 0,0
Xsg13cmos5l_decap_8_865 VPWR VGND sg13cmos5l_decap_8
* cell instance sg13cmos5l_decap_8_866 r0 *1 0,0
Xsg13cmos5l_decap_8_866 VPWR VGND sg13cmos5l_decap_8
* cell instance sg13cmos5l_decap_8_867 r0 *1 0,0
Xsg13cmos5l_decap_8_867 VPWR VGND sg13cmos5l_decap_8
* cell instance sg13cmos5l_decap_8_868 r0 *1 0,0
Xsg13cmos5l_decap_8_868 VPWR VGND sg13cmos5l_decap_8
* cell instance sg13cmos5l_decap_8_869 r0 *1 0,0
Xsg13cmos5l_decap_8_869 VPWR VGND sg13cmos5l_decap_8
* cell instance sg13cmos5l_decap_8_870 r0 *1 0,0
Xsg13cmos5l_decap_8_870 VPWR VGND sg13cmos5l_decap_8
* cell instance sg13cmos5l_decap_8_871 r0 *1 0,0
Xsg13cmos5l_decap_8_871 VPWR VGND sg13cmos5l_decap_8
* cell instance sg13cmos5l_decap_8_872 r0 *1 0,0
Xsg13cmos5l_decap_8_872 VPWR VGND sg13cmos5l_decap_8
* cell instance sg13cmos5l_decap_8_873 r0 *1 0,0
Xsg13cmos5l_decap_8_873 VPWR VGND sg13cmos5l_decap_8
* cell instance sg13cmos5l_decap_8_874 r0 *1 0,0
Xsg13cmos5l_decap_8_874 VPWR VGND sg13cmos5l_decap_8
* cell instance sg13cmos5l_decap_8_875 r0 *1 0,0
Xsg13cmos5l_decap_8_875 VPWR VGND sg13cmos5l_decap_8
* cell instance sg13cmos5l_decap_8_876 r0 *1 0,0
Xsg13cmos5l_decap_8_876 VPWR VGND sg13cmos5l_decap_8
* cell instance sg13cmos5l_decap_8_877 r0 *1 0,0
Xsg13cmos5l_decap_8_877 VPWR VGND sg13cmos5l_decap_8
* cell instance sg13cmos5l_decap_8_878 r0 *1 0,0
Xsg13cmos5l_decap_8_878 VPWR VGND sg13cmos5l_decap_8
* cell instance sg13cmos5l_decap_8_879 r0 *1 0,0
Xsg13cmos5l_decap_8_879 VPWR VGND sg13cmos5l_decap_8
* cell instance sg13cmos5l_decap_8_880 r0 *1 0,0
Xsg13cmos5l_decap_8_880 VPWR VGND sg13cmos5l_decap_8
* cell instance sg13cmos5l_decap_8_881 r0 *1 0,0
Xsg13cmos5l_decap_8_881 VPWR VGND sg13cmos5l_decap_8
* cell instance sg13cmos5l_decap_8_882 r0 *1 0,0
Xsg13cmos5l_decap_8_882 VPWR VGND sg13cmos5l_decap_8
* cell instance sg13cmos5l_decap_8_883 r0 *1 0,0
Xsg13cmos5l_decap_8_883 VPWR VGND sg13cmos5l_decap_8
* cell instance sg13cmos5l_decap_8_884 r0 *1 0,0
Xsg13cmos5l_decap_8_884 VPWR VGND sg13cmos5l_decap_8
* cell instance sg13cmos5l_decap_8_885 r0 *1 0,0
Xsg13cmos5l_decap_8_885 VPWR VGND sg13cmos5l_decap_8
* cell instance sg13cmos5l_decap_8_886 r0 *1 0,0
Xsg13cmos5l_decap_8_886 VPWR VGND sg13cmos5l_decap_8
* cell instance sg13cmos5l_decap_8_887 r0 *1 0,0
Xsg13cmos5l_decap_8_887 VPWR VGND sg13cmos5l_decap_8
* cell instance sg13cmos5l_decap_8_888 r0 *1 0,0
Xsg13cmos5l_decap_8_888 VPWR VGND sg13cmos5l_decap_8
* cell instance sg13cmos5l_decap_8_889 r0 *1 0,0
Xsg13cmos5l_decap_8_889 VPWR VGND sg13cmos5l_decap_8
* cell instance sg13cmos5l_decap_8_890 r0 *1 0,0
Xsg13cmos5l_decap_8_890 VPWR VGND sg13cmos5l_decap_8
* cell instance sg13cmos5l_decap_8_891 r0 *1 0,0
Xsg13cmos5l_decap_8_891 VPWR VGND sg13cmos5l_decap_8
* cell instance sg13cmos5l_decap_8_892 r0 *1 0,0
Xsg13cmos5l_decap_8_892 VPWR VGND sg13cmos5l_decap_8
* cell instance sg13cmos5l_decap_8_893 r0 *1 0,0
Xsg13cmos5l_decap_8_893 VPWR VGND sg13cmos5l_decap_8
* cell instance sg13cmos5l_decap_8_894 r0 *1 0,0
Xsg13cmos5l_decap_8_894 VPWR VGND sg13cmos5l_decap_8
* cell instance sg13cmos5l_decap_8_895 r0 *1 0,0
Xsg13cmos5l_decap_8_895 VPWR VGND sg13cmos5l_decap_8
* cell instance sg13cmos5l_decap_8_896 r0 *1 0,0
Xsg13cmos5l_decap_8_896 VPWR VGND sg13cmos5l_decap_8
* cell instance sg13cmos5l_decap_8_897 r0 *1 0,0
Xsg13cmos5l_decap_8_897 VPWR VGND sg13cmos5l_decap_8
* cell instance sg13cmos5l_decap_8_898 r0 *1 0,0
Xsg13cmos5l_decap_8_898 VPWR VGND sg13cmos5l_decap_8
* cell instance sg13cmos5l_decap_8_899 r0 *1 0,0
Xsg13cmos5l_decap_8_899 VPWR VGND sg13cmos5l_decap_8
* cell instance sg13cmos5l_decap_8_900 r0 *1 0,0
Xsg13cmos5l_decap_8_900 VPWR VGND sg13cmos5l_decap_8
* cell instance sg13cmos5l_decap_8_901 r0 *1 0,0
Xsg13cmos5l_decap_8_901 VPWR VGND sg13cmos5l_decap_8
* cell instance sg13cmos5l_decap_8_902 r0 *1 0,0
Xsg13cmos5l_decap_8_902 VPWR VGND sg13cmos5l_decap_8
* cell instance sg13cmos5l_decap_8_903 r0 *1 0,0
Xsg13cmos5l_decap_8_903 VPWR VGND sg13cmos5l_decap_8
* cell instance sg13cmos5l_decap_8_904 r0 *1 0,0
Xsg13cmos5l_decap_8_904 VPWR VGND sg13cmos5l_decap_8
* cell instance sg13cmos5l_decap_8_905 r0 *1 0,0
Xsg13cmos5l_decap_8_905 VPWR VGND sg13cmos5l_decap_8
* cell instance sg13cmos5l_decap_8_906 r0 *1 0,0
Xsg13cmos5l_decap_8_906 VPWR VGND sg13cmos5l_decap_8
* cell instance sg13cmos5l_decap_8_907 r0 *1 0,0
Xsg13cmos5l_decap_8_907 VPWR VGND sg13cmos5l_decap_8
* cell instance sg13cmos5l_decap_8_908 r0 *1 0,0
Xsg13cmos5l_decap_8_908 VPWR VGND sg13cmos5l_decap_8
* cell instance sg13cmos5l_decap_8_909 r0 *1 0,0
Xsg13cmos5l_decap_8_909 VPWR VGND sg13cmos5l_decap_8
* cell instance sg13cmos5l_decap_8_910 r0 *1 0,0
Xsg13cmos5l_decap_8_910 VPWR VGND sg13cmos5l_decap_8
* cell instance sg13cmos5l_decap_8_911 r0 *1 0,0
Xsg13cmos5l_decap_8_911 VPWR VGND sg13cmos5l_decap_8
* cell instance sg13cmos5l_decap_8_912 r0 *1 0,0
Xsg13cmos5l_decap_8_912 VPWR VGND sg13cmos5l_decap_8
* cell instance sg13cmos5l_decap_8_913 r0 *1 0,0
Xsg13cmos5l_decap_8_913 VPWR VGND sg13cmos5l_decap_8
* cell instance sg13cmos5l_decap_8_914 r0 *1 0,0
Xsg13cmos5l_decap_8_914 VPWR VGND sg13cmos5l_decap_8
* cell instance sg13cmos5l_decap_8_915 r0 *1 0,0
Xsg13cmos5l_decap_8_915 VPWR VGND sg13cmos5l_decap_8
* cell instance sg13cmos5l_decap_8_916 r0 *1 0,0
Xsg13cmos5l_decap_8_916 VPWR VGND sg13cmos5l_decap_8
* cell instance sg13cmos5l_decap_8_917 r0 *1 0,0
Xsg13cmos5l_decap_8_917 VPWR VGND sg13cmos5l_decap_8
* cell instance sg13cmos5l_decap_8_918 r0 *1 0,0
Xsg13cmos5l_decap_8_918 VPWR VGND sg13cmos5l_decap_8
* cell instance sg13cmos5l_decap_8_919 r0 *1 0,0
Xsg13cmos5l_decap_8_919 VPWR VGND sg13cmos5l_decap_8
* cell instance sg13cmos5l_decap_8_920 r0 *1 0,0
Xsg13cmos5l_decap_8_920 VPWR VGND sg13cmos5l_decap_8
* cell instance sg13cmos5l_decap_8_921 r0 *1 0,0
Xsg13cmos5l_decap_8_921 VPWR VGND sg13cmos5l_decap_8
* cell instance sg13cmos5l_decap_8_922 r0 *1 0,0
Xsg13cmos5l_decap_8_922 VPWR VGND sg13cmos5l_decap_8
* cell instance sg13cmos5l_decap_8_923 r0 *1 0,0
Xsg13cmos5l_decap_8_923 VPWR VGND sg13cmos5l_decap_8
* cell instance sg13cmos5l_decap_8_924 r0 *1 0,0
Xsg13cmos5l_decap_8_924 VPWR VGND sg13cmos5l_decap_8
* cell instance sg13cmos5l_decap_8_925 r0 *1 0,0
Xsg13cmos5l_decap_8_925 VPWR VGND sg13cmos5l_decap_8
* cell instance sg13cmos5l_decap_8_926 r0 *1 0,0
Xsg13cmos5l_decap_8_926 VPWR VGND sg13cmos5l_decap_8
* cell instance sg13cmos5l_decap_8_927 r0 *1 0,0
Xsg13cmos5l_decap_8_927 VPWR VGND sg13cmos5l_decap_8
* cell instance sg13cmos5l_decap_8_928 r0 *1 0,0
Xsg13cmos5l_decap_8_928 VPWR VGND sg13cmos5l_decap_8
* cell instance sg13cmos5l_decap_8_929 r0 *1 0,0
Xsg13cmos5l_decap_8_929 VPWR VGND sg13cmos5l_decap_8
* cell instance sg13cmos5l_decap_8_930 r0 *1 0,0
Xsg13cmos5l_decap_8_930 VPWR VGND sg13cmos5l_decap_8
* cell instance sg13cmos5l_decap_8_931 r0 *1 0,0
Xsg13cmos5l_decap_8_931 VPWR VGND sg13cmos5l_decap_8
* cell instance sg13cmos5l_decap_8_932 r0 *1 0,0
Xsg13cmos5l_decap_8_932 VPWR VGND sg13cmos5l_decap_8
* cell instance sg13cmos5l_decap_8_933 r0 *1 0,0
Xsg13cmos5l_decap_8_933 VPWR VGND sg13cmos5l_decap_8
* cell instance sg13cmos5l_decap_8_934 r0 *1 0,0
Xsg13cmos5l_decap_8_934 VPWR VGND sg13cmos5l_decap_8
* cell instance sg13cmos5l_decap_8_935 r0 *1 0,0
Xsg13cmos5l_decap_8_935 VPWR VGND sg13cmos5l_decap_8
* cell instance sg13cmos5l_decap_8_936 r0 *1 0,0
Xsg13cmos5l_decap_8_936 VPWR VGND sg13cmos5l_decap_8
* cell instance sg13cmos5l_decap_8_937 r0 *1 0,0
Xsg13cmos5l_decap_8_937 VPWR VGND sg13cmos5l_decap_8
* cell instance sg13cmos5l_decap_8_938 r0 *1 0,0
Xsg13cmos5l_decap_8_938 VPWR VGND sg13cmos5l_decap_8
* cell instance sg13cmos5l_decap_8_939 r0 *1 0,0
Xsg13cmos5l_decap_8_939 VPWR VGND sg13cmos5l_decap_8
* cell instance sg13cmos5l_decap_8_940 r0 *1 0,0
Xsg13cmos5l_decap_8_940 VPWR VGND sg13cmos5l_decap_8
* cell instance sg13cmos5l_decap_8_941 r0 *1 0,0
Xsg13cmos5l_decap_8_941 VPWR VGND sg13cmos5l_decap_8
* cell instance sg13cmos5l_decap_8_942 r0 *1 0,0
Xsg13cmos5l_decap_8_942 VPWR VGND sg13cmos5l_decap_8
* cell instance sg13cmos5l_decap_8_943 r0 *1 0,0
Xsg13cmos5l_decap_8_943 VPWR VGND sg13cmos5l_decap_8
* cell instance sg13cmos5l_decap_8_944 r0 *1 0,0
Xsg13cmos5l_decap_8_944 VPWR VGND sg13cmos5l_decap_8
* cell instance sg13cmos5l_decap_8_945 r0 *1 0,0
Xsg13cmos5l_decap_8_945 VPWR VGND sg13cmos5l_decap_8
* cell instance sg13cmos5l_decap_8_946 r0 *1 0,0
Xsg13cmos5l_decap_8_946 VPWR VGND sg13cmos5l_decap_8
* cell instance sg13cmos5l_decap_8_947 r0 *1 0,0
Xsg13cmos5l_decap_8_947 VPWR VGND sg13cmos5l_decap_8
* cell instance sg13cmos5l_decap_8_948 r0 *1 0,0
Xsg13cmos5l_decap_8_948 VPWR VGND sg13cmos5l_decap_8
* cell instance sg13cmos5l_decap_8_949 r0 *1 0,0
Xsg13cmos5l_decap_8_949 VPWR VGND sg13cmos5l_decap_8
* cell instance sg13cmos5l_decap_8_950 r0 *1 0,0
Xsg13cmos5l_decap_8_950 VPWR VGND sg13cmos5l_decap_8
* cell instance sg13cmos5l_decap_8_951 r0 *1 0,0
Xsg13cmos5l_decap_8_951 VPWR VGND sg13cmos5l_decap_8
* cell instance sg13cmos5l_decap_8_952 r0 *1 0,0
Xsg13cmos5l_decap_8_952 VPWR VGND sg13cmos5l_decap_8
* cell instance sg13cmos5l_decap_8_953 r0 *1 0,0
Xsg13cmos5l_decap_8_953 VPWR VGND sg13cmos5l_decap_8
* cell instance sg13cmos5l_decap_8_954 r0 *1 0,0
Xsg13cmos5l_decap_8_954 VPWR VGND sg13cmos5l_decap_8
* cell instance sg13cmos5l_decap_8_955 r0 *1 0,0
Xsg13cmos5l_decap_8_955 VPWR VGND sg13cmos5l_decap_8
* cell instance sg13cmos5l_decap_8_956 r0 *1 0,0
Xsg13cmos5l_decap_8_956 VPWR VGND sg13cmos5l_decap_8
* cell instance sg13cmos5l_decap_8_957 r0 *1 0,0
Xsg13cmos5l_decap_8_957 VPWR VGND sg13cmos5l_decap_8
* cell instance sg13cmos5l_decap_8_958 r0 *1 0,0
Xsg13cmos5l_decap_8_958 VPWR VGND sg13cmos5l_decap_8
* cell instance sg13cmos5l_decap_8_959 r0 *1 0,0
Xsg13cmos5l_decap_8_959 VPWR VGND sg13cmos5l_decap_8
* cell instance sg13cmos5l_decap_8_960 r0 *1 0,0
Xsg13cmos5l_decap_8_960 VPWR VGND sg13cmos5l_decap_8
* cell instance sg13cmos5l_decap_8_961 r0 *1 0,0
Xsg13cmos5l_decap_8_961 VPWR VGND sg13cmos5l_decap_8
* cell instance sg13cmos5l_decap_8_962 r0 *1 0,0
Xsg13cmos5l_decap_8_962 VPWR VGND sg13cmos5l_decap_8
* cell instance sg13cmos5l_decap_8_963 r0 *1 0,0
Xsg13cmos5l_decap_8_963 VPWR VGND sg13cmos5l_decap_8
* cell instance sg13cmos5l_decap_8_964 r0 *1 0,0
Xsg13cmos5l_decap_8_964 VPWR VGND sg13cmos5l_decap_8
* cell instance sg13cmos5l_decap_8_965 r0 *1 0,0
Xsg13cmos5l_decap_8_965 VPWR VGND sg13cmos5l_decap_8
* cell instance sg13cmos5l_decap_8_966 r0 *1 0,0
Xsg13cmos5l_decap_8_966 VPWR VGND sg13cmos5l_decap_8
* cell instance sg13cmos5l_decap_8_967 r0 *1 0,0
Xsg13cmos5l_decap_8_967 VPWR VGND sg13cmos5l_decap_8
* cell instance sg13cmos5l_decap_8_968 r0 *1 0,0
Xsg13cmos5l_decap_8_968 VPWR VGND sg13cmos5l_decap_8
* cell instance sg13cmos5l_decap_8_969 r0 *1 0,0
Xsg13cmos5l_decap_8_969 VPWR VGND sg13cmos5l_decap_8
* cell instance sg13cmos5l_decap_8_970 r0 *1 0,0
Xsg13cmos5l_decap_8_970 VPWR VGND sg13cmos5l_decap_8
* cell instance sg13cmos5l_decap_8_971 r0 *1 0,0
Xsg13cmos5l_decap_8_971 VPWR VGND sg13cmos5l_decap_8
* cell instance sg13cmos5l_decap_8_972 r0 *1 0,0
Xsg13cmos5l_decap_8_972 VPWR VGND sg13cmos5l_decap_8
* cell instance sg13cmos5l_decap_8_973 r0 *1 0,0
Xsg13cmos5l_decap_8_973 VPWR VGND sg13cmos5l_decap_8
* cell instance sg13cmos5l_decap_8_974 r0 *1 0,0
Xsg13cmos5l_decap_8_974 VPWR VGND sg13cmos5l_decap_8
* cell instance sg13cmos5l_decap_8_975 r0 *1 0,0
Xsg13cmos5l_decap_8_975 VPWR VGND sg13cmos5l_decap_8
* cell instance sg13cmos5l_decap_8_976 r0 *1 0,0
Xsg13cmos5l_decap_8_976 VPWR VGND sg13cmos5l_decap_8
* cell instance sg13cmos5l_decap_8_977 r0 *1 0,0
Xsg13cmos5l_decap_8_977 VPWR VGND sg13cmos5l_decap_8
* cell instance sg13cmos5l_decap_8_978 r0 *1 0,0
Xsg13cmos5l_decap_8_978 VPWR VGND sg13cmos5l_decap_8
* cell instance sg13cmos5l_decap_8_979 r0 *1 0,0
Xsg13cmos5l_decap_8_979 VPWR VGND sg13cmos5l_decap_8
* cell instance sg13cmos5l_decap_8_980 r0 *1 0,0
Xsg13cmos5l_decap_8_980 VPWR VGND sg13cmos5l_decap_8
* cell instance sg13cmos5l_decap_8_981 r0 *1 0,0
Xsg13cmos5l_decap_8_981 VPWR VGND sg13cmos5l_decap_8
* cell instance sg13cmos5l_decap_8_982 r0 *1 0,0
Xsg13cmos5l_decap_8_982 VPWR VGND sg13cmos5l_decap_8
* cell instance sg13cmos5l_decap_8_983 r0 *1 0,0
Xsg13cmos5l_decap_8_983 VPWR VGND sg13cmos5l_decap_8
* cell instance sg13cmos5l_decap_8_984 r0 *1 0,0
Xsg13cmos5l_decap_8_984 VPWR VGND sg13cmos5l_decap_8
* cell instance sg13cmos5l_decap_8_985 r0 *1 0,0
Xsg13cmos5l_decap_8_985 VPWR VGND sg13cmos5l_decap_8
* cell instance sg13cmos5l_decap_8_986 r0 *1 0,0
Xsg13cmos5l_decap_8_986 VPWR VGND sg13cmos5l_decap_8
* cell instance sg13cmos5l_decap_8_987 r0 *1 0,0
Xsg13cmos5l_decap_8_987 VPWR VGND sg13cmos5l_decap_8
* cell instance sg13cmos5l_decap_8_988 r0 *1 0,0
Xsg13cmos5l_decap_8_988 VPWR VGND sg13cmos5l_decap_8
* cell instance sg13cmos5l_decap_8_989 r0 *1 0,0
Xsg13cmos5l_decap_8_989 VPWR VGND sg13cmos5l_decap_8
* cell instance sg13cmos5l_decap_8_990 r0 *1 0,0
Xsg13cmos5l_decap_8_990 VPWR VGND sg13cmos5l_decap_8
* cell instance sg13cmos5l_decap_8_991 r0 *1 0,0
Xsg13cmos5l_decap_8_991 VPWR VGND sg13cmos5l_decap_8
* cell instance sg13cmos5l_decap_8_992 r0 *1 0,0
Xsg13cmos5l_decap_8_992 VPWR VGND sg13cmos5l_decap_8
* cell instance sg13cmos5l_decap_8_993 r0 *1 0,0
Xsg13cmos5l_decap_8_993 VPWR VGND sg13cmos5l_decap_8
* cell instance sg13cmos5l_decap_8_994 r0 *1 0,0
Xsg13cmos5l_decap_8_994 VPWR VGND sg13cmos5l_decap_8
* cell instance sg13cmos5l_decap_8_995 r0 *1 0,0
Xsg13cmos5l_decap_8_995 VPWR VGND sg13cmos5l_decap_8
* cell instance sg13cmos5l_decap_8_996 r0 *1 0,0
Xsg13cmos5l_decap_8_996 VPWR VGND sg13cmos5l_decap_8
* cell instance sg13cmos5l_decap_8_997 r0 *1 0,0
Xsg13cmos5l_decap_8_997 VPWR VGND sg13cmos5l_decap_8
* cell instance sg13cmos5l_decap_8_998 r0 *1 0,0
Xsg13cmos5l_decap_8_998 VPWR VGND sg13cmos5l_decap_8
* cell instance sg13cmos5l_decap_8_999 r0 *1 0,0
Xsg13cmos5l_decap_8_999 VPWR VGND sg13cmos5l_decap_8
* cell instance sg13cmos5l_decap_8_1000 r0 *1 0,0
Xsg13cmos5l_decap_8_1000 VPWR VGND sg13cmos5l_decap_8
* cell instance sg13cmos5l_decap_8_1001 r0 *1 0,0
Xsg13cmos5l_decap_8_1001 VPWR VGND sg13cmos5l_decap_8
* cell instance sg13cmos5l_decap_8_1002 r0 *1 0,0
Xsg13cmos5l_decap_8_1002 VPWR VGND sg13cmos5l_decap_8
* cell instance sg13cmos5l_decap_8_1003 r0 *1 0,0
Xsg13cmos5l_decap_8_1003 VPWR VGND sg13cmos5l_decap_8
* cell instance sg13cmos5l_decap_8_1004 r0 *1 0,0
Xsg13cmos5l_decap_8_1004 VPWR VGND sg13cmos5l_decap_8
* cell instance sg13cmos5l_decap_8_1005 r0 *1 0,0
Xsg13cmos5l_decap_8_1005 VPWR VGND sg13cmos5l_decap_8
* cell instance sg13cmos5l_decap_8_1006 r0 *1 0,0
Xsg13cmos5l_decap_8_1006 VPWR VGND sg13cmos5l_decap_8
* cell instance sg13cmos5l_decap_8_1007 r0 *1 0,0
Xsg13cmos5l_decap_8_1007 VPWR VGND sg13cmos5l_decap_8
* cell instance sg13cmos5l_decap_8_1008 r0 *1 0,0
Xsg13cmos5l_decap_8_1008 VPWR VGND sg13cmos5l_decap_8
* cell instance sg13cmos5l_decap_8_1009 r0 *1 0,0
Xsg13cmos5l_decap_8_1009 VPWR VGND sg13cmos5l_decap_8
* cell instance sg13cmos5l_decap_8_1010 r0 *1 0,0
Xsg13cmos5l_decap_8_1010 VPWR VGND sg13cmos5l_decap_8
* cell instance sg13cmos5l_decap_8_1011 r0 *1 0,0
Xsg13cmos5l_decap_8_1011 VPWR VGND sg13cmos5l_decap_8
* cell instance sg13cmos5l_decap_8_1012 r0 *1 0,0
Xsg13cmos5l_decap_8_1012 VPWR VGND sg13cmos5l_decap_8
* cell instance sg13cmos5l_decap_8_1013 r0 *1 0,0
Xsg13cmos5l_decap_8_1013 VPWR VGND sg13cmos5l_decap_8
* cell instance sg13cmos5l_decap_8_1014 r0 *1 0,0
Xsg13cmos5l_decap_8_1014 VPWR VGND sg13cmos5l_decap_8
* cell instance sg13cmos5l_decap_8_1015 r0 *1 0,0
Xsg13cmos5l_decap_8_1015 VPWR VGND sg13cmos5l_decap_8
* cell instance sg13cmos5l_decap_8_1016 r0 *1 0,0
Xsg13cmos5l_decap_8_1016 VPWR VGND sg13cmos5l_decap_8
* cell instance sg13cmos5l_decap_8_1017 r0 *1 0,0
Xsg13cmos5l_decap_8_1017 VPWR VGND sg13cmos5l_decap_8
* cell instance sg13cmos5l_decap_8_1018 r0 *1 0,0
Xsg13cmos5l_decap_8_1018 VPWR VGND sg13cmos5l_decap_8
* cell instance sg13cmos5l_decap_8_1019 r0 *1 0,0
Xsg13cmos5l_decap_8_1019 VPWR VGND sg13cmos5l_decap_8
* cell instance sg13cmos5l_decap_8_1020 r0 *1 0,0
Xsg13cmos5l_decap_8_1020 VPWR VGND sg13cmos5l_decap_8
* cell instance sg13cmos5l_decap_8_1021 r0 *1 0,0
Xsg13cmos5l_decap_8_1021 VPWR VGND sg13cmos5l_decap_8
* cell instance sg13cmos5l_decap_8_1022 r0 *1 0,0
Xsg13cmos5l_decap_8_1022 VPWR VGND sg13cmos5l_decap_8
* cell instance sg13cmos5l_decap_8_1023 r0 *1 0,0
Xsg13cmos5l_decap_8_1023 VPWR VGND sg13cmos5l_decap_8
* cell instance sg13cmos5l_decap_8_1024 r0 *1 0,0
Xsg13cmos5l_decap_8_1024 VPWR VGND sg13cmos5l_decap_8
* cell instance sg13cmos5l_decap_8_1025 r0 *1 0,0
Xsg13cmos5l_decap_8_1025 VPWR VGND sg13cmos5l_decap_8
* cell instance sg13cmos5l_decap_8_1026 r0 *1 0,0
Xsg13cmos5l_decap_8_1026 VPWR VGND sg13cmos5l_decap_8
* cell instance sg13cmos5l_decap_8_1027 r0 *1 0,0
Xsg13cmos5l_decap_8_1027 VPWR VGND sg13cmos5l_decap_8
* cell instance sg13cmos5l_decap_8_1028 r0 *1 0,0
Xsg13cmos5l_decap_8_1028 VPWR VGND sg13cmos5l_decap_8
* cell instance sg13cmos5l_decap_8_1029 r0 *1 0,0
Xsg13cmos5l_decap_8_1029 VPWR VGND sg13cmos5l_decap_8
* cell instance sg13cmos5l_decap_8_1030 r0 *1 0,0
Xsg13cmos5l_decap_8_1030 VPWR VGND sg13cmos5l_decap_8
* cell instance sg13cmos5l_decap_8_1031 r0 *1 0,0
Xsg13cmos5l_decap_8_1031 VPWR VGND sg13cmos5l_decap_8
* cell instance sg13cmos5l_decap_8_1032 r0 *1 0,0
Xsg13cmos5l_decap_8_1032 VPWR VGND sg13cmos5l_decap_8
* cell instance sg13cmos5l_decap_8_1033 r0 *1 0,0
Xsg13cmos5l_decap_8_1033 VPWR VGND sg13cmos5l_decap_8
* cell instance sg13cmos5l_decap_8_1034 r0 *1 0,0
Xsg13cmos5l_decap_8_1034 VPWR VGND sg13cmos5l_decap_8
* cell instance sg13cmos5l_decap_8_1035 r0 *1 0,0
Xsg13cmos5l_decap_8_1035 VPWR VGND sg13cmos5l_decap_8
* cell instance sg13cmos5l_decap_8_1036 r0 *1 0,0
Xsg13cmos5l_decap_8_1036 VPWR VGND sg13cmos5l_decap_8
* cell instance sg13cmos5l_decap_8_1037 r0 *1 0,0
Xsg13cmos5l_decap_8_1037 VPWR VGND sg13cmos5l_decap_8
* cell instance sg13cmos5l_decap_8_1038 r0 *1 0,0
Xsg13cmos5l_decap_8_1038 VPWR VGND sg13cmos5l_decap_8
* cell instance sg13cmos5l_decap_8_1039 r0 *1 0,0
Xsg13cmos5l_decap_8_1039 VPWR VGND sg13cmos5l_decap_8
* cell instance sg13cmos5l_decap_8_1040 r0 *1 0,0
Xsg13cmos5l_decap_8_1040 VPWR VGND sg13cmos5l_decap_8
* cell instance sg13cmos5l_decap_8_1041 r0 *1 0,0
Xsg13cmos5l_decap_8_1041 VPWR VGND sg13cmos5l_decap_8
* cell instance sg13cmos5l_decap_8_1042 r0 *1 0,0
Xsg13cmos5l_decap_8_1042 VPWR VGND sg13cmos5l_decap_8
* cell instance sg13cmos5l_decap_8_1043 r0 *1 0,0
Xsg13cmos5l_decap_8_1043 VPWR VGND sg13cmos5l_decap_8
* cell instance sg13cmos5l_decap_8_1044 r0 *1 0,0
Xsg13cmos5l_decap_8_1044 VPWR VGND sg13cmos5l_decap_8
* cell instance sg13cmos5l_decap_8_1045 r0 *1 0,0
Xsg13cmos5l_decap_8_1045 VPWR VGND sg13cmos5l_decap_8
* cell instance sg13cmos5l_decap_8_1046 r0 *1 0,0
Xsg13cmos5l_decap_8_1046 VPWR VGND sg13cmos5l_decap_8
* cell instance sg13cmos5l_decap_8_1047 r0 *1 0,0
Xsg13cmos5l_decap_8_1047 VPWR VGND sg13cmos5l_decap_8
* cell instance sg13cmos5l_decap_8_1048 r0 *1 0,0
Xsg13cmos5l_decap_8_1048 VPWR VGND sg13cmos5l_decap_8
* cell instance sg13cmos5l_decap_8_1049 r0 *1 0,0
Xsg13cmos5l_decap_8_1049 VPWR VGND sg13cmos5l_decap_8
* cell instance sg13cmos5l_decap_8_1050 r0 *1 0,0
Xsg13cmos5l_decap_8_1050 VPWR VGND sg13cmos5l_decap_8
* cell instance sg13cmos5l_decap_8_1051 r0 *1 0,0
Xsg13cmos5l_decap_8_1051 VPWR VGND sg13cmos5l_decap_8
* cell instance sg13cmos5l_decap_8_1052 r0 *1 0,0
Xsg13cmos5l_decap_8_1052 VPWR VGND sg13cmos5l_decap_8
* cell instance sg13cmos5l_decap_8_1053 r0 *1 0,0
Xsg13cmos5l_decap_8_1053 VPWR VGND sg13cmos5l_decap_8
* cell instance sg13cmos5l_decap_8_1054 r0 *1 0,0
Xsg13cmos5l_decap_8_1054 VPWR VGND sg13cmos5l_decap_8
* cell instance sg13cmos5l_decap_8_1055 r0 *1 0,0
Xsg13cmos5l_decap_8_1055 VPWR VGND sg13cmos5l_decap_8
* cell instance sg13cmos5l_decap_8_1056 r0 *1 0,0
Xsg13cmos5l_decap_8_1056 VPWR VGND sg13cmos5l_decap_8
* cell instance sg13cmos5l_decap_8_1057 r0 *1 0,0
Xsg13cmos5l_decap_8_1057 VPWR VGND sg13cmos5l_decap_8
* cell instance sg13cmos5l_decap_8_1058 r0 *1 0,0
Xsg13cmos5l_decap_8_1058 VPWR VGND sg13cmos5l_decap_8
* cell instance sg13cmos5l_decap_8_1059 r0 *1 0,0
Xsg13cmos5l_decap_8_1059 VPWR VGND sg13cmos5l_decap_8
* cell instance sg13cmos5l_decap_8_1060 r0 *1 0,0
Xsg13cmos5l_decap_8_1060 VPWR VGND sg13cmos5l_decap_8
* cell instance sg13cmos5l_decap_8_1061 r0 *1 0,0
Xsg13cmos5l_decap_8_1061 VPWR VGND sg13cmos5l_decap_8
* cell instance sg13cmos5l_decap_8_1062 r0 *1 0,0
Xsg13cmos5l_decap_8_1062 VPWR VGND sg13cmos5l_decap_8
* cell instance sg13cmos5l_decap_8_1063 r0 *1 0,0
Xsg13cmos5l_decap_8_1063 VPWR VGND sg13cmos5l_decap_8
* cell instance sg13cmos5l_decap_8_1064 r0 *1 0,0
Xsg13cmos5l_decap_8_1064 VPWR VGND sg13cmos5l_decap_8
* cell instance sg13cmos5l_decap_8_1065 r0 *1 0,0
Xsg13cmos5l_decap_8_1065 VPWR VGND sg13cmos5l_decap_8
* cell instance sg13cmos5l_decap_8_1066 r0 *1 0,0
Xsg13cmos5l_decap_8_1066 VPWR VGND sg13cmos5l_decap_8
* cell instance sg13cmos5l_decap_8_1067 r0 *1 0,0
Xsg13cmos5l_decap_8_1067 VPWR VGND sg13cmos5l_decap_8
* cell instance sg13cmos5l_decap_8_1068 r0 *1 0,0
Xsg13cmos5l_decap_8_1068 VPWR VGND sg13cmos5l_decap_8
* cell instance sg13cmos5l_decap_8_1069 r0 *1 0,0
Xsg13cmos5l_decap_8_1069 VPWR VGND sg13cmos5l_decap_8
* cell instance sg13cmos5l_decap_8_1070 r0 *1 0,0
Xsg13cmos5l_decap_8_1070 VPWR VGND sg13cmos5l_decap_8
* cell instance sg13cmos5l_decap_8_1071 r0 *1 0,0
Xsg13cmos5l_decap_8_1071 VPWR VGND sg13cmos5l_decap_8
* cell instance sg13cmos5l_decap_8_1072 r0 *1 0,0
Xsg13cmos5l_decap_8_1072 VPWR VGND sg13cmos5l_decap_8
* cell instance sg13cmos5l_decap_8_1073 r0 *1 0,0
Xsg13cmos5l_decap_8_1073 VPWR VGND sg13cmos5l_decap_8
* cell instance sg13cmos5l_decap_8_1074 r0 *1 0,0
Xsg13cmos5l_decap_8_1074 VPWR VGND sg13cmos5l_decap_8
* cell instance sg13cmos5l_decap_8_1075 r0 *1 0,0
Xsg13cmos5l_decap_8_1075 VPWR VGND sg13cmos5l_decap_8
* cell instance sg13cmos5l_decap_8_1076 r0 *1 0,0
Xsg13cmos5l_decap_8_1076 VPWR VGND sg13cmos5l_decap_8
* cell instance sg13cmos5l_decap_8_1077 r0 *1 0,0
Xsg13cmos5l_decap_8_1077 VPWR VGND sg13cmos5l_decap_8
* cell instance sg13cmos5l_decap_8_1078 r0 *1 0,0
Xsg13cmos5l_decap_8_1078 VPWR VGND sg13cmos5l_decap_8
* cell instance sg13cmos5l_decap_8_1079 r0 *1 0,0
Xsg13cmos5l_decap_8_1079 VPWR VGND sg13cmos5l_decap_8
* cell instance sg13cmos5l_decap_8_1080 r0 *1 0,0
Xsg13cmos5l_decap_8_1080 VPWR VGND sg13cmos5l_decap_8
* cell instance sg13cmos5l_decap_8_1081 r0 *1 0,0
Xsg13cmos5l_decap_8_1081 VPWR VGND sg13cmos5l_decap_8
* cell instance sg13cmos5l_decap_8_1082 r0 *1 0,0
Xsg13cmos5l_decap_8_1082 VPWR VGND sg13cmos5l_decap_8
* cell instance sg13cmos5l_decap_8_1083 r0 *1 0,0
Xsg13cmos5l_decap_8_1083 VPWR VGND sg13cmos5l_decap_8
* cell instance sg13cmos5l_decap_8_1084 r0 *1 0,0
Xsg13cmos5l_decap_8_1084 VPWR VGND sg13cmos5l_decap_8
* cell instance sg13cmos5l_decap_8_1085 r0 *1 0,0
Xsg13cmos5l_decap_8_1085 VPWR VGND sg13cmos5l_decap_8
* cell instance sg13cmos5l_decap_8_1086 r0 *1 0,0
Xsg13cmos5l_decap_8_1086 VPWR VGND sg13cmos5l_decap_8
* cell instance sg13cmos5l_decap_8_1087 r0 *1 0,0
Xsg13cmos5l_decap_8_1087 VPWR VGND sg13cmos5l_decap_8
* cell instance sg13cmos5l_decap_8_1088 r0 *1 0,0
Xsg13cmos5l_decap_8_1088 VPWR VGND sg13cmos5l_decap_8
* cell instance sg13cmos5l_decap_8_1089 r0 *1 0,0
Xsg13cmos5l_decap_8_1089 VPWR VGND sg13cmos5l_decap_8
* cell instance sg13cmos5l_decap_8_1090 r0 *1 0,0
Xsg13cmos5l_decap_8_1090 VPWR VGND sg13cmos5l_decap_8
* cell instance sg13cmos5l_decap_8_1091 r0 *1 0,0
Xsg13cmos5l_decap_8_1091 VPWR VGND sg13cmos5l_decap_8
* cell instance sg13cmos5l_decap_8_1092 r0 *1 0,0
Xsg13cmos5l_decap_8_1092 VPWR VGND sg13cmos5l_decap_8
* cell instance sg13cmos5l_decap_8_1093 r0 *1 0,0
Xsg13cmos5l_decap_8_1093 VPWR VGND sg13cmos5l_decap_8
* cell instance sg13cmos5l_decap_8_1094 r0 *1 0,0
Xsg13cmos5l_decap_8_1094 VPWR VGND sg13cmos5l_decap_8
* cell instance sg13cmos5l_decap_8_1095 r0 *1 0,0
Xsg13cmos5l_decap_8_1095 VPWR VGND sg13cmos5l_decap_8
* cell instance sg13cmos5l_decap_8_1096 r0 *1 0,0
Xsg13cmos5l_decap_8_1096 VPWR VGND sg13cmos5l_decap_8
* cell instance sg13cmos5l_decap_8_1097 r0 *1 0,0
Xsg13cmos5l_decap_8_1097 VPWR VGND sg13cmos5l_decap_8
* cell instance sg13cmos5l_decap_8_1098 r0 *1 0,0
Xsg13cmos5l_decap_8_1098 VPWR VGND sg13cmos5l_decap_8
* cell instance sg13cmos5l_decap_8_1099 r0 *1 0,0
Xsg13cmos5l_decap_8_1099 VPWR VGND sg13cmos5l_decap_8
* cell instance sg13cmos5l_decap_8_1100 r0 *1 0,0
Xsg13cmos5l_decap_8_1100 VPWR VGND sg13cmos5l_decap_8
* cell instance sg13cmos5l_decap_8_1101 r0 *1 0,0
Xsg13cmos5l_decap_8_1101 VPWR VGND sg13cmos5l_decap_8
* cell instance sg13cmos5l_decap_8_1102 r0 *1 0,0
Xsg13cmos5l_decap_8_1102 VPWR VGND sg13cmos5l_decap_8
* cell instance sg13cmos5l_decap_8_1103 r0 *1 0,0
Xsg13cmos5l_decap_8_1103 VPWR VGND sg13cmos5l_decap_8
* cell instance sg13cmos5l_decap_8_1104 r0 *1 0,0
Xsg13cmos5l_decap_8_1104 VPWR VGND sg13cmos5l_decap_8
* cell instance sg13cmos5l_decap_8_1105 r0 *1 0,0
Xsg13cmos5l_decap_8_1105 VPWR VGND sg13cmos5l_decap_8
* cell instance sg13cmos5l_decap_8_1106 r0 *1 0,0
Xsg13cmos5l_decap_8_1106 VPWR VGND sg13cmos5l_decap_8
* cell instance sg13cmos5l_decap_8_1107 r0 *1 0,0
Xsg13cmos5l_decap_8_1107 VPWR VGND sg13cmos5l_decap_8
* cell instance sg13cmos5l_decap_8_1108 r0 *1 0,0
Xsg13cmos5l_decap_8_1108 VPWR VGND sg13cmos5l_decap_8
* cell instance sg13cmos5l_decap_8_1109 r0 *1 0,0
Xsg13cmos5l_decap_8_1109 VPWR VGND sg13cmos5l_decap_8
* cell instance sg13cmos5l_decap_8_1110 r0 *1 0,0
Xsg13cmos5l_decap_8_1110 VPWR VGND sg13cmos5l_decap_8
* cell instance sg13cmos5l_decap_8_1111 r0 *1 0,0
Xsg13cmos5l_decap_8_1111 VPWR VGND sg13cmos5l_decap_8
* cell instance sg13cmos5l_decap_8_1112 r0 *1 0,0
Xsg13cmos5l_decap_8_1112 VPWR VGND sg13cmos5l_decap_8
* cell instance sg13cmos5l_decap_8_1113 r0 *1 0,0
Xsg13cmos5l_decap_8_1113 VPWR VGND sg13cmos5l_decap_8
* cell instance sg13cmos5l_decap_8_1114 r0 *1 0,0
Xsg13cmos5l_decap_8_1114 VPWR VGND sg13cmos5l_decap_8
* cell instance sg13cmos5l_decap_8_1115 r0 *1 0,0
Xsg13cmos5l_decap_8_1115 VPWR VGND sg13cmos5l_decap_8
* cell instance sg13cmos5l_decap_8_1116 r0 *1 0,0
Xsg13cmos5l_decap_8_1116 VPWR VGND sg13cmos5l_decap_8
* cell instance sg13cmos5l_decap_8_1117 r0 *1 0,0
Xsg13cmos5l_decap_8_1117 VPWR VGND sg13cmos5l_decap_8
* cell instance sg13cmos5l_decap_8_1118 r0 *1 0,0
Xsg13cmos5l_decap_8_1118 VPWR VGND sg13cmos5l_decap_8
* cell instance sg13cmos5l_decap_8_1119 r0 *1 0,0
Xsg13cmos5l_decap_8_1119 VPWR VGND sg13cmos5l_decap_8
* cell instance sg13cmos5l_decap_8_1120 r0 *1 0,0
Xsg13cmos5l_decap_8_1120 VPWR VGND sg13cmos5l_decap_8
* cell instance sg13cmos5l_decap_8_1121 r0 *1 0,0
Xsg13cmos5l_decap_8_1121 VPWR VGND sg13cmos5l_decap_8
* cell instance sg13cmos5l_decap_8_1122 r0 *1 0,0
Xsg13cmos5l_decap_8_1122 VPWR VGND sg13cmos5l_decap_8
* cell instance sg13cmos5l_decap_8_1123 r0 *1 0,0
Xsg13cmos5l_decap_8_1123 VPWR VGND sg13cmos5l_decap_8
* cell instance sg13cmos5l_decap_8_1124 r0 *1 0,0
Xsg13cmos5l_decap_8_1124 VPWR VGND sg13cmos5l_decap_8
* cell instance sg13cmos5l_decap_8_1125 r0 *1 0,0
Xsg13cmos5l_decap_8_1125 VPWR VGND sg13cmos5l_decap_8
* cell instance sg13cmos5l_decap_8_1126 r0 *1 0,0
Xsg13cmos5l_decap_8_1126 VPWR VGND sg13cmos5l_decap_8
* cell instance sg13cmos5l_decap_8_1127 r0 *1 0,0
Xsg13cmos5l_decap_8_1127 VPWR VGND sg13cmos5l_decap_8
* cell instance sg13cmos5l_decap_8_1128 r0 *1 0,0
Xsg13cmos5l_decap_8_1128 VPWR VGND sg13cmos5l_decap_8
* cell instance sg13cmos5l_decap_8_1129 r0 *1 0,0
Xsg13cmos5l_decap_8_1129 VPWR VGND sg13cmos5l_decap_8
* cell instance sg13cmos5l_decap_8_1130 r0 *1 0,0
Xsg13cmos5l_decap_8_1130 VPWR VGND sg13cmos5l_decap_8
* cell instance sg13cmos5l_decap_8_1131 r0 *1 0,0
Xsg13cmos5l_decap_8_1131 VPWR VGND sg13cmos5l_decap_8
* cell instance sg13cmos5l_decap_8_1132 r0 *1 0,0
Xsg13cmos5l_decap_8_1132 VPWR VGND sg13cmos5l_decap_8
* cell instance sg13cmos5l_decap_8_1133 r0 *1 0,0
Xsg13cmos5l_decap_8_1133 VPWR VGND sg13cmos5l_decap_8
* cell instance sg13cmos5l_decap_8_1134 r0 *1 0,0
Xsg13cmos5l_decap_8_1134 VPWR VGND sg13cmos5l_decap_8
* cell instance sg13cmos5l_decap_8_1135 r0 *1 0,0
Xsg13cmos5l_decap_8_1135 VPWR VGND sg13cmos5l_decap_8
* cell instance sg13cmos5l_decap_8_1136 r0 *1 0,0
Xsg13cmos5l_decap_8_1136 VPWR VGND sg13cmos5l_decap_8
* cell instance sg13cmos5l_decap_8_1137 r0 *1 0,0
Xsg13cmos5l_decap_8_1137 VPWR VGND sg13cmos5l_decap_8
* cell instance sg13cmos5l_decap_8_1138 r0 *1 0,0
Xsg13cmos5l_decap_8_1138 VPWR VGND sg13cmos5l_decap_8
* cell instance sg13cmos5l_decap_8_1139 r0 *1 0,0
Xsg13cmos5l_decap_8_1139 VPWR VGND sg13cmos5l_decap_8
* cell instance sg13cmos5l_decap_8_1140 r0 *1 0,0
Xsg13cmos5l_decap_8_1140 VPWR VGND sg13cmos5l_decap_8
* cell instance sg13cmos5l_decap_8_1141 r0 *1 0,0
Xsg13cmos5l_decap_8_1141 VPWR VGND sg13cmos5l_decap_8
* cell instance sg13cmos5l_decap_8_1142 r0 *1 0,0
Xsg13cmos5l_decap_8_1142 VPWR VGND sg13cmos5l_decap_8
* cell instance sg13cmos5l_decap_8_1143 r0 *1 0,0
Xsg13cmos5l_decap_8_1143 VPWR VGND sg13cmos5l_decap_8
* cell instance sg13cmos5l_decap_8_1144 r0 *1 0,0
Xsg13cmos5l_decap_8_1144 VPWR VGND sg13cmos5l_decap_8
* cell instance sg13cmos5l_decap_8_1145 r0 *1 0,0
Xsg13cmos5l_decap_8_1145 VPWR VGND sg13cmos5l_decap_8
* cell instance sg13cmos5l_decap_8_1146 r0 *1 0,0
Xsg13cmos5l_decap_8_1146 VPWR VGND sg13cmos5l_decap_8
* cell instance sg13cmos5l_decap_8_1147 r0 *1 0,0
Xsg13cmos5l_decap_8_1147 VPWR VGND sg13cmos5l_decap_8
* cell instance sg13cmos5l_decap_8_1148 r0 *1 0,0
Xsg13cmos5l_decap_8_1148 VPWR VGND sg13cmos5l_decap_8
* cell instance sg13cmos5l_decap_8_1149 r0 *1 0,0
Xsg13cmos5l_decap_8_1149 VPWR VGND sg13cmos5l_decap_8
* cell instance sg13cmos5l_decap_8_1150 r0 *1 0,0
Xsg13cmos5l_decap_8_1150 VPWR VGND sg13cmos5l_decap_8
* cell instance sg13cmos5l_decap_8_1151 r0 *1 0,0
Xsg13cmos5l_decap_8_1151 VPWR VGND sg13cmos5l_decap_8
* cell instance sg13cmos5l_decap_8_1152 r0 *1 0,0
Xsg13cmos5l_decap_8_1152 VPWR VGND sg13cmos5l_decap_8
* cell instance sg13cmos5l_decap_8_1153 r0 *1 0,0
Xsg13cmos5l_decap_8_1153 VPWR VGND sg13cmos5l_decap_8
* cell instance sg13cmos5l_decap_8_1154 r0 *1 0,0
Xsg13cmos5l_decap_8_1154 VPWR VGND sg13cmos5l_decap_8
* cell instance sg13cmos5l_decap_8_1155 r0 *1 0,0
Xsg13cmos5l_decap_8_1155 VPWR VGND sg13cmos5l_decap_8
* cell instance sg13cmos5l_decap_8_1156 r0 *1 0,0
Xsg13cmos5l_decap_8_1156 VPWR VGND sg13cmos5l_decap_8
* cell instance sg13cmos5l_decap_8_1157 r0 *1 0,0
Xsg13cmos5l_decap_8_1157 VPWR VGND sg13cmos5l_decap_8
* cell instance sg13cmos5l_decap_8_1158 r0 *1 0,0
Xsg13cmos5l_decap_8_1158 VPWR VGND sg13cmos5l_decap_8
* cell instance sg13cmos5l_decap_8_1159 r0 *1 0,0
Xsg13cmos5l_decap_8_1159 VPWR VGND sg13cmos5l_decap_8
* cell instance sg13cmos5l_decap_8_1160 r0 *1 0,0
Xsg13cmos5l_decap_8_1160 VPWR VGND sg13cmos5l_decap_8
* cell instance sg13cmos5l_decap_8_1161 r0 *1 0,0
Xsg13cmos5l_decap_8_1161 VPWR VGND sg13cmos5l_decap_8
* cell instance sg13cmos5l_decap_8_1162 r0 *1 0,0
Xsg13cmos5l_decap_8_1162 VPWR VGND sg13cmos5l_decap_8
* cell instance sg13cmos5l_decap_8_1163 r0 *1 0,0
Xsg13cmos5l_decap_8_1163 VPWR VGND sg13cmos5l_decap_8
* cell instance sg13cmos5l_decap_8_1164 r0 *1 0,0
Xsg13cmos5l_decap_8_1164 VPWR VGND sg13cmos5l_decap_8
* cell instance sg13cmos5l_decap_8_1165 r0 *1 0,0
Xsg13cmos5l_decap_8_1165 VPWR VGND sg13cmos5l_decap_8
* cell instance sg13cmos5l_decap_8_1166 r0 *1 0,0
Xsg13cmos5l_decap_8_1166 VPWR VGND sg13cmos5l_decap_8
* cell instance sg13cmos5l_decap_8_1167 r0 *1 0,0
Xsg13cmos5l_decap_8_1167 VPWR VGND sg13cmos5l_decap_8
* cell instance sg13cmos5l_decap_8_1168 r0 *1 0,0
Xsg13cmos5l_decap_8_1168 VPWR VGND sg13cmos5l_decap_8
* cell instance sg13cmos5l_decap_8_1169 r0 *1 0,0
Xsg13cmos5l_decap_8_1169 VPWR VGND sg13cmos5l_decap_8
* cell instance sg13cmos5l_decap_8_1170 r0 *1 0,0
Xsg13cmos5l_decap_8_1170 VPWR VGND sg13cmos5l_decap_8
* cell instance sg13cmos5l_decap_8_1171 r0 *1 0,0
Xsg13cmos5l_decap_8_1171 VPWR VGND sg13cmos5l_decap_8
* cell instance sg13cmos5l_decap_8_1172 r0 *1 0,0
Xsg13cmos5l_decap_8_1172 VPWR VGND sg13cmos5l_decap_8
* cell instance sg13cmos5l_decap_8_1173 r0 *1 0,0
Xsg13cmos5l_decap_8_1173 VPWR VGND sg13cmos5l_decap_8
* cell instance sg13cmos5l_decap_8_1174 r0 *1 0,0
Xsg13cmos5l_decap_8_1174 VPWR VGND sg13cmos5l_decap_8
* cell instance sg13cmos5l_decap_8_1175 r0 *1 0,0
Xsg13cmos5l_decap_8_1175 VPWR VGND sg13cmos5l_decap_8
* cell instance sg13cmos5l_decap_8_1176 r0 *1 0,0
Xsg13cmos5l_decap_8_1176 VPWR VGND sg13cmos5l_decap_8
* cell instance sg13cmos5l_decap_8_1177 r0 *1 0,0
Xsg13cmos5l_decap_8_1177 VPWR VGND sg13cmos5l_decap_8
* cell instance sg13cmos5l_decap_8_1178 r0 *1 0,0
Xsg13cmos5l_decap_8_1178 VPWR VGND sg13cmos5l_decap_8
* cell instance sg13cmos5l_decap_8_1179 r0 *1 0,0
Xsg13cmos5l_decap_8_1179 VPWR VGND sg13cmos5l_decap_8
* cell instance sg13cmos5l_decap_8_1180 r0 *1 0,0
Xsg13cmos5l_decap_8_1180 VPWR VGND sg13cmos5l_decap_8
* cell instance sg13cmos5l_decap_8_1181 r0 *1 0,0
Xsg13cmos5l_decap_8_1181 VPWR VGND sg13cmos5l_decap_8
* cell instance sg13cmos5l_decap_8_1182 r0 *1 0,0
Xsg13cmos5l_decap_8_1182 VPWR VGND sg13cmos5l_decap_8
* cell instance sg13cmos5l_decap_8_1183 r0 *1 0,0
Xsg13cmos5l_decap_8_1183 VPWR VGND sg13cmos5l_decap_8
* cell instance sg13cmos5l_decap_8_1184 r0 *1 0,0
Xsg13cmos5l_decap_8_1184 VPWR VGND sg13cmos5l_decap_8
* cell instance sg13cmos5l_decap_8_1185 r0 *1 0,0
Xsg13cmos5l_decap_8_1185 VPWR VGND sg13cmos5l_decap_8
* cell instance sg13cmos5l_decap_8_1186 r0 *1 0,0
Xsg13cmos5l_decap_8_1186 VPWR VGND sg13cmos5l_decap_8
* cell instance sg13cmos5l_decap_8_1187 r0 *1 0,0
Xsg13cmos5l_decap_8_1187 VPWR VGND sg13cmos5l_decap_8
* cell instance sg13cmos5l_decap_8_1188 r0 *1 0,0
Xsg13cmos5l_decap_8_1188 VPWR VGND sg13cmos5l_decap_8
* cell instance sg13cmos5l_decap_8_1189 r0 *1 0,0
Xsg13cmos5l_decap_8_1189 VPWR VGND sg13cmos5l_decap_8
* cell instance sg13cmos5l_decap_8_1190 r0 *1 0,0
Xsg13cmos5l_decap_8_1190 VPWR VGND sg13cmos5l_decap_8
* cell instance sg13cmos5l_decap_8_1191 r0 *1 0,0
Xsg13cmos5l_decap_8_1191 VPWR VGND sg13cmos5l_decap_8
* cell instance sg13cmos5l_decap_8_1192 r0 *1 0,0
Xsg13cmos5l_decap_8_1192 VPWR VGND sg13cmos5l_decap_8
* cell instance sg13cmos5l_decap_8_1193 r0 *1 0,0
Xsg13cmos5l_decap_8_1193 VPWR VGND sg13cmos5l_decap_8
* cell instance sg13cmos5l_decap_8_1194 r0 *1 0,0
Xsg13cmos5l_decap_8_1194 VPWR VGND sg13cmos5l_decap_8
* cell instance sg13cmos5l_decap_8_1195 r0 *1 0,0
Xsg13cmos5l_decap_8_1195 VPWR VGND sg13cmos5l_decap_8
* cell instance sg13cmos5l_decap_8_1196 r0 *1 0,0
Xsg13cmos5l_decap_8_1196 VPWR VGND sg13cmos5l_decap_8
* cell instance sg13cmos5l_decap_8_1197 r0 *1 0,0
Xsg13cmos5l_decap_8_1197 VPWR VGND sg13cmos5l_decap_8
* cell instance sg13cmos5l_decap_8_1198 r0 *1 0,0
Xsg13cmos5l_decap_8_1198 VPWR VGND sg13cmos5l_decap_8
* cell instance sg13cmos5l_decap_8_1199 r0 *1 0,0
Xsg13cmos5l_decap_8_1199 VPWR VGND sg13cmos5l_decap_8
* cell instance sg13cmos5l_decap_8_1200 r0 *1 0,0
Xsg13cmos5l_decap_8_1200 VPWR VGND sg13cmos5l_decap_8
* cell instance sg13cmos5l_decap_8_1201 r0 *1 0,0
Xsg13cmos5l_decap_8_1201 VPWR VGND sg13cmos5l_decap_8
* cell instance sg13cmos5l_decap_8_1202 r0 *1 0,0
Xsg13cmos5l_decap_8_1202 VPWR VGND sg13cmos5l_decap_8
* cell instance sg13cmos5l_decap_8_1203 r0 *1 0,0
Xsg13cmos5l_decap_8_1203 VPWR VGND sg13cmos5l_decap_8
* cell instance sg13cmos5l_decap_8_1204 r0 *1 0,0
Xsg13cmos5l_decap_8_1204 VPWR VGND sg13cmos5l_decap_8
* cell instance sg13cmos5l_decap_8_1205 r0 *1 0,0
Xsg13cmos5l_decap_8_1205 VPWR VGND sg13cmos5l_decap_8
* cell instance sg13cmos5l_decap_8_1206 r0 *1 0,0
Xsg13cmos5l_decap_8_1206 VPWR VGND sg13cmos5l_decap_8
* cell instance sg13cmos5l_decap_8_1207 r0 *1 0,0
Xsg13cmos5l_decap_8_1207 VPWR VGND sg13cmos5l_decap_8
* cell instance sg13cmos5l_decap_8_1208 r0 *1 0,0
Xsg13cmos5l_decap_8_1208 VPWR VGND sg13cmos5l_decap_8
* cell instance sg13cmos5l_decap_8_1209 r0 *1 0,0
Xsg13cmos5l_decap_8_1209 VPWR VGND sg13cmos5l_decap_8
* cell instance sg13cmos5l_decap_8_1210 r0 *1 0,0
Xsg13cmos5l_decap_8_1210 VPWR VGND sg13cmos5l_decap_8
* cell instance sg13cmos5l_decap_8_1211 r0 *1 0,0
Xsg13cmos5l_decap_8_1211 VPWR VGND sg13cmos5l_decap_8
* cell instance sg13cmos5l_decap_8_1212 r0 *1 0,0
Xsg13cmos5l_decap_8_1212 VPWR VGND sg13cmos5l_decap_8
* cell instance sg13cmos5l_decap_8_1213 r0 *1 0,0
Xsg13cmos5l_decap_8_1213 VPWR VGND sg13cmos5l_decap_8
* cell instance sg13cmos5l_decap_8_1214 r0 *1 0,0
Xsg13cmos5l_decap_8_1214 VPWR VGND sg13cmos5l_decap_8
* cell instance sg13cmos5l_decap_8_1215 r0 *1 0,0
Xsg13cmos5l_decap_8_1215 VPWR VGND sg13cmos5l_decap_8
* cell instance sg13cmos5l_decap_8_1216 r0 *1 0,0
Xsg13cmos5l_decap_8_1216 VPWR VGND sg13cmos5l_decap_8
* cell instance sg13cmos5l_decap_8_1217 r0 *1 0,0
Xsg13cmos5l_decap_8_1217 VPWR VGND sg13cmos5l_decap_8
* cell instance sg13cmos5l_decap_8_1218 r0 *1 0,0
Xsg13cmos5l_decap_8_1218 VPWR VGND sg13cmos5l_decap_8
* cell instance sg13cmos5l_decap_8_1219 r0 *1 0,0
Xsg13cmos5l_decap_8_1219 VPWR VGND sg13cmos5l_decap_8
* cell instance sg13cmos5l_decap_8_1220 r0 *1 0,0
Xsg13cmos5l_decap_8_1220 VPWR VGND sg13cmos5l_decap_8
* cell instance sg13cmos5l_decap_8_1221 r0 *1 0,0
Xsg13cmos5l_decap_8_1221 VPWR VGND sg13cmos5l_decap_8
* cell instance sg13cmos5l_decap_8_1222 r0 *1 0,0
Xsg13cmos5l_decap_8_1222 VPWR VGND sg13cmos5l_decap_8
* cell instance sg13cmos5l_decap_8_1223 r0 *1 0,0
Xsg13cmos5l_decap_8_1223 VPWR VGND sg13cmos5l_decap_8
* cell instance sg13cmos5l_decap_8_1224 r0 *1 0,0
Xsg13cmos5l_decap_8_1224 VPWR VGND sg13cmos5l_decap_8
* cell instance sg13cmos5l_decap_8_1225 r0 *1 0,0
Xsg13cmos5l_decap_8_1225 VPWR VGND sg13cmos5l_decap_8
* cell instance sg13cmos5l_decap_8_1226 r0 *1 0,0
Xsg13cmos5l_decap_8_1226 VPWR VGND sg13cmos5l_decap_8
* cell instance sg13cmos5l_decap_8_1227 r0 *1 0,0
Xsg13cmos5l_decap_8_1227 VPWR VGND sg13cmos5l_decap_8
* cell instance sg13cmos5l_decap_8_1228 r0 *1 0,0
Xsg13cmos5l_decap_8_1228 VPWR VGND sg13cmos5l_decap_8
* cell instance sg13cmos5l_decap_8_1229 r0 *1 0,0
Xsg13cmos5l_decap_8_1229 VPWR VGND sg13cmos5l_decap_8
* cell instance sg13cmos5l_decap_8_1230 r0 *1 0,0
Xsg13cmos5l_decap_8_1230 VPWR VGND sg13cmos5l_decap_8
* cell instance sg13cmos5l_decap_8_1231 r0 *1 0,0
Xsg13cmos5l_decap_8_1231 VPWR VGND sg13cmos5l_decap_8
* cell instance sg13cmos5l_decap_8_1232 r0 *1 0,0
Xsg13cmos5l_decap_8_1232 VPWR VGND sg13cmos5l_decap_8
* cell instance sg13cmos5l_decap_8_1233 r0 *1 0,0
Xsg13cmos5l_decap_8_1233 VPWR VGND sg13cmos5l_decap_8
* cell instance sg13cmos5l_decap_8_1234 r0 *1 0,0
Xsg13cmos5l_decap_8_1234 VPWR VGND sg13cmos5l_decap_8
* cell instance sg13cmos5l_decap_8_1235 r0 *1 0,0
Xsg13cmos5l_decap_8_1235 VPWR VGND sg13cmos5l_decap_8
* cell instance sg13cmos5l_decap_8_1236 r0 *1 0,0
Xsg13cmos5l_decap_8_1236 VPWR VGND sg13cmos5l_decap_8
* cell instance sg13cmos5l_decap_8_1237 r0 *1 0,0
Xsg13cmos5l_decap_8_1237 VPWR VGND sg13cmos5l_decap_8
* cell instance sg13cmos5l_decap_8_1238 r0 *1 0,0
Xsg13cmos5l_decap_8_1238 VPWR VGND sg13cmos5l_decap_8
* cell instance sg13cmos5l_decap_8_1239 r0 *1 0,0
Xsg13cmos5l_decap_8_1239 VPWR VGND sg13cmos5l_decap_8
* cell instance sg13cmos5l_decap_8_1240 r0 *1 0,0
Xsg13cmos5l_decap_8_1240 VPWR VGND sg13cmos5l_decap_8
* cell instance sg13cmos5l_decap_8_1241 r0 *1 0,0
Xsg13cmos5l_decap_8_1241 VPWR VGND sg13cmos5l_decap_8
* cell instance sg13cmos5l_decap_8_1242 r0 *1 0,0
Xsg13cmos5l_decap_8_1242 VPWR VGND sg13cmos5l_decap_8
* cell instance sg13cmos5l_decap_8_1243 r0 *1 0,0
Xsg13cmos5l_decap_8_1243 VPWR VGND sg13cmos5l_decap_8
* cell instance sg13cmos5l_decap_8_1244 r0 *1 0,0
Xsg13cmos5l_decap_8_1244 VPWR VGND sg13cmos5l_decap_8
* cell instance sg13cmos5l_decap_8_1245 r0 *1 0,0
Xsg13cmos5l_decap_8_1245 VPWR VGND sg13cmos5l_decap_8
* cell instance sg13cmos5l_decap_8_1246 r0 *1 0,0
Xsg13cmos5l_decap_8_1246 VPWR VGND sg13cmos5l_decap_8
* cell instance sg13cmos5l_decap_8_1247 r0 *1 0,0
Xsg13cmos5l_decap_8_1247 VPWR VGND sg13cmos5l_decap_8
* cell instance sg13cmos5l_decap_8_1248 r0 *1 0,0
Xsg13cmos5l_decap_8_1248 VPWR VGND sg13cmos5l_decap_8
* cell instance sg13cmos5l_decap_8_1249 r0 *1 0,0
Xsg13cmos5l_decap_8_1249 VPWR VGND sg13cmos5l_decap_8
* cell instance sg13cmos5l_decap_8_1250 r0 *1 0,0
Xsg13cmos5l_decap_8_1250 VPWR VGND sg13cmos5l_decap_8
* cell instance sg13cmos5l_decap_8_1251 r0 *1 0,0
Xsg13cmos5l_decap_8_1251 VPWR VGND sg13cmos5l_decap_8
* cell instance sg13cmos5l_decap_8_1252 r0 *1 0,0
Xsg13cmos5l_decap_8_1252 VPWR VGND sg13cmos5l_decap_8
* cell instance sg13cmos5l_decap_8_1253 r0 *1 0,0
Xsg13cmos5l_decap_8_1253 VPWR VGND sg13cmos5l_decap_8
* cell instance sg13cmos5l_decap_8_1254 r0 *1 0,0
Xsg13cmos5l_decap_8_1254 VPWR VGND sg13cmos5l_decap_8
* cell instance sg13cmos5l_decap_8_1255 r0 *1 0,0
Xsg13cmos5l_decap_8_1255 VPWR VGND sg13cmos5l_decap_8
* cell instance sg13cmos5l_decap_8_1256 r0 *1 0,0
Xsg13cmos5l_decap_8_1256 VPWR VGND sg13cmos5l_decap_8
* cell instance sg13cmos5l_decap_8_1257 r0 *1 0,0
Xsg13cmos5l_decap_8_1257 VPWR VGND sg13cmos5l_decap_8
* cell instance sg13cmos5l_decap_8_1258 r0 *1 0,0
Xsg13cmos5l_decap_8_1258 VPWR VGND sg13cmos5l_decap_8
* cell instance sg13cmos5l_decap_8_1259 r0 *1 0,0
Xsg13cmos5l_decap_8_1259 VPWR VGND sg13cmos5l_decap_8
* cell instance sg13cmos5l_decap_8_1260 r0 *1 0,0
Xsg13cmos5l_decap_8_1260 VPWR VGND sg13cmos5l_decap_8
* cell instance sg13cmos5l_decap_8_1261 r0 *1 0,0
Xsg13cmos5l_decap_8_1261 VPWR VGND sg13cmos5l_decap_8
* cell instance sg13cmos5l_decap_8_1262 r0 *1 0,0
Xsg13cmos5l_decap_8_1262 VPWR VGND sg13cmos5l_decap_8
* cell instance sg13cmos5l_decap_8_1263 r0 *1 0,0
Xsg13cmos5l_decap_8_1263 VPWR VGND sg13cmos5l_decap_8
* cell instance sg13cmos5l_decap_8_1264 r0 *1 0,0
Xsg13cmos5l_decap_8_1264 VPWR VGND sg13cmos5l_decap_8
* cell instance sg13cmos5l_decap_8_1265 r0 *1 0,0
Xsg13cmos5l_decap_8_1265 VPWR VGND sg13cmos5l_decap_8
* cell instance sg13cmos5l_decap_8_1266 r0 *1 0,0
Xsg13cmos5l_decap_8_1266 VPWR VGND sg13cmos5l_decap_8
* cell instance sg13cmos5l_decap_8_1267 r0 *1 0,0
Xsg13cmos5l_decap_8_1267 VPWR VGND sg13cmos5l_decap_8
* cell instance sg13cmos5l_decap_8_1268 r0 *1 0,0
Xsg13cmos5l_decap_8_1268 VPWR VGND sg13cmos5l_decap_8
* cell instance sg13cmos5l_decap_8_1269 r0 *1 0,0
Xsg13cmos5l_decap_8_1269 VPWR VGND sg13cmos5l_decap_8
* cell instance sg13cmos5l_decap_8_1270 r0 *1 0,0
Xsg13cmos5l_decap_8_1270 VPWR VGND sg13cmos5l_decap_8
* cell instance sg13cmos5l_decap_8_1271 r0 *1 0,0
Xsg13cmos5l_decap_8_1271 VPWR VGND sg13cmos5l_decap_8
* cell instance sg13cmos5l_decap_8_1272 r0 *1 0,0
Xsg13cmos5l_decap_8_1272 VPWR VGND sg13cmos5l_decap_8
* cell instance sg13cmos5l_decap_8_1273 r0 *1 0,0
Xsg13cmos5l_decap_8_1273 VPWR VGND sg13cmos5l_decap_8
* cell instance sg13cmos5l_decap_8_1274 r0 *1 0,0
Xsg13cmos5l_decap_8_1274 VPWR VGND sg13cmos5l_decap_8
* cell instance sg13cmos5l_decap_8_1275 r0 *1 0,0
Xsg13cmos5l_decap_8_1275 VPWR VGND sg13cmos5l_decap_8
* cell instance sg13cmos5l_decap_8_1276 r0 *1 0,0
Xsg13cmos5l_decap_8_1276 VPWR VGND sg13cmos5l_decap_8
* cell instance sg13cmos5l_decap_8_1277 r0 *1 0,0
Xsg13cmos5l_decap_8_1277 VPWR VGND sg13cmos5l_decap_8
* cell instance sg13cmos5l_decap_8_1278 r0 *1 0,0
Xsg13cmos5l_decap_8_1278 VPWR VGND sg13cmos5l_decap_8
* cell instance sg13cmos5l_decap_8_1279 r0 *1 0,0
Xsg13cmos5l_decap_8_1279 VPWR VGND sg13cmos5l_decap_8
* cell instance sg13cmos5l_decap_8_1280 r0 *1 0,0
Xsg13cmos5l_decap_8_1280 VPWR VGND sg13cmos5l_decap_8
* cell instance sg13cmos5l_decap_8_1281 r0 *1 0,0
Xsg13cmos5l_decap_8_1281 VPWR VGND sg13cmos5l_decap_8
* cell instance sg13cmos5l_decap_8_1282 r0 *1 0,0
Xsg13cmos5l_decap_8_1282 VPWR VGND sg13cmos5l_decap_8
* cell instance sg13cmos5l_decap_8_1283 r0 *1 0,0
Xsg13cmos5l_decap_8_1283 VPWR VGND sg13cmos5l_decap_8
* cell instance sg13cmos5l_decap_8_1284 r0 *1 0,0
Xsg13cmos5l_decap_8_1284 VPWR VGND sg13cmos5l_decap_8
* cell instance sg13cmos5l_decap_8_1285 r0 *1 0,0
Xsg13cmos5l_decap_8_1285 VPWR VGND sg13cmos5l_decap_8
* cell instance sg13cmos5l_decap_8_1286 r0 *1 0,0
Xsg13cmos5l_decap_8_1286 VPWR VGND sg13cmos5l_decap_8
* cell instance sg13cmos5l_decap_8_1287 r0 *1 0,0
Xsg13cmos5l_decap_8_1287 VPWR VGND sg13cmos5l_decap_8
* cell instance sg13cmos5l_decap_8_1288 r0 *1 0,0
Xsg13cmos5l_decap_8_1288 VPWR VGND sg13cmos5l_decap_8
* cell instance sg13cmos5l_decap_8_1289 r0 *1 0,0
Xsg13cmos5l_decap_8_1289 VPWR VGND sg13cmos5l_decap_8
* cell instance sg13cmos5l_decap_8_1290 r0 *1 0,0
Xsg13cmos5l_decap_8_1290 VPWR VGND sg13cmos5l_decap_8
* cell instance sg13cmos5l_decap_8_1291 r0 *1 0,0
Xsg13cmos5l_decap_8_1291 VPWR VGND sg13cmos5l_decap_8
* cell instance sg13cmos5l_decap_8_1292 r0 *1 0,0
Xsg13cmos5l_decap_8_1292 VPWR VGND sg13cmos5l_decap_8
* cell instance sg13cmos5l_decap_8_1293 r0 *1 0,0
Xsg13cmos5l_decap_8_1293 VPWR VGND sg13cmos5l_decap_8
* cell instance sg13cmos5l_decap_8_1294 r0 *1 0,0
Xsg13cmos5l_decap_8_1294 VPWR VGND sg13cmos5l_decap_8
* cell instance sg13cmos5l_decap_8_1295 r0 *1 0,0
Xsg13cmos5l_decap_8_1295 VPWR VGND sg13cmos5l_decap_8
* cell instance sg13cmos5l_decap_8_1296 r0 *1 0,0
Xsg13cmos5l_decap_8_1296 VPWR VGND sg13cmos5l_decap_8
* cell instance sg13cmos5l_decap_8_1297 r0 *1 0,0
Xsg13cmos5l_decap_8_1297 VPWR VGND sg13cmos5l_decap_8
* cell instance sg13cmos5l_decap_8_1298 r0 *1 0,0
Xsg13cmos5l_decap_8_1298 VPWR VGND sg13cmos5l_decap_8
* cell instance sg13cmos5l_decap_8_1299 r0 *1 0,0
Xsg13cmos5l_decap_8_1299 VPWR VGND sg13cmos5l_decap_8
* cell instance sg13cmos5l_decap_8_1300 r0 *1 0,0
Xsg13cmos5l_decap_8_1300 VPWR VGND sg13cmos5l_decap_8
* cell instance sg13cmos5l_decap_8_1301 r0 *1 0,0
Xsg13cmos5l_decap_8_1301 VPWR VGND sg13cmos5l_decap_8
* cell instance sg13cmos5l_decap_8_1302 r0 *1 0,0
Xsg13cmos5l_decap_8_1302 VPWR VGND sg13cmos5l_decap_8
* cell instance sg13cmos5l_decap_8_1303 r0 *1 0,0
Xsg13cmos5l_decap_8_1303 VPWR VGND sg13cmos5l_decap_8
* cell instance sg13cmos5l_decap_8_1304 r0 *1 0,0
Xsg13cmos5l_decap_8_1304 VPWR VGND sg13cmos5l_decap_8
* cell instance sg13cmos5l_decap_8_1305 r0 *1 0,0
Xsg13cmos5l_decap_8_1305 VPWR VGND sg13cmos5l_decap_8
* cell instance sg13cmos5l_decap_8_1306 r0 *1 0,0
Xsg13cmos5l_decap_8_1306 VPWR VGND sg13cmos5l_decap_8
* cell instance sg13cmos5l_decap_8_1307 r0 *1 0,0
Xsg13cmos5l_decap_8_1307 VPWR VGND sg13cmos5l_decap_8
* cell instance sg13cmos5l_decap_8_1308 r0 *1 0,0
Xsg13cmos5l_decap_8_1308 VPWR VGND sg13cmos5l_decap_8
* cell instance sg13cmos5l_decap_8_1309 r0 *1 0,0
Xsg13cmos5l_decap_8_1309 VPWR VGND sg13cmos5l_decap_8
* cell instance sg13cmos5l_decap_8_1310 r0 *1 0,0
Xsg13cmos5l_decap_8_1310 VPWR VGND sg13cmos5l_decap_8
* cell instance sg13cmos5l_decap_8_1311 r0 *1 0,0
Xsg13cmos5l_decap_8_1311 VPWR VGND sg13cmos5l_decap_8
* cell instance sg13cmos5l_decap_8_1312 r0 *1 0,0
Xsg13cmos5l_decap_8_1312 VPWR VGND sg13cmos5l_decap_8
* cell instance sg13cmos5l_decap_8_1313 r0 *1 0,0
Xsg13cmos5l_decap_8_1313 VPWR VGND sg13cmos5l_decap_8
* cell instance sg13cmos5l_decap_8_1314 r0 *1 0,0
Xsg13cmos5l_decap_8_1314 VPWR VGND sg13cmos5l_decap_8
* cell instance sg13cmos5l_decap_8_1315 r0 *1 0,0
Xsg13cmos5l_decap_8_1315 VPWR VGND sg13cmos5l_decap_8
* cell instance sg13cmos5l_decap_8_1316 r0 *1 0,0
Xsg13cmos5l_decap_8_1316 VPWR VGND sg13cmos5l_decap_8
* cell instance sg13cmos5l_decap_8_1317 r0 *1 0,0
Xsg13cmos5l_decap_8_1317 VPWR VGND sg13cmos5l_decap_8
* cell instance sg13cmos5l_decap_8_1318 r0 *1 0,0
Xsg13cmos5l_decap_8_1318 VPWR VGND sg13cmos5l_decap_8
* cell instance sg13cmos5l_decap_8_1319 r0 *1 0,0
Xsg13cmos5l_decap_8_1319 VPWR VGND sg13cmos5l_decap_8
* cell instance sg13cmos5l_decap_8_1320 r0 *1 0,0
Xsg13cmos5l_decap_8_1320 VPWR VGND sg13cmos5l_decap_8
* cell instance sg13cmos5l_decap_8_1321 r0 *1 0,0
Xsg13cmos5l_decap_8_1321 VPWR VGND sg13cmos5l_decap_8
* cell instance sg13cmos5l_decap_8_1322 r0 *1 0,0
Xsg13cmos5l_decap_8_1322 VPWR VGND sg13cmos5l_decap_8
* cell instance sg13cmos5l_decap_8_1323 r0 *1 0,0
Xsg13cmos5l_decap_8_1323 VPWR VGND sg13cmos5l_decap_8
* cell instance sg13cmos5l_decap_8_1324 r0 *1 0,0
Xsg13cmos5l_decap_8_1324 VPWR VGND sg13cmos5l_decap_8
* cell instance sg13cmos5l_decap_8_1325 r0 *1 0,0
Xsg13cmos5l_decap_8_1325 VPWR VGND sg13cmos5l_decap_8
* cell instance sg13cmos5l_decap_8_1326 r0 *1 0,0
Xsg13cmos5l_decap_8_1326 VPWR VGND sg13cmos5l_decap_8
* cell instance sg13cmos5l_decap_8_1327 r0 *1 0,0
Xsg13cmos5l_decap_8_1327 VPWR VGND sg13cmos5l_decap_8
* cell instance sg13cmos5l_decap_8_1328 r0 *1 0,0
Xsg13cmos5l_decap_8_1328 VPWR VGND sg13cmos5l_decap_8
* cell instance sg13cmos5l_decap_8_1329 r0 *1 0,0
Xsg13cmos5l_decap_8_1329 VPWR VGND sg13cmos5l_decap_8
* cell instance sg13cmos5l_decap_8_1330 r0 *1 0,0
Xsg13cmos5l_decap_8_1330 VPWR VGND sg13cmos5l_decap_8
* cell instance sg13cmos5l_decap_8_1331 r0 *1 0,0
Xsg13cmos5l_decap_8_1331 VPWR VGND sg13cmos5l_decap_8
* cell instance sg13cmos5l_decap_8_1332 r0 *1 0,0
Xsg13cmos5l_decap_8_1332 VPWR VGND sg13cmos5l_decap_8
* cell instance sg13cmos5l_decap_8_1333 r0 *1 0,0
Xsg13cmos5l_decap_8_1333 VPWR VGND sg13cmos5l_decap_8
* cell instance sg13cmos5l_decap_8_1334 r0 *1 0,0
Xsg13cmos5l_decap_8_1334 VPWR VGND sg13cmos5l_decap_8
* cell instance sg13cmos5l_decap_8_1335 r0 *1 0,0
Xsg13cmos5l_decap_8_1335 VPWR VGND sg13cmos5l_decap_8
* cell instance sg13cmos5l_decap_8_1336 r0 *1 0,0
Xsg13cmos5l_decap_8_1336 VPWR VGND sg13cmos5l_decap_8
* cell instance sg13cmos5l_decap_8_1337 r0 *1 0,0
Xsg13cmos5l_decap_8_1337 VPWR VGND sg13cmos5l_decap_8
* cell instance sg13cmos5l_decap_8_1338 r0 *1 0,0
Xsg13cmos5l_decap_8_1338 VPWR VGND sg13cmos5l_decap_8
* cell instance sg13cmos5l_decap_8_1339 r0 *1 0,0
Xsg13cmos5l_decap_8_1339 VPWR VGND sg13cmos5l_decap_8
* cell instance sg13cmos5l_decap_8_1340 r0 *1 0,0
Xsg13cmos5l_decap_8_1340 VPWR VGND sg13cmos5l_decap_8
* cell instance sg13cmos5l_decap_8_1341 r0 *1 0,0
Xsg13cmos5l_decap_8_1341 VPWR VGND sg13cmos5l_decap_8
* cell instance sg13cmos5l_decap_8_1342 r0 *1 0,0
Xsg13cmos5l_decap_8_1342 VPWR VGND sg13cmos5l_decap_8
* cell instance sg13cmos5l_decap_8_1343 r0 *1 0,0
Xsg13cmos5l_decap_8_1343 VPWR VGND sg13cmos5l_decap_8
* cell instance sg13cmos5l_decap_8_1344 r0 *1 0,0
Xsg13cmos5l_decap_8_1344 VPWR VGND sg13cmos5l_decap_8
* cell instance sg13cmos5l_decap_8_1345 r0 *1 0,0
Xsg13cmos5l_decap_8_1345 VPWR VGND sg13cmos5l_decap_8
* cell instance sg13cmos5l_decap_8_1346 r0 *1 0,0
Xsg13cmos5l_decap_8_1346 VPWR VGND sg13cmos5l_decap_8
* cell instance sg13cmos5l_decap_8_1347 r0 *1 0,0
Xsg13cmos5l_decap_8_1347 VPWR VGND sg13cmos5l_decap_8
* cell instance sg13cmos5l_decap_8_1348 r0 *1 0,0
Xsg13cmos5l_decap_8_1348 VPWR VGND sg13cmos5l_decap_8
* cell instance sg13cmos5l_decap_8_1349 r0 *1 0,0
Xsg13cmos5l_decap_8_1349 VPWR VGND sg13cmos5l_decap_8
* cell instance sg13cmos5l_decap_8_1350 r0 *1 0,0
Xsg13cmos5l_decap_8_1350 VPWR VGND sg13cmos5l_decap_8
* cell instance sg13cmos5l_decap_8_1351 r0 *1 0,0
Xsg13cmos5l_decap_8_1351 VPWR VGND sg13cmos5l_decap_8
* cell instance sg13cmos5l_decap_8_1352 r0 *1 0,0
Xsg13cmos5l_decap_8_1352 VPWR VGND sg13cmos5l_decap_8
* cell instance sg13cmos5l_decap_8_1353 r0 *1 0,0
Xsg13cmos5l_decap_8_1353 VPWR VGND sg13cmos5l_decap_8
* cell instance sg13cmos5l_decap_8_1354 r0 *1 0,0
Xsg13cmos5l_decap_8_1354 VPWR VGND sg13cmos5l_decap_8
* cell instance sg13cmos5l_decap_8_1355 r0 *1 0,0
Xsg13cmos5l_decap_8_1355 VPWR VGND sg13cmos5l_decap_8
* cell instance sg13cmos5l_decap_8_1356 r0 *1 0,0
Xsg13cmos5l_decap_8_1356 VPWR VGND sg13cmos5l_decap_8
* cell instance sg13cmos5l_decap_8_1357 r0 *1 0,0
Xsg13cmos5l_decap_8_1357 VPWR VGND sg13cmos5l_decap_8
* cell instance sg13cmos5l_decap_8_1358 r0 *1 0,0
Xsg13cmos5l_decap_8_1358 VPWR VGND sg13cmos5l_decap_8
* cell instance sg13cmos5l_decap_8_1359 r0 *1 0,0
Xsg13cmos5l_decap_8_1359 VPWR VGND sg13cmos5l_decap_8
* cell instance sg13cmos5l_decap_8_1360 r0 *1 0,0
Xsg13cmos5l_decap_8_1360 VPWR VGND sg13cmos5l_decap_8
* cell instance sg13cmos5l_decap_8_1361 r0 *1 0,0
Xsg13cmos5l_decap_8_1361 VPWR VGND sg13cmos5l_decap_8
* cell instance sg13cmos5l_decap_8_1362 r0 *1 0,0
Xsg13cmos5l_decap_8_1362 VPWR VGND sg13cmos5l_decap_8
* cell instance sg13cmos5l_decap_8_1363 r0 *1 0,0
Xsg13cmos5l_decap_8_1363 VPWR VGND sg13cmos5l_decap_8
* cell instance sg13cmos5l_decap_8_1364 r0 *1 0,0
Xsg13cmos5l_decap_8_1364 VPWR VGND sg13cmos5l_decap_8
* cell instance sg13cmos5l_decap_8_1365 r0 *1 0,0
Xsg13cmos5l_decap_8_1365 VPWR VGND sg13cmos5l_decap_8
* cell instance sg13cmos5l_decap_8_1366 r0 *1 0,0
Xsg13cmos5l_decap_8_1366 VPWR VGND sg13cmos5l_decap_8
* cell instance sg13cmos5l_decap_8_1367 r0 *1 0,0
Xsg13cmos5l_decap_8_1367 VPWR VGND sg13cmos5l_decap_8
* cell instance sg13cmos5l_decap_8_1368 r0 *1 0,0
Xsg13cmos5l_decap_8_1368 VPWR VGND sg13cmos5l_decap_8
* cell instance sg13cmos5l_decap_8_1369 r0 *1 0,0
Xsg13cmos5l_decap_8_1369 VPWR VGND sg13cmos5l_decap_8
* cell instance sg13cmos5l_decap_8_1370 r0 *1 0,0
Xsg13cmos5l_decap_8_1370 VPWR VGND sg13cmos5l_decap_8
* cell instance sg13cmos5l_decap_8_1371 r0 *1 0,0
Xsg13cmos5l_decap_8_1371 VPWR VGND sg13cmos5l_decap_8
* cell instance sg13cmos5l_decap_8_1372 r0 *1 0,0
Xsg13cmos5l_decap_8_1372 VPWR VGND sg13cmos5l_decap_8
* cell instance sg13cmos5l_decap_8_1373 r0 *1 0,0
Xsg13cmos5l_decap_8_1373 VPWR VGND sg13cmos5l_decap_8
* cell instance sg13cmos5l_decap_8_1374 r0 *1 0,0
Xsg13cmos5l_decap_8_1374 VPWR VGND sg13cmos5l_decap_8
* cell instance sg13cmos5l_decap_8_1375 r0 *1 0,0
Xsg13cmos5l_decap_8_1375 VPWR VGND sg13cmos5l_decap_8
* cell instance sg13cmos5l_decap_8_1376 r0 *1 0,0
Xsg13cmos5l_decap_8_1376 VPWR VGND sg13cmos5l_decap_8
* cell instance sg13cmos5l_decap_8_1377 r0 *1 0,0
Xsg13cmos5l_decap_8_1377 VPWR VGND sg13cmos5l_decap_8
* cell instance sg13cmos5l_decap_8_1378 r0 *1 0,0
Xsg13cmos5l_decap_8_1378 VPWR VGND sg13cmos5l_decap_8
* cell instance sg13cmos5l_decap_8_1379 r0 *1 0,0
Xsg13cmos5l_decap_8_1379 VPWR VGND sg13cmos5l_decap_8
* cell instance sg13cmos5l_decap_8_1380 r0 *1 0,0
Xsg13cmos5l_decap_8_1380 VPWR VGND sg13cmos5l_decap_8
* cell instance sg13cmos5l_decap_8_1381 r0 *1 0,0
Xsg13cmos5l_decap_8_1381 VPWR VGND sg13cmos5l_decap_8
* cell instance sg13cmos5l_decap_8_1382 r0 *1 0,0
Xsg13cmos5l_decap_8_1382 VPWR VGND sg13cmos5l_decap_8
* cell instance sg13cmos5l_decap_8_1383 r0 *1 0,0
Xsg13cmos5l_decap_8_1383 VPWR VGND sg13cmos5l_decap_8
* cell instance sg13cmos5l_decap_8_1384 r0 *1 0,0
Xsg13cmos5l_decap_8_1384 VPWR VGND sg13cmos5l_decap_8
* cell instance sg13cmos5l_decap_8_1385 r0 *1 0,0
Xsg13cmos5l_decap_8_1385 VPWR VGND sg13cmos5l_decap_8
* cell instance sg13cmos5l_decap_8_1386 r0 *1 0,0
Xsg13cmos5l_decap_8_1386 VPWR VGND sg13cmos5l_decap_8
* cell instance sg13cmos5l_decap_8_1387 r0 *1 0,0
Xsg13cmos5l_decap_8_1387 VPWR VGND sg13cmos5l_decap_8
* cell instance sg13cmos5l_decap_8_1388 r0 *1 0,0
Xsg13cmos5l_decap_8_1388 VPWR VGND sg13cmos5l_decap_8
* cell instance sg13cmos5l_decap_8_1389 r0 *1 0,0
Xsg13cmos5l_decap_8_1389 VPWR VGND sg13cmos5l_decap_8
* cell instance sg13cmos5l_decap_8_1390 r0 *1 0,0
Xsg13cmos5l_decap_8_1390 VPWR VGND sg13cmos5l_decap_8
* cell instance sg13cmos5l_decap_8_1391 r0 *1 0,0
Xsg13cmos5l_decap_8_1391 VPWR VGND sg13cmos5l_decap_8
* cell instance sg13cmos5l_decap_8_1392 r0 *1 0,0
Xsg13cmos5l_decap_8_1392 VPWR VGND sg13cmos5l_decap_8
* cell instance sg13cmos5l_decap_8_1393 r0 *1 0,0
Xsg13cmos5l_decap_8_1393 VPWR VGND sg13cmos5l_decap_8
* cell instance sg13cmos5l_decap_8_1394 r0 *1 0,0
Xsg13cmos5l_decap_8_1394 VPWR VGND sg13cmos5l_decap_8
* cell instance sg13cmos5l_decap_8_1395 r0 *1 0,0
Xsg13cmos5l_decap_8_1395 VPWR VGND sg13cmos5l_decap_8
* cell instance sg13cmos5l_decap_8_1396 r0 *1 0,0
Xsg13cmos5l_decap_8_1396 VPWR VGND sg13cmos5l_decap_8
* cell instance sg13cmos5l_decap_8_1397 r0 *1 0,0
Xsg13cmos5l_decap_8_1397 VPWR VGND sg13cmos5l_decap_8
* cell instance sg13cmos5l_decap_8_1398 r0 *1 0,0
Xsg13cmos5l_decap_8_1398 VPWR VGND sg13cmos5l_decap_8
* cell instance sg13cmos5l_decap_8_1399 r0 *1 0,0
Xsg13cmos5l_decap_8_1399 VPWR VGND sg13cmos5l_decap_8
* cell instance sg13cmos5l_decap_8_1400 r0 *1 0,0
Xsg13cmos5l_decap_8_1400 VPWR VGND sg13cmos5l_decap_8
* cell instance sg13cmos5l_decap_8_1401 r0 *1 0,0
Xsg13cmos5l_decap_8_1401 VPWR VGND sg13cmos5l_decap_8
* cell instance sg13cmos5l_decap_8_1402 r0 *1 0,0
Xsg13cmos5l_decap_8_1402 VPWR VGND sg13cmos5l_decap_8
* cell instance sg13cmos5l_decap_8_1403 r0 *1 0,0
Xsg13cmos5l_decap_8_1403 VPWR VGND sg13cmos5l_decap_8
* cell instance sg13cmos5l_decap_8_1404 r0 *1 0,0
Xsg13cmos5l_decap_8_1404 VPWR VGND sg13cmos5l_decap_8
* cell instance sg13cmos5l_decap_8_1405 r0 *1 0,0
Xsg13cmos5l_decap_8_1405 VPWR VGND sg13cmos5l_decap_8
* cell instance sg13cmos5l_decap_8_1406 r0 *1 0,0
Xsg13cmos5l_decap_8_1406 VPWR VGND sg13cmos5l_decap_8
* cell instance sg13cmos5l_decap_8_1407 r0 *1 0,0
Xsg13cmos5l_decap_8_1407 VPWR VGND sg13cmos5l_decap_8
* cell instance sg13cmos5l_decap_8_1408 r0 *1 0,0
Xsg13cmos5l_decap_8_1408 VPWR VGND sg13cmos5l_decap_8
* cell instance sg13cmos5l_decap_8_1409 r0 *1 0,0
Xsg13cmos5l_decap_8_1409 VPWR VGND sg13cmos5l_decap_8
* cell instance sg13cmos5l_decap_8_1410 r0 *1 0,0
Xsg13cmos5l_decap_8_1410 VPWR VGND sg13cmos5l_decap_8
* cell instance sg13cmos5l_decap_8_1411 r0 *1 0,0
Xsg13cmos5l_decap_8_1411 VPWR VGND sg13cmos5l_decap_8
* cell instance sg13cmos5l_decap_8_1412 r0 *1 0,0
Xsg13cmos5l_decap_8_1412 VPWR VGND sg13cmos5l_decap_8
* cell instance sg13cmos5l_decap_8_1413 r0 *1 0,0
Xsg13cmos5l_decap_8_1413 VPWR VGND sg13cmos5l_decap_8
* cell instance sg13cmos5l_decap_8_1414 r0 *1 0,0
Xsg13cmos5l_decap_8_1414 VPWR VGND sg13cmos5l_decap_8
* cell instance sg13cmos5l_decap_8_1415 r0 *1 0,0
Xsg13cmos5l_decap_8_1415 VPWR VGND sg13cmos5l_decap_8
* cell instance sg13cmos5l_decap_8_1416 r0 *1 0,0
Xsg13cmos5l_decap_8_1416 VPWR VGND sg13cmos5l_decap_8
* cell instance sg13cmos5l_decap_8_1417 r0 *1 0,0
Xsg13cmos5l_decap_8_1417 VPWR VGND sg13cmos5l_decap_8
* cell instance sg13cmos5l_decap_8_1418 r0 *1 0,0
Xsg13cmos5l_decap_8_1418 VPWR VGND sg13cmos5l_decap_8
* cell instance sg13cmos5l_decap_8_1419 r0 *1 0,0
Xsg13cmos5l_decap_8_1419 VPWR VGND sg13cmos5l_decap_8
* cell instance sg13cmos5l_decap_8_1420 r0 *1 0,0
Xsg13cmos5l_decap_8_1420 VPWR VGND sg13cmos5l_decap_8
* cell instance sg13cmos5l_decap_8_1421 r0 *1 0,0
Xsg13cmos5l_decap_8_1421 VPWR VGND sg13cmos5l_decap_8
* cell instance sg13cmos5l_decap_8_1422 r0 *1 0,0
Xsg13cmos5l_decap_8_1422 VPWR VGND sg13cmos5l_decap_8
* cell instance sg13cmos5l_decap_8_1423 r0 *1 0,0
Xsg13cmos5l_decap_8_1423 VPWR VGND sg13cmos5l_decap_8
* cell instance sg13cmos5l_decap_8_1424 r0 *1 0,0
Xsg13cmos5l_decap_8_1424 VPWR VGND sg13cmos5l_decap_8
* cell instance sg13cmos5l_decap_8_1425 r0 *1 0,0
Xsg13cmos5l_decap_8_1425 VPWR VGND sg13cmos5l_decap_8
* cell instance sg13cmos5l_decap_8_1426 r0 *1 0,0
Xsg13cmos5l_decap_8_1426 VPWR VGND sg13cmos5l_decap_8
* cell instance sg13cmos5l_decap_8_1427 r0 *1 0,0
Xsg13cmos5l_decap_8_1427 VPWR VGND sg13cmos5l_decap_8
* cell instance sg13cmos5l_decap_8_1428 r0 *1 0,0
Xsg13cmos5l_decap_8_1428 VPWR VGND sg13cmos5l_decap_8
* cell instance sg13cmos5l_decap_8_1429 r0 *1 0,0
Xsg13cmos5l_decap_8_1429 VPWR VGND sg13cmos5l_decap_8
* cell instance sg13cmos5l_decap_8_1430 r0 *1 0,0
Xsg13cmos5l_decap_8_1430 VPWR VGND sg13cmos5l_decap_8
* cell instance sg13cmos5l_decap_8_1431 r0 *1 0,0
Xsg13cmos5l_decap_8_1431 VPWR VGND sg13cmos5l_decap_8
* cell instance sg13cmos5l_decap_8_1432 r0 *1 0,0
Xsg13cmos5l_decap_8_1432 VPWR VGND sg13cmos5l_decap_8
* cell instance sg13cmos5l_decap_8_1433 r0 *1 0,0
Xsg13cmos5l_decap_8_1433 VPWR VGND sg13cmos5l_decap_8
* cell instance sg13cmos5l_decap_8_1434 r0 *1 0,0
Xsg13cmos5l_decap_8_1434 VPWR VGND sg13cmos5l_decap_8
* cell instance sg13cmos5l_decap_8_1435 r0 *1 0,0
Xsg13cmos5l_decap_8_1435 VPWR VGND sg13cmos5l_decap_8
* cell instance sg13cmos5l_decap_8_1436 r0 *1 0,0
Xsg13cmos5l_decap_8_1436 VPWR VGND sg13cmos5l_decap_8
* cell instance sg13cmos5l_decap_8_1437 r0 *1 0,0
Xsg13cmos5l_decap_8_1437 VPWR VGND sg13cmos5l_decap_8
* cell instance sg13cmos5l_decap_8_1438 r0 *1 0,0
Xsg13cmos5l_decap_8_1438 VPWR VGND sg13cmos5l_decap_8
* cell instance sg13cmos5l_decap_8_1439 r0 *1 0,0
Xsg13cmos5l_decap_8_1439 VPWR VGND sg13cmos5l_decap_8
* cell instance sg13cmos5l_decap_8_1440 r0 *1 0,0
Xsg13cmos5l_decap_8_1440 VPWR VGND sg13cmos5l_decap_8
* cell instance sg13cmos5l_decap_8_1441 r0 *1 0,0
Xsg13cmos5l_decap_8_1441 VPWR VGND sg13cmos5l_decap_8
* cell instance sg13cmos5l_decap_8_1442 r0 *1 0,0
Xsg13cmos5l_decap_8_1442 VPWR VGND sg13cmos5l_decap_8
* cell instance sg13cmos5l_decap_8_1443 r0 *1 0,0
Xsg13cmos5l_decap_8_1443 VPWR VGND sg13cmos5l_decap_8
* cell instance sg13cmos5l_decap_8_1444 r0 *1 0,0
Xsg13cmos5l_decap_8_1444 VPWR VGND sg13cmos5l_decap_8
* cell instance sg13cmos5l_decap_8_1445 r0 *1 0,0
Xsg13cmos5l_decap_8_1445 VPWR VGND sg13cmos5l_decap_8
* cell instance sg13cmos5l_decap_8_1446 r0 *1 0,0
Xsg13cmos5l_decap_8_1446 VPWR VGND sg13cmos5l_decap_8
* cell instance sg13cmos5l_decap_8_1447 r0 *1 0,0
Xsg13cmos5l_decap_8_1447 VPWR VGND sg13cmos5l_decap_8
* cell instance sg13cmos5l_decap_8_1448 r0 *1 0,0
Xsg13cmos5l_decap_8_1448 VPWR VGND sg13cmos5l_decap_8
* cell instance sg13cmos5l_decap_8_1449 r0 *1 0,0
Xsg13cmos5l_decap_8_1449 VPWR VGND sg13cmos5l_decap_8
* cell instance sg13cmos5l_decap_8_1450 r0 *1 0,0
Xsg13cmos5l_decap_8_1450 VPWR VGND sg13cmos5l_decap_8
* cell instance sg13cmos5l_decap_8_1451 r0 *1 0,0
Xsg13cmos5l_decap_8_1451 VPWR VGND sg13cmos5l_decap_8
* cell instance sg13cmos5l_decap_8_1452 r0 *1 0,0
Xsg13cmos5l_decap_8_1452 VPWR VGND sg13cmos5l_decap_8
* cell instance sg13cmos5l_decap_8_1453 r0 *1 0,0
Xsg13cmos5l_decap_8_1453 VPWR VGND sg13cmos5l_decap_8
* cell instance sg13cmos5l_decap_8_1454 r0 *1 0,0
Xsg13cmos5l_decap_8_1454 VPWR VGND sg13cmos5l_decap_8
* cell instance sg13cmos5l_decap_8_1455 r0 *1 0,0
Xsg13cmos5l_decap_8_1455 VPWR VGND sg13cmos5l_decap_8
* cell instance sg13cmos5l_decap_8_1456 r0 *1 0,0
Xsg13cmos5l_decap_8_1456 VPWR VGND sg13cmos5l_decap_8
* cell instance sg13cmos5l_decap_8_1457 r0 *1 0,0
Xsg13cmos5l_decap_8_1457 VPWR VGND sg13cmos5l_decap_8
* cell instance sg13cmos5l_decap_8_1458 r0 *1 0,0
Xsg13cmos5l_decap_8_1458 VPWR VGND sg13cmos5l_decap_8
* cell instance sg13cmos5l_decap_8_1459 r0 *1 0,0
Xsg13cmos5l_decap_8_1459 VPWR VGND sg13cmos5l_decap_8
* cell instance sg13cmos5l_decap_8_1460 r0 *1 0,0
Xsg13cmos5l_decap_8_1460 VPWR VGND sg13cmos5l_decap_8
* cell instance sg13cmos5l_decap_8_1461 r0 *1 0,0
Xsg13cmos5l_decap_8_1461 VPWR VGND sg13cmos5l_decap_8
* cell instance sg13cmos5l_decap_8_1462 r0 *1 0,0
Xsg13cmos5l_decap_8_1462 VPWR VGND sg13cmos5l_decap_8
* cell instance sg13cmos5l_decap_8_1463 r0 *1 0,0
Xsg13cmos5l_decap_8_1463 VPWR VGND sg13cmos5l_decap_8
* cell instance sg13cmos5l_decap_8_1464 r0 *1 0,0
Xsg13cmos5l_decap_8_1464 VPWR VGND sg13cmos5l_decap_8
* cell instance sg13cmos5l_decap_8_1465 r0 *1 0,0
Xsg13cmos5l_decap_8_1465 VPWR VGND sg13cmos5l_decap_8
* cell instance sg13cmos5l_decap_8_1466 r0 *1 0,0
Xsg13cmos5l_decap_8_1466 VPWR VGND sg13cmos5l_decap_8
* cell instance sg13cmos5l_decap_8_1467 r0 *1 0,0
Xsg13cmos5l_decap_8_1467 VPWR VGND sg13cmos5l_decap_8
* cell instance sg13cmos5l_decap_8_1468 r0 *1 0,0
Xsg13cmos5l_decap_8_1468 VPWR VGND sg13cmos5l_decap_8
* cell instance sg13cmos5l_decap_8_1469 r0 *1 0,0
Xsg13cmos5l_decap_8_1469 VPWR VGND sg13cmos5l_decap_8
* cell instance sg13cmos5l_decap_8_1470 r0 *1 0,0
Xsg13cmos5l_decap_8_1470 VPWR VGND sg13cmos5l_decap_8
* cell instance sg13cmos5l_decap_8_1471 r0 *1 0,0
Xsg13cmos5l_decap_8_1471 VPWR VGND sg13cmos5l_decap_8
* cell instance sg13cmos5l_decap_8_1472 r0 *1 0,0
Xsg13cmos5l_decap_8_1472 VPWR VGND sg13cmos5l_decap_8
* cell instance sg13cmos5l_decap_8_1473 r0 *1 0,0
Xsg13cmos5l_decap_8_1473 VPWR VGND sg13cmos5l_decap_8
* cell instance sg13cmos5l_decap_8_1474 r0 *1 0,0
Xsg13cmos5l_decap_8_1474 VPWR VGND sg13cmos5l_decap_8
* cell instance sg13cmos5l_decap_8_1475 r0 *1 0,0
Xsg13cmos5l_decap_8_1475 VPWR VGND sg13cmos5l_decap_8
* cell instance sg13cmos5l_decap_8_1476 r0 *1 0,0
Xsg13cmos5l_decap_8_1476 VPWR VGND sg13cmos5l_decap_8
* cell instance sg13cmos5l_decap_8_1477 r0 *1 0,0
Xsg13cmos5l_decap_8_1477 VPWR VGND sg13cmos5l_decap_8
* cell instance sg13cmos5l_decap_8_1478 r0 *1 0,0
Xsg13cmos5l_decap_8_1478 VPWR VGND sg13cmos5l_decap_8
* cell instance sg13cmos5l_decap_8_1479 r0 *1 0,0
Xsg13cmos5l_decap_8_1479 VPWR VGND sg13cmos5l_decap_8
* cell instance sg13cmos5l_decap_8_1480 r0 *1 0,0
Xsg13cmos5l_decap_8_1480 VPWR VGND sg13cmos5l_decap_8
* cell instance sg13cmos5l_decap_8_1481 r0 *1 0,0
Xsg13cmos5l_decap_8_1481 VPWR VGND sg13cmos5l_decap_8
* cell instance sg13cmos5l_decap_8_1482 r0 *1 0,0
Xsg13cmos5l_decap_8_1482 VPWR VGND sg13cmos5l_decap_8
* cell instance sg13cmos5l_decap_8_1483 r0 *1 0,0
Xsg13cmos5l_decap_8_1483 VPWR VGND sg13cmos5l_decap_8
* cell instance sg13cmos5l_decap_8_1484 r0 *1 0,0
Xsg13cmos5l_decap_8_1484 VPWR VGND sg13cmos5l_decap_8
* cell instance sg13cmos5l_decap_8_1485 r0 *1 0,0
Xsg13cmos5l_decap_8_1485 VPWR VGND sg13cmos5l_decap_8
* cell instance sg13cmos5l_decap_8_1486 r0 *1 0,0
Xsg13cmos5l_decap_8_1486 VPWR VGND sg13cmos5l_decap_8
* cell instance sg13cmos5l_decap_8_1487 r0 *1 0,0
Xsg13cmos5l_decap_8_1487 VPWR VGND sg13cmos5l_decap_8
* cell instance sg13cmos5l_decap_8_1488 r0 *1 0,0
Xsg13cmos5l_decap_8_1488 VPWR VGND sg13cmos5l_decap_8
* cell instance sg13cmos5l_decap_8_1489 r0 *1 0,0
Xsg13cmos5l_decap_8_1489 VPWR VGND sg13cmos5l_decap_8
* cell instance sg13cmos5l_decap_8_1490 r0 *1 0,0
Xsg13cmos5l_decap_8_1490 VPWR VGND sg13cmos5l_decap_8
* cell instance sg13cmos5l_decap_8_1491 r0 *1 0,0
Xsg13cmos5l_decap_8_1491 VPWR VGND sg13cmos5l_decap_8
* cell instance sg13cmos5l_decap_8_1492 r0 *1 0,0
Xsg13cmos5l_decap_8_1492 VPWR VGND sg13cmos5l_decap_8
* cell instance sg13cmos5l_decap_8_1493 r0 *1 0,0
Xsg13cmos5l_decap_8_1493 VPWR VGND sg13cmos5l_decap_8
* cell instance sg13cmos5l_decap_8_1494 r0 *1 0,0
Xsg13cmos5l_decap_8_1494 VPWR VGND sg13cmos5l_decap_8
* cell instance sg13cmos5l_decap_8_1495 r0 *1 0,0
Xsg13cmos5l_decap_8_1495 VPWR VGND sg13cmos5l_decap_8
* cell instance sg13cmos5l_decap_8_1496 r0 *1 0,0
Xsg13cmos5l_decap_8_1496 VPWR VGND sg13cmos5l_decap_8
* cell instance sg13cmos5l_decap_8_1497 r0 *1 0,0
Xsg13cmos5l_decap_8_1497 VPWR VGND sg13cmos5l_decap_8
* cell instance sg13cmos5l_decap_8_1498 r0 *1 0,0
Xsg13cmos5l_decap_8_1498 VPWR VGND sg13cmos5l_decap_8
* cell instance sg13cmos5l_decap_8_1499 r0 *1 0,0
Xsg13cmos5l_decap_8_1499 VPWR VGND sg13cmos5l_decap_8
* cell instance sg13cmos5l_decap_8_1500 r0 *1 0,0
Xsg13cmos5l_decap_8_1500 VPWR VGND sg13cmos5l_decap_8
* cell instance sg13cmos5l_decap_8_1501 r0 *1 0,0
Xsg13cmos5l_decap_8_1501 VPWR VGND sg13cmos5l_decap_8
* cell instance sg13cmos5l_decap_8_1502 r0 *1 0,0
Xsg13cmos5l_decap_8_1502 VPWR VGND sg13cmos5l_decap_8
* cell instance sg13cmos5l_decap_8_1503 r0 *1 0,0
Xsg13cmos5l_decap_8_1503 VPWR VGND sg13cmos5l_decap_8
* cell instance sg13cmos5l_decap_8_1504 r0 *1 0,0
Xsg13cmos5l_decap_8_1504 VPWR VGND sg13cmos5l_decap_8
* cell instance sg13cmos5l_decap_8_1505 r0 *1 0,0
Xsg13cmos5l_decap_8_1505 VPWR VGND sg13cmos5l_decap_8
* cell instance sg13cmos5l_decap_8_1506 r0 *1 0,0
Xsg13cmos5l_decap_8_1506 VPWR VGND sg13cmos5l_decap_8
* cell instance sg13cmos5l_decap_8_1507 r0 *1 0,0
Xsg13cmos5l_decap_8_1507 VPWR VGND sg13cmos5l_decap_8
* cell instance sg13cmos5l_decap_8_1508 r0 *1 0,0
Xsg13cmos5l_decap_8_1508 VPWR VGND sg13cmos5l_decap_8
* cell instance sg13cmos5l_decap_8_1509 r0 *1 0,0
Xsg13cmos5l_decap_8_1509 VPWR VGND sg13cmos5l_decap_8
* cell instance sg13cmos5l_decap_8_1510 r0 *1 0,0
Xsg13cmos5l_decap_8_1510 VPWR VGND sg13cmos5l_decap_8
* cell instance sg13cmos5l_decap_8_1511 r0 *1 0,0
Xsg13cmos5l_decap_8_1511 VPWR VGND sg13cmos5l_decap_8
* cell instance sg13cmos5l_decap_8_1512 r0 *1 0,0
Xsg13cmos5l_decap_8_1512 VPWR VGND sg13cmos5l_decap_8
* cell instance sg13cmos5l_decap_8_1513 r0 *1 0,0
Xsg13cmos5l_decap_8_1513 VPWR VGND sg13cmos5l_decap_8
* cell instance sg13cmos5l_decap_8_1514 r0 *1 0,0
Xsg13cmos5l_decap_8_1514 VPWR VGND sg13cmos5l_decap_8
* cell instance sg13cmos5l_decap_8_1515 r0 *1 0,0
Xsg13cmos5l_decap_8_1515 VPWR VGND sg13cmos5l_decap_8
* cell instance sg13cmos5l_decap_8_1516 r0 *1 0,0
Xsg13cmos5l_decap_8_1516 VPWR VGND sg13cmos5l_decap_8
* cell instance sg13cmos5l_decap_8_1517 r0 *1 0,0
Xsg13cmos5l_decap_8_1517 VPWR VGND sg13cmos5l_decap_8
* cell instance sg13cmos5l_decap_8_1518 r0 *1 0,0
Xsg13cmos5l_decap_8_1518 VPWR VGND sg13cmos5l_decap_8
* cell instance sg13cmos5l_decap_8_1519 r0 *1 0,0
Xsg13cmos5l_decap_8_1519 VPWR VGND sg13cmos5l_decap_8
* cell instance sg13cmos5l_decap_8_1520 r0 *1 0,0
Xsg13cmos5l_decap_8_1520 VPWR VGND sg13cmos5l_decap_8
* cell instance sg13cmos5l_decap_8_1521 r0 *1 0,0
Xsg13cmos5l_decap_8_1521 VPWR VGND sg13cmos5l_decap_8
* cell instance sg13cmos5l_decap_8_1522 r0 *1 0,0
Xsg13cmos5l_decap_8_1522 VPWR VGND sg13cmos5l_decap_8
* cell instance sg13cmos5l_decap_8_1523 r0 *1 0,0
Xsg13cmos5l_decap_8_1523 VPWR VGND sg13cmos5l_decap_8
* cell instance sg13cmos5l_decap_8_1524 r0 *1 0,0
Xsg13cmos5l_decap_8_1524 VPWR VGND sg13cmos5l_decap_8
* cell instance sg13cmos5l_decap_8_1525 r0 *1 0,0
Xsg13cmos5l_decap_8_1525 VPWR VGND sg13cmos5l_decap_8
* cell instance sg13cmos5l_decap_8_1526 r0 *1 0,0
Xsg13cmos5l_decap_8_1526 VPWR VGND sg13cmos5l_decap_8
* cell instance sg13cmos5l_decap_8_1527 r0 *1 0,0
Xsg13cmos5l_decap_8_1527 VPWR VGND sg13cmos5l_decap_8
* cell instance sg13cmos5l_decap_8_1528 r0 *1 0,0
Xsg13cmos5l_decap_8_1528 VPWR VGND sg13cmos5l_decap_8
* cell instance sg13cmos5l_decap_8_1529 r0 *1 0,0
Xsg13cmos5l_decap_8_1529 VPWR VGND sg13cmos5l_decap_8
* cell instance sg13cmos5l_decap_8_1530 r0 *1 0,0
Xsg13cmos5l_decap_8_1530 VPWR VGND sg13cmos5l_decap_8
* cell instance sg13cmos5l_decap_8_1531 r0 *1 0,0
Xsg13cmos5l_decap_8_1531 VPWR VGND sg13cmos5l_decap_8
* cell instance sg13cmos5l_decap_8_1532 r0 *1 0,0
Xsg13cmos5l_decap_8_1532 VPWR VGND sg13cmos5l_decap_8
* cell instance sg13cmos5l_decap_8_1533 r0 *1 0,0
Xsg13cmos5l_decap_8_1533 VPWR VGND sg13cmos5l_decap_8
* cell instance sg13cmos5l_decap_8_1534 r0 *1 0,0
Xsg13cmos5l_decap_8_1534 VPWR VGND sg13cmos5l_decap_8
* cell instance sg13cmos5l_decap_8_1535 r0 *1 0,0
Xsg13cmos5l_decap_8_1535 VPWR VGND sg13cmos5l_decap_8
* cell instance sg13cmos5l_decap_8_1536 r0 *1 0,0
Xsg13cmos5l_decap_8_1536 VPWR VGND sg13cmos5l_decap_8
* cell instance sg13cmos5l_decap_8_1537 r0 *1 0,0
Xsg13cmos5l_decap_8_1537 VPWR VGND sg13cmos5l_decap_8
* cell instance sg13cmos5l_decap_8_1538 r0 *1 0,0
Xsg13cmos5l_decap_8_1538 VPWR VGND sg13cmos5l_decap_8
* cell instance sg13cmos5l_decap_8_1539 r0 *1 0,0
Xsg13cmos5l_decap_8_1539 VPWR VGND sg13cmos5l_decap_8
* cell instance sg13cmos5l_decap_8_1540 r0 *1 0,0
Xsg13cmos5l_decap_8_1540 VPWR VGND sg13cmos5l_decap_8
* cell instance sg13cmos5l_decap_8_1541 r0 *1 0,0
Xsg13cmos5l_decap_8_1541 VPWR VGND sg13cmos5l_decap_8
* cell instance sg13cmos5l_decap_8_1542 r0 *1 0,0
Xsg13cmos5l_decap_8_1542 VPWR VGND sg13cmos5l_decap_8
* cell instance sg13cmos5l_decap_8_1543 r0 *1 0,0
Xsg13cmos5l_decap_8_1543 VPWR VGND sg13cmos5l_decap_8
* cell instance sg13cmos5l_decap_8_1544 r0 *1 0,0
Xsg13cmos5l_decap_8_1544 VPWR VGND sg13cmos5l_decap_8
* cell instance sg13cmos5l_decap_8_1545 r0 *1 0,0
Xsg13cmos5l_decap_8_1545 VPWR VGND sg13cmos5l_decap_8
* cell instance sg13cmos5l_decap_8_1546 r0 *1 0,0
Xsg13cmos5l_decap_8_1546 VPWR VGND sg13cmos5l_decap_8
* cell instance sg13cmos5l_decap_8_1547 r0 *1 0,0
Xsg13cmos5l_decap_8_1547 VPWR VGND sg13cmos5l_decap_8
* cell instance sg13cmos5l_decap_8_1548 r0 *1 0,0
Xsg13cmos5l_decap_8_1548 VPWR VGND sg13cmos5l_decap_8
* cell instance sg13cmos5l_decap_8_1549 r0 *1 0,0
Xsg13cmos5l_decap_8_1549 VPWR VGND sg13cmos5l_decap_8
* cell instance sg13cmos5l_decap_8_1550 r0 *1 0,0
Xsg13cmos5l_decap_8_1550 VPWR VGND sg13cmos5l_decap_8
* cell instance sg13cmos5l_decap_8_1551 r0 *1 0,0
Xsg13cmos5l_decap_8_1551 VPWR VGND sg13cmos5l_decap_8
* cell instance sg13cmos5l_decap_8_1552 r0 *1 0,0
Xsg13cmos5l_decap_8_1552 VPWR VGND sg13cmos5l_decap_8
* cell instance sg13cmos5l_decap_8_1553 r0 *1 0,0
Xsg13cmos5l_decap_8_1553 VPWR VGND sg13cmos5l_decap_8
* cell instance sg13cmos5l_decap_8_1554 r0 *1 0,0
Xsg13cmos5l_decap_8_1554 VPWR VGND sg13cmos5l_decap_8
* cell instance sg13cmos5l_decap_8_1555 r0 *1 0,0
Xsg13cmos5l_decap_8_1555 VPWR VGND sg13cmos5l_decap_8
* cell instance sg13cmos5l_decap_8_1556 r0 *1 0,0
Xsg13cmos5l_decap_8_1556 VPWR VGND sg13cmos5l_decap_8
* cell instance sg13cmos5l_decap_8_1557 r0 *1 0,0
Xsg13cmos5l_decap_8_1557 VPWR VGND sg13cmos5l_decap_8
* cell instance sg13cmos5l_decap_8_1558 r0 *1 0,0
Xsg13cmos5l_decap_8_1558 VPWR VGND sg13cmos5l_decap_8
* cell instance sg13cmos5l_decap_8_1559 r0 *1 0,0
Xsg13cmos5l_decap_8_1559 VPWR VGND sg13cmos5l_decap_8
* cell instance sg13cmos5l_decap_8_1560 r0 *1 0,0
Xsg13cmos5l_decap_8_1560 VPWR VGND sg13cmos5l_decap_8
* cell instance sg13cmos5l_decap_8_1561 r0 *1 0,0
Xsg13cmos5l_decap_8_1561 VPWR VGND sg13cmos5l_decap_8
* cell instance sg13cmos5l_decap_8_1562 r0 *1 0,0
Xsg13cmos5l_decap_8_1562 VPWR VGND sg13cmos5l_decap_8
* cell instance sg13cmos5l_decap_8_1563 r0 *1 0,0
Xsg13cmos5l_decap_8_1563 VPWR VGND sg13cmos5l_decap_8
* cell instance sg13cmos5l_decap_8_1564 r0 *1 0,0
Xsg13cmos5l_decap_8_1564 VPWR VGND sg13cmos5l_decap_8
* cell instance sg13cmos5l_decap_8_1565 r0 *1 0,0
Xsg13cmos5l_decap_8_1565 VPWR VGND sg13cmos5l_decap_8
* cell instance sg13cmos5l_decap_8_1566 r0 *1 0,0
Xsg13cmos5l_decap_8_1566 VPWR VGND sg13cmos5l_decap_8
* cell instance sg13cmos5l_decap_8_1567 r0 *1 0,0
Xsg13cmos5l_decap_8_1567 VPWR VGND sg13cmos5l_decap_8
* cell instance sg13cmos5l_decap_8_1568 r0 *1 0,0
Xsg13cmos5l_decap_8_1568 VPWR VGND sg13cmos5l_decap_8
* cell instance sg13cmos5l_decap_8_1569 r0 *1 0,0
Xsg13cmos5l_decap_8_1569 VPWR VGND sg13cmos5l_decap_8
* cell instance sg13cmos5l_decap_8_1570 r0 *1 0,0
Xsg13cmos5l_decap_8_1570 VPWR VGND sg13cmos5l_decap_8
* cell instance sg13cmos5l_decap_8_1571 r0 *1 0,0
Xsg13cmos5l_decap_8_1571 VPWR VGND sg13cmos5l_decap_8
* cell instance sg13cmos5l_decap_8_1572 r0 *1 0,0
Xsg13cmos5l_decap_8_1572 VPWR VGND sg13cmos5l_decap_8
* cell instance sg13cmos5l_decap_8_1573 r0 *1 0,0
Xsg13cmos5l_decap_8_1573 VPWR VGND sg13cmos5l_decap_8
* cell instance sg13cmos5l_decap_8_1574 r0 *1 0,0
Xsg13cmos5l_decap_8_1574 VPWR VGND sg13cmos5l_decap_8
* cell instance sg13cmos5l_decap_8_1575 r0 *1 0,0
Xsg13cmos5l_decap_8_1575 VPWR VGND sg13cmos5l_decap_8
* cell instance sg13cmos5l_decap_8_1576 r0 *1 0,0
Xsg13cmos5l_decap_8_1576 VPWR VGND sg13cmos5l_decap_8
* cell instance sg13cmos5l_decap_8_1577 r0 *1 0,0
Xsg13cmos5l_decap_8_1577 VPWR VGND sg13cmos5l_decap_8
* cell instance sg13cmos5l_decap_8_1578 r0 *1 0,0
Xsg13cmos5l_decap_8_1578 VPWR VGND sg13cmos5l_decap_8
* cell instance sg13cmos5l_decap_8_1579 r0 *1 0,0
Xsg13cmos5l_decap_8_1579 VPWR VGND sg13cmos5l_decap_8
* cell instance sg13cmos5l_decap_8_1580 r0 *1 0,0
Xsg13cmos5l_decap_8_1580 VPWR VGND sg13cmos5l_decap_8
* cell instance sg13cmos5l_decap_8_1581 r0 *1 0,0
Xsg13cmos5l_decap_8_1581 VPWR VGND sg13cmos5l_decap_8
* cell instance sg13cmos5l_decap_8_1582 r0 *1 0,0
Xsg13cmos5l_decap_8_1582 VPWR VGND sg13cmos5l_decap_8
* cell instance sg13cmos5l_decap_8_1583 r0 *1 0,0
Xsg13cmos5l_decap_8_1583 VPWR VGND sg13cmos5l_decap_8
* cell instance sg13cmos5l_decap_8_1584 r0 *1 0,0
Xsg13cmos5l_decap_8_1584 VPWR VGND sg13cmos5l_decap_8
* cell instance sg13cmos5l_decap_8_1585 r0 *1 0,0
Xsg13cmos5l_decap_8_1585 VPWR VGND sg13cmos5l_decap_8
* cell instance sg13cmos5l_decap_8_1586 r0 *1 0,0
Xsg13cmos5l_decap_8_1586 VPWR VGND sg13cmos5l_decap_8
* cell instance sg13cmos5l_decap_8_1587 r0 *1 0,0
Xsg13cmos5l_decap_8_1587 VPWR VGND sg13cmos5l_decap_8
* cell instance sg13cmos5l_decap_8_1588 r0 *1 0,0
Xsg13cmos5l_decap_8_1588 VPWR VGND sg13cmos5l_decap_8
* cell instance sg13cmos5l_decap_8_1589 r0 *1 0,0
Xsg13cmos5l_decap_8_1589 VPWR VGND sg13cmos5l_decap_8
* cell instance sg13cmos5l_decap_8_1590 r0 *1 0,0
Xsg13cmos5l_decap_8_1590 VPWR VGND sg13cmos5l_decap_8
* cell instance sg13cmos5l_decap_8_1591 r0 *1 0,0
Xsg13cmos5l_decap_8_1591 VPWR VGND sg13cmos5l_decap_8
* cell instance sg13cmos5l_decap_8_1592 r0 *1 0,0
Xsg13cmos5l_decap_8_1592 VPWR VGND sg13cmos5l_decap_8
* cell instance sg13cmos5l_decap_8_1593 r0 *1 0,0
Xsg13cmos5l_decap_8_1593 VPWR VGND sg13cmos5l_decap_8
* cell instance sg13cmos5l_decap_8_1594 r0 *1 0,0
Xsg13cmos5l_decap_8_1594 VPWR VGND sg13cmos5l_decap_8
* cell instance sg13cmos5l_decap_8_1595 r0 *1 0,0
Xsg13cmos5l_decap_8_1595 VPWR VGND sg13cmos5l_decap_8
* cell instance sg13cmos5l_decap_8_1596 r0 *1 0,0
Xsg13cmos5l_decap_8_1596 VPWR VGND sg13cmos5l_decap_8
* cell instance sg13cmos5l_decap_8_1597 r0 *1 0,0
Xsg13cmos5l_decap_8_1597 VPWR VGND sg13cmos5l_decap_8
* cell instance sg13cmos5l_decap_8_1598 r0 *1 0,0
Xsg13cmos5l_decap_8_1598 VPWR VGND sg13cmos5l_decap_8
* cell instance sg13cmos5l_decap_8_1599 r0 *1 0,0
Xsg13cmos5l_decap_8_1599 VPWR VGND sg13cmos5l_decap_8
* cell instance sg13cmos5l_decap_8_1600 r0 *1 0,0
Xsg13cmos5l_decap_8_1600 VPWR VGND sg13cmos5l_decap_8
* cell instance sg13cmos5l_decap_8_1601 r0 *1 0,0
Xsg13cmos5l_decap_8_1601 VPWR VGND sg13cmos5l_decap_8
* cell instance sg13cmos5l_decap_8_1602 r0 *1 0,0
Xsg13cmos5l_decap_8_1602 VPWR VGND sg13cmos5l_decap_8
* cell instance sg13cmos5l_decap_8_1603 r0 *1 0,0
Xsg13cmos5l_decap_8_1603 VPWR VGND sg13cmos5l_decap_8
* cell instance sg13cmos5l_decap_8_1604 r0 *1 0,0
Xsg13cmos5l_decap_8_1604 VPWR VGND sg13cmos5l_decap_8
* cell instance sg13cmos5l_decap_8_1605 r0 *1 0,0
Xsg13cmos5l_decap_8_1605 VPWR VGND sg13cmos5l_decap_8
* cell instance sg13cmos5l_decap_8_1606 r0 *1 0,0
Xsg13cmos5l_decap_8_1606 VPWR VGND sg13cmos5l_decap_8
* cell instance sg13cmos5l_decap_8_1607 r0 *1 0,0
Xsg13cmos5l_decap_8_1607 VPWR VGND sg13cmos5l_decap_8
* cell instance sg13cmos5l_decap_8_1608 r0 *1 0,0
Xsg13cmos5l_decap_8_1608 VPWR VGND sg13cmos5l_decap_8
* cell instance sg13cmos5l_decap_8_1609 r0 *1 0,0
Xsg13cmos5l_decap_8_1609 VPWR VGND sg13cmos5l_decap_8
* cell instance sg13cmos5l_decap_8_1610 r0 *1 0,0
Xsg13cmos5l_decap_8_1610 VPWR VGND sg13cmos5l_decap_8
* cell instance sg13cmos5l_decap_8_1611 r0 *1 0,0
Xsg13cmos5l_decap_8_1611 VPWR VGND sg13cmos5l_decap_8
* cell instance sg13cmos5l_decap_8_1612 r0 *1 0,0
Xsg13cmos5l_decap_8_1612 VPWR VGND sg13cmos5l_decap_8
* cell instance sg13cmos5l_decap_8_1613 r0 *1 0,0
Xsg13cmos5l_decap_8_1613 VPWR VGND sg13cmos5l_decap_8
* cell instance sg13cmos5l_decap_8_1614 r0 *1 0,0
Xsg13cmos5l_decap_8_1614 VPWR VGND sg13cmos5l_decap_8
* cell instance sg13cmos5l_decap_8_1615 r0 *1 0,0
Xsg13cmos5l_decap_8_1615 VPWR VGND sg13cmos5l_decap_8
* cell instance sg13cmos5l_decap_8_1616 r0 *1 0,0
Xsg13cmos5l_decap_8_1616 VPWR VGND sg13cmos5l_decap_8
* cell instance sg13cmos5l_decap_8_1617 r0 *1 0,0
Xsg13cmos5l_decap_8_1617 VPWR VGND sg13cmos5l_decap_8
* cell instance sg13cmos5l_decap_8_1618 r0 *1 0,0
Xsg13cmos5l_decap_8_1618 VPWR VGND sg13cmos5l_decap_8
* cell instance sg13cmos5l_decap_8_1619 r0 *1 0,0
Xsg13cmos5l_decap_8_1619 VPWR VGND sg13cmos5l_decap_8
* cell instance sg13cmos5l_decap_8_1620 r0 *1 0,0
Xsg13cmos5l_decap_8_1620 VPWR VGND sg13cmos5l_decap_8
* cell instance sg13cmos5l_decap_8_1621 r0 *1 0,0
Xsg13cmos5l_decap_8_1621 VPWR VGND sg13cmos5l_decap_8
* cell instance sg13cmos5l_decap_8_1622 r0 *1 0,0
Xsg13cmos5l_decap_8_1622 VPWR VGND sg13cmos5l_decap_8
* cell instance sg13cmos5l_decap_8_1623 r0 *1 0,0
Xsg13cmos5l_decap_8_1623 VPWR VGND sg13cmos5l_decap_8
* cell instance sg13cmos5l_decap_8_1624 r0 *1 0,0
Xsg13cmos5l_decap_8_1624 VPWR VGND sg13cmos5l_decap_8
* cell instance sg13cmos5l_decap_8_1625 r0 *1 0,0
Xsg13cmos5l_decap_8_1625 VPWR VGND sg13cmos5l_decap_8
* cell instance sg13cmos5l_decap_8_1626 r0 *1 0,0
Xsg13cmos5l_decap_8_1626 VPWR VGND sg13cmos5l_decap_8
* cell instance sg13cmos5l_decap_8_1627 r0 *1 0,0
Xsg13cmos5l_decap_8_1627 VPWR VGND sg13cmos5l_decap_8
* cell instance sg13cmos5l_decap_8_1628 r0 *1 0,0
Xsg13cmos5l_decap_8_1628 VPWR VGND sg13cmos5l_decap_8
* cell instance sg13cmos5l_decap_8_1629 r0 *1 0,0
Xsg13cmos5l_decap_8_1629 VPWR VGND sg13cmos5l_decap_8
* cell instance sg13cmos5l_decap_8_1630 r0 *1 0,0
Xsg13cmos5l_decap_8_1630 VPWR VGND sg13cmos5l_decap_8
* cell instance sg13cmos5l_decap_8_1631 r0 *1 0,0
Xsg13cmos5l_decap_8_1631 VPWR VGND sg13cmos5l_decap_8
* cell instance sg13cmos5l_decap_8_1632 r0 *1 0,0
Xsg13cmos5l_decap_8_1632 VPWR VGND sg13cmos5l_decap_8
* cell instance sg13cmos5l_decap_8_1633 r0 *1 0,0
Xsg13cmos5l_decap_8_1633 VPWR VGND sg13cmos5l_decap_8
* cell instance sg13cmos5l_decap_8_1634 r0 *1 0,0
Xsg13cmos5l_decap_8_1634 VPWR VGND sg13cmos5l_decap_8
* cell instance sg13cmos5l_decap_8_1635 r0 *1 0,0
Xsg13cmos5l_decap_8_1635 VPWR VGND sg13cmos5l_decap_8
* cell instance sg13cmos5l_decap_8_1636 r0 *1 0,0
Xsg13cmos5l_decap_8_1636 VPWR VGND sg13cmos5l_decap_8
* cell instance sg13cmos5l_decap_8_1637 r0 *1 0,0
Xsg13cmos5l_decap_8_1637 VPWR VGND sg13cmos5l_decap_8
* cell instance sg13cmos5l_decap_8_1638 r0 *1 0,0
Xsg13cmos5l_decap_8_1638 VPWR VGND sg13cmos5l_decap_8
* cell instance sg13cmos5l_decap_8_1639 r0 *1 0,0
Xsg13cmos5l_decap_8_1639 VPWR VGND sg13cmos5l_decap_8
* cell instance sg13cmos5l_decap_8_1640 r0 *1 0,0
Xsg13cmos5l_decap_8_1640 VPWR VGND sg13cmos5l_decap_8
* cell instance sg13cmos5l_decap_8_1641 r0 *1 0,0
Xsg13cmos5l_decap_8_1641 VPWR VGND sg13cmos5l_decap_8
* cell instance sg13cmos5l_decap_8_1642 r0 *1 0,0
Xsg13cmos5l_decap_8_1642 VPWR VGND sg13cmos5l_decap_8
* cell instance sg13cmos5l_decap_8_1643 r0 *1 0,0
Xsg13cmos5l_decap_8_1643 VPWR VGND sg13cmos5l_decap_8
* cell instance sg13cmos5l_decap_8_1644 r0 *1 0,0
Xsg13cmos5l_decap_8_1644 VPWR VGND sg13cmos5l_decap_8
* cell instance sg13cmos5l_decap_8_1645 r0 *1 0,0
Xsg13cmos5l_decap_8_1645 VPWR VGND sg13cmos5l_decap_8
* cell instance sg13cmos5l_decap_8_1646 r0 *1 0,0
Xsg13cmos5l_decap_8_1646 VPWR VGND sg13cmos5l_decap_8
* cell instance sg13cmos5l_decap_8_1647 r0 *1 0,0
Xsg13cmos5l_decap_8_1647 VPWR VGND sg13cmos5l_decap_8
* cell instance sg13cmos5l_decap_8_1648 r0 *1 0,0
Xsg13cmos5l_decap_8_1648 VPWR VGND sg13cmos5l_decap_8
* cell instance sg13cmos5l_decap_8_1649 r0 *1 0,0
Xsg13cmos5l_decap_8_1649 VPWR VGND sg13cmos5l_decap_8
* cell instance sg13cmos5l_decap_8_1650 r0 *1 0,0
Xsg13cmos5l_decap_8_1650 VPWR VGND sg13cmos5l_decap_8
* cell instance sg13cmos5l_decap_8_1651 r0 *1 0,0
Xsg13cmos5l_decap_8_1651 VPWR VGND sg13cmos5l_decap_8
* cell instance sg13cmos5l_decap_8_1652 r0 *1 0,0
Xsg13cmos5l_decap_8_1652 VPWR VGND sg13cmos5l_decap_8
* cell instance sg13cmos5l_decap_8_1653 r0 *1 0,0
Xsg13cmos5l_decap_8_1653 VPWR VGND sg13cmos5l_decap_8
* cell instance sg13cmos5l_decap_8_1654 r0 *1 0,0
Xsg13cmos5l_decap_8_1654 VPWR VGND sg13cmos5l_decap_8
* cell instance sg13cmos5l_decap_8_1655 r0 *1 0,0
Xsg13cmos5l_decap_8_1655 VPWR VGND sg13cmos5l_decap_8
* cell instance sg13cmos5l_decap_8_1656 r0 *1 0,0
Xsg13cmos5l_decap_8_1656 VPWR VGND sg13cmos5l_decap_8
* cell instance sg13cmos5l_decap_8_1657 r0 *1 0,0
Xsg13cmos5l_decap_8_1657 VPWR VGND sg13cmos5l_decap_8
* cell instance sg13cmos5l_decap_8_1658 r0 *1 0,0
Xsg13cmos5l_decap_8_1658 VPWR VGND sg13cmos5l_decap_8
* cell instance sg13cmos5l_decap_8_1659 r0 *1 0,0
Xsg13cmos5l_decap_8_1659 VPWR VGND sg13cmos5l_decap_8
* cell instance sg13cmos5l_decap_8_1660 r0 *1 0,0
Xsg13cmos5l_decap_8_1660 VPWR VGND sg13cmos5l_decap_8
* cell instance sg13cmos5l_decap_8_1661 r0 *1 0,0
Xsg13cmos5l_decap_8_1661 VPWR VGND sg13cmos5l_decap_8
* cell instance sg13cmos5l_decap_8_1662 r0 *1 0,0
Xsg13cmos5l_decap_8_1662 VPWR VGND sg13cmos5l_decap_8
* cell instance sg13cmos5l_decap_8_1663 r0 *1 0,0
Xsg13cmos5l_decap_8_1663 VPWR VGND sg13cmos5l_decap_8
* cell instance sg13cmos5l_decap_8_1664 r0 *1 0,0
Xsg13cmos5l_decap_8_1664 VPWR VGND sg13cmos5l_decap_8
* cell instance sg13cmos5l_decap_8_1665 r0 *1 0,0
Xsg13cmos5l_decap_8_1665 VPWR VGND sg13cmos5l_decap_8
* cell instance sg13cmos5l_decap_8_1666 r0 *1 0,0
Xsg13cmos5l_decap_8_1666 VPWR VGND sg13cmos5l_decap_8
* cell instance sg13cmos5l_decap_8_1667 r0 *1 0,0
Xsg13cmos5l_decap_8_1667 VPWR VGND sg13cmos5l_decap_8
* cell instance sg13cmos5l_decap_8_1668 r0 *1 0,0
Xsg13cmos5l_decap_8_1668 VPWR VGND sg13cmos5l_decap_8
* cell instance sg13cmos5l_decap_8_1669 r0 *1 0,0
Xsg13cmos5l_decap_8_1669 VPWR VGND sg13cmos5l_decap_8
* cell instance sg13cmos5l_decap_8_1670 r0 *1 0,0
Xsg13cmos5l_decap_8_1670 VPWR VGND sg13cmos5l_decap_8
* cell instance sg13cmos5l_decap_8_1671 r0 *1 0,0
Xsg13cmos5l_decap_8_1671 VPWR VGND sg13cmos5l_decap_8
* cell instance sg13cmos5l_decap_8_1672 r0 *1 0,0
Xsg13cmos5l_decap_8_1672 VPWR VGND sg13cmos5l_decap_8
* cell instance sg13cmos5l_decap_8_1673 r0 *1 0,0
Xsg13cmos5l_decap_8_1673 VPWR VGND sg13cmos5l_decap_8
* cell instance sg13cmos5l_decap_8_1674 r0 *1 0,0
Xsg13cmos5l_decap_8_1674 VPWR VGND sg13cmos5l_decap_8
* cell instance sg13cmos5l_decap_8_1675 r0 *1 0,0
Xsg13cmos5l_decap_8_1675 VPWR VGND sg13cmos5l_decap_8
* cell instance sg13cmos5l_decap_8_1676 r0 *1 0,0
Xsg13cmos5l_decap_8_1676 VPWR VGND sg13cmos5l_decap_8
* cell instance sg13cmos5l_decap_8_1677 r0 *1 0,0
Xsg13cmos5l_decap_8_1677 VPWR VGND sg13cmos5l_decap_8
* cell instance sg13cmos5l_decap_8_1678 r0 *1 0,0
Xsg13cmos5l_decap_8_1678 VPWR VGND sg13cmos5l_decap_8
* cell instance sg13cmos5l_decap_8_1679 r0 *1 0,0
Xsg13cmos5l_decap_8_1679 VPWR VGND sg13cmos5l_decap_8
* cell instance sg13cmos5l_decap_8_1680 r0 *1 0,0
Xsg13cmos5l_decap_8_1680 VPWR VGND sg13cmos5l_decap_8
* cell instance sg13cmos5l_decap_8_1681 r0 *1 0,0
Xsg13cmos5l_decap_8_1681 VPWR VGND sg13cmos5l_decap_8
* cell instance sg13cmos5l_decap_8_1682 r0 *1 0,0
Xsg13cmos5l_decap_8_1682 VPWR VGND sg13cmos5l_decap_8
* cell instance sg13cmos5l_decap_8_1683 r0 *1 0,0
Xsg13cmos5l_decap_8_1683 VPWR VGND sg13cmos5l_decap_8
* cell instance sg13cmos5l_decap_8_1684 r0 *1 0,0
Xsg13cmos5l_decap_8_1684 VPWR VGND sg13cmos5l_decap_8
* cell instance sg13cmos5l_decap_8_1685 r0 *1 0,0
Xsg13cmos5l_decap_8_1685 VPWR VGND sg13cmos5l_decap_8
* cell instance sg13cmos5l_decap_8_1686 r0 *1 0,0
Xsg13cmos5l_decap_8_1686 VPWR VGND sg13cmos5l_decap_8
* cell instance sg13cmos5l_decap_8_1687 r0 *1 0,0
Xsg13cmos5l_decap_8_1687 VPWR VGND sg13cmos5l_decap_8
* cell instance sg13cmos5l_decap_8_1688 r0 *1 0,0
Xsg13cmos5l_decap_8_1688 VPWR VGND sg13cmos5l_decap_8
* cell instance sg13cmos5l_decap_8_1689 r0 *1 0,0
Xsg13cmos5l_decap_8_1689 VPWR VGND sg13cmos5l_decap_8
* cell instance sg13cmos5l_decap_8_1690 r0 *1 0,0
Xsg13cmos5l_decap_8_1690 VPWR VGND sg13cmos5l_decap_8
* cell instance sg13cmos5l_decap_8_1691 r0 *1 0,0
Xsg13cmos5l_decap_8_1691 VPWR VGND sg13cmos5l_decap_8
* cell instance sg13cmos5l_decap_8_1692 r0 *1 0,0
Xsg13cmos5l_decap_8_1692 VPWR VGND sg13cmos5l_decap_8
* cell instance sg13cmos5l_decap_8_1693 r0 *1 0,0
Xsg13cmos5l_decap_8_1693 VPWR VGND sg13cmos5l_decap_8
* cell instance sg13cmos5l_decap_8_1694 r0 *1 0,0
Xsg13cmos5l_decap_8_1694 VPWR VGND sg13cmos5l_decap_8
* cell instance sg13cmos5l_decap_8_1695 r0 *1 0,0
Xsg13cmos5l_decap_8_1695 VPWR VGND sg13cmos5l_decap_8
* cell instance sg13cmos5l_decap_8_1696 r0 *1 0,0
Xsg13cmos5l_decap_8_1696 VPWR VGND sg13cmos5l_decap_8
* cell instance sg13cmos5l_decap_8_1697 r0 *1 0,0
Xsg13cmos5l_decap_8_1697 VPWR VGND sg13cmos5l_decap_8
* cell instance sg13cmos5l_decap_8_1698 r0 *1 0,0
Xsg13cmos5l_decap_8_1698 VPWR VGND sg13cmos5l_decap_8
* cell instance sg13cmos5l_decap_8_1699 r0 *1 0,0
Xsg13cmos5l_decap_8_1699 VPWR VGND sg13cmos5l_decap_8
* cell instance sg13cmos5l_decap_8_1700 r0 *1 0,0
Xsg13cmos5l_decap_8_1700 VPWR VGND sg13cmos5l_decap_8
* cell instance sg13cmos5l_decap_8_1701 r0 *1 0,0
Xsg13cmos5l_decap_8_1701 VPWR VGND sg13cmos5l_decap_8
* cell instance sg13cmos5l_decap_8_1702 r0 *1 0,0
Xsg13cmos5l_decap_8_1702 VPWR VGND sg13cmos5l_decap_8
* cell instance sg13cmos5l_decap_8_1703 r0 *1 0,0
Xsg13cmos5l_decap_8_1703 VPWR VGND sg13cmos5l_decap_8
* cell instance sg13cmos5l_decap_8_1704 r0 *1 0,0
Xsg13cmos5l_decap_8_1704 VPWR VGND sg13cmos5l_decap_8
* cell instance sg13cmos5l_decap_8_1705 r0 *1 0,0
Xsg13cmos5l_decap_8_1705 VPWR VGND sg13cmos5l_decap_8
* cell instance sg13cmos5l_decap_8_1706 r0 *1 0,0
Xsg13cmos5l_decap_8_1706 VPWR VGND sg13cmos5l_decap_8
* cell instance sg13cmos5l_decap_8_1707 r0 *1 0,0
Xsg13cmos5l_decap_8_1707 VPWR VGND sg13cmos5l_decap_8
* cell instance sg13cmos5l_decap_8_1708 r0 *1 0,0
Xsg13cmos5l_decap_8_1708 VPWR VGND sg13cmos5l_decap_8
* cell instance sg13cmos5l_decap_8_1709 r0 *1 0,0
Xsg13cmos5l_decap_8_1709 VPWR VGND sg13cmos5l_decap_8
* cell instance sg13cmos5l_decap_8_1710 r0 *1 0,0
Xsg13cmos5l_decap_8_1710 VPWR VGND sg13cmos5l_decap_8
* cell instance sg13cmos5l_decap_8_1711 r0 *1 0,0
Xsg13cmos5l_decap_8_1711 VPWR VGND sg13cmos5l_decap_8
* cell instance sg13cmos5l_decap_8_1712 r0 *1 0,0
Xsg13cmos5l_decap_8_1712 VPWR VGND sg13cmos5l_decap_8
* cell instance sg13cmos5l_decap_8_1713 r0 *1 0,0
Xsg13cmos5l_decap_8_1713 VPWR VGND sg13cmos5l_decap_8
* cell instance sg13cmos5l_decap_8_1714 r0 *1 0,0
Xsg13cmos5l_decap_8_1714 VPWR VGND sg13cmos5l_decap_8
* cell instance sg13cmos5l_decap_8_1715 r0 *1 0,0
Xsg13cmos5l_decap_8_1715 VPWR VGND sg13cmos5l_decap_8
* cell instance sg13cmos5l_decap_8_1716 r0 *1 0,0
Xsg13cmos5l_decap_8_1716 VPWR VGND sg13cmos5l_decap_8
* cell instance sg13cmos5l_decap_8_1717 r0 *1 0,0
Xsg13cmos5l_decap_8_1717 VPWR VGND sg13cmos5l_decap_8
* cell instance sg13cmos5l_decap_8_1718 r0 *1 0,0
Xsg13cmos5l_decap_8_1718 VPWR VGND sg13cmos5l_decap_8
* cell instance sg13cmos5l_decap_8_1719 r0 *1 0,0
Xsg13cmos5l_decap_8_1719 VPWR VGND sg13cmos5l_decap_8
* cell instance sg13cmos5l_decap_8_1720 r0 *1 0,0
Xsg13cmos5l_decap_8_1720 VPWR VGND sg13cmos5l_decap_8
* cell instance sg13cmos5l_decap_8_1721 r0 *1 0,0
Xsg13cmos5l_decap_8_1721 VPWR VGND sg13cmos5l_decap_8
* cell instance sg13cmos5l_decap_8_1722 r0 *1 0,0
Xsg13cmos5l_decap_8_1722 VPWR VGND sg13cmos5l_decap_8
* cell instance sg13cmos5l_decap_8_1723 r0 *1 0,0
Xsg13cmos5l_decap_8_1723 VPWR VGND sg13cmos5l_decap_8
* cell instance sg13cmos5l_decap_8_1724 r0 *1 0,0
Xsg13cmos5l_decap_8_1724 VPWR VGND sg13cmos5l_decap_8
* cell instance sg13cmos5l_decap_8_1725 r0 *1 0,0
Xsg13cmos5l_decap_8_1725 VPWR VGND sg13cmos5l_decap_8
* cell instance sg13cmos5l_decap_8_1726 r0 *1 0,0
Xsg13cmos5l_decap_8_1726 VPWR VGND sg13cmos5l_decap_8
* cell instance sg13cmos5l_decap_8_1727 r0 *1 0,0
Xsg13cmos5l_decap_8_1727 VPWR VGND sg13cmos5l_decap_8
* cell instance sg13cmos5l_decap_8_1728 r0 *1 0,0
Xsg13cmos5l_decap_8_1728 VPWR VGND sg13cmos5l_decap_8
* cell instance sg13cmos5l_decap_8_1729 r0 *1 0,0
Xsg13cmos5l_decap_8_1729 VPWR VGND sg13cmos5l_decap_8
* cell instance sg13cmos5l_decap_8_1730 r0 *1 0,0
Xsg13cmos5l_decap_8_1730 VPWR VGND sg13cmos5l_decap_8
* cell instance sg13cmos5l_decap_8_1731 r0 *1 0,0
Xsg13cmos5l_decap_8_1731 VPWR VGND sg13cmos5l_decap_8
* cell instance sg13cmos5l_decap_8_1732 r0 *1 0,0
Xsg13cmos5l_decap_8_1732 VPWR VGND sg13cmos5l_decap_8
* cell instance sg13cmos5l_decap_8_1733 r0 *1 0,0
Xsg13cmos5l_decap_8_1733 VPWR VGND sg13cmos5l_decap_8
* cell instance sg13cmos5l_decap_8_1734 r0 *1 0,0
Xsg13cmos5l_decap_8_1734 VPWR VGND sg13cmos5l_decap_8
* cell instance sg13cmos5l_decap_8_1735 r0 *1 0,0
Xsg13cmos5l_decap_8_1735 VPWR VGND sg13cmos5l_decap_8
* cell instance sg13cmos5l_decap_8_1736 r0 *1 0,0
Xsg13cmos5l_decap_8_1736 VPWR VGND sg13cmos5l_decap_8
* cell instance sg13cmos5l_decap_8_1737 r0 *1 0,0
Xsg13cmos5l_decap_8_1737 VPWR VGND sg13cmos5l_decap_8
* cell instance sg13cmos5l_decap_8_1738 r0 *1 0,0
Xsg13cmos5l_decap_8_1738 VPWR VGND sg13cmos5l_decap_8
* cell instance sg13cmos5l_decap_8_1739 r0 *1 0,0
Xsg13cmos5l_decap_8_1739 VPWR VGND sg13cmos5l_decap_8
* cell instance sg13cmos5l_decap_8_1740 r0 *1 0,0
Xsg13cmos5l_decap_8_1740 VPWR VGND sg13cmos5l_decap_8
* cell instance sg13cmos5l_decap_8_1741 r0 *1 0,0
Xsg13cmos5l_decap_8_1741 VPWR VGND sg13cmos5l_decap_8
* cell instance sg13cmos5l_decap_8_1742 r0 *1 0,0
Xsg13cmos5l_decap_8_1742 VPWR VGND sg13cmos5l_decap_8
* cell instance sg13cmos5l_decap_8_1743 r0 *1 0,0
Xsg13cmos5l_decap_8_1743 VPWR VGND sg13cmos5l_decap_8
* cell instance sg13cmos5l_decap_8_1744 r0 *1 0,0
Xsg13cmos5l_decap_8_1744 VPWR VGND sg13cmos5l_decap_8
* cell instance sg13cmos5l_decap_8_1745 r0 *1 0,0
Xsg13cmos5l_decap_8_1745 VPWR VGND sg13cmos5l_decap_8
* cell instance sg13cmos5l_decap_8_1746 r0 *1 0,0
Xsg13cmos5l_decap_8_1746 VPWR VGND sg13cmos5l_decap_8
* cell instance sg13cmos5l_decap_8_1747 r0 *1 0,0
Xsg13cmos5l_decap_8_1747 VPWR VGND sg13cmos5l_decap_8
* cell instance sg13cmos5l_decap_8_1748 r0 *1 0,0
Xsg13cmos5l_decap_8_1748 VPWR VGND sg13cmos5l_decap_8
* cell instance sg13cmos5l_decap_8_1749 r0 *1 0,0
Xsg13cmos5l_decap_8_1749 VPWR VGND sg13cmos5l_decap_8
* cell instance sg13cmos5l_decap_8_1750 r0 *1 0,0
Xsg13cmos5l_decap_8_1750 VPWR VGND sg13cmos5l_decap_8
* cell instance sg13cmos5l_decap_8_1751 r0 *1 0,0
Xsg13cmos5l_decap_8_1751 VPWR VGND sg13cmos5l_decap_8
* cell instance sg13cmos5l_decap_8_1752 r0 *1 0,0
Xsg13cmos5l_decap_8_1752 VPWR VGND sg13cmos5l_decap_8
* cell instance sg13cmos5l_decap_8_1753 r0 *1 0,0
Xsg13cmos5l_decap_8_1753 VPWR VGND sg13cmos5l_decap_8
* cell instance sg13cmos5l_decap_8_1754 r0 *1 0,0
Xsg13cmos5l_decap_8_1754 VPWR VGND sg13cmos5l_decap_8
* cell instance sg13cmos5l_decap_8_1755 r0 *1 0,0
Xsg13cmos5l_decap_8_1755 VPWR VGND sg13cmos5l_decap_8
* cell instance sg13cmos5l_decap_8_1756 r0 *1 0,0
Xsg13cmos5l_decap_8_1756 VPWR VGND sg13cmos5l_decap_8
* cell instance sg13cmos5l_decap_8_1757 r0 *1 0,0
Xsg13cmos5l_decap_8_1757 VPWR VGND sg13cmos5l_decap_8
* cell instance sg13cmos5l_decap_8_1758 r0 *1 0,0
Xsg13cmos5l_decap_8_1758 VPWR VGND sg13cmos5l_decap_8
* cell instance sg13cmos5l_decap_8_1759 r0 *1 0,0
Xsg13cmos5l_decap_8_1759 VPWR VGND sg13cmos5l_decap_8
* cell instance sg13cmos5l_decap_8_1760 r0 *1 0,0
Xsg13cmos5l_decap_8_1760 VPWR VGND sg13cmos5l_decap_8
* cell instance sg13cmos5l_decap_8_1761 r0 *1 0,0
Xsg13cmos5l_decap_8_1761 VPWR VGND sg13cmos5l_decap_8
* cell instance sg13cmos5l_decap_8_1762 r0 *1 0,0
Xsg13cmos5l_decap_8_1762 VPWR VGND sg13cmos5l_decap_8
* cell instance sg13cmos5l_decap_8_1763 r0 *1 0,0
Xsg13cmos5l_decap_8_1763 VPWR VGND sg13cmos5l_decap_8
* cell instance sg13cmos5l_decap_8_1764 r0 *1 0,0
Xsg13cmos5l_decap_8_1764 VPWR VGND sg13cmos5l_decap_8
* cell instance sg13cmos5l_decap_8_1765 r0 *1 0,0
Xsg13cmos5l_decap_8_1765 VPWR VGND sg13cmos5l_decap_8
* cell instance sg13cmos5l_decap_8_1766 r0 *1 0,0
Xsg13cmos5l_decap_8_1766 VPWR VGND sg13cmos5l_decap_8
* cell instance sg13cmos5l_decap_8_1767 r0 *1 0,0
Xsg13cmos5l_decap_8_1767 VPWR VGND sg13cmos5l_decap_8
* cell instance sg13cmos5l_decap_8_1768 r0 *1 0,0
Xsg13cmos5l_decap_8_1768 VPWR VGND sg13cmos5l_decap_8
* cell instance sg13cmos5l_decap_8_1769 r0 *1 0,0
Xsg13cmos5l_decap_8_1769 VPWR VGND sg13cmos5l_decap_8
* cell instance sg13cmos5l_decap_8_1770 r0 *1 0,0
Xsg13cmos5l_decap_8_1770 VPWR VGND sg13cmos5l_decap_8
* cell instance sg13cmos5l_decap_8_1771 r0 *1 0,0
Xsg13cmos5l_decap_8_1771 VPWR VGND sg13cmos5l_decap_8
* cell instance sg13cmos5l_decap_8_1772 r0 *1 0,0
Xsg13cmos5l_decap_8_1772 VPWR VGND sg13cmos5l_decap_8
* cell instance sg13cmos5l_decap_8_1773 r0 *1 0,0
Xsg13cmos5l_decap_8_1773 VPWR VGND sg13cmos5l_decap_8
* cell instance sg13cmos5l_decap_8_1774 r0 *1 0,0
Xsg13cmos5l_decap_8_1774 VPWR VGND sg13cmos5l_decap_8
* cell instance sg13cmos5l_decap_8_1775 r0 *1 0,0
Xsg13cmos5l_decap_8_1775 VPWR VGND sg13cmos5l_decap_8
* cell instance sg13cmos5l_decap_8_1776 r0 *1 0,0
Xsg13cmos5l_decap_8_1776 VPWR VGND sg13cmos5l_decap_8
* cell instance sg13cmos5l_decap_8_1777 r0 *1 0,0
Xsg13cmos5l_decap_8_1777 VPWR VGND sg13cmos5l_decap_8
* cell instance sg13cmos5l_decap_8_1778 r0 *1 0,0
Xsg13cmos5l_decap_8_1778 VPWR VGND sg13cmos5l_decap_8
* cell instance sg13cmos5l_decap_8_1779 r0 *1 0,0
Xsg13cmos5l_decap_8_1779 VPWR VGND sg13cmos5l_decap_8
* cell instance sg13cmos5l_decap_8_1780 r0 *1 0,0
Xsg13cmos5l_decap_8_1780 VPWR VGND sg13cmos5l_decap_8
* cell instance sg13cmos5l_decap_8_1781 r0 *1 0,0
Xsg13cmos5l_decap_8_1781 VPWR VGND sg13cmos5l_decap_8
* cell instance sg13cmos5l_decap_8_1782 r0 *1 0,0
Xsg13cmos5l_decap_8_1782 VPWR VGND sg13cmos5l_decap_8
* cell instance sg13cmos5l_decap_8_1783 r0 *1 0,0
Xsg13cmos5l_decap_8_1783 VPWR VGND sg13cmos5l_decap_8
* cell instance sg13cmos5l_decap_8_1784 r0 *1 0,0
Xsg13cmos5l_decap_8_1784 VPWR VGND sg13cmos5l_decap_8
* cell instance sg13cmos5l_decap_8_1785 r0 *1 0,0
Xsg13cmos5l_decap_8_1785 VPWR VGND sg13cmos5l_decap_8
* cell instance sg13cmos5l_decap_8_1786 r0 *1 0,0
Xsg13cmos5l_decap_8_1786 VPWR VGND sg13cmos5l_decap_8
* cell instance sg13cmos5l_decap_8_1787 r0 *1 0,0
Xsg13cmos5l_decap_8_1787 VPWR VGND sg13cmos5l_decap_8
* cell instance sg13cmos5l_decap_8_1788 r0 *1 0,0
Xsg13cmos5l_decap_8_1788 VPWR VGND sg13cmos5l_decap_8
* cell instance sg13cmos5l_decap_8_1789 r0 *1 0,0
Xsg13cmos5l_decap_8_1789 VPWR VGND sg13cmos5l_decap_8
* cell instance sg13cmos5l_decap_8_1790 r0 *1 0,0
Xsg13cmos5l_decap_8_1790 VPWR VGND sg13cmos5l_decap_8
* cell instance sg13cmos5l_decap_8_1791 r0 *1 0,0
Xsg13cmos5l_decap_8_1791 VPWR VGND sg13cmos5l_decap_8
* cell instance sg13cmos5l_decap_8_1792 r0 *1 0,0
Xsg13cmos5l_decap_8_1792 VPWR VGND sg13cmos5l_decap_8
* cell instance sg13cmos5l_decap_8_1793 r0 *1 0,0
Xsg13cmos5l_decap_8_1793 VPWR VGND sg13cmos5l_decap_8
* cell instance sg13cmos5l_decap_8_1794 r0 *1 0,0
Xsg13cmos5l_decap_8_1794 VPWR VGND sg13cmos5l_decap_8
* cell instance sg13cmos5l_decap_8_1795 r0 *1 0,0
Xsg13cmos5l_decap_8_1795 VPWR VGND sg13cmos5l_decap_8
* cell instance sg13cmos5l_decap_8_1796 r0 *1 0,0
Xsg13cmos5l_decap_8_1796 VPWR VGND sg13cmos5l_decap_8
* cell instance sg13cmos5l_decap_8_1797 r0 *1 0,0
Xsg13cmos5l_decap_8_1797 VPWR VGND sg13cmos5l_decap_8
* cell instance sg13cmos5l_decap_8_1798 r0 *1 0,0
Xsg13cmos5l_decap_8_1798 VPWR VGND sg13cmos5l_decap_8
* cell instance sg13cmos5l_decap_8_1799 r0 *1 0,0
Xsg13cmos5l_decap_8_1799 VPWR VGND sg13cmos5l_decap_8
* cell instance sg13cmos5l_decap_8_1800 r0 *1 0,0
Xsg13cmos5l_decap_8_1800 VPWR VGND sg13cmos5l_decap_8
* cell instance sg13cmos5l_decap_8_1801 r0 *1 0,0
Xsg13cmos5l_decap_8_1801 VPWR VGND sg13cmos5l_decap_8
* cell instance sg13cmos5l_decap_8_1802 r0 *1 0,0
Xsg13cmos5l_decap_8_1802 VPWR VGND sg13cmos5l_decap_8
* cell instance sg13cmos5l_decap_8_1803 r0 *1 0,0
Xsg13cmos5l_decap_8_1803 VPWR VGND sg13cmos5l_decap_8
* cell instance sg13cmos5l_decap_8_1804 r0 *1 0,0
Xsg13cmos5l_decap_8_1804 VPWR VGND sg13cmos5l_decap_8
* cell instance sg13cmos5l_decap_8_1805 r0 *1 0,0
Xsg13cmos5l_decap_8_1805 VPWR VGND sg13cmos5l_decap_8
* cell instance sg13cmos5l_decap_8_1806 r0 *1 0,0
Xsg13cmos5l_decap_8_1806 VPWR VGND sg13cmos5l_decap_8
* cell instance sg13cmos5l_decap_8_1807 r0 *1 0,0
Xsg13cmos5l_decap_8_1807 VPWR VGND sg13cmos5l_decap_8
* cell instance sg13cmos5l_decap_8_1808 r0 *1 0,0
Xsg13cmos5l_decap_8_1808 VPWR VGND sg13cmos5l_decap_8
* cell instance sg13cmos5l_decap_8_1809 r0 *1 0,0
Xsg13cmos5l_decap_8_1809 VPWR VGND sg13cmos5l_decap_8
* cell instance sg13cmos5l_decap_8_1810 r0 *1 0,0
Xsg13cmos5l_decap_8_1810 VPWR VGND sg13cmos5l_decap_8
* cell instance sg13cmos5l_decap_8_1811 r0 *1 0,0
Xsg13cmos5l_decap_8_1811 VPWR VGND sg13cmos5l_decap_8
* cell instance sg13cmos5l_decap_8_1812 r0 *1 0,0
Xsg13cmos5l_decap_8_1812 VPWR VGND sg13cmos5l_decap_8
* cell instance sg13cmos5l_decap_8_1813 r0 *1 0,0
Xsg13cmos5l_decap_8_1813 VPWR VGND sg13cmos5l_decap_8
* cell instance sg13cmos5l_decap_8_1814 r0 *1 0,0
Xsg13cmos5l_decap_8_1814 VPWR VGND sg13cmos5l_decap_8
* cell instance sg13cmos5l_decap_8_1815 r0 *1 0,0
Xsg13cmos5l_decap_8_1815 VPWR VGND sg13cmos5l_decap_8
* cell instance sg13cmos5l_decap_8_1816 r0 *1 0,0
Xsg13cmos5l_decap_8_1816 VPWR VGND sg13cmos5l_decap_8
* cell instance sg13cmos5l_decap_8_1817 r0 *1 0,0
Xsg13cmos5l_decap_8_1817 VPWR VGND sg13cmos5l_decap_8
* cell instance sg13cmos5l_decap_8_1818 r0 *1 0,0
Xsg13cmos5l_decap_8_1818 VPWR VGND sg13cmos5l_decap_8
* cell instance sg13cmos5l_decap_8_1819 r0 *1 0,0
Xsg13cmos5l_decap_8_1819 VPWR VGND sg13cmos5l_decap_8
* cell instance sg13cmos5l_decap_8_1820 r0 *1 0,0
Xsg13cmos5l_decap_8_1820 VPWR VGND sg13cmos5l_decap_8
* cell instance sg13cmos5l_decap_8_1821 r0 *1 0,0
Xsg13cmos5l_decap_8_1821 VPWR VGND sg13cmos5l_decap_8
* cell instance sg13cmos5l_decap_8_1822 r0 *1 0,0
Xsg13cmos5l_decap_8_1822 VPWR VGND sg13cmos5l_decap_8
* cell instance sg13cmos5l_decap_8_1823 r0 *1 0,0
Xsg13cmos5l_decap_8_1823 VPWR VGND sg13cmos5l_decap_8
* cell instance sg13cmos5l_decap_8_1824 r0 *1 0,0
Xsg13cmos5l_decap_8_1824 VPWR VGND sg13cmos5l_decap_8
* cell instance sg13cmos5l_decap_8_1825 r0 *1 0,0
Xsg13cmos5l_decap_8_1825 VPWR VGND sg13cmos5l_decap_8
* cell instance sg13cmos5l_decap_8_1826 r0 *1 0,0
Xsg13cmos5l_decap_8_1826 VPWR VGND sg13cmos5l_decap_8
* cell instance sg13cmos5l_decap_8_1827 r0 *1 0,0
Xsg13cmos5l_decap_8_1827 VPWR VGND sg13cmos5l_decap_8
* cell instance sg13cmos5l_decap_8_1828 r0 *1 0,0
Xsg13cmos5l_decap_8_1828 VPWR VGND sg13cmos5l_decap_8
* cell instance sg13cmos5l_decap_8_1829 r0 *1 0,0
Xsg13cmos5l_decap_8_1829 VPWR VGND sg13cmos5l_decap_8
* cell instance sg13cmos5l_decap_8_1830 r0 *1 0,0
Xsg13cmos5l_decap_8_1830 VPWR VGND sg13cmos5l_decap_8
* cell instance sg13cmos5l_decap_8_1831 r0 *1 0,0
Xsg13cmos5l_decap_8_1831 VPWR VGND sg13cmos5l_decap_8
* cell instance sg13cmos5l_decap_8_1832 r0 *1 0,0
Xsg13cmos5l_decap_8_1832 VPWR VGND sg13cmos5l_decap_8
* cell instance sg13cmos5l_decap_8_1833 r0 *1 0,0
Xsg13cmos5l_decap_8_1833 VPWR VGND sg13cmos5l_decap_8
* cell instance sg13cmos5l_decap_8_1834 r0 *1 0,0
Xsg13cmos5l_decap_8_1834 VPWR VGND sg13cmos5l_decap_8
* cell instance sg13cmos5l_decap_8_1835 r0 *1 0,0
Xsg13cmos5l_decap_8_1835 VPWR VGND sg13cmos5l_decap_8
* cell instance sg13cmos5l_decap_8_1836 r0 *1 0,0
Xsg13cmos5l_decap_8_1836 VPWR VGND sg13cmos5l_decap_8
* cell instance sg13cmos5l_decap_8_1837 r0 *1 0,0
Xsg13cmos5l_decap_8_1837 VPWR VGND sg13cmos5l_decap_8
* cell instance sg13cmos5l_decap_8_1838 r0 *1 0,0
Xsg13cmos5l_decap_8_1838 VPWR VGND sg13cmos5l_decap_8
* cell instance sg13cmos5l_decap_8_1839 r0 *1 0,0
Xsg13cmos5l_decap_8_1839 VPWR VGND sg13cmos5l_decap_8
* cell instance sg13cmos5l_decap_8_1840 r0 *1 0,0
Xsg13cmos5l_decap_8_1840 VPWR VGND sg13cmos5l_decap_8
* cell instance sg13cmos5l_decap_8_1841 r0 *1 0,0
Xsg13cmos5l_decap_8_1841 VPWR VGND sg13cmos5l_decap_8
* cell instance sg13cmos5l_decap_8_1842 r0 *1 0,0
Xsg13cmos5l_decap_8_1842 VPWR VGND sg13cmos5l_decap_8
* cell instance sg13cmos5l_decap_8_1843 r0 *1 0,0
Xsg13cmos5l_decap_8_1843 VPWR VGND sg13cmos5l_decap_8
* cell instance sg13cmos5l_decap_8_1844 r0 *1 0,0
Xsg13cmos5l_decap_8_1844 VPWR VGND sg13cmos5l_decap_8
* cell instance sg13cmos5l_decap_8_1845 r0 *1 0,0
Xsg13cmos5l_decap_8_1845 VPWR VGND sg13cmos5l_decap_8
* cell instance sg13cmos5l_decap_8_1846 r0 *1 0,0
Xsg13cmos5l_decap_8_1846 VPWR VGND sg13cmos5l_decap_8
* cell instance sg13cmos5l_decap_8_1847 r0 *1 0,0
Xsg13cmos5l_decap_8_1847 VPWR VGND sg13cmos5l_decap_8
* cell instance sg13cmos5l_decap_8_1848 r0 *1 0,0
Xsg13cmos5l_decap_8_1848 VPWR VGND sg13cmos5l_decap_8
* cell instance sg13cmos5l_decap_8_1849 r0 *1 0,0
Xsg13cmos5l_decap_8_1849 VPWR VGND sg13cmos5l_decap_8
* cell instance sg13cmos5l_decap_8_1850 r0 *1 0,0
Xsg13cmos5l_decap_8_1850 VPWR VGND sg13cmos5l_decap_8
* cell instance sg13cmos5l_decap_8_1851 r0 *1 0,0
Xsg13cmos5l_decap_8_1851 VPWR VGND sg13cmos5l_decap_8
* cell instance sg13cmos5l_decap_8_1852 r0 *1 0,0
Xsg13cmos5l_decap_8_1852 VPWR VGND sg13cmos5l_decap_8
* cell instance sg13cmos5l_decap_8_1853 r0 *1 0,0
Xsg13cmos5l_decap_8_1853 VPWR VGND sg13cmos5l_decap_8
* cell instance sg13cmos5l_decap_8_1854 r0 *1 0,0
Xsg13cmos5l_decap_8_1854 VPWR VGND sg13cmos5l_decap_8
* cell instance sg13cmos5l_decap_8_1855 r0 *1 0,0
Xsg13cmos5l_decap_8_1855 VPWR VGND sg13cmos5l_decap_8
* cell instance sg13cmos5l_decap_8_1856 r0 *1 0,0
Xsg13cmos5l_decap_8_1856 VPWR VGND sg13cmos5l_decap_8
* cell instance sg13cmos5l_decap_8_1857 r0 *1 0,0
Xsg13cmos5l_decap_8_1857 VPWR VGND sg13cmos5l_decap_8
* cell instance sg13cmos5l_decap_8_1858 r0 *1 0,0
Xsg13cmos5l_decap_8_1858 VPWR VGND sg13cmos5l_decap_8
* cell instance sg13cmos5l_decap_8_1859 r0 *1 0,0
Xsg13cmos5l_decap_8_1859 VPWR VGND sg13cmos5l_decap_8
* cell instance sg13cmos5l_decap_8_1860 r0 *1 0,0
Xsg13cmos5l_decap_8_1860 VPWR VGND sg13cmos5l_decap_8
* cell instance sg13cmos5l_decap_8_1861 r0 *1 0,0
Xsg13cmos5l_decap_8_1861 VPWR VGND sg13cmos5l_decap_8
* cell instance sg13cmos5l_decap_8_1862 r0 *1 0,0
Xsg13cmos5l_decap_8_1862 VPWR VGND sg13cmos5l_decap_8
* cell instance sg13cmos5l_decap_8_1863 r0 *1 0,0
Xsg13cmos5l_decap_8_1863 VPWR VGND sg13cmos5l_decap_8
* cell instance sg13cmos5l_decap_8_1864 r0 *1 0,0
Xsg13cmos5l_decap_8_1864 VPWR VGND sg13cmos5l_decap_8
* cell instance sg13cmos5l_decap_8_1865 r0 *1 0,0
Xsg13cmos5l_decap_8_1865 VPWR VGND sg13cmos5l_decap_8
* cell instance sg13cmos5l_decap_8_1866 r0 *1 0,0
Xsg13cmos5l_decap_8_1866 VPWR VGND sg13cmos5l_decap_8
* cell instance sg13cmos5l_decap_8_1867 r0 *1 0,0
Xsg13cmos5l_decap_8_1867 VPWR VGND sg13cmos5l_decap_8
* cell instance sg13cmos5l_decap_8_1868 r0 *1 0,0
Xsg13cmos5l_decap_8_1868 VPWR VGND sg13cmos5l_decap_8
* cell instance sg13cmos5l_decap_8_1869 r0 *1 0,0
Xsg13cmos5l_decap_8_1869 VPWR VGND sg13cmos5l_decap_8
* cell instance sg13cmos5l_decap_8_1870 r0 *1 0,0
Xsg13cmos5l_decap_8_1870 VPWR VGND sg13cmos5l_decap_8
* cell instance sg13cmos5l_decap_8_1871 r0 *1 0,0
Xsg13cmos5l_decap_8_1871 VPWR VGND sg13cmos5l_decap_8
* cell instance sg13cmos5l_decap_8_1872 r0 *1 0,0
Xsg13cmos5l_decap_8_1872 VPWR VGND sg13cmos5l_decap_8
* cell instance sg13cmos5l_decap_8_1873 r0 *1 0,0
Xsg13cmos5l_decap_8_1873 VPWR VGND sg13cmos5l_decap_8
* cell instance sg13cmos5l_decap_8_1874 r0 *1 0,0
Xsg13cmos5l_decap_8_1874 VPWR VGND sg13cmos5l_decap_8
* cell instance sg13cmos5l_decap_8_1875 r0 *1 0,0
Xsg13cmos5l_decap_8_1875 VPWR VGND sg13cmos5l_decap_8
* cell instance sg13cmos5l_decap_8_1876 r0 *1 0,0
Xsg13cmos5l_decap_8_1876 VPWR VGND sg13cmos5l_decap_8
* cell instance sg13cmos5l_decap_8_1877 r0 *1 0,0
Xsg13cmos5l_decap_8_1877 VPWR VGND sg13cmos5l_decap_8
* cell instance sg13cmos5l_decap_8_1878 r0 *1 0,0
Xsg13cmos5l_decap_8_1878 VPWR VGND sg13cmos5l_decap_8
* cell instance sg13cmos5l_decap_8_1879 r0 *1 0,0
Xsg13cmos5l_decap_8_1879 VPWR VGND sg13cmos5l_decap_8
* cell instance sg13cmos5l_decap_8_1880 r0 *1 0,0
Xsg13cmos5l_decap_8_1880 VPWR VGND sg13cmos5l_decap_8
* cell instance sg13cmos5l_decap_8_1881 r0 *1 0,0
Xsg13cmos5l_decap_8_1881 VPWR VGND sg13cmos5l_decap_8
* cell instance sg13cmos5l_decap_8_1882 r0 *1 0,0
Xsg13cmos5l_decap_8_1882 VPWR VGND sg13cmos5l_decap_8
* cell instance sg13cmos5l_decap_8_1883 r0 *1 0,0
Xsg13cmos5l_decap_8_1883 VPWR VGND sg13cmos5l_decap_8
* cell instance sg13cmos5l_decap_8_1884 r0 *1 0,0
Xsg13cmos5l_decap_8_1884 VPWR VGND sg13cmos5l_decap_8
* cell instance sg13cmos5l_decap_8_1885 r0 *1 0,0
Xsg13cmos5l_decap_8_1885 VPWR VGND sg13cmos5l_decap_8
* cell instance sg13cmos5l_decap_8_1886 r0 *1 0,0
Xsg13cmos5l_decap_8_1886 VPWR VGND sg13cmos5l_decap_8
* cell instance sg13cmos5l_decap_8_1887 r0 *1 0,0
Xsg13cmos5l_decap_8_1887 VPWR VGND sg13cmos5l_decap_8
* cell instance sg13cmos5l_decap_8_1888 r0 *1 0,0
Xsg13cmos5l_decap_8_1888 VPWR VGND sg13cmos5l_decap_8
* cell instance sg13cmos5l_decap_8_1889 r0 *1 0,0
Xsg13cmos5l_decap_8_1889 VPWR VGND sg13cmos5l_decap_8
* cell instance sg13cmos5l_decap_8_1890 r0 *1 0,0
Xsg13cmos5l_decap_8_1890 VPWR VGND sg13cmos5l_decap_8
* cell instance sg13cmos5l_decap_8_1891 r0 *1 0,0
Xsg13cmos5l_decap_8_1891 VPWR VGND sg13cmos5l_decap_8
* cell instance sg13cmos5l_decap_8_1892 r0 *1 0,0
Xsg13cmos5l_decap_8_1892 VPWR VGND sg13cmos5l_decap_8
* cell instance sg13cmos5l_decap_8_1893 r0 *1 0,0
Xsg13cmos5l_decap_8_1893 VPWR VGND sg13cmos5l_decap_8
* cell instance sg13cmos5l_decap_8_1894 r0 *1 0,0
Xsg13cmos5l_decap_8_1894 VPWR VGND sg13cmos5l_decap_8
* cell instance sg13cmos5l_decap_8_1895 r0 *1 0,0
Xsg13cmos5l_decap_8_1895 VPWR VGND sg13cmos5l_decap_8
* cell instance sg13cmos5l_decap_8_1896 r0 *1 0,0
Xsg13cmos5l_decap_8_1896 VPWR VGND sg13cmos5l_decap_8
* cell instance sg13cmos5l_decap_8_1897 r0 *1 0,0
Xsg13cmos5l_decap_8_1897 VPWR VGND sg13cmos5l_decap_8
* cell instance sg13cmos5l_decap_8_1898 r0 *1 0,0
Xsg13cmos5l_decap_8_1898 VPWR VGND sg13cmos5l_decap_8
* cell instance sg13cmos5l_decap_8_1899 r0 *1 0,0
Xsg13cmos5l_decap_8_1899 VPWR VGND sg13cmos5l_decap_8
* cell instance sg13cmos5l_decap_8_1900 r0 *1 0,0
Xsg13cmos5l_decap_8_1900 VPWR VGND sg13cmos5l_decap_8
* cell instance sg13cmos5l_decap_8_1901 r0 *1 0,0
Xsg13cmos5l_decap_8_1901 VPWR VGND sg13cmos5l_decap_8
* cell instance sg13cmos5l_decap_8_1902 r0 *1 0,0
Xsg13cmos5l_decap_8_1902 VPWR VGND sg13cmos5l_decap_8
* cell instance sg13cmos5l_decap_8_1903 r0 *1 0,0
Xsg13cmos5l_decap_8_1903 VPWR VGND sg13cmos5l_decap_8
* cell instance sg13cmos5l_decap_8_1904 r0 *1 0,0
Xsg13cmos5l_decap_8_1904 VPWR VGND sg13cmos5l_decap_8
* cell instance sg13cmos5l_decap_8_1905 r0 *1 0,0
Xsg13cmos5l_decap_8_1905 VPWR VGND sg13cmos5l_decap_8
* cell instance sg13cmos5l_decap_8_1906 r0 *1 0,0
Xsg13cmos5l_decap_8_1906 VPWR VGND sg13cmos5l_decap_8
* cell instance sg13cmos5l_decap_8_1907 r0 *1 0,0
Xsg13cmos5l_decap_8_1907 VPWR VGND sg13cmos5l_decap_8
* cell instance sg13cmos5l_decap_8_1908 r0 *1 0,0
Xsg13cmos5l_decap_8_1908 VPWR VGND sg13cmos5l_decap_8
* cell instance sg13cmos5l_decap_8_1909 r0 *1 0,0
Xsg13cmos5l_decap_8_1909 VPWR VGND sg13cmos5l_decap_8
* cell instance sg13cmos5l_decap_8_1910 r0 *1 0,0
Xsg13cmos5l_decap_8_1910 VPWR VGND sg13cmos5l_decap_8
* cell instance sg13cmos5l_decap_8_1911 r0 *1 0,0
Xsg13cmos5l_decap_8_1911 VPWR VGND sg13cmos5l_decap_8
* cell instance sg13cmos5l_decap_8_1912 r0 *1 0,0
Xsg13cmos5l_decap_8_1912 VPWR VGND sg13cmos5l_decap_8
* cell instance sg13cmos5l_decap_8_1913 r0 *1 0,0
Xsg13cmos5l_decap_8_1913 VPWR VGND sg13cmos5l_decap_8
* cell instance sg13cmos5l_decap_8_1914 r0 *1 0,0
Xsg13cmos5l_decap_8_1914 VPWR VGND sg13cmos5l_decap_8
* cell instance sg13cmos5l_decap_8_1915 r0 *1 0,0
Xsg13cmos5l_decap_8_1915 VPWR VGND sg13cmos5l_decap_8
* cell instance sg13cmos5l_decap_8_1916 r0 *1 0,0
Xsg13cmos5l_decap_8_1916 VPWR VGND sg13cmos5l_decap_8
* cell instance sg13cmos5l_decap_8_1917 r0 *1 0,0
Xsg13cmos5l_decap_8_1917 VPWR VGND sg13cmos5l_decap_8
* cell instance sg13cmos5l_decap_8_1918 r0 *1 0,0
Xsg13cmos5l_decap_8_1918 VPWR VGND sg13cmos5l_decap_8
* cell instance sg13cmos5l_decap_8_1919 r0 *1 0,0
Xsg13cmos5l_decap_8_1919 VPWR VGND sg13cmos5l_decap_8
* cell instance sg13cmos5l_decap_8_1920 r0 *1 0,0
Xsg13cmos5l_decap_8_1920 VPWR VGND sg13cmos5l_decap_8
* cell instance sg13cmos5l_decap_8_1921 r0 *1 0,0
Xsg13cmos5l_decap_8_1921 VPWR VGND sg13cmos5l_decap_8
* cell instance sg13cmos5l_decap_8_1922 r0 *1 0,0
Xsg13cmos5l_decap_8_1922 VPWR VGND sg13cmos5l_decap_8
* cell instance sg13cmos5l_decap_8_1923 r0 *1 0,0
Xsg13cmos5l_decap_8_1923 VPWR VGND sg13cmos5l_decap_8
* cell instance sg13cmos5l_decap_8_1924 r0 *1 0,0
Xsg13cmos5l_decap_8_1924 VPWR VGND sg13cmos5l_decap_8
* cell instance sg13cmos5l_decap_8_1925 r0 *1 0,0
Xsg13cmos5l_decap_8_1925 VPWR VGND sg13cmos5l_decap_8
* cell instance sg13cmos5l_decap_8_1926 r0 *1 0,0
Xsg13cmos5l_decap_8_1926 VPWR VGND sg13cmos5l_decap_8
* cell instance sg13cmos5l_decap_8_1927 r0 *1 0,0
Xsg13cmos5l_decap_8_1927 VPWR VGND sg13cmos5l_decap_8
* cell instance sg13cmos5l_decap_8_1928 r0 *1 0,0
Xsg13cmos5l_decap_8_1928 VPWR VGND sg13cmos5l_decap_8
* cell instance sg13cmos5l_decap_8_1929 r0 *1 0,0
Xsg13cmos5l_decap_8_1929 VPWR VGND sg13cmos5l_decap_8
* cell instance sg13cmos5l_decap_8_1930 r0 *1 0,0
Xsg13cmos5l_decap_8_1930 VPWR VGND sg13cmos5l_decap_8
* cell instance sg13cmos5l_decap_8_1931 r0 *1 0,0
Xsg13cmos5l_decap_8_1931 VPWR VGND sg13cmos5l_decap_8
* cell instance sg13cmos5l_decap_8_1932 r0 *1 0,0
Xsg13cmos5l_decap_8_1932 VPWR VGND sg13cmos5l_decap_8
* cell instance sg13cmos5l_decap_8_1933 r0 *1 0,0
Xsg13cmos5l_decap_8_1933 VPWR VGND sg13cmos5l_decap_8
* cell instance sg13cmos5l_decap_8_1934 r0 *1 0,0
Xsg13cmos5l_decap_8_1934 VPWR VGND sg13cmos5l_decap_8
* cell instance sg13cmos5l_decap_8_1935 r0 *1 0,0
Xsg13cmos5l_decap_8_1935 VPWR VGND sg13cmos5l_decap_8
* cell instance sg13cmos5l_decap_8_1936 r0 *1 0,0
Xsg13cmos5l_decap_8_1936 VPWR VGND sg13cmos5l_decap_8
* cell instance sg13cmos5l_decap_8_1937 r0 *1 0,0
Xsg13cmos5l_decap_8_1937 VPWR VGND sg13cmos5l_decap_8
* cell instance sg13cmos5l_decap_8_1938 r0 *1 0,0
Xsg13cmos5l_decap_8_1938 VPWR VGND sg13cmos5l_decap_8
* cell instance sg13cmos5l_decap_8_1939 r0 *1 0,0
Xsg13cmos5l_decap_8_1939 VPWR VGND sg13cmos5l_decap_8
* cell instance sg13cmos5l_decap_8_1940 r0 *1 0,0
Xsg13cmos5l_decap_8_1940 VPWR VGND sg13cmos5l_decap_8
* cell instance sg13cmos5l_decap_8_1941 r0 *1 0,0
Xsg13cmos5l_decap_8_1941 VPWR VGND sg13cmos5l_decap_8
* cell instance sg13cmos5l_decap_8_1942 r0 *1 0,0
Xsg13cmos5l_decap_8_1942 VPWR VGND sg13cmos5l_decap_8
* cell instance sg13cmos5l_decap_8_1943 r0 *1 0,0
Xsg13cmos5l_decap_8_1943 VPWR VGND sg13cmos5l_decap_8
* cell instance sg13cmos5l_decap_8_1944 r0 *1 0,0
Xsg13cmos5l_decap_8_1944 VPWR VGND sg13cmos5l_decap_8
* cell instance sg13cmos5l_decap_8_1945 r0 *1 0,0
Xsg13cmos5l_decap_8_1945 VPWR VGND sg13cmos5l_decap_8
* cell instance sg13cmos5l_decap_8_1946 r0 *1 0,0
Xsg13cmos5l_decap_8_1946 VPWR VGND sg13cmos5l_decap_8
* cell instance sg13cmos5l_decap_8_1947 r0 *1 0,0
Xsg13cmos5l_decap_8_1947 VPWR VGND sg13cmos5l_decap_8
* cell instance sg13cmos5l_decap_8_1948 r0 *1 0,0
Xsg13cmos5l_decap_8_1948 VPWR VGND sg13cmos5l_decap_8
* cell instance sg13cmos5l_decap_8_1949 r0 *1 0,0
Xsg13cmos5l_decap_8_1949 VPWR VGND sg13cmos5l_decap_8
* cell instance sg13cmos5l_decap_8_1950 r0 *1 0,0
Xsg13cmos5l_decap_8_1950 VPWR VGND sg13cmos5l_decap_8
* cell instance sg13cmos5l_decap_8_1951 r0 *1 0,0
Xsg13cmos5l_decap_8_1951 VPWR VGND sg13cmos5l_decap_8
* cell instance sg13cmos5l_decap_8_1952 r0 *1 0,0
Xsg13cmos5l_decap_8_1952 VPWR VGND sg13cmos5l_decap_8
* cell instance sg13cmos5l_decap_8_1953 r0 *1 0,0
Xsg13cmos5l_decap_8_1953 VPWR VGND sg13cmos5l_decap_8
* cell instance sg13cmos5l_decap_8_1954 r0 *1 0,0
Xsg13cmos5l_decap_8_1954 VPWR VGND sg13cmos5l_decap_8
* cell instance sg13cmos5l_decap_8_1955 r0 *1 0,0
Xsg13cmos5l_decap_8_1955 VPWR VGND sg13cmos5l_decap_8
* cell instance sg13cmos5l_decap_8_1956 r0 *1 0,0
Xsg13cmos5l_decap_8_1956 VPWR VGND sg13cmos5l_decap_8
* cell instance sg13cmos5l_decap_8_1957 r0 *1 0,0
Xsg13cmos5l_decap_8_1957 VPWR VGND sg13cmos5l_decap_8
* cell instance sg13cmos5l_decap_8_1958 r0 *1 0,0
Xsg13cmos5l_decap_8_1958 VPWR VGND sg13cmos5l_decap_8
* cell instance sg13cmos5l_decap_8_1959 r0 *1 0,0
Xsg13cmos5l_decap_8_1959 VPWR VGND sg13cmos5l_decap_8
* cell instance sg13cmos5l_decap_8_1960 r0 *1 0,0
Xsg13cmos5l_decap_8_1960 VPWR VGND sg13cmos5l_decap_8
* cell instance sg13cmos5l_decap_8_1961 r0 *1 0,0
Xsg13cmos5l_decap_8_1961 VPWR VGND sg13cmos5l_decap_8
* cell instance sg13cmos5l_decap_8_1962 r0 *1 0,0
Xsg13cmos5l_decap_8_1962 VPWR VGND sg13cmos5l_decap_8
* cell instance sg13cmos5l_decap_8_1963 r0 *1 0,0
Xsg13cmos5l_decap_8_1963 VPWR VGND sg13cmos5l_decap_8
* cell instance sg13cmos5l_decap_8_1964 r0 *1 0,0
Xsg13cmos5l_decap_8_1964 VPWR VGND sg13cmos5l_decap_8
* cell instance sg13cmos5l_decap_8_1965 r0 *1 0,0
Xsg13cmos5l_decap_8_1965 VPWR VGND sg13cmos5l_decap_8
* cell instance sg13cmos5l_decap_8_1966 r0 *1 0,0
Xsg13cmos5l_decap_8_1966 VPWR VGND sg13cmos5l_decap_8
* cell instance sg13cmos5l_decap_8_1967 r0 *1 0,0
Xsg13cmos5l_decap_8_1967 VPWR VGND sg13cmos5l_decap_8
* cell instance sg13cmos5l_decap_8_1968 r0 *1 0,0
Xsg13cmos5l_decap_8_1968 VPWR VGND sg13cmos5l_decap_8
* cell instance sg13cmos5l_decap_8_1969 r0 *1 0,0
Xsg13cmos5l_decap_8_1969 VPWR VGND sg13cmos5l_decap_8
* cell instance sg13cmos5l_decap_8_1970 r0 *1 0,0
Xsg13cmos5l_decap_8_1970 VPWR VGND sg13cmos5l_decap_8
* cell instance sg13cmos5l_decap_8_1971 r0 *1 0,0
Xsg13cmos5l_decap_8_1971 VPWR VGND sg13cmos5l_decap_8
* cell instance sg13cmos5l_decap_8_1972 r0 *1 0,0
Xsg13cmos5l_decap_8_1972 VPWR VGND sg13cmos5l_decap_8
* cell instance sg13cmos5l_decap_8_1973 r0 *1 0,0
Xsg13cmos5l_decap_8_1973 VPWR VGND sg13cmos5l_decap_8
* cell instance sg13cmos5l_decap_8_1974 r0 *1 0,0
Xsg13cmos5l_decap_8_1974 VPWR VGND sg13cmos5l_decap_8
* cell instance sg13cmos5l_decap_8_1975 r0 *1 0,0
Xsg13cmos5l_decap_8_1975 VPWR VGND sg13cmos5l_decap_8
* cell instance sg13cmos5l_decap_8_1976 r0 *1 0,0
Xsg13cmos5l_decap_8_1976 VPWR VGND sg13cmos5l_decap_8
* cell instance sg13cmos5l_decap_8_1977 r0 *1 0,0
Xsg13cmos5l_decap_8_1977 VPWR VGND sg13cmos5l_decap_8
* cell instance sg13cmos5l_decap_8_1978 r0 *1 0,0
Xsg13cmos5l_decap_8_1978 VPWR VGND sg13cmos5l_decap_8
* cell instance sg13cmos5l_decap_8_1979 r0 *1 0,0
Xsg13cmos5l_decap_8_1979 VPWR VGND sg13cmos5l_decap_8
* cell instance sg13cmos5l_decap_8_1980 r0 *1 0,0
Xsg13cmos5l_decap_8_1980 VPWR VGND sg13cmos5l_decap_8
* cell instance sg13cmos5l_decap_8_1981 r0 *1 0,0
Xsg13cmos5l_decap_8_1981 VPWR VGND sg13cmos5l_decap_8
* cell instance sg13cmos5l_decap_8_1982 r0 *1 0,0
Xsg13cmos5l_decap_8_1982 VPWR VGND sg13cmos5l_decap_8
* cell instance sg13cmos5l_decap_8_1983 r0 *1 0,0
Xsg13cmos5l_decap_8_1983 VPWR VGND sg13cmos5l_decap_8
* cell instance sg13cmos5l_decap_8_1984 r0 *1 0,0
Xsg13cmos5l_decap_8_1984 VPWR VGND sg13cmos5l_decap_8
* cell instance sg13cmos5l_decap_8_1985 r0 *1 0,0
Xsg13cmos5l_decap_8_1985 VPWR VGND sg13cmos5l_decap_8
* cell instance sg13cmos5l_decap_8_1986 r0 *1 0,0
Xsg13cmos5l_decap_8_1986 VPWR VGND sg13cmos5l_decap_8
* cell instance sg13cmos5l_decap_8_1987 r0 *1 0,0
Xsg13cmos5l_decap_8_1987 VPWR VGND sg13cmos5l_decap_8
* cell instance sg13cmos5l_decap_8_1988 r0 *1 0,0
Xsg13cmos5l_decap_8_1988 VPWR VGND sg13cmos5l_decap_8
* cell instance sg13cmos5l_decap_8_1989 r0 *1 0,0
Xsg13cmos5l_decap_8_1989 VPWR VGND sg13cmos5l_decap_8
* cell instance sg13cmos5l_decap_8_1990 r0 *1 0,0
Xsg13cmos5l_decap_8_1990 VPWR VGND sg13cmos5l_decap_8
* cell instance sg13cmos5l_decap_8_1991 r0 *1 0,0
Xsg13cmos5l_decap_8_1991 VPWR VGND sg13cmos5l_decap_8
* cell instance sg13cmos5l_decap_8_1992 r0 *1 0,0
Xsg13cmos5l_decap_8_1992 VPWR VGND sg13cmos5l_decap_8
* cell instance sg13cmos5l_decap_8_1993 r0 *1 0,0
Xsg13cmos5l_decap_8_1993 VPWR VGND sg13cmos5l_decap_8
* cell instance sg13cmos5l_decap_8_1994 r0 *1 0,0
Xsg13cmos5l_decap_8_1994 VPWR VGND sg13cmos5l_decap_8
* cell instance sg13cmos5l_decap_8_1995 r0 *1 0,0
Xsg13cmos5l_decap_8_1995 VPWR VGND sg13cmos5l_decap_8
* cell instance sg13cmos5l_decap_8_1996 r0 *1 0,0
Xsg13cmos5l_decap_8_1996 VPWR VGND sg13cmos5l_decap_8
* cell instance sg13cmos5l_decap_8_1997 r0 *1 0,0
Xsg13cmos5l_decap_8_1997 VPWR VGND sg13cmos5l_decap_8
* cell instance sg13cmos5l_decap_8_1998 r0 *1 0,0
Xsg13cmos5l_decap_8_1998 VPWR VGND sg13cmos5l_decap_8
* cell instance sg13cmos5l_decap_8_1999 r0 *1 0,0
Xsg13cmos5l_decap_8_1999 VPWR VGND sg13cmos5l_decap_8
* cell instance sg13cmos5l_decap_8_2000 r0 *1 0,0
Xsg13cmos5l_decap_8_2000 VPWR VGND sg13cmos5l_decap_8
* cell instance sg13cmos5l_decap_8_2001 r0 *1 0,0
Xsg13cmos5l_decap_8_2001 VPWR VGND sg13cmos5l_decap_8
* cell instance sg13cmos5l_decap_8_2002 r0 *1 0,0
Xsg13cmos5l_decap_8_2002 VPWR VGND sg13cmos5l_decap_8
* cell instance sg13cmos5l_decap_8_2003 r0 *1 0,0
Xsg13cmos5l_decap_8_2003 VPWR VGND sg13cmos5l_decap_8
* cell instance sg13cmos5l_decap_8_2004 r0 *1 0,0
Xsg13cmos5l_decap_8_2004 VPWR VGND sg13cmos5l_decap_8
* cell instance sg13cmos5l_decap_8_2005 r0 *1 0,0
Xsg13cmos5l_decap_8_2005 VPWR VGND sg13cmos5l_decap_8
* cell instance sg13cmos5l_decap_8_2006 r0 *1 0,0
Xsg13cmos5l_decap_8_2006 VPWR VGND sg13cmos5l_decap_8
* cell instance sg13cmos5l_decap_8_2007 r0 *1 0,0
Xsg13cmos5l_decap_8_2007 VPWR VGND sg13cmos5l_decap_8
* cell instance sg13cmos5l_decap_8_2008 r0 *1 0,0
Xsg13cmos5l_decap_8_2008 VPWR VGND sg13cmos5l_decap_8
* cell instance sg13cmos5l_decap_8_2009 r0 *1 0,0
Xsg13cmos5l_decap_8_2009 VPWR VGND sg13cmos5l_decap_8
* cell instance sg13cmos5l_decap_8_2010 r0 *1 0,0
Xsg13cmos5l_decap_8_2010 VPWR VGND sg13cmos5l_decap_8
* cell instance sg13cmos5l_decap_8_2011 r0 *1 0,0
Xsg13cmos5l_decap_8_2011 VPWR VGND sg13cmos5l_decap_8
* cell instance sg13cmos5l_decap_8_2012 r0 *1 0,0
Xsg13cmos5l_decap_8_2012 VPWR VGND sg13cmos5l_decap_8
* cell instance sg13cmos5l_decap_8_2013 r0 *1 0,0
Xsg13cmos5l_decap_8_2013 VPWR VGND sg13cmos5l_decap_8
* cell instance sg13cmos5l_decap_8_2014 r0 *1 0,0
Xsg13cmos5l_decap_8_2014 VPWR VGND sg13cmos5l_decap_8
* cell instance sg13cmos5l_decap_8_2015 r0 *1 0,0
Xsg13cmos5l_decap_8_2015 VPWR VGND sg13cmos5l_decap_8
* cell instance sg13cmos5l_decap_8_2016 r0 *1 0,0
Xsg13cmos5l_decap_8_2016 VPWR VGND sg13cmos5l_decap_8
* cell instance sg13cmos5l_decap_8_2017 r0 *1 0,0
Xsg13cmos5l_decap_8_2017 VPWR VGND sg13cmos5l_decap_8
* cell instance sg13cmos5l_decap_8_2018 r0 *1 0,0
Xsg13cmos5l_decap_8_2018 VPWR VGND sg13cmos5l_decap_8
* cell instance sg13cmos5l_decap_8_2019 r0 *1 0,0
Xsg13cmos5l_decap_8_2019 VPWR VGND sg13cmos5l_decap_8
* cell instance sg13cmos5l_decap_8_2020 r0 *1 0,0
Xsg13cmos5l_decap_8_2020 VPWR VGND sg13cmos5l_decap_8
* cell instance sg13cmos5l_decap_8_2021 r0 *1 0,0
Xsg13cmos5l_decap_8_2021 VPWR VGND sg13cmos5l_decap_8
* cell instance sg13cmos5l_decap_8_2022 r0 *1 0,0
Xsg13cmos5l_decap_8_2022 VPWR VGND sg13cmos5l_decap_8
* cell instance sg13cmos5l_decap_8_2023 r0 *1 0,0
Xsg13cmos5l_decap_8_2023 VPWR VGND sg13cmos5l_decap_8
* cell instance sg13cmos5l_decap_8_2024 r0 *1 0,0
Xsg13cmos5l_decap_8_2024 VPWR VGND sg13cmos5l_decap_8
* cell instance sg13cmos5l_decap_8_2025 r0 *1 0,0
Xsg13cmos5l_decap_8_2025 VPWR VGND sg13cmos5l_decap_8
* cell instance sg13cmos5l_decap_8_2026 r0 *1 0,0
Xsg13cmos5l_decap_8_2026 VPWR VGND sg13cmos5l_decap_8
* cell instance sg13cmos5l_decap_8_2027 r0 *1 0,0
Xsg13cmos5l_decap_8_2027 VPWR VGND sg13cmos5l_decap_8
* cell instance sg13cmos5l_decap_8_2028 r0 *1 0,0
Xsg13cmos5l_decap_8_2028 VPWR VGND sg13cmos5l_decap_8
* cell instance sg13cmos5l_decap_8_2029 r0 *1 0,0
Xsg13cmos5l_decap_8_2029 VPWR VGND sg13cmos5l_decap_8
* cell instance sg13cmos5l_decap_8_2030 r0 *1 0,0
Xsg13cmos5l_decap_8_2030 VPWR VGND sg13cmos5l_decap_8
* cell instance sg13cmos5l_decap_8_2031 r0 *1 0,0
Xsg13cmos5l_decap_8_2031 VPWR VGND sg13cmos5l_decap_8
* cell instance sg13cmos5l_decap_8_2032 r0 *1 0,0
Xsg13cmos5l_decap_8_2032 VPWR VGND sg13cmos5l_decap_8
* cell instance sg13cmos5l_decap_8_2033 r0 *1 0,0
Xsg13cmos5l_decap_8_2033 VPWR VGND sg13cmos5l_decap_8
* cell instance sg13cmos5l_decap_8_2034 r0 *1 0,0
Xsg13cmos5l_decap_8_2034 VPWR VGND sg13cmos5l_decap_8
* cell instance sg13cmos5l_decap_8_2035 r0 *1 0,0
Xsg13cmos5l_decap_8_2035 VPWR VGND sg13cmos5l_decap_8
* cell instance sg13cmos5l_decap_8_2036 r0 *1 0,0
Xsg13cmos5l_decap_8_2036 VPWR VGND sg13cmos5l_decap_8
* cell instance sg13cmos5l_decap_8_2037 r0 *1 0,0
Xsg13cmos5l_decap_8_2037 VPWR VGND sg13cmos5l_decap_8
* cell instance sg13cmos5l_decap_8_2038 r0 *1 0,0
Xsg13cmos5l_decap_8_2038 VPWR VGND sg13cmos5l_decap_8
* cell instance sg13cmos5l_decap_8_2039 r0 *1 0,0
Xsg13cmos5l_decap_8_2039 VPWR VGND sg13cmos5l_decap_8
* cell instance sg13cmos5l_decap_8_2040 r0 *1 0,0
Xsg13cmos5l_decap_8_2040 VPWR VGND sg13cmos5l_decap_8
* cell instance sg13cmos5l_decap_8_2041 r0 *1 0,0
Xsg13cmos5l_decap_8_2041 VPWR VGND sg13cmos5l_decap_8
* cell instance sg13cmos5l_decap_8_2042 r0 *1 0,0
Xsg13cmos5l_decap_8_2042 VPWR VGND sg13cmos5l_decap_8
* cell instance sg13cmos5l_decap_8_2043 r0 *1 0,0
Xsg13cmos5l_decap_8_2043 VPWR VGND sg13cmos5l_decap_8
* cell instance sg13cmos5l_decap_8_2044 r0 *1 0,0
Xsg13cmos5l_decap_8_2044 VPWR VGND sg13cmos5l_decap_8
* cell instance sg13cmos5l_decap_8_2045 r0 *1 0,0
Xsg13cmos5l_decap_8_2045 VPWR VGND sg13cmos5l_decap_8
* cell instance sg13cmos5l_decap_8_2046 r0 *1 0,0
Xsg13cmos5l_decap_8_2046 VPWR VGND sg13cmos5l_decap_8
* cell instance sg13cmos5l_decap_8_2047 r0 *1 0,0
Xsg13cmos5l_decap_8_2047 VPWR VGND sg13cmos5l_decap_8
* cell instance sg13cmos5l_decap_8_2048 r0 *1 0,0
Xsg13cmos5l_decap_8_2048 VPWR VGND sg13cmos5l_decap_8
* cell instance sg13cmos5l_decap_8_2049 r0 *1 0,0
Xsg13cmos5l_decap_8_2049 VPWR VGND sg13cmos5l_decap_8
* cell instance sg13cmos5l_decap_8_2050 r0 *1 0,0
Xsg13cmos5l_decap_8_2050 VPWR VGND sg13cmos5l_decap_8
* cell instance sg13cmos5l_decap_8_2051 r0 *1 0,0
Xsg13cmos5l_decap_8_2051 VPWR VGND sg13cmos5l_decap_8
* cell instance sg13cmos5l_decap_8_2052 r0 *1 0,0
Xsg13cmos5l_decap_8_2052 VPWR VGND sg13cmos5l_decap_8
* cell instance sg13cmos5l_decap_8_2053 r0 *1 0,0
Xsg13cmos5l_decap_8_2053 VPWR VGND sg13cmos5l_decap_8
* cell instance sg13cmos5l_decap_8_2054 r0 *1 0,0
Xsg13cmos5l_decap_8_2054 VPWR VGND sg13cmos5l_decap_8
* cell instance sg13cmos5l_decap_8_2055 r0 *1 0,0
Xsg13cmos5l_decap_8_2055 VPWR VGND sg13cmos5l_decap_8
* cell instance sg13cmos5l_decap_8_2056 r0 *1 0,0
Xsg13cmos5l_decap_8_2056 VPWR VGND sg13cmos5l_decap_8
* cell instance sg13cmos5l_decap_8_2057 r0 *1 0,0
Xsg13cmos5l_decap_8_2057 VPWR VGND sg13cmos5l_decap_8
* cell instance sg13cmos5l_decap_8_2058 r0 *1 0,0
Xsg13cmos5l_decap_8_2058 VPWR VGND sg13cmos5l_decap_8
* cell instance sg13cmos5l_decap_8_2059 r0 *1 0,0
Xsg13cmos5l_decap_8_2059 VPWR VGND sg13cmos5l_decap_8
* cell instance sg13cmos5l_decap_8_2060 r0 *1 0,0
Xsg13cmos5l_decap_8_2060 VPWR VGND sg13cmos5l_decap_8
* cell instance sg13cmos5l_decap_8_2061 r0 *1 0,0
Xsg13cmos5l_decap_8_2061 VPWR VGND sg13cmos5l_decap_8
* cell instance sg13cmos5l_decap_8_2062 r0 *1 0,0
Xsg13cmos5l_decap_8_2062 VPWR VGND sg13cmos5l_decap_8
* cell instance sg13cmos5l_decap_8_2063 r0 *1 0,0
Xsg13cmos5l_decap_8_2063 VPWR VGND sg13cmos5l_decap_8
* cell instance sg13cmos5l_decap_8_2064 r0 *1 0,0
Xsg13cmos5l_decap_8_2064 VPWR VGND sg13cmos5l_decap_8
* cell instance sg13cmos5l_decap_8_2065 r0 *1 0,0
Xsg13cmos5l_decap_8_2065 VPWR VGND sg13cmos5l_decap_8
* cell instance sg13cmos5l_decap_8_2066 r0 *1 0,0
Xsg13cmos5l_decap_8_2066 VPWR VGND sg13cmos5l_decap_8
* cell instance sg13cmos5l_decap_8_2067 r0 *1 0,0
Xsg13cmos5l_decap_8_2067 VPWR VGND sg13cmos5l_decap_8
* cell instance sg13cmos5l_decap_8_2068 r0 *1 0,0
Xsg13cmos5l_decap_8_2068 VPWR VGND sg13cmos5l_decap_8
* cell instance sg13cmos5l_decap_8_2069 r0 *1 0,0
Xsg13cmos5l_decap_8_2069 VPWR VGND sg13cmos5l_decap_8
* cell instance sg13cmos5l_decap_8_2070 r0 *1 0,0
Xsg13cmos5l_decap_8_2070 VPWR VGND sg13cmos5l_decap_8
* cell instance sg13cmos5l_decap_8_2071 r0 *1 0,0
Xsg13cmos5l_decap_8_2071 VPWR VGND sg13cmos5l_decap_8
* cell instance sg13cmos5l_decap_8_2072 r0 *1 0,0
Xsg13cmos5l_decap_8_2072 VPWR VGND sg13cmos5l_decap_8
* cell instance sg13cmos5l_decap_8_2073 r0 *1 0,0
Xsg13cmos5l_decap_8_2073 VPWR VGND sg13cmos5l_decap_8
* cell instance sg13cmos5l_decap_8_2074 r0 *1 0,0
Xsg13cmos5l_decap_8_2074 VPWR VGND sg13cmos5l_decap_8
* cell instance sg13cmos5l_decap_8_2075 r0 *1 0,0
Xsg13cmos5l_decap_8_2075 VPWR VGND sg13cmos5l_decap_8
* cell instance sg13cmos5l_decap_8_2076 r0 *1 0,0
Xsg13cmos5l_decap_8_2076 VPWR VGND sg13cmos5l_decap_8
* cell instance sg13cmos5l_decap_8_2077 r0 *1 0,0
Xsg13cmos5l_decap_8_2077 VPWR VGND sg13cmos5l_decap_8
* cell instance sg13cmos5l_decap_8_2078 r0 *1 0,0
Xsg13cmos5l_decap_8_2078 VPWR VGND sg13cmos5l_decap_8
* cell instance sg13cmos5l_decap_8_2079 r0 *1 0,0
Xsg13cmos5l_decap_8_2079 VPWR VGND sg13cmos5l_decap_8
* cell instance sg13cmos5l_decap_8_2080 r0 *1 0,0
Xsg13cmos5l_decap_8_2080 VPWR VGND sg13cmos5l_decap_8
* cell instance sg13cmos5l_decap_8_2081 r0 *1 0,0
Xsg13cmos5l_decap_8_2081 VPWR VGND sg13cmos5l_decap_8
* cell instance sg13cmos5l_decap_8_2082 r0 *1 0,0
Xsg13cmos5l_decap_8_2082 VPWR VGND sg13cmos5l_decap_8
* cell instance sg13cmos5l_decap_8_2083 r0 *1 0,0
Xsg13cmos5l_decap_8_2083 VPWR VGND sg13cmos5l_decap_8
* cell instance sg13cmos5l_decap_8_2084 r0 *1 0,0
Xsg13cmos5l_decap_8_2084 VPWR VGND sg13cmos5l_decap_8
* cell instance sg13cmos5l_decap_8_2085 r0 *1 0,0
Xsg13cmos5l_decap_8_2085 VPWR VGND sg13cmos5l_decap_8
* cell instance sg13cmos5l_decap_8_2086 r0 *1 0,0
Xsg13cmos5l_decap_8_2086 VPWR VGND sg13cmos5l_decap_8
* cell instance sg13cmos5l_decap_8_2087 r0 *1 0,0
Xsg13cmos5l_decap_8_2087 VPWR VGND sg13cmos5l_decap_8
* cell instance sg13cmos5l_decap_8_2088 r0 *1 0,0
Xsg13cmos5l_decap_8_2088 VPWR VGND sg13cmos5l_decap_8
* cell instance sg13cmos5l_decap_8_2089 r0 *1 0,0
Xsg13cmos5l_decap_8_2089 VPWR VGND sg13cmos5l_decap_8
* cell instance sg13cmos5l_decap_8_2090 r0 *1 0,0
Xsg13cmos5l_decap_8_2090 VPWR VGND sg13cmos5l_decap_8
* cell instance sg13cmos5l_decap_8_2091 r0 *1 0,0
Xsg13cmos5l_decap_8_2091 VPWR VGND sg13cmos5l_decap_8
* cell instance sg13cmos5l_decap_8_2092 r0 *1 0,0
Xsg13cmos5l_decap_8_2092 VPWR VGND sg13cmos5l_decap_8
* cell instance sg13cmos5l_decap_8_2093 r0 *1 0,0
Xsg13cmos5l_decap_8_2093 VPWR VGND sg13cmos5l_decap_8
* cell instance sg13cmos5l_decap_8_2094 r0 *1 0,0
Xsg13cmos5l_decap_8_2094 VPWR VGND sg13cmos5l_decap_8
* cell instance sg13cmos5l_decap_8_2095 r0 *1 0,0
Xsg13cmos5l_decap_8_2095 VPWR VGND sg13cmos5l_decap_8
* cell instance sg13cmos5l_decap_8_2096 r0 *1 0,0
Xsg13cmos5l_decap_8_2096 VPWR VGND sg13cmos5l_decap_8
* cell instance sg13cmos5l_decap_8_2097 r0 *1 0,0
Xsg13cmos5l_decap_8_2097 VPWR VGND sg13cmos5l_decap_8
* cell instance sg13cmos5l_decap_8_2098 r0 *1 0,0
Xsg13cmos5l_decap_8_2098 VPWR VGND sg13cmos5l_decap_8
* cell instance sg13cmos5l_decap_8_2099 r0 *1 0,0
Xsg13cmos5l_decap_8_2099 VPWR VGND sg13cmos5l_decap_8
* cell instance sg13cmos5l_decap_8_2100 r0 *1 0,0
Xsg13cmos5l_decap_8_2100 VPWR VGND sg13cmos5l_decap_8
* cell instance sg13cmos5l_decap_8_2101 r0 *1 0,0
Xsg13cmos5l_decap_8_2101 VPWR VGND sg13cmos5l_decap_8
* cell instance sg13cmos5l_decap_8_2102 r0 *1 0,0
Xsg13cmos5l_decap_8_2102 VPWR VGND sg13cmos5l_decap_8
* cell instance sg13cmos5l_decap_8_2103 r0 *1 0,0
Xsg13cmos5l_decap_8_2103 VPWR VGND sg13cmos5l_decap_8
* cell instance sg13cmos5l_decap_8_2104 r0 *1 0,0
Xsg13cmos5l_decap_8_2104 VPWR VGND sg13cmos5l_decap_8
* cell instance sg13cmos5l_decap_8_2105 r0 *1 0,0
Xsg13cmos5l_decap_8_2105 VPWR VGND sg13cmos5l_decap_8
* cell instance sg13cmos5l_decap_8_2106 r0 *1 0,0
Xsg13cmos5l_decap_8_2106 VPWR VGND sg13cmos5l_decap_8
* cell instance sg13cmos5l_decap_8_2107 r0 *1 0,0
Xsg13cmos5l_decap_8_2107 VPWR VGND sg13cmos5l_decap_8
* cell instance sg13cmos5l_decap_8_2108 r0 *1 0,0
Xsg13cmos5l_decap_8_2108 VPWR VGND sg13cmos5l_decap_8
* cell instance sg13cmos5l_decap_8_2109 r0 *1 0,0
Xsg13cmos5l_decap_8_2109 VPWR VGND sg13cmos5l_decap_8
* cell instance sg13cmos5l_decap_8_2110 r0 *1 0,0
Xsg13cmos5l_decap_8_2110 VPWR VGND sg13cmos5l_decap_8
* cell instance sg13cmos5l_decap_8_2111 r0 *1 0,0
Xsg13cmos5l_decap_8_2111 VPWR VGND sg13cmos5l_decap_8
* cell instance sg13cmos5l_decap_8_2112 r0 *1 0,0
Xsg13cmos5l_decap_8_2112 VPWR VGND sg13cmos5l_decap_8
* cell instance sg13cmos5l_decap_8_2113 r0 *1 0,0
Xsg13cmos5l_decap_8_2113 VPWR VGND sg13cmos5l_decap_8
* cell instance sg13cmos5l_decap_8_2114 r0 *1 0,0
Xsg13cmos5l_decap_8_2114 VPWR VGND sg13cmos5l_decap_8
* cell instance sg13cmos5l_decap_8_2115 r0 *1 0,0
Xsg13cmos5l_decap_8_2115 VPWR VGND sg13cmos5l_decap_8
* cell instance sg13cmos5l_decap_8_2116 r0 *1 0,0
Xsg13cmos5l_decap_8_2116 VPWR VGND sg13cmos5l_decap_8
* cell instance sg13cmos5l_decap_8_2117 r0 *1 0,0
Xsg13cmos5l_decap_8_2117 VPWR VGND sg13cmos5l_decap_8
* cell instance sg13cmos5l_decap_8_2118 r0 *1 0,0
Xsg13cmos5l_decap_8_2118 VPWR VGND sg13cmos5l_decap_8
* cell instance sg13cmos5l_decap_8_2119 r0 *1 0,0
Xsg13cmos5l_decap_8_2119 VPWR VGND sg13cmos5l_decap_8
* cell instance sg13cmos5l_decap_8_2120 r0 *1 0,0
Xsg13cmos5l_decap_8_2120 VPWR VGND sg13cmos5l_decap_8
* cell instance sg13cmos5l_decap_8_2121 r0 *1 0,0
Xsg13cmos5l_decap_8_2121 VPWR VGND sg13cmos5l_decap_8
* cell instance sg13cmos5l_decap_8_2122 r0 *1 0,0
Xsg13cmos5l_decap_8_2122 VPWR VGND sg13cmos5l_decap_8
* cell instance sg13cmos5l_decap_8_2123 r0 *1 0,0
Xsg13cmos5l_decap_8_2123 VPWR VGND sg13cmos5l_decap_8
* cell instance sg13cmos5l_decap_8_2124 r0 *1 0,0
Xsg13cmos5l_decap_8_2124 VPWR VGND sg13cmos5l_decap_8
* cell instance sg13cmos5l_decap_8_2125 r0 *1 0,0
Xsg13cmos5l_decap_8_2125 VPWR VGND sg13cmos5l_decap_8
* cell instance sg13cmos5l_decap_8_2126 r0 *1 0,0
Xsg13cmos5l_decap_8_2126 VPWR VGND sg13cmos5l_decap_8
* cell instance sg13cmos5l_decap_8_2127 r0 *1 0,0
Xsg13cmos5l_decap_8_2127 VPWR VGND sg13cmos5l_decap_8
* cell instance sg13cmos5l_decap_8_2128 r0 *1 0,0
Xsg13cmos5l_decap_8_2128 VPWR VGND sg13cmos5l_decap_8
* cell instance sg13cmos5l_decap_8_2129 r0 *1 0,0
Xsg13cmos5l_decap_8_2129 VPWR VGND sg13cmos5l_decap_8
* cell instance sg13cmos5l_decap_8_2130 r0 *1 0,0
Xsg13cmos5l_decap_8_2130 VPWR VGND sg13cmos5l_decap_8
* cell instance sg13cmos5l_decap_8_2131 r0 *1 0,0
Xsg13cmos5l_decap_8_2131 VPWR VGND sg13cmos5l_decap_8
* cell instance sg13cmos5l_decap_8_2132 r0 *1 0,0
Xsg13cmos5l_decap_8_2132 VPWR VGND sg13cmos5l_decap_8
* cell instance sg13cmos5l_decap_8_2133 r0 *1 0,0
Xsg13cmos5l_decap_8_2133 VPWR VGND sg13cmos5l_decap_8
* cell instance sg13cmos5l_decap_8_2134 r0 *1 0,0
Xsg13cmos5l_decap_8_2134 VPWR VGND sg13cmos5l_decap_8
* cell instance sg13cmos5l_decap_8_2135 r0 *1 0,0
Xsg13cmos5l_decap_8_2135 VPWR VGND sg13cmos5l_decap_8
* cell instance sg13cmos5l_decap_8_2136 r0 *1 0,0
Xsg13cmos5l_decap_8_2136 VPWR VGND sg13cmos5l_decap_8
* cell instance sg13cmos5l_decap_8_2137 r0 *1 0,0
Xsg13cmos5l_decap_8_2137 VPWR VGND sg13cmos5l_decap_8
* cell instance sg13cmos5l_decap_8_2138 r0 *1 0,0
Xsg13cmos5l_decap_8_2138 VPWR VGND sg13cmos5l_decap_8
* cell instance sg13cmos5l_decap_8_2139 r0 *1 0,0
Xsg13cmos5l_decap_8_2139 VPWR VGND sg13cmos5l_decap_8
* cell instance sg13cmos5l_decap_8_2140 r0 *1 0,0
Xsg13cmos5l_decap_8_2140 VPWR VGND sg13cmos5l_decap_8
* cell instance sg13cmos5l_decap_8_2141 r0 *1 0,0
Xsg13cmos5l_decap_8_2141 VPWR VGND sg13cmos5l_decap_8
* cell instance sg13cmos5l_decap_8_2142 r0 *1 0,0
Xsg13cmos5l_decap_8_2142 VPWR VGND sg13cmos5l_decap_8
* cell instance sg13cmos5l_decap_8_2143 r0 *1 0,0
Xsg13cmos5l_decap_8_2143 VPWR VGND sg13cmos5l_decap_8
* cell instance sg13cmos5l_decap_8_2144 r0 *1 0,0
Xsg13cmos5l_decap_8_2144 VPWR VGND sg13cmos5l_decap_8
* cell instance sg13cmos5l_decap_8_2145 r0 *1 0,0
Xsg13cmos5l_decap_8_2145 VPWR VGND sg13cmos5l_decap_8
* cell instance sg13cmos5l_decap_8_2146 r0 *1 0,0
Xsg13cmos5l_decap_8_2146 VPWR VGND sg13cmos5l_decap_8
* cell instance sg13cmos5l_decap_8_2147 r0 *1 0,0
Xsg13cmos5l_decap_8_2147 VPWR VGND sg13cmos5l_decap_8
* cell instance sg13cmos5l_decap_8_2148 r0 *1 0,0
Xsg13cmos5l_decap_8_2148 VPWR VGND sg13cmos5l_decap_8
* cell instance sg13cmos5l_decap_8_2149 r0 *1 0,0
Xsg13cmos5l_decap_8_2149 VPWR VGND sg13cmos5l_decap_8
* cell instance sg13cmos5l_decap_8_2150 r0 *1 0,0
Xsg13cmos5l_decap_8_2150 VPWR VGND sg13cmos5l_decap_8
* cell instance sg13cmos5l_decap_8_2151 r0 *1 0,0
Xsg13cmos5l_decap_8_2151 VPWR VGND sg13cmos5l_decap_8
* cell instance sg13cmos5l_decap_8_2152 r0 *1 0,0
Xsg13cmos5l_decap_8_2152 VPWR VGND sg13cmos5l_decap_8
* cell instance sg13cmos5l_decap_8_2153 r0 *1 0,0
Xsg13cmos5l_decap_8_2153 VPWR VGND sg13cmos5l_decap_8
* cell instance sg13cmos5l_decap_8_2154 r0 *1 0,0
Xsg13cmos5l_decap_8_2154 VPWR VGND sg13cmos5l_decap_8
* cell instance sg13cmos5l_decap_8_2155 r0 *1 0,0
Xsg13cmos5l_decap_8_2155 VPWR VGND sg13cmos5l_decap_8
* cell instance sg13cmos5l_decap_8_2156 r0 *1 0,0
Xsg13cmos5l_decap_8_2156 VPWR VGND sg13cmos5l_decap_8
* cell instance sg13cmos5l_decap_8_2157 r0 *1 0,0
Xsg13cmos5l_decap_8_2157 VPWR VGND sg13cmos5l_decap_8
* cell instance sg13cmos5l_decap_8_2158 r0 *1 0,0
Xsg13cmos5l_decap_8_2158 VPWR VGND sg13cmos5l_decap_8
* cell instance sg13cmos5l_decap_8_2159 r0 *1 0,0
Xsg13cmos5l_decap_8_2159 VPWR VGND sg13cmos5l_decap_8
* cell instance sg13cmos5l_decap_8_2160 r0 *1 0,0
Xsg13cmos5l_decap_8_2160 VPWR VGND sg13cmos5l_decap_8
* cell instance sg13cmos5l_decap_8_2161 r0 *1 0,0
Xsg13cmos5l_decap_8_2161 VPWR VGND sg13cmos5l_decap_8
* cell instance sg13cmos5l_decap_8_2162 r0 *1 0,0
Xsg13cmos5l_decap_8_2162 VPWR VGND sg13cmos5l_decap_8
* cell instance sg13cmos5l_decap_8_2163 r0 *1 0,0
Xsg13cmos5l_decap_8_2163 VPWR VGND sg13cmos5l_decap_8
* cell instance sg13cmos5l_decap_8_2164 r0 *1 0,0
Xsg13cmos5l_decap_8_2164 VPWR VGND sg13cmos5l_decap_8
* cell instance sg13cmos5l_decap_8_2165 r0 *1 0,0
Xsg13cmos5l_decap_8_2165 VPWR VGND sg13cmos5l_decap_8
* cell instance sg13cmos5l_decap_8_2166 r0 *1 0,0
Xsg13cmos5l_decap_8_2166 VPWR VGND sg13cmos5l_decap_8
* cell instance sg13cmos5l_decap_8_2167 r0 *1 0,0
Xsg13cmos5l_decap_8_2167 VPWR VGND sg13cmos5l_decap_8
* cell instance sg13cmos5l_decap_8_2168 r0 *1 0,0
Xsg13cmos5l_decap_8_2168 VPWR VGND sg13cmos5l_decap_8
* cell instance sg13cmos5l_decap_8_2169 r0 *1 0,0
Xsg13cmos5l_decap_8_2169 VPWR VGND sg13cmos5l_decap_8
* cell instance sg13cmos5l_decap_8_2170 r0 *1 0,0
Xsg13cmos5l_decap_8_2170 VPWR VGND sg13cmos5l_decap_8
* cell instance sg13cmos5l_decap_8_2171 r0 *1 0,0
Xsg13cmos5l_decap_8_2171 VPWR VGND sg13cmos5l_decap_8
* cell instance sg13cmos5l_decap_8_2172 r0 *1 0,0
Xsg13cmos5l_decap_8_2172 VPWR VGND sg13cmos5l_decap_8
* cell instance sg13cmos5l_decap_8_2173 r0 *1 0,0
Xsg13cmos5l_decap_8_2173 VPWR VGND sg13cmos5l_decap_8
* cell instance sg13cmos5l_decap_8_2174 r0 *1 0,0
Xsg13cmos5l_decap_8_2174 VPWR VGND sg13cmos5l_decap_8
* cell instance sg13cmos5l_decap_8_2175 r0 *1 0,0
Xsg13cmos5l_decap_8_2175 VPWR VGND sg13cmos5l_decap_8
* cell instance sg13cmos5l_decap_8_2176 r0 *1 0,0
Xsg13cmos5l_decap_8_2176 VPWR VGND sg13cmos5l_decap_8
* cell instance sg13cmos5l_decap_8_2177 r0 *1 0,0
Xsg13cmos5l_decap_8_2177 VPWR VGND sg13cmos5l_decap_8
* cell instance sg13cmos5l_decap_8_2178 r0 *1 0,0
Xsg13cmos5l_decap_8_2178 VPWR VGND sg13cmos5l_decap_8
* cell instance sg13cmos5l_decap_8_2179 r0 *1 0,0
Xsg13cmos5l_decap_8_2179 VPWR VGND sg13cmos5l_decap_8
* cell instance sg13cmos5l_decap_8_2180 r0 *1 0,0
Xsg13cmos5l_decap_8_2180 VPWR VGND sg13cmos5l_decap_8
* cell instance sg13cmos5l_decap_8_2181 r0 *1 0,0
Xsg13cmos5l_decap_8_2181 VPWR VGND sg13cmos5l_decap_8
* cell instance sg13cmos5l_decap_8_2182 r0 *1 0,0
Xsg13cmos5l_decap_8_2182 VPWR VGND sg13cmos5l_decap_8
* cell instance sg13cmos5l_decap_8_2183 r0 *1 0,0
Xsg13cmos5l_decap_8_2183 VPWR VGND sg13cmos5l_decap_8
* cell instance sg13cmos5l_decap_8_2184 r0 *1 0,0
Xsg13cmos5l_decap_8_2184 VPWR VGND sg13cmos5l_decap_8
* cell instance sg13cmos5l_decap_8_2185 r0 *1 0,0
Xsg13cmos5l_decap_8_2185 VPWR VGND sg13cmos5l_decap_8
* cell instance sg13cmos5l_decap_8_2186 r0 *1 0,0
Xsg13cmos5l_decap_8_2186 VPWR VGND sg13cmos5l_decap_8
* cell instance sg13cmos5l_decap_8_2187 r0 *1 0,0
Xsg13cmos5l_decap_8_2187 VPWR VGND sg13cmos5l_decap_8
* cell instance sg13cmos5l_decap_8_2188 r0 *1 0,0
Xsg13cmos5l_decap_8_2188 VPWR VGND sg13cmos5l_decap_8
* cell instance sg13cmos5l_decap_8_2189 r0 *1 0,0
Xsg13cmos5l_decap_8_2189 VPWR VGND sg13cmos5l_decap_8
* cell instance sg13cmos5l_decap_8_2190 r0 *1 0,0
Xsg13cmos5l_decap_8_2190 VPWR VGND sg13cmos5l_decap_8
* cell instance sg13cmos5l_decap_8_2191 r0 *1 0,0
Xsg13cmos5l_decap_8_2191 VPWR VGND sg13cmos5l_decap_8
* cell instance sg13cmos5l_decap_8_2192 r0 *1 0,0
Xsg13cmos5l_decap_8_2192 VPWR VGND sg13cmos5l_decap_8
* cell instance sg13cmos5l_decap_8_2193 r0 *1 0,0
Xsg13cmos5l_decap_8_2193 VPWR VGND sg13cmos5l_decap_8
* cell instance sg13cmos5l_decap_8_2194 r0 *1 0,0
Xsg13cmos5l_decap_8_2194 VPWR VGND sg13cmos5l_decap_8
* cell instance sg13cmos5l_decap_8_2195 r0 *1 0,0
Xsg13cmos5l_decap_8_2195 VPWR VGND sg13cmos5l_decap_8
* cell instance sg13cmos5l_decap_8_2196 r0 *1 0,0
Xsg13cmos5l_decap_8_2196 VPWR VGND sg13cmos5l_decap_8
* cell instance sg13cmos5l_decap_8_2197 r0 *1 0,0
Xsg13cmos5l_decap_8_2197 VPWR VGND sg13cmos5l_decap_8
* cell instance sg13cmos5l_decap_8_2198 r0 *1 0,0
Xsg13cmos5l_decap_8_2198 VPWR VGND sg13cmos5l_decap_8
* cell instance sg13cmos5l_decap_8_2199 r0 *1 0,0
Xsg13cmos5l_decap_8_2199 VPWR VGND sg13cmos5l_decap_8
* cell instance sg13cmos5l_decap_8_2200 r0 *1 0,0
Xsg13cmos5l_decap_8_2200 VPWR VGND sg13cmos5l_decap_8
* cell instance sg13cmos5l_decap_8_2201 r0 *1 0,0
Xsg13cmos5l_decap_8_2201 VPWR VGND sg13cmos5l_decap_8
* cell instance sg13cmos5l_decap_8_2202 r0 *1 0,0
Xsg13cmos5l_decap_8_2202 VPWR VGND sg13cmos5l_decap_8
* cell instance sg13cmos5l_decap_8_2203 r0 *1 0,0
Xsg13cmos5l_decap_8_2203 VPWR VGND sg13cmos5l_decap_8
* cell instance sg13cmos5l_decap_8_2204 r0 *1 0,0
Xsg13cmos5l_decap_8_2204 VPWR VGND sg13cmos5l_decap_8
* cell instance sg13cmos5l_decap_8_2205 r0 *1 0,0
Xsg13cmos5l_decap_8_2205 VPWR VGND sg13cmos5l_decap_8
* cell instance sg13cmos5l_decap_8_2206 r0 *1 0,0
Xsg13cmos5l_decap_8_2206 VPWR VGND sg13cmos5l_decap_8
* cell instance sg13cmos5l_decap_8_2207 r0 *1 0,0
Xsg13cmos5l_decap_8_2207 VPWR VGND sg13cmos5l_decap_8
* cell instance sg13cmos5l_decap_8_2208 r0 *1 0,0
Xsg13cmos5l_decap_8_2208 VPWR VGND sg13cmos5l_decap_8
* cell instance sg13cmos5l_decap_8_2209 r0 *1 0,0
Xsg13cmos5l_decap_8_2209 VPWR VGND sg13cmos5l_decap_8
* cell instance sg13cmos5l_decap_8_2210 r0 *1 0,0
Xsg13cmos5l_decap_8_2210 VPWR VGND sg13cmos5l_decap_8
* cell instance sg13cmos5l_decap_8_2211 r0 *1 0,0
Xsg13cmos5l_decap_8_2211 VPWR VGND sg13cmos5l_decap_8
* cell instance sg13cmos5l_decap_8_2212 r0 *1 0,0
Xsg13cmos5l_decap_8_2212 VPWR VGND sg13cmos5l_decap_8
* cell instance sg13cmos5l_decap_8_2213 r0 *1 0,0
Xsg13cmos5l_decap_8_2213 VPWR VGND sg13cmos5l_decap_8
* cell instance sg13cmos5l_decap_8_2214 r0 *1 0,0
Xsg13cmos5l_decap_8_2214 VPWR VGND sg13cmos5l_decap_8
* cell instance sg13cmos5l_decap_8_2215 r0 *1 0,0
Xsg13cmos5l_decap_8_2215 VPWR VGND sg13cmos5l_decap_8
* cell instance sg13cmos5l_decap_8_2216 r0 *1 0,0
Xsg13cmos5l_decap_8_2216 VPWR VGND sg13cmos5l_decap_8
* cell instance sg13cmos5l_decap_8_2217 r0 *1 0,0
Xsg13cmos5l_decap_8_2217 VPWR VGND sg13cmos5l_decap_8
* cell instance sg13cmos5l_decap_8_2218 r0 *1 0,0
Xsg13cmos5l_decap_8_2218 VPWR VGND sg13cmos5l_decap_8
* cell instance sg13cmos5l_decap_8_2219 r0 *1 0,0
Xsg13cmos5l_decap_8_2219 VPWR VGND sg13cmos5l_decap_8
* cell instance sg13cmos5l_decap_8_2220 r0 *1 0,0
Xsg13cmos5l_decap_8_2220 VPWR VGND sg13cmos5l_decap_8
* cell instance sg13cmos5l_decap_8_2221 r0 *1 0,0
Xsg13cmos5l_decap_8_2221 VPWR VGND sg13cmos5l_decap_8
* cell instance sg13cmos5l_decap_8_2222 r0 *1 0,0
Xsg13cmos5l_decap_8_2222 VPWR VGND sg13cmos5l_decap_8
* cell instance sg13cmos5l_decap_8_2223 r0 *1 0,0
Xsg13cmos5l_decap_8_2223 VPWR VGND sg13cmos5l_decap_8
* cell instance sg13cmos5l_decap_8_2224 r0 *1 0,0
Xsg13cmos5l_decap_8_2224 VPWR VGND sg13cmos5l_decap_8
* cell instance sg13cmos5l_decap_8_2225 r0 *1 0,0
Xsg13cmos5l_decap_8_2225 VPWR VGND sg13cmos5l_decap_8
* cell instance sg13cmos5l_decap_8_2226 r0 *1 0,0
Xsg13cmos5l_decap_8_2226 VPWR VGND sg13cmos5l_decap_8
* cell instance sg13cmos5l_decap_8_2227 r0 *1 0,0
Xsg13cmos5l_decap_8_2227 VPWR VGND sg13cmos5l_decap_8
* cell instance sg13cmos5l_decap_8_2228 r0 *1 0,0
Xsg13cmos5l_decap_8_2228 VPWR VGND sg13cmos5l_decap_8
* cell instance sg13cmos5l_decap_8_2229 r0 *1 0,0
Xsg13cmos5l_decap_8_2229 VPWR VGND sg13cmos5l_decap_8
* cell instance sg13cmos5l_decap_8_2230 r0 *1 0,0
Xsg13cmos5l_decap_8_2230 VPWR VGND sg13cmos5l_decap_8
* cell instance sg13cmos5l_decap_8_2231 r0 *1 0,0
Xsg13cmos5l_decap_8_2231 VPWR VGND sg13cmos5l_decap_8
* cell instance sg13cmos5l_decap_8_2232 r0 *1 0,0
Xsg13cmos5l_decap_8_2232 VPWR VGND sg13cmos5l_decap_8
* cell instance sg13cmos5l_decap_8_2233 r0 *1 0,0
Xsg13cmos5l_decap_8_2233 VPWR VGND sg13cmos5l_decap_8
* cell instance sg13cmos5l_decap_8_2234 r0 *1 0,0
Xsg13cmos5l_decap_8_2234 VPWR VGND sg13cmos5l_decap_8
* cell instance sg13cmos5l_decap_8_2235 r0 *1 0,0
Xsg13cmos5l_decap_8_2235 VPWR VGND sg13cmos5l_decap_8
* cell instance sg13cmos5l_decap_8_2236 r0 *1 0,0
Xsg13cmos5l_decap_8_2236 VPWR VGND sg13cmos5l_decap_8
* cell instance sg13cmos5l_decap_8_2237 r0 *1 0,0
Xsg13cmos5l_decap_8_2237 VPWR VGND sg13cmos5l_decap_8
* cell instance sg13cmos5l_decap_8_2238 r0 *1 0,0
Xsg13cmos5l_decap_8_2238 VPWR VGND sg13cmos5l_decap_8
* cell instance sg13cmos5l_decap_8_2239 r0 *1 0,0
Xsg13cmos5l_decap_8_2239 VPWR VGND sg13cmos5l_decap_8
* cell instance sg13cmos5l_decap_8_2240 r0 *1 0,0
Xsg13cmos5l_decap_8_2240 VPWR VGND sg13cmos5l_decap_8
* cell instance sg13cmos5l_decap_8_2241 r0 *1 0,0
Xsg13cmos5l_decap_8_2241 VPWR VGND sg13cmos5l_decap_8
* cell instance sg13cmos5l_decap_8_2242 r0 *1 0,0
Xsg13cmos5l_decap_8_2242 VPWR VGND sg13cmos5l_decap_8
* cell instance sg13cmos5l_decap_8_2243 r0 *1 0,0
Xsg13cmos5l_decap_8_2243 VPWR VGND sg13cmos5l_decap_8
* cell instance sg13cmos5l_decap_8_2244 r0 *1 0,0
Xsg13cmos5l_decap_8_2244 VPWR VGND sg13cmos5l_decap_8
* cell instance sg13cmos5l_decap_8_2245 r0 *1 0,0
Xsg13cmos5l_decap_8_2245 VPWR VGND sg13cmos5l_decap_8
* cell instance sg13cmos5l_decap_8_2246 r0 *1 0,0
Xsg13cmos5l_decap_8_2246 VPWR VGND sg13cmos5l_decap_8
* cell instance sg13cmos5l_decap_8_2247 r0 *1 0,0
Xsg13cmos5l_decap_8_2247 VPWR VGND sg13cmos5l_decap_8
* cell instance sg13cmos5l_decap_8_2248 r0 *1 0,0
Xsg13cmos5l_decap_8_2248 VPWR VGND sg13cmos5l_decap_8
* cell instance sg13cmos5l_decap_8_2249 r0 *1 0,0
Xsg13cmos5l_decap_8_2249 VPWR VGND sg13cmos5l_decap_8
* cell instance sg13cmos5l_decap_8_2250 r0 *1 0,0
Xsg13cmos5l_decap_8_2250 VPWR VGND sg13cmos5l_decap_8
* cell instance sg13cmos5l_decap_8_2251 r0 *1 0,0
Xsg13cmos5l_decap_8_2251 VPWR VGND sg13cmos5l_decap_8
* cell instance sg13cmos5l_decap_8_2252 r0 *1 0,0
Xsg13cmos5l_decap_8_2252 VPWR VGND sg13cmos5l_decap_8
* cell instance sg13cmos5l_decap_8_2253 r0 *1 0,0
Xsg13cmos5l_decap_8_2253 VPWR VGND sg13cmos5l_decap_8
* cell instance sg13cmos5l_decap_8_2254 r0 *1 0,0
Xsg13cmos5l_decap_8_2254 VPWR VGND sg13cmos5l_decap_8
* cell instance sg13cmos5l_decap_8_2255 r0 *1 0,0
Xsg13cmos5l_decap_8_2255 VPWR VGND sg13cmos5l_decap_8
* cell instance sg13cmos5l_decap_8_2256 r0 *1 0,0
Xsg13cmos5l_decap_8_2256 VPWR VGND sg13cmos5l_decap_8
* cell instance sg13cmos5l_decap_8_2257 r0 *1 0,0
Xsg13cmos5l_decap_8_2257 VPWR VGND sg13cmos5l_decap_8
* cell instance sg13cmos5l_decap_8_2258 r0 *1 0,0
Xsg13cmos5l_decap_8_2258 VPWR VGND sg13cmos5l_decap_8
* cell instance sg13cmos5l_decap_8_2259 r0 *1 0,0
Xsg13cmos5l_decap_8_2259 VPWR VGND sg13cmos5l_decap_8
* cell instance sg13cmos5l_decap_8_2260 r0 *1 0,0
Xsg13cmos5l_decap_8_2260 VPWR VGND sg13cmos5l_decap_8
* cell instance sg13cmos5l_decap_8_2261 r0 *1 0,0
Xsg13cmos5l_decap_8_2261 VPWR VGND sg13cmos5l_decap_8
* cell instance sg13cmos5l_decap_8_2262 r0 *1 0,0
Xsg13cmos5l_decap_8_2262 VPWR VGND sg13cmos5l_decap_8
* cell instance sg13cmos5l_decap_8_2263 r0 *1 0,0
Xsg13cmos5l_decap_8_2263 VPWR VGND sg13cmos5l_decap_8
* cell instance sg13cmos5l_decap_8_2264 r0 *1 0,0
Xsg13cmos5l_decap_8_2264 VPWR VGND sg13cmos5l_decap_8
* cell instance sg13cmos5l_decap_8_2265 r0 *1 0,0
Xsg13cmos5l_decap_8_2265 VPWR VGND sg13cmos5l_decap_8
* cell instance sg13cmos5l_decap_8_2266 r0 *1 0,0
Xsg13cmos5l_decap_8_2266 VPWR VGND sg13cmos5l_decap_8
* cell instance sg13cmos5l_decap_8_2267 r0 *1 0,0
Xsg13cmos5l_decap_8_2267 VPWR VGND sg13cmos5l_decap_8
* cell instance sg13cmos5l_decap_8_2268 r0 *1 0,0
Xsg13cmos5l_decap_8_2268 VPWR VGND sg13cmos5l_decap_8
* cell instance sg13cmos5l_decap_8_2269 r0 *1 0,0
Xsg13cmos5l_decap_8_2269 VPWR VGND sg13cmos5l_decap_8
* cell instance sg13cmos5l_decap_8_2270 r0 *1 0,0
Xsg13cmos5l_decap_8_2270 VPWR VGND sg13cmos5l_decap_8
* cell instance sg13cmos5l_decap_8_2271 r0 *1 0,0
Xsg13cmos5l_decap_8_2271 VPWR VGND sg13cmos5l_decap_8
* cell instance sg13cmos5l_decap_8_2272 r0 *1 0,0
Xsg13cmos5l_decap_8_2272 VPWR VGND sg13cmos5l_decap_8
* cell instance sg13cmos5l_decap_8_2273 r0 *1 0,0
Xsg13cmos5l_decap_8_2273 VPWR VGND sg13cmos5l_decap_8
* cell instance sg13cmos5l_decap_8_2274 r0 *1 0,0
Xsg13cmos5l_decap_8_2274 VPWR VGND sg13cmos5l_decap_8
* cell instance sg13cmos5l_decap_8_2275 r0 *1 0,0
Xsg13cmos5l_decap_8_2275 VPWR VGND sg13cmos5l_decap_8
* cell instance sg13cmos5l_decap_8_2276 r0 *1 0,0
Xsg13cmos5l_decap_8_2276 VPWR VGND sg13cmos5l_decap_8
* cell instance sg13cmos5l_decap_8_2277 r0 *1 0,0
Xsg13cmos5l_decap_8_2277 VPWR VGND sg13cmos5l_decap_8
* cell instance sg13cmos5l_decap_8_2278 r0 *1 0,0
Xsg13cmos5l_decap_8_2278 VPWR VGND sg13cmos5l_decap_8
* cell instance sg13cmos5l_decap_8_2279 r0 *1 0,0
Xsg13cmos5l_decap_8_2279 VPWR VGND sg13cmos5l_decap_8
* cell instance sg13cmos5l_decap_8_2280 r0 *1 0,0
Xsg13cmos5l_decap_8_2280 VPWR VGND sg13cmos5l_decap_8
* cell instance sg13cmos5l_decap_8_2281 r0 *1 0,0
Xsg13cmos5l_decap_8_2281 VPWR VGND sg13cmos5l_decap_8
* cell instance sg13cmos5l_decap_8_2282 r0 *1 0,0
Xsg13cmos5l_decap_8_2282 VPWR VGND sg13cmos5l_decap_8
* cell instance sg13cmos5l_decap_8_2283 r0 *1 0,0
Xsg13cmos5l_decap_8_2283 VPWR VGND sg13cmos5l_decap_8
* cell instance sg13cmos5l_decap_8_2284 r0 *1 0,0
Xsg13cmos5l_decap_8_2284 VPWR VGND sg13cmos5l_decap_8
* cell instance sg13cmos5l_decap_8_2285 r0 *1 0,0
Xsg13cmos5l_decap_8_2285 VPWR VGND sg13cmos5l_decap_8
* cell instance sg13cmos5l_decap_8_2286 r0 *1 0,0
Xsg13cmos5l_decap_8_2286 VPWR VGND sg13cmos5l_decap_8
* cell instance sg13cmos5l_decap_8_2287 r0 *1 0,0
Xsg13cmos5l_decap_8_2287 VPWR VGND sg13cmos5l_decap_8
* cell instance sg13cmos5l_decap_8_2288 r0 *1 0,0
Xsg13cmos5l_decap_8_2288 VPWR VGND sg13cmos5l_decap_8
* cell instance sg13cmos5l_decap_8_2289 r0 *1 0,0
Xsg13cmos5l_decap_8_2289 VPWR VGND sg13cmos5l_decap_8
* cell instance sg13cmos5l_decap_8_2290 r0 *1 0,0
Xsg13cmos5l_decap_8_2290 VPWR VGND sg13cmos5l_decap_8
* cell instance sg13cmos5l_decap_8_2291 r0 *1 0,0
Xsg13cmos5l_decap_8_2291 VPWR VGND sg13cmos5l_decap_8
* cell instance sg13cmos5l_decap_8_2292 r0 *1 0,0
Xsg13cmos5l_decap_8_2292 VPWR VGND sg13cmos5l_decap_8
* cell instance sg13cmos5l_decap_8_2293 r0 *1 0,0
Xsg13cmos5l_decap_8_2293 VPWR VGND sg13cmos5l_decap_8
* cell instance sg13cmos5l_decap_8_2294 r0 *1 0,0
Xsg13cmos5l_decap_8_2294 VPWR VGND sg13cmos5l_decap_8
* cell instance sg13cmos5l_decap_8_2295 r0 *1 0,0
Xsg13cmos5l_decap_8_2295 VPWR VGND sg13cmos5l_decap_8
* cell instance sg13cmos5l_decap_8_2296 r0 *1 0,0
Xsg13cmos5l_decap_8_2296 VPWR VGND sg13cmos5l_decap_8
* cell instance sg13cmos5l_decap_8_2297 r0 *1 0,0
Xsg13cmos5l_decap_8_2297 VPWR VGND sg13cmos5l_decap_8
* cell instance sg13cmos5l_decap_8_2298 r0 *1 0,0
Xsg13cmos5l_decap_8_2298 VPWR VGND sg13cmos5l_decap_8
* cell instance sg13cmos5l_decap_8_2299 r0 *1 0,0
Xsg13cmos5l_decap_8_2299 VPWR VGND sg13cmos5l_decap_8
* cell instance sg13cmos5l_decap_8_2300 r0 *1 0,0
Xsg13cmos5l_decap_8_2300 VPWR VGND sg13cmos5l_decap_8
* cell instance sg13cmos5l_decap_8_2301 r0 *1 0,0
Xsg13cmos5l_decap_8_2301 VPWR VGND sg13cmos5l_decap_8
* cell instance sg13cmos5l_decap_8_2302 r0 *1 0,0
Xsg13cmos5l_decap_8_2302 VPWR VGND sg13cmos5l_decap_8
* cell instance sg13cmos5l_decap_8_2303 r0 *1 0,0
Xsg13cmos5l_decap_8_2303 VPWR VGND sg13cmos5l_decap_8
* cell instance sg13cmos5l_decap_8_2304 r0 *1 0,0
Xsg13cmos5l_decap_8_2304 VPWR VGND sg13cmos5l_decap_8
* cell instance sg13cmos5l_decap_8_2305 r0 *1 0,0
Xsg13cmos5l_decap_8_2305 VPWR VGND sg13cmos5l_decap_8
* cell instance sg13cmos5l_decap_8_2306 r0 *1 0,0
Xsg13cmos5l_decap_8_2306 VPWR VGND sg13cmos5l_decap_8
* cell instance sg13cmos5l_decap_8_2307 r0 *1 0,0
Xsg13cmos5l_decap_8_2307 VPWR VGND sg13cmos5l_decap_8
* cell instance sg13cmos5l_decap_8_2308 r0 *1 0,0
Xsg13cmos5l_decap_8_2308 VPWR VGND sg13cmos5l_decap_8
* cell instance sg13cmos5l_decap_8_2309 r0 *1 0,0
Xsg13cmos5l_decap_8_2309 VPWR VGND sg13cmos5l_decap_8
* cell instance sg13cmos5l_decap_8_2310 r0 *1 0,0
Xsg13cmos5l_decap_8_2310 VPWR VGND sg13cmos5l_decap_8
* cell instance sg13cmos5l_decap_8_2311 r0 *1 0,0
Xsg13cmos5l_decap_8_2311 VPWR VGND sg13cmos5l_decap_8
* cell instance sg13cmos5l_decap_8_2312 r0 *1 0,0
Xsg13cmos5l_decap_8_2312 VPWR VGND sg13cmos5l_decap_8
* cell instance sg13cmos5l_decap_8_2313 r0 *1 0,0
Xsg13cmos5l_decap_8_2313 VPWR VGND sg13cmos5l_decap_8
* cell instance sg13cmos5l_decap_8_2314 r0 *1 0,0
Xsg13cmos5l_decap_8_2314 VPWR VGND sg13cmos5l_decap_8
* cell instance sg13cmos5l_decap_8_2315 r0 *1 0,0
Xsg13cmos5l_decap_8_2315 VPWR VGND sg13cmos5l_decap_8
* cell instance sg13cmos5l_decap_8_2316 r0 *1 0,0
Xsg13cmos5l_decap_8_2316 VPWR VGND sg13cmos5l_decap_8
* cell instance sg13cmos5l_decap_8_2317 r0 *1 0,0
Xsg13cmos5l_decap_8_2317 VPWR VGND sg13cmos5l_decap_8
* cell instance sg13cmos5l_decap_8_2318 r0 *1 0,0
Xsg13cmos5l_decap_8_2318 VPWR VGND sg13cmos5l_decap_8
* cell instance sg13cmos5l_decap_8_2319 r0 *1 0,0
Xsg13cmos5l_decap_8_2319 VPWR VGND sg13cmos5l_decap_8
* cell instance sg13cmos5l_decap_8_2320 r0 *1 0,0
Xsg13cmos5l_decap_8_2320 VPWR VGND sg13cmos5l_decap_8
* cell instance sg13cmos5l_decap_8_2321 r0 *1 0,0
Xsg13cmos5l_decap_8_2321 VPWR VGND sg13cmos5l_decap_8
* cell instance sg13cmos5l_decap_8_2322 r0 *1 0,0
Xsg13cmos5l_decap_8_2322 VPWR VGND sg13cmos5l_decap_8
* cell instance sg13cmos5l_decap_8_2323 r0 *1 0,0
Xsg13cmos5l_decap_8_2323 VPWR VGND sg13cmos5l_decap_8
* cell instance sg13cmos5l_decap_8_2324 r0 *1 0,0
Xsg13cmos5l_decap_8_2324 VPWR VGND sg13cmos5l_decap_8
* cell instance sg13cmos5l_decap_8_2325 r0 *1 0,0
Xsg13cmos5l_decap_8_2325 VPWR VGND sg13cmos5l_decap_8
* cell instance sg13cmos5l_decap_8_2326 r0 *1 0,0
Xsg13cmos5l_decap_8_2326 VPWR VGND sg13cmos5l_decap_8
* cell instance sg13cmos5l_decap_8_2327 r0 *1 0,0
Xsg13cmos5l_decap_8_2327 VPWR VGND sg13cmos5l_decap_8
* cell instance sg13cmos5l_decap_8_2328 r0 *1 0,0
Xsg13cmos5l_decap_8_2328 VPWR VGND sg13cmos5l_decap_8
* cell instance sg13cmos5l_decap_8_2329 r0 *1 0,0
Xsg13cmos5l_decap_8_2329 VPWR VGND sg13cmos5l_decap_8
* cell instance sg13cmos5l_decap_8_2330 r0 *1 0,0
Xsg13cmos5l_decap_8_2330 VPWR VGND sg13cmos5l_decap_8
* cell instance sg13cmos5l_decap_8_2331 r0 *1 0,0
Xsg13cmos5l_decap_8_2331 VPWR VGND sg13cmos5l_decap_8
* cell instance sg13cmos5l_decap_8_2332 r0 *1 0,0
Xsg13cmos5l_decap_8_2332 VPWR VGND sg13cmos5l_decap_8
* cell instance sg13cmos5l_decap_8_2333 r0 *1 0,0
Xsg13cmos5l_decap_8_2333 VPWR VGND sg13cmos5l_decap_8
* cell instance sg13cmos5l_decap_8_2334 r0 *1 0,0
Xsg13cmos5l_decap_8_2334 VPWR VGND sg13cmos5l_decap_8
* cell instance sg13cmos5l_decap_8_2335 r0 *1 0,0
Xsg13cmos5l_decap_8_2335 VPWR VGND sg13cmos5l_decap_8
* cell instance sg13cmos5l_decap_8_2336 r0 *1 0,0
Xsg13cmos5l_decap_8_2336 VPWR VGND sg13cmos5l_decap_8
* cell instance sg13cmos5l_decap_8_2337 r0 *1 0,0
Xsg13cmos5l_decap_8_2337 VPWR VGND sg13cmos5l_decap_8
* cell instance sg13cmos5l_decap_8_2338 r0 *1 0,0
Xsg13cmos5l_decap_8_2338 VPWR VGND sg13cmos5l_decap_8
* cell instance sg13cmos5l_decap_8_2339 r0 *1 0,0
Xsg13cmos5l_decap_8_2339 VPWR VGND sg13cmos5l_decap_8
* cell instance sg13cmos5l_decap_8_2340 r0 *1 0,0
Xsg13cmos5l_decap_8_2340 VPWR VGND sg13cmos5l_decap_8
* cell instance sg13cmos5l_decap_8_2341 r0 *1 0,0
Xsg13cmos5l_decap_8_2341 VPWR VGND sg13cmos5l_decap_8
* cell instance sg13cmos5l_decap_8_2342 r0 *1 0,0
Xsg13cmos5l_decap_8_2342 VPWR VGND sg13cmos5l_decap_8
* cell instance sg13cmos5l_decap_8_2343 r0 *1 0,0
Xsg13cmos5l_decap_8_2343 VPWR VGND sg13cmos5l_decap_8
* cell instance sg13cmos5l_decap_8_2344 r0 *1 0,0
Xsg13cmos5l_decap_8_2344 VPWR VGND sg13cmos5l_decap_8
* cell instance sg13cmos5l_decap_8_2345 r0 *1 0,0
Xsg13cmos5l_decap_8_2345 VPWR VGND sg13cmos5l_decap_8
* cell instance sg13cmos5l_decap_8_2346 r0 *1 0,0
Xsg13cmos5l_decap_8_2346 VPWR VGND sg13cmos5l_decap_8
* cell instance sg13cmos5l_decap_8_2347 r0 *1 0,0
Xsg13cmos5l_decap_8_2347 VPWR VGND sg13cmos5l_decap_8
* cell instance sg13cmos5l_decap_8_2348 r0 *1 0,0
Xsg13cmos5l_decap_8_2348 VPWR VGND sg13cmos5l_decap_8
* cell instance sg13cmos5l_decap_8_2349 r0 *1 0,0
Xsg13cmos5l_decap_8_2349 VPWR VGND sg13cmos5l_decap_8
* cell instance sg13cmos5l_decap_8_2350 r0 *1 0,0
Xsg13cmos5l_decap_8_2350 VPWR VGND sg13cmos5l_decap_8
* cell instance sg13cmos5l_decap_8_2351 r0 *1 0,0
Xsg13cmos5l_decap_8_2351 VPWR VGND sg13cmos5l_decap_8
* cell instance sg13cmos5l_decap_8_2352 r0 *1 0,0
Xsg13cmos5l_decap_8_2352 VPWR VGND sg13cmos5l_decap_8
* cell instance sg13cmos5l_decap_8_2353 r0 *1 0,0
Xsg13cmos5l_decap_8_2353 VPWR VGND sg13cmos5l_decap_8
* cell instance sg13cmos5l_decap_8_2354 r0 *1 0,0
Xsg13cmos5l_decap_8_2354 VPWR VGND sg13cmos5l_decap_8
* cell instance sg13cmos5l_decap_8_2355 r0 *1 0,0
Xsg13cmos5l_decap_8_2355 VPWR VGND sg13cmos5l_decap_8
* cell instance sg13cmos5l_decap_8_2356 r0 *1 0,0
Xsg13cmos5l_decap_8_2356 VPWR VGND sg13cmos5l_decap_8
* cell instance sg13cmos5l_decap_8_2357 r0 *1 0,0
Xsg13cmos5l_decap_8_2357 VPWR VGND sg13cmos5l_decap_8
* cell instance sg13cmos5l_decap_8_2358 r0 *1 0,0
Xsg13cmos5l_decap_8_2358 VPWR VGND sg13cmos5l_decap_8
* cell instance sg13cmos5l_decap_8_2359 r0 *1 0,0
Xsg13cmos5l_decap_8_2359 VPWR VGND sg13cmos5l_decap_8
* cell instance sg13cmos5l_decap_8_2360 r0 *1 0,0
Xsg13cmos5l_decap_8_2360 VPWR VGND sg13cmos5l_decap_8
* cell instance sg13cmos5l_decap_8_2361 r0 *1 0,0
Xsg13cmos5l_decap_8_2361 VPWR VGND sg13cmos5l_decap_8
* cell instance sg13cmos5l_decap_8_2362 r0 *1 0,0
Xsg13cmos5l_decap_8_2362 VPWR VGND sg13cmos5l_decap_8
* cell instance sg13cmos5l_decap_8_2363 r0 *1 0,0
Xsg13cmos5l_decap_8_2363 VPWR VGND sg13cmos5l_decap_8
* cell instance sg13cmos5l_decap_8_2364 r0 *1 0,0
Xsg13cmos5l_decap_8_2364 VPWR VGND sg13cmos5l_decap_8
* cell instance sg13cmos5l_decap_8_2365 r0 *1 0,0
Xsg13cmos5l_decap_8_2365 VPWR VGND sg13cmos5l_decap_8
* cell instance sg13cmos5l_decap_8_2366 r0 *1 0,0
Xsg13cmos5l_decap_8_2366 VPWR VGND sg13cmos5l_decap_8
* cell instance sg13cmos5l_decap_8_2367 r0 *1 0,0
Xsg13cmos5l_decap_8_2367 VPWR VGND sg13cmos5l_decap_8
* cell instance sg13cmos5l_decap_8_2368 r0 *1 0,0
Xsg13cmos5l_decap_8_2368 VPWR VGND sg13cmos5l_decap_8
* cell instance sg13cmos5l_decap_8_2369 r0 *1 0,0
Xsg13cmos5l_decap_8_2369 VPWR VGND sg13cmos5l_decap_8
* cell instance sg13cmos5l_decap_8_2370 r0 *1 0,0
Xsg13cmos5l_decap_8_2370 VPWR VGND sg13cmos5l_decap_8
* cell instance sg13cmos5l_decap_8_2371 r0 *1 0,0
Xsg13cmos5l_decap_8_2371 VPWR VGND sg13cmos5l_decap_8
* cell instance sg13cmos5l_decap_8_2372 r0 *1 0,0
Xsg13cmos5l_decap_8_2372 VPWR VGND sg13cmos5l_decap_8
* cell instance sg13cmos5l_decap_8_2373 r0 *1 0,0
Xsg13cmos5l_decap_8_2373 VPWR VGND sg13cmos5l_decap_8
* cell instance sg13cmos5l_decap_8_2374 r0 *1 0,0
Xsg13cmos5l_decap_8_2374 VPWR VGND sg13cmos5l_decap_8
* cell instance sg13cmos5l_decap_8_2375 r0 *1 0,0
Xsg13cmos5l_decap_8_2375 VPWR VGND sg13cmos5l_decap_8
* cell instance sg13cmos5l_decap_8_2376 r0 *1 0,0
Xsg13cmos5l_decap_8_2376 VPWR VGND sg13cmos5l_decap_8
* cell instance sg13cmos5l_decap_8_2377 r0 *1 0,0
Xsg13cmos5l_decap_8_2377 VPWR VGND sg13cmos5l_decap_8
* cell instance sg13cmos5l_decap_8_2378 r0 *1 0,0
Xsg13cmos5l_decap_8_2378 VPWR VGND sg13cmos5l_decap_8
* cell instance sg13cmos5l_decap_8_2379 r0 *1 0,0
Xsg13cmos5l_decap_8_2379 VPWR VGND sg13cmos5l_decap_8
* cell instance sg13cmos5l_decap_8_2380 r0 *1 0,0
Xsg13cmos5l_decap_8_2380 VPWR VGND sg13cmos5l_decap_8
* cell instance sg13cmos5l_decap_8_2381 r0 *1 0,0
Xsg13cmos5l_decap_8_2381 VPWR VGND sg13cmos5l_decap_8
* cell instance sg13cmos5l_decap_8_2382 r0 *1 0,0
Xsg13cmos5l_decap_8_2382 VPWR VGND sg13cmos5l_decap_8
* cell instance sg13cmos5l_decap_8_2383 r0 *1 0,0
Xsg13cmos5l_decap_8_2383 VPWR VGND sg13cmos5l_decap_8
* cell instance sg13cmos5l_decap_8_2384 r0 *1 0,0
Xsg13cmos5l_decap_8_2384 VPWR VGND sg13cmos5l_decap_8
* cell instance sg13cmos5l_decap_8_2385 r0 *1 0,0
Xsg13cmos5l_decap_8_2385 VPWR VGND sg13cmos5l_decap_8
* cell instance sg13cmos5l_decap_8_2386 r0 *1 0,0
Xsg13cmos5l_decap_8_2386 VPWR VGND sg13cmos5l_decap_8
* cell instance sg13cmos5l_decap_8_2387 r0 *1 0,0
Xsg13cmos5l_decap_8_2387 VPWR VGND sg13cmos5l_decap_8
* cell instance sg13cmos5l_decap_8_2388 r0 *1 0,0
Xsg13cmos5l_decap_8_2388 VPWR VGND sg13cmos5l_decap_8
* cell instance sg13cmos5l_decap_8_2389 r0 *1 0,0
Xsg13cmos5l_decap_8_2389 VPWR VGND sg13cmos5l_decap_8
* cell instance sg13cmos5l_decap_8_2390 r0 *1 0,0
Xsg13cmos5l_decap_8_2390 VPWR VGND sg13cmos5l_decap_8
* cell instance sg13cmos5l_decap_8_2391 r0 *1 0,0
Xsg13cmos5l_decap_8_2391 VPWR VGND sg13cmos5l_decap_8
* cell instance sg13cmos5l_decap_8_2392 r0 *1 0,0
Xsg13cmos5l_decap_8_2392 VPWR VGND sg13cmos5l_decap_8
* cell instance sg13cmos5l_decap_8_2393 r0 *1 0,0
Xsg13cmos5l_decap_8_2393 VPWR VGND sg13cmos5l_decap_8
* cell instance sg13cmos5l_decap_8_2394 r0 *1 0,0
Xsg13cmos5l_decap_8_2394 VPWR VGND sg13cmos5l_decap_8
* cell instance sg13cmos5l_decap_8_2395 r0 *1 0,0
Xsg13cmos5l_decap_8_2395 VPWR VGND sg13cmos5l_decap_8
* cell instance sg13cmos5l_decap_8_2396 r0 *1 0,0
Xsg13cmos5l_decap_8_2396 VPWR VGND sg13cmos5l_decap_8
* cell instance sg13cmos5l_decap_8_2397 r0 *1 0,0
Xsg13cmos5l_decap_8_2397 VPWR VGND sg13cmos5l_decap_8
* cell instance sg13cmos5l_decap_8_2398 r0 *1 0,0
Xsg13cmos5l_decap_8_2398 VPWR VGND sg13cmos5l_decap_8
* cell instance sg13cmos5l_decap_8_2399 r0 *1 0,0
Xsg13cmos5l_decap_8_2399 VPWR VGND sg13cmos5l_decap_8
* cell instance sg13cmos5l_decap_8_2400 r0 *1 0,0
Xsg13cmos5l_decap_8_2400 VPWR VGND sg13cmos5l_decap_8
* cell instance sg13cmos5l_decap_8_2401 r0 *1 0,0
Xsg13cmos5l_decap_8_2401 VPWR VGND sg13cmos5l_decap_8
* cell instance sg13cmos5l_decap_8_2402 r0 *1 0,0
Xsg13cmos5l_decap_8_2402 VPWR VGND sg13cmos5l_decap_8
* cell instance sg13cmos5l_decap_8_2403 r0 *1 0,0
Xsg13cmos5l_decap_8_2403 VPWR VGND sg13cmos5l_decap_8
* cell instance sg13cmos5l_decap_8_2404 r0 *1 0,0
Xsg13cmos5l_decap_8_2404 VPWR VGND sg13cmos5l_decap_8
* cell instance sg13cmos5l_decap_8_2405 r0 *1 0,0
Xsg13cmos5l_decap_8_2405 VPWR VGND sg13cmos5l_decap_8
* cell instance sg13cmos5l_decap_8_2406 r0 *1 0,0
Xsg13cmos5l_decap_8_2406 VPWR VGND sg13cmos5l_decap_8
* cell instance sg13cmos5l_decap_8_2407 r0 *1 0,0
Xsg13cmos5l_decap_8_2407 VPWR VGND sg13cmos5l_decap_8
* cell instance sg13cmos5l_decap_8_2408 r0 *1 0,0
Xsg13cmos5l_decap_8_2408 VPWR VGND sg13cmos5l_decap_8
* cell instance sg13cmos5l_decap_8_2409 r0 *1 0,0
Xsg13cmos5l_decap_8_2409 VPWR VGND sg13cmos5l_decap_8
* cell instance sg13cmos5l_decap_8_2410 r0 *1 0,0
Xsg13cmos5l_decap_8_2410 VPWR VGND sg13cmos5l_decap_8
* cell instance sg13cmos5l_decap_8_2411 r0 *1 0,0
Xsg13cmos5l_decap_8_2411 VPWR VGND sg13cmos5l_decap_8
* cell instance sg13cmos5l_decap_8_2412 r0 *1 0,0
Xsg13cmos5l_decap_8_2412 VPWR VGND sg13cmos5l_decap_8
* cell instance sg13cmos5l_decap_8_2413 r0 *1 0,0
Xsg13cmos5l_decap_8_2413 VPWR VGND sg13cmos5l_decap_8
* cell instance sg13cmos5l_decap_8_2414 r0 *1 0,0
Xsg13cmos5l_decap_8_2414 VPWR VGND sg13cmos5l_decap_8
* cell instance sg13cmos5l_decap_8_2415 r0 *1 0,0
Xsg13cmos5l_decap_8_2415 VPWR VGND sg13cmos5l_decap_8
* cell instance sg13cmos5l_decap_8_2416 r0 *1 0,0
Xsg13cmos5l_decap_8_2416 VPWR VGND sg13cmos5l_decap_8
* cell instance sg13cmos5l_decap_8_2417 r0 *1 0,0
Xsg13cmos5l_decap_8_2417 VPWR VGND sg13cmos5l_decap_8
* cell instance sg13cmos5l_decap_8_2418 r0 *1 0,0
Xsg13cmos5l_decap_8_2418 VPWR VGND sg13cmos5l_decap_8
* cell instance sg13cmos5l_decap_8_2419 r0 *1 0,0
Xsg13cmos5l_decap_8_2419 VPWR VGND sg13cmos5l_decap_8
* cell instance sg13cmos5l_decap_8_2420 r0 *1 0,0
Xsg13cmos5l_decap_8_2420 VPWR VGND sg13cmos5l_decap_8
* cell instance sg13cmos5l_decap_8_2421 r0 *1 0,0
Xsg13cmos5l_decap_8_2421 VPWR VGND sg13cmos5l_decap_8
* cell instance sg13cmos5l_decap_8_2422 r0 *1 0,0
Xsg13cmos5l_decap_8_2422 VPWR VGND sg13cmos5l_decap_8
* cell instance sg13cmos5l_decap_8_2423 r0 *1 0,0
Xsg13cmos5l_decap_8_2423 VPWR VGND sg13cmos5l_decap_8
* cell instance sg13cmos5l_decap_8_2424 r0 *1 0,0
Xsg13cmos5l_decap_8_2424 VPWR VGND sg13cmos5l_decap_8
* cell instance sg13cmos5l_decap_8_2425 r0 *1 0,0
Xsg13cmos5l_decap_8_2425 VPWR VGND sg13cmos5l_decap_8
* cell instance sg13cmos5l_decap_8_2426 r0 *1 0,0
Xsg13cmos5l_decap_8_2426 VPWR VGND sg13cmos5l_decap_8
* cell instance sg13cmos5l_decap_8_2427 r0 *1 0,0
Xsg13cmos5l_decap_8_2427 VPWR VGND sg13cmos5l_decap_8
* cell instance sg13cmos5l_decap_8_2428 r0 *1 0,0
Xsg13cmos5l_decap_8_2428 VPWR VGND sg13cmos5l_decap_8
* cell instance sg13cmos5l_decap_8_2429 r0 *1 0,0
Xsg13cmos5l_decap_8_2429 VPWR VGND sg13cmos5l_decap_8
* cell instance sg13cmos5l_decap_8_2430 r0 *1 0,0
Xsg13cmos5l_decap_8_2430 VPWR VGND sg13cmos5l_decap_8
* cell instance sg13cmos5l_decap_8_2431 r0 *1 0,0
Xsg13cmos5l_decap_8_2431 VPWR VGND sg13cmos5l_decap_8
* cell instance sg13cmos5l_decap_8_2432 r0 *1 0,0
Xsg13cmos5l_decap_8_2432 VPWR VGND sg13cmos5l_decap_8
* cell instance sg13cmos5l_decap_8_2433 r0 *1 0,0
Xsg13cmos5l_decap_8_2433 VPWR VGND sg13cmos5l_decap_8
* cell instance sg13cmos5l_decap_8_2434 r0 *1 0,0
Xsg13cmos5l_decap_8_2434 VPWR VGND sg13cmos5l_decap_8
* cell instance sg13cmos5l_decap_8_2435 r0 *1 0,0
Xsg13cmos5l_decap_8_2435 VPWR VGND sg13cmos5l_decap_8
* cell instance sg13cmos5l_decap_8_2436 r0 *1 0,0
Xsg13cmos5l_decap_8_2436 VPWR VGND sg13cmos5l_decap_8
* cell instance sg13cmos5l_decap_8_2437 r0 *1 0,0
Xsg13cmos5l_decap_8_2437 VPWR VGND sg13cmos5l_decap_8
* cell instance sg13cmos5l_decap_8_2438 r0 *1 0,0
Xsg13cmos5l_decap_8_2438 VPWR VGND sg13cmos5l_decap_8
* cell instance sg13cmos5l_decap_8_2439 r0 *1 0,0
Xsg13cmos5l_decap_8_2439 VPWR VGND sg13cmos5l_decap_8
* cell instance sg13cmos5l_decap_8_2440 r0 *1 0,0
Xsg13cmos5l_decap_8_2440 VPWR VGND sg13cmos5l_decap_8
* cell instance sg13cmos5l_decap_8_2441 r0 *1 0,0
Xsg13cmos5l_decap_8_2441 VPWR VGND sg13cmos5l_decap_8
* cell instance sg13cmos5l_decap_8_2442 r0 *1 0,0
Xsg13cmos5l_decap_8_2442 VPWR VGND sg13cmos5l_decap_8
* cell instance sg13cmos5l_decap_8_2443 r0 *1 0,0
Xsg13cmos5l_decap_8_2443 VPWR VGND sg13cmos5l_decap_8
* cell instance sg13cmos5l_decap_8_2444 r0 *1 0,0
Xsg13cmos5l_decap_8_2444 VPWR VGND sg13cmos5l_decap_8
* cell instance sg13cmos5l_decap_8_2445 r0 *1 0,0
Xsg13cmos5l_decap_8_2445 VPWR VGND sg13cmos5l_decap_8
* cell instance sg13cmos5l_decap_8_2446 r0 *1 0,0
Xsg13cmos5l_decap_8_2446 VPWR VGND sg13cmos5l_decap_8
* cell instance sg13cmos5l_decap_8_2447 r0 *1 0,0
Xsg13cmos5l_decap_8_2447 VPWR VGND sg13cmos5l_decap_8
* cell instance sg13cmos5l_decap_8_2448 r0 *1 0,0
Xsg13cmos5l_decap_8_2448 VPWR VGND sg13cmos5l_decap_8
* cell instance sg13cmos5l_decap_8_2449 r0 *1 0,0
Xsg13cmos5l_decap_8_2449 VPWR VGND sg13cmos5l_decap_8
* cell instance sg13cmos5l_decap_8_2450 r0 *1 0,0
Xsg13cmos5l_decap_8_2450 VPWR VGND sg13cmos5l_decap_8
* cell instance sg13cmos5l_decap_8_2451 r0 *1 0,0
Xsg13cmos5l_decap_8_2451 VPWR VGND sg13cmos5l_decap_8
* cell instance sg13cmos5l_decap_8_2452 r0 *1 0,0
Xsg13cmos5l_decap_8_2452 VPWR VGND sg13cmos5l_decap_8
* cell instance sg13cmos5l_decap_8_2453 r0 *1 0,0
Xsg13cmos5l_decap_8_2453 VPWR VGND sg13cmos5l_decap_8
* cell instance sg13cmos5l_decap_8_2454 r0 *1 0,0
Xsg13cmos5l_decap_8_2454 VPWR VGND sg13cmos5l_decap_8
* cell instance sg13cmos5l_decap_8_2455 r0 *1 0,0
Xsg13cmos5l_decap_8_2455 VPWR VGND sg13cmos5l_decap_8
* cell instance sg13cmos5l_decap_8_2456 r0 *1 0,0
Xsg13cmos5l_decap_8_2456 VPWR VGND sg13cmos5l_decap_8
* cell instance sg13cmos5l_decap_8_2457 r0 *1 0,0
Xsg13cmos5l_decap_8_2457 VPWR VGND sg13cmos5l_decap_8
* cell instance sg13cmos5l_decap_8_2458 r0 *1 0,0
Xsg13cmos5l_decap_8_2458 VPWR VGND sg13cmos5l_decap_8
* cell instance sg13cmos5l_decap_8_2459 r0 *1 0,0
Xsg13cmos5l_decap_8_2459 VPWR VGND sg13cmos5l_decap_8
* cell instance sg13cmos5l_decap_8_2460 r0 *1 0,0
Xsg13cmos5l_decap_8_2460 VPWR VGND sg13cmos5l_decap_8
* cell instance sg13cmos5l_decap_8_2461 r0 *1 0,0
Xsg13cmos5l_decap_8_2461 VPWR VGND sg13cmos5l_decap_8
* cell instance sg13cmos5l_decap_8_2462 r0 *1 0,0
Xsg13cmos5l_decap_8_2462 VPWR VGND sg13cmos5l_decap_8
* cell instance sg13cmos5l_decap_8_2463 r0 *1 0,0
Xsg13cmos5l_decap_8_2463 VPWR VGND sg13cmos5l_decap_8
* cell instance sg13cmos5l_decap_8_2464 r0 *1 0,0
Xsg13cmos5l_decap_8_2464 VPWR VGND sg13cmos5l_decap_8
* cell instance sg13cmos5l_decap_8_2465 r0 *1 0,0
Xsg13cmos5l_decap_8_2465 VPWR VGND sg13cmos5l_decap_8
* cell instance sg13cmos5l_decap_8_2466 r0 *1 0,0
Xsg13cmos5l_decap_8_2466 VPWR VGND sg13cmos5l_decap_8
* cell instance sg13cmos5l_decap_8_2467 r0 *1 0,0
Xsg13cmos5l_decap_8_2467 VPWR VGND sg13cmos5l_decap_8
* cell instance sg13cmos5l_decap_8_2468 r0 *1 0,0
Xsg13cmos5l_decap_8_2468 VPWR VGND sg13cmos5l_decap_8
* cell instance sg13cmos5l_decap_8_2469 r0 *1 0,0
Xsg13cmos5l_decap_8_2469 VPWR VGND sg13cmos5l_decap_8
* cell instance sg13cmos5l_decap_8_2470 r0 *1 0,0
Xsg13cmos5l_decap_8_2470 VPWR VGND sg13cmos5l_decap_8
* cell instance sg13cmos5l_decap_8_2471 r0 *1 0,0
Xsg13cmos5l_decap_8_2471 VPWR VGND sg13cmos5l_decap_8
* cell instance sg13cmos5l_decap_8_2472 r0 *1 0,0
Xsg13cmos5l_decap_8_2472 VPWR VGND sg13cmos5l_decap_8
* cell instance sg13cmos5l_decap_8_2473 r0 *1 0,0
Xsg13cmos5l_decap_8_2473 VPWR VGND sg13cmos5l_decap_8
* cell instance sg13cmos5l_decap_8_2474 r0 *1 0,0
Xsg13cmos5l_decap_8_2474 VPWR VGND sg13cmos5l_decap_8
* cell instance sg13cmos5l_decap_8_2475 r0 *1 0,0
Xsg13cmos5l_decap_8_2475 VPWR VGND sg13cmos5l_decap_8
* cell instance sg13cmos5l_decap_8_2476 r0 *1 0,0
Xsg13cmos5l_decap_8_2476 VPWR VGND sg13cmos5l_decap_8
* cell instance sg13cmos5l_decap_8_2477 r0 *1 0,0
Xsg13cmos5l_decap_8_2477 VPWR VGND sg13cmos5l_decap_8
* cell instance sg13cmos5l_decap_8_2478 r0 *1 0,0
Xsg13cmos5l_decap_8_2478 VPWR VGND sg13cmos5l_decap_8
* cell instance sg13cmos5l_decap_8_2479 r0 *1 0,0
Xsg13cmos5l_decap_8_2479 VPWR VGND sg13cmos5l_decap_8
* cell instance sg13cmos5l_decap_8_2480 r0 *1 0,0
Xsg13cmos5l_decap_8_2480 VPWR VGND sg13cmos5l_decap_8
* cell instance sg13cmos5l_decap_8_2481 r0 *1 0,0
Xsg13cmos5l_decap_8_2481 VPWR VGND sg13cmos5l_decap_8
* cell instance sg13cmos5l_decap_8_2482 r0 *1 0,0
Xsg13cmos5l_decap_8_2482 VPWR VGND sg13cmos5l_decap_8
* cell instance sg13cmos5l_decap_8_2483 r0 *1 0,0
Xsg13cmos5l_decap_8_2483 VPWR VGND sg13cmos5l_decap_8
* cell instance sg13cmos5l_decap_8_2484 r0 *1 0,0
Xsg13cmos5l_decap_8_2484 VPWR VGND sg13cmos5l_decap_8
* cell instance sg13cmos5l_decap_8_2485 r0 *1 0,0
Xsg13cmos5l_decap_8_2485 VPWR VGND sg13cmos5l_decap_8
* cell instance sg13cmos5l_decap_8_2486 r0 *1 0,0
Xsg13cmos5l_decap_8_2486 VPWR VGND sg13cmos5l_decap_8
* cell instance sg13cmos5l_decap_8_2487 r0 *1 0,0
Xsg13cmos5l_decap_8_2487 VPWR VGND sg13cmos5l_decap_8
* cell instance sg13cmos5l_decap_8_2488 r0 *1 0,0
Xsg13cmos5l_decap_8_2488 VPWR VGND sg13cmos5l_decap_8
* cell instance sg13cmos5l_decap_8_2489 r0 *1 0,0
Xsg13cmos5l_decap_8_2489 VPWR VGND sg13cmos5l_decap_8
* cell instance sg13cmos5l_decap_8_2490 r0 *1 0,0
Xsg13cmos5l_decap_8_2490 VPWR VGND sg13cmos5l_decap_8
* cell instance sg13cmos5l_decap_8_2491 r0 *1 0,0
Xsg13cmos5l_decap_8_2491 VPWR VGND sg13cmos5l_decap_8
* cell instance sg13cmos5l_decap_8_2492 r0 *1 0,0
Xsg13cmos5l_decap_8_2492 VPWR VGND sg13cmos5l_decap_8
* cell instance sg13cmos5l_decap_8_2493 r0 *1 0,0
Xsg13cmos5l_decap_8_2493 VPWR VGND sg13cmos5l_decap_8
* cell instance sg13cmos5l_decap_8_2494 r0 *1 0,0
Xsg13cmos5l_decap_8_2494 VPWR VGND sg13cmos5l_decap_8
* cell instance sg13cmos5l_decap_8_2495 r0 *1 0,0
Xsg13cmos5l_decap_8_2495 VPWR VGND sg13cmos5l_decap_8
* cell instance sg13cmos5l_decap_8_2496 r0 *1 0,0
Xsg13cmos5l_decap_8_2496 VPWR VGND sg13cmos5l_decap_8
* cell instance sg13cmos5l_decap_8_2497 r0 *1 0,0
Xsg13cmos5l_decap_8_2497 VPWR VGND sg13cmos5l_decap_8
* cell instance sg13cmos5l_decap_8_2498 r0 *1 0,0
Xsg13cmos5l_decap_8_2498 VPWR VGND sg13cmos5l_decap_8
* cell instance sg13cmos5l_decap_8_2499 r0 *1 0,0
Xsg13cmos5l_decap_8_2499 VPWR VGND sg13cmos5l_decap_8
* cell instance sg13cmos5l_decap_8_2500 r0 *1 0,0
Xsg13cmos5l_decap_8_2500 VPWR VGND sg13cmos5l_decap_8
* cell instance sg13cmos5l_decap_8_2501 r0 *1 0,0
Xsg13cmos5l_decap_8_2501 VPWR VGND sg13cmos5l_decap_8
* cell instance sg13cmos5l_decap_8_2502 r0 *1 0,0
Xsg13cmos5l_decap_8_2502 VPWR VGND sg13cmos5l_decap_8
* cell instance sg13cmos5l_decap_8_2503 r0 *1 0,0
Xsg13cmos5l_decap_8_2503 VPWR VGND sg13cmos5l_decap_8
* cell instance sg13cmos5l_decap_8_2504 r0 *1 0,0
Xsg13cmos5l_decap_8_2504 VPWR VGND sg13cmos5l_decap_8
* cell instance sg13cmos5l_decap_8_2505 r0 *1 0,0
Xsg13cmos5l_decap_8_2505 VPWR VGND sg13cmos5l_decap_8
* cell instance sg13cmos5l_decap_8_2506 r0 *1 0,0
Xsg13cmos5l_decap_8_2506 VPWR VGND sg13cmos5l_decap_8
* cell instance sg13cmos5l_decap_8_2507 r0 *1 0,0
Xsg13cmos5l_decap_8_2507 VPWR VGND sg13cmos5l_decap_8
* cell instance sg13cmos5l_decap_8_2508 r0 *1 0,0
Xsg13cmos5l_decap_8_2508 VPWR VGND sg13cmos5l_decap_8
* cell instance sg13cmos5l_decap_8_2509 r0 *1 0,0
Xsg13cmos5l_decap_8_2509 VPWR VGND sg13cmos5l_decap_8
* cell instance sg13cmos5l_decap_8_2510 r0 *1 0,0
Xsg13cmos5l_decap_8_2510 VPWR VGND sg13cmos5l_decap_8
* cell instance sg13cmos5l_decap_8_2511 r0 *1 0,0
Xsg13cmos5l_decap_8_2511 VPWR VGND sg13cmos5l_decap_8
* cell instance sg13cmos5l_decap_8_2512 r0 *1 0,0
Xsg13cmos5l_decap_8_2512 VPWR VGND sg13cmos5l_decap_8
* cell instance sg13cmos5l_decap_8_2513 r0 *1 0,0
Xsg13cmos5l_decap_8_2513 VPWR VGND sg13cmos5l_decap_8
* cell instance sg13cmos5l_decap_8_2514 r0 *1 0,0
Xsg13cmos5l_decap_8_2514 VPWR VGND sg13cmos5l_decap_8
* cell instance sg13cmos5l_decap_8_2515 r0 *1 0,0
Xsg13cmos5l_decap_8_2515 VPWR VGND sg13cmos5l_decap_8
* cell instance sg13cmos5l_decap_8_2516 r0 *1 0,0
Xsg13cmos5l_decap_8_2516 VPWR VGND sg13cmos5l_decap_8
* cell instance sg13cmos5l_decap_8_2517 r0 *1 0,0
Xsg13cmos5l_decap_8_2517 VPWR VGND sg13cmos5l_decap_8
* cell instance sg13cmos5l_decap_8_2518 r0 *1 0,0
Xsg13cmos5l_decap_8_2518 VPWR VGND sg13cmos5l_decap_8
* cell instance sg13cmos5l_decap_8_2519 r0 *1 0,0
Xsg13cmos5l_decap_8_2519 VPWR VGND sg13cmos5l_decap_8
* cell instance sg13cmos5l_decap_8_2520 r0 *1 0,0
Xsg13cmos5l_decap_8_2520 VPWR VGND sg13cmos5l_decap_8
* cell instance sg13cmos5l_decap_8_2521 r0 *1 0,0
Xsg13cmos5l_decap_8_2521 VPWR VGND sg13cmos5l_decap_8
* cell instance sg13cmos5l_decap_8_2522 r0 *1 0,0
Xsg13cmos5l_decap_8_2522 VPWR VGND sg13cmos5l_decap_8
* cell instance sg13cmos5l_decap_8_2523 r0 *1 0,0
Xsg13cmos5l_decap_8_2523 VPWR VGND sg13cmos5l_decap_8
* cell instance sg13cmos5l_decap_8_2524 r0 *1 0,0
Xsg13cmos5l_decap_8_2524 VPWR VGND sg13cmos5l_decap_8
* cell instance sg13cmos5l_decap_8_2525 r0 *1 0,0
Xsg13cmos5l_decap_8_2525 VPWR VGND sg13cmos5l_decap_8
* cell instance sg13cmos5l_decap_8_2526 r0 *1 0,0
Xsg13cmos5l_decap_8_2526 VPWR VGND sg13cmos5l_decap_8
* cell instance sg13cmos5l_decap_8_2527 r0 *1 0,0
Xsg13cmos5l_decap_8_2527 VPWR VGND sg13cmos5l_decap_8
* cell instance sg13cmos5l_decap_8_2528 r0 *1 0,0
Xsg13cmos5l_decap_8_2528 VPWR VGND sg13cmos5l_decap_8
* cell instance sg13cmos5l_decap_8_2529 r0 *1 0,0
Xsg13cmos5l_decap_8_2529 VPWR VGND sg13cmos5l_decap_8
* cell instance sg13cmos5l_decap_8_2530 r0 *1 0,0
Xsg13cmos5l_decap_8_2530 VPWR VGND sg13cmos5l_decap_8
* cell instance sg13cmos5l_decap_8_2531 r0 *1 0,0
Xsg13cmos5l_decap_8_2531 VPWR VGND sg13cmos5l_decap_8
* cell instance sg13cmos5l_decap_8_2532 r0 *1 0,0
Xsg13cmos5l_decap_8_2532 VPWR VGND sg13cmos5l_decap_8
* cell instance sg13cmos5l_decap_8_2533 r0 *1 0,0
Xsg13cmos5l_decap_8_2533 VPWR VGND sg13cmos5l_decap_8
* cell instance sg13cmos5l_decap_8_2534 r0 *1 0,0
Xsg13cmos5l_decap_8_2534 VPWR VGND sg13cmos5l_decap_8
* cell instance sg13cmos5l_decap_8_2535 r0 *1 0,0
Xsg13cmos5l_decap_8_2535 VPWR VGND sg13cmos5l_decap_8
* cell instance sg13cmos5l_decap_8_2536 r0 *1 0,0
Xsg13cmos5l_decap_8_2536 VPWR VGND sg13cmos5l_decap_8
* cell instance sg13cmos5l_decap_8_2537 r0 *1 0,0
Xsg13cmos5l_decap_8_2537 VPWR VGND sg13cmos5l_decap_8
* cell instance sg13cmos5l_decap_8_2538 r0 *1 0,0
Xsg13cmos5l_decap_8_2538 VPWR VGND sg13cmos5l_decap_8
* cell instance sg13cmos5l_decap_8_2539 r0 *1 0,0
Xsg13cmos5l_decap_8_2539 VPWR VGND sg13cmos5l_decap_8
* cell instance sg13cmos5l_decap_8_2540 r0 *1 0,0
Xsg13cmos5l_decap_8_2540 VPWR VGND sg13cmos5l_decap_8
* cell instance sg13cmos5l_decap_8_2541 r0 *1 0,0
Xsg13cmos5l_decap_8_2541 VPWR VGND sg13cmos5l_decap_8
* cell instance sg13cmos5l_decap_8_2542 r0 *1 0,0
Xsg13cmos5l_decap_8_2542 VPWR VGND sg13cmos5l_decap_8
* cell instance sg13cmos5l_decap_8_2543 r0 *1 0,0
Xsg13cmos5l_decap_8_2543 VPWR VGND sg13cmos5l_decap_8
* cell instance sg13cmos5l_decap_8_2544 r0 *1 0,0
Xsg13cmos5l_decap_8_2544 VPWR VGND sg13cmos5l_decap_8
* cell instance sg13cmos5l_decap_8_2545 r0 *1 0,0
Xsg13cmos5l_decap_8_2545 VPWR VGND sg13cmos5l_decap_8
* cell instance sg13cmos5l_decap_8_2546 r0 *1 0,0
Xsg13cmos5l_decap_8_2546 VPWR VGND sg13cmos5l_decap_8
* cell instance sg13cmos5l_decap_8_2547 r0 *1 0,0
Xsg13cmos5l_decap_8_2547 VPWR VGND sg13cmos5l_decap_8
* cell instance sg13cmos5l_decap_8_2548 r0 *1 0,0
Xsg13cmos5l_decap_8_2548 VPWR VGND sg13cmos5l_decap_8
* cell instance sg13cmos5l_decap_8_2549 r0 *1 0,0
Xsg13cmos5l_decap_8_2549 VPWR VGND sg13cmos5l_decap_8
* cell instance sg13cmos5l_decap_8_2550 r0 *1 0,0
Xsg13cmos5l_decap_8_2550 VPWR VGND sg13cmos5l_decap_8
* cell instance sg13cmos5l_decap_8_2551 r0 *1 0,0
Xsg13cmos5l_decap_8_2551 VPWR VGND sg13cmos5l_decap_8
* cell instance sg13cmos5l_decap_8_2552 r0 *1 0,0
Xsg13cmos5l_decap_8_2552 VPWR VGND sg13cmos5l_decap_8
* cell instance sg13cmos5l_decap_8_2553 r0 *1 0,0
Xsg13cmos5l_decap_8_2553 VPWR VGND sg13cmos5l_decap_8
* cell instance sg13cmos5l_decap_8_2554 r0 *1 0,0
Xsg13cmos5l_decap_8_2554 VPWR VGND sg13cmos5l_decap_8
* cell instance sg13cmos5l_decap_8_2555 r0 *1 0,0
Xsg13cmos5l_decap_8_2555 VPWR VGND sg13cmos5l_decap_8
* cell instance sg13cmos5l_decap_8_2556 r0 *1 0,0
Xsg13cmos5l_decap_8_2556 VPWR VGND sg13cmos5l_decap_8
* cell instance sg13cmos5l_decap_8_2557 r0 *1 0,0
Xsg13cmos5l_decap_8_2557 VPWR VGND sg13cmos5l_decap_8
* cell instance sg13cmos5l_decap_8_2558 r0 *1 0,0
Xsg13cmos5l_decap_8_2558 VPWR VGND sg13cmos5l_decap_8
* cell instance sg13cmos5l_decap_8_2559 r0 *1 0,0
Xsg13cmos5l_decap_8_2559 VPWR VGND sg13cmos5l_decap_8
* cell instance sg13cmos5l_decap_8_2560 r0 *1 0,0
Xsg13cmos5l_decap_8_2560 VPWR VGND sg13cmos5l_decap_8
* cell instance sg13cmos5l_decap_8_2561 r0 *1 0,0
Xsg13cmos5l_decap_8_2561 VPWR VGND sg13cmos5l_decap_8
* cell instance sg13cmos5l_decap_8_2562 r0 *1 0,0
Xsg13cmos5l_decap_8_2562 VPWR VGND sg13cmos5l_decap_8
* cell instance sg13cmos5l_decap_8_2563 r0 *1 0,0
Xsg13cmos5l_decap_8_2563 VPWR VGND sg13cmos5l_decap_8
* cell instance sg13cmos5l_decap_8_2564 r0 *1 0,0
Xsg13cmos5l_decap_8_2564 VPWR VGND sg13cmos5l_decap_8
* cell instance sg13cmos5l_decap_8_2565 r0 *1 0,0
Xsg13cmos5l_decap_8_2565 VPWR VGND sg13cmos5l_decap_8
* cell instance sg13cmos5l_decap_8_2566 r0 *1 0,0
Xsg13cmos5l_decap_8_2566 VPWR VGND sg13cmos5l_decap_8
* cell instance sg13cmos5l_decap_8_2567 r0 *1 0,0
Xsg13cmos5l_decap_8_2567 VPWR VGND sg13cmos5l_decap_8
* cell instance sg13cmos5l_decap_8_2568 r0 *1 0,0
Xsg13cmos5l_decap_8_2568 VPWR VGND sg13cmos5l_decap_8
* cell instance sg13cmos5l_decap_8_2569 r0 *1 0,0
Xsg13cmos5l_decap_8_2569 VPWR VGND sg13cmos5l_decap_8
* cell instance sg13cmos5l_decap_8_2570 r0 *1 0,0
Xsg13cmos5l_decap_8_2570 VPWR VGND sg13cmos5l_decap_8
* cell instance sg13cmos5l_decap_8_2571 r0 *1 0,0
Xsg13cmos5l_decap_8_2571 VPWR VGND sg13cmos5l_decap_8
* cell instance sg13cmos5l_decap_8_2572 r0 *1 0,0
Xsg13cmos5l_decap_8_2572 VPWR VGND sg13cmos5l_decap_8
* cell instance sg13cmos5l_decap_8_2573 r0 *1 0,0
Xsg13cmos5l_decap_8_2573 VPWR VGND sg13cmos5l_decap_8
* cell instance sg13cmos5l_decap_8_2574 r0 *1 0,0
Xsg13cmos5l_decap_8_2574 VPWR VGND sg13cmos5l_decap_8
* cell instance sg13cmos5l_decap_8_2575 r0 *1 0,0
Xsg13cmos5l_decap_8_2575 VPWR VGND sg13cmos5l_decap_8
* cell instance sg13cmos5l_decap_8_2576 r0 *1 0,0
Xsg13cmos5l_decap_8_2576 VPWR VGND sg13cmos5l_decap_8
* cell instance sg13cmos5l_decap_8_2577 r0 *1 0,0
Xsg13cmos5l_decap_8_2577 VPWR VGND sg13cmos5l_decap_8
* cell instance sg13cmos5l_decap_8_2578 r0 *1 0,0
Xsg13cmos5l_decap_8_2578 VPWR VGND sg13cmos5l_decap_8
* cell instance sg13cmos5l_decap_8_2579 r0 *1 0,0
Xsg13cmos5l_decap_8_2579 VPWR VGND sg13cmos5l_decap_8
* cell instance sg13cmos5l_decap_8_2580 r0 *1 0,0
Xsg13cmos5l_decap_8_2580 VPWR VGND sg13cmos5l_decap_8
* cell instance sg13cmos5l_decap_8_2581 r0 *1 0,0
Xsg13cmos5l_decap_8_2581 VPWR VGND sg13cmos5l_decap_8
* cell instance sg13cmos5l_decap_8_2582 r0 *1 0,0
Xsg13cmos5l_decap_8_2582 VPWR VGND sg13cmos5l_decap_8
* cell instance sg13cmos5l_decap_8_2583 r0 *1 0,0
Xsg13cmos5l_decap_8_2583 VPWR VGND sg13cmos5l_decap_8
* cell instance sg13cmos5l_decap_8_2584 r0 *1 0,0
Xsg13cmos5l_decap_8_2584 VPWR VGND sg13cmos5l_decap_8
* cell instance sg13cmos5l_decap_8_2585 r0 *1 0,0
Xsg13cmos5l_decap_8_2585 VPWR VGND sg13cmos5l_decap_8
* cell instance sg13cmos5l_decap_8_2586 r0 *1 0,0
Xsg13cmos5l_decap_8_2586 VPWR VGND sg13cmos5l_decap_8
* cell instance sg13cmos5l_decap_8_2587 r0 *1 0,0
Xsg13cmos5l_decap_8_2587 VPWR VGND sg13cmos5l_decap_8
* cell instance sg13cmos5l_decap_8_2588 r0 *1 0,0
Xsg13cmos5l_decap_8_2588 VPWR VGND sg13cmos5l_decap_8
* cell instance sg13cmos5l_decap_8_2589 r0 *1 0,0
Xsg13cmos5l_decap_8_2589 VPWR VGND sg13cmos5l_decap_8
* cell instance sg13cmos5l_decap_8_2590 r0 *1 0,0
Xsg13cmos5l_decap_8_2590 VPWR VGND sg13cmos5l_decap_8
* cell instance sg13cmos5l_decap_8_2591 r0 *1 0,0
Xsg13cmos5l_decap_8_2591 VPWR VGND sg13cmos5l_decap_8
* cell instance sg13cmos5l_decap_8_2592 r0 *1 0,0
Xsg13cmos5l_decap_8_2592 VPWR VGND sg13cmos5l_decap_8
* cell instance sg13cmos5l_decap_8_2593 r0 *1 0,0
Xsg13cmos5l_decap_8_2593 VPWR VGND sg13cmos5l_decap_8
* cell instance sg13cmos5l_decap_8_2594 r0 *1 0,0
Xsg13cmos5l_decap_8_2594 VPWR VGND sg13cmos5l_decap_8
* cell instance sg13cmos5l_decap_8_2595 r0 *1 0,0
Xsg13cmos5l_decap_8_2595 VPWR VGND sg13cmos5l_decap_8
* cell instance sg13cmos5l_decap_8_2596 r0 *1 0,0
Xsg13cmos5l_decap_8_2596 VPWR VGND sg13cmos5l_decap_8
* cell instance sg13cmos5l_decap_8_2597 r0 *1 0,0
Xsg13cmos5l_decap_8_2597 VPWR VGND sg13cmos5l_decap_8
* cell instance sg13cmos5l_decap_8_2598 r0 *1 0,0
Xsg13cmos5l_decap_8_2598 VPWR VGND sg13cmos5l_decap_8
* cell instance sg13cmos5l_decap_8_2599 r0 *1 0,0
Xsg13cmos5l_decap_8_2599 VPWR VGND sg13cmos5l_decap_8
* cell instance sg13cmos5l_decap_8_2600 r0 *1 0,0
Xsg13cmos5l_decap_8_2600 VPWR VGND sg13cmos5l_decap_8
* cell instance sg13cmos5l_decap_8_2601 r0 *1 0,0
Xsg13cmos5l_decap_8_2601 VPWR VGND sg13cmos5l_decap_8
* cell instance sg13cmos5l_decap_8_2602 r0 *1 0,0
Xsg13cmos5l_decap_8_2602 VPWR VGND sg13cmos5l_decap_8
* cell instance sg13cmos5l_decap_8_2603 r0 *1 0,0
Xsg13cmos5l_decap_8_2603 VPWR VGND sg13cmos5l_decap_8
* cell instance sg13cmos5l_decap_8_2604 r0 *1 0,0
Xsg13cmos5l_decap_8_2604 VPWR VGND sg13cmos5l_decap_8
* cell instance sg13cmos5l_decap_8_2605 r0 *1 0,0
Xsg13cmos5l_decap_8_2605 VPWR VGND sg13cmos5l_decap_8
* cell instance sg13cmos5l_decap_8_2606 r0 *1 0,0
Xsg13cmos5l_decap_8_2606 VPWR VGND sg13cmos5l_decap_8
* cell instance sg13cmos5l_decap_8_2607 r0 *1 0,0
Xsg13cmos5l_decap_8_2607 VPWR VGND sg13cmos5l_decap_8
* cell instance sg13cmos5l_decap_8_2608 r0 *1 0,0
Xsg13cmos5l_decap_8_2608 VPWR VGND sg13cmos5l_decap_8
* cell instance sg13cmos5l_decap_8_2609 r0 *1 0,0
Xsg13cmos5l_decap_8_2609 VPWR VGND sg13cmos5l_decap_8
* cell instance sg13cmos5l_decap_8_2610 r0 *1 0,0
Xsg13cmos5l_decap_8_2610 VPWR VGND sg13cmos5l_decap_8
* cell instance sg13cmos5l_decap_8_2611 r0 *1 0,0
Xsg13cmos5l_decap_8_2611 VPWR VGND sg13cmos5l_decap_8
* cell instance sg13cmos5l_decap_8_2612 r0 *1 0,0
Xsg13cmos5l_decap_8_2612 VPWR VGND sg13cmos5l_decap_8
* cell instance sg13cmos5l_decap_8_2613 r0 *1 0,0
Xsg13cmos5l_decap_8_2613 VPWR VGND sg13cmos5l_decap_8
* cell instance sg13cmos5l_decap_8_2614 r0 *1 0,0
Xsg13cmos5l_decap_8_2614 VPWR VGND sg13cmos5l_decap_8
* cell instance sg13cmos5l_decap_8_2615 r0 *1 0,0
Xsg13cmos5l_decap_8_2615 VPWR VGND sg13cmos5l_decap_8
* cell instance sg13cmos5l_decap_8_2616 r0 *1 0,0
Xsg13cmos5l_decap_8_2616 VPWR VGND sg13cmos5l_decap_8
* cell instance sg13cmos5l_decap_8_2617 r0 *1 0,0
Xsg13cmos5l_decap_8_2617 VPWR VGND sg13cmos5l_decap_8
* cell instance sg13cmos5l_decap_8_2618 r0 *1 0,0
Xsg13cmos5l_decap_8_2618 VPWR VGND sg13cmos5l_decap_8
* cell instance sg13cmos5l_decap_8_2619 r0 *1 0,0
Xsg13cmos5l_decap_8_2619 VPWR VGND sg13cmos5l_decap_8
* cell instance sg13cmos5l_decap_8_2620 r0 *1 0,0
Xsg13cmos5l_decap_8_2620 VPWR VGND sg13cmos5l_decap_8
* cell instance sg13cmos5l_decap_8_2621 r0 *1 0,0
Xsg13cmos5l_decap_8_2621 VPWR VGND sg13cmos5l_decap_8
* cell instance sg13cmos5l_decap_8_2622 r0 *1 0,0
Xsg13cmos5l_decap_8_2622 VPWR VGND sg13cmos5l_decap_8
* cell instance sg13cmos5l_decap_8_2623 r0 *1 0,0
Xsg13cmos5l_decap_8_2623 VPWR VGND sg13cmos5l_decap_8
* cell instance sg13cmos5l_decap_8_2624 r0 *1 0,0
Xsg13cmos5l_decap_8_2624 VPWR VGND sg13cmos5l_decap_8
* cell instance sg13cmos5l_decap_8_2625 r0 *1 0,0
Xsg13cmos5l_decap_8_2625 VPWR VGND sg13cmos5l_decap_8
* cell instance sg13cmos5l_decap_8_2626 r0 *1 0,0
Xsg13cmos5l_decap_8_2626 VPWR VGND sg13cmos5l_decap_8
* cell instance sg13cmos5l_decap_8_2627 r0 *1 0,0
Xsg13cmos5l_decap_8_2627 VPWR VGND sg13cmos5l_decap_8
* cell instance sg13cmos5l_decap_8_2628 r0 *1 0,0
Xsg13cmos5l_decap_8_2628 VPWR VGND sg13cmos5l_decap_8
* cell instance sg13cmos5l_decap_8_2629 r0 *1 0,0
Xsg13cmos5l_decap_8_2629 VPWR VGND sg13cmos5l_decap_8
* cell instance sg13cmos5l_decap_8_2630 r0 *1 0,0
Xsg13cmos5l_decap_8_2630 VPWR VGND sg13cmos5l_decap_8
* cell instance sg13cmos5l_decap_8_2631 r0 *1 0,0
Xsg13cmos5l_decap_8_2631 VPWR VGND sg13cmos5l_decap_8
* cell instance sg13cmos5l_decap_8_2632 r0 *1 0,0
Xsg13cmos5l_decap_8_2632 VPWR VGND sg13cmos5l_decap_8
* cell instance sg13cmos5l_decap_8_2633 r0 *1 0,0
Xsg13cmos5l_decap_8_2633 VPWR VGND sg13cmos5l_decap_8
* cell instance sg13cmos5l_decap_8_2634 r0 *1 0,0
Xsg13cmos5l_decap_8_2634 VPWR VGND sg13cmos5l_decap_8
* cell instance sg13cmos5l_decap_8_2635 r0 *1 0,0
Xsg13cmos5l_decap_8_2635 VPWR VGND sg13cmos5l_decap_8
* cell instance sg13cmos5l_decap_8_2636 r0 *1 0,0
Xsg13cmos5l_decap_8_2636 VPWR VGND sg13cmos5l_decap_8
* cell instance sg13cmos5l_decap_8_2637 r0 *1 0,0
Xsg13cmos5l_decap_8_2637 VPWR VGND sg13cmos5l_decap_8
* cell instance sg13cmos5l_decap_8_2638 r0 *1 0,0
Xsg13cmos5l_decap_8_2638 VPWR VGND sg13cmos5l_decap_8
* cell instance sg13cmos5l_decap_8_2639 r0 *1 0,0
Xsg13cmos5l_decap_8_2639 VPWR VGND sg13cmos5l_decap_8
* cell instance sg13cmos5l_decap_8_2640 r0 *1 0,0
Xsg13cmos5l_decap_8_2640 VPWR VGND sg13cmos5l_decap_8
* cell instance sg13cmos5l_decap_8_2641 r0 *1 0,0
Xsg13cmos5l_decap_8_2641 VPWR VGND sg13cmos5l_decap_8
* cell instance sg13cmos5l_decap_8_2642 r0 *1 0,0
Xsg13cmos5l_decap_8_2642 VPWR VGND sg13cmos5l_decap_8
* cell instance sg13cmos5l_decap_8_2643 r0 *1 0,0
Xsg13cmos5l_decap_8_2643 VPWR VGND sg13cmos5l_decap_8
* cell instance sg13cmos5l_decap_8_2644 r0 *1 0,0
Xsg13cmos5l_decap_8_2644 VPWR VGND sg13cmos5l_decap_8
* cell instance sg13cmos5l_decap_8_2645 r0 *1 0,0
Xsg13cmos5l_decap_8_2645 VPWR VGND sg13cmos5l_decap_8
* cell instance sg13cmos5l_decap_8_2646 r0 *1 0,0
Xsg13cmos5l_decap_8_2646 VPWR VGND sg13cmos5l_decap_8
* cell instance sg13cmos5l_decap_8_2647 r0 *1 0,0
Xsg13cmos5l_decap_8_2647 VPWR VGND sg13cmos5l_decap_8
* cell instance sg13cmos5l_decap_8_2648 r0 *1 0,0
Xsg13cmos5l_decap_8_2648 VPWR VGND sg13cmos5l_decap_8
* cell instance sg13cmos5l_decap_8_2649 r0 *1 0,0
Xsg13cmos5l_decap_8_2649 VPWR VGND sg13cmos5l_decap_8
* cell instance sg13cmos5l_decap_8_2650 r0 *1 0,0
Xsg13cmos5l_decap_8_2650 VPWR VGND sg13cmos5l_decap_8
* cell instance sg13cmos5l_decap_8_2651 r0 *1 0,0
Xsg13cmos5l_decap_8_2651 VPWR VGND sg13cmos5l_decap_8
* cell instance sg13cmos5l_decap_8_2652 r0 *1 0,0
Xsg13cmos5l_decap_8_2652 VPWR VGND sg13cmos5l_decap_8
* cell instance sg13cmos5l_decap_8_2653 r0 *1 0,0
Xsg13cmos5l_decap_8_2653 VPWR VGND sg13cmos5l_decap_8
* cell instance sg13cmos5l_decap_8_2654 r0 *1 0,0
Xsg13cmos5l_decap_8_2654 VPWR VGND sg13cmos5l_decap_8
* cell instance sg13cmos5l_decap_8_2655 r0 *1 0,0
Xsg13cmos5l_decap_8_2655 VPWR VGND sg13cmos5l_decap_8
* cell instance sg13cmos5l_decap_8_2656 r0 *1 0,0
Xsg13cmos5l_decap_8_2656 VPWR VGND sg13cmos5l_decap_8
* cell instance sg13cmos5l_decap_8_2657 r0 *1 0,0
Xsg13cmos5l_decap_8_2657 VPWR VGND sg13cmos5l_decap_8
* cell instance sg13cmos5l_decap_8_2658 r0 *1 0,0
Xsg13cmos5l_decap_8_2658 VPWR VGND sg13cmos5l_decap_8
* cell instance sg13cmos5l_decap_8_2659 r0 *1 0,0
Xsg13cmos5l_decap_8_2659 VPWR VGND sg13cmos5l_decap_8
* cell instance sg13cmos5l_decap_8_2660 r0 *1 0,0
Xsg13cmos5l_decap_8_2660 VPWR VGND sg13cmos5l_decap_8
* cell instance sg13cmos5l_decap_8_2661 r0 *1 0,0
Xsg13cmos5l_decap_8_2661 VPWR VGND sg13cmos5l_decap_8
* cell instance sg13cmos5l_decap_8_2662 r0 *1 0,0
Xsg13cmos5l_decap_8_2662 VPWR VGND sg13cmos5l_decap_8
* cell instance sg13cmos5l_decap_8_2663 r0 *1 0,0
Xsg13cmos5l_decap_8_2663 VPWR VGND sg13cmos5l_decap_8
* cell instance sg13cmos5l_decap_8_2664 r0 *1 0,0
Xsg13cmos5l_decap_8_2664 VPWR VGND sg13cmos5l_decap_8
* cell instance sg13cmos5l_decap_8_2665 r0 *1 0,0
Xsg13cmos5l_decap_8_2665 VPWR VGND sg13cmos5l_decap_8
* cell instance sg13cmos5l_decap_8_2666 r0 *1 0,0
Xsg13cmos5l_decap_8_2666 VPWR VGND sg13cmos5l_decap_8
* cell instance sg13cmos5l_decap_8_2667 r0 *1 0,0
Xsg13cmos5l_decap_8_2667 VPWR VGND sg13cmos5l_decap_8
* cell instance sg13cmos5l_decap_8_2668 r0 *1 0,0
Xsg13cmos5l_decap_8_2668 VPWR VGND sg13cmos5l_decap_8
* cell instance sg13cmos5l_decap_8_2669 r0 *1 0,0
Xsg13cmos5l_decap_8_2669 VPWR VGND sg13cmos5l_decap_8
* cell instance sg13cmos5l_decap_8_2670 r0 *1 0,0
Xsg13cmos5l_decap_8_2670 VPWR VGND sg13cmos5l_decap_8
* cell instance sg13cmos5l_decap_8_2671 r0 *1 0,0
Xsg13cmos5l_decap_8_2671 VPWR VGND sg13cmos5l_decap_8
* cell instance sg13cmos5l_decap_8_2672 r0 *1 0,0
Xsg13cmos5l_decap_8_2672 VPWR VGND sg13cmos5l_decap_8
* cell instance sg13cmos5l_decap_8_2673 r0 *1 0,0
Xsg13cmos5l_decap_8_2673 VPWR VGND sg13cmos5l_decap_8
* cell instance sg13cmos5l_decap_8_2674 r0 *1 0,0
Xsg13cmos5l_decap_8_2674 VPWR VGND sg13cmos5l_decap_8
* cell instance sg13cmos5l_decap_8_2675 r0 *1 0,0
Xsg13cmos5l_decap_8_2675 VPWR VGND sg13cmos5l_decap_8
* cell instance sg13cmos5l_decap_8_2676 r0 *1 0,0
Xsg13cmos5l_decap_8_2676 VPWR VGND sg13cmos5l_decap_8
* cell instance sg13cmos5l_decap_8_2677 r0 *1 0,0
Xsg13cmos5l_decap_8_2677 VPWR VGND sg13cmos5l_decap_8
* cell instance sg13cmos5l_decap_8_2678 r0 *1 0,0
Xsg13cmos5l_decap_8_2678 VPWR VGND sg13cmos5l_decap_8
* cell instance sg13cmos5l_decap_8_2679 r0 *1 0,0
Xsg13cmos5l_decap_8_2679 VPWR VGND sg13cmos5l_decap_8
* cell instance sg13cmos5l_decap_8_2680 r0 *1 0,0
Xsg13cmos5l_decap_8_2680 VPWR VGND sg13cmos5l_decap_8
* cell instance sg13cmos5l_decap_8_2681 r0 *1 0,0
Xsg13cmos5l_decap_8_2681 VPWR VGND sg13cmos5l_decap_8
* cell instance sg13cmos5l_decap_8_2682 r0 *1 0,0
Xsg13cmos5l_decap_8_2682 VPWR VGND sg13cmos5l_decap_8
* cell instance sg13cmos5l_decap_8_2683 r0 *1 0,0
Xsg13cmos5l_decap_8_2683 VPWR VGND sg13cmos5l_decap_8
* cell instance sg13cmos5l_decap_8_2684 r0 *1 0,0
Xsg13cmos5l_decap_8_2684 VPWR VGND sg13cmos5l_decap_8
* cell instance sg13cmos5l_decap_8_2685 r0 *1 0,0
Xsg13cmos5l_decap_8_2685 VPWR VGND sg13cmos5l_decap_8
* cell instance sg13cmos5l_decap_8_2686 r0 *1 0,0
Xsg13cmos5l_decap_8_2686 VPWR VGND sg13cmos5l_decap_8
* cell instance sg13cmos5l_decap_8_2687 r0 *1 0,0
Xsg13cmos5l_decap_8_2687 VPWR VGND sg13cmos5l_decap_8
* cell instance sg13cmos5l_decap_8_2688 r0 *1 0,0
Xsg13cmos5l_decap_8_2688 VPWR VGND sg13cmos5l_decap_8
* cell instance sg13cmos5l_decap_8_2689 r0 *1 0,0
Xsg13cmos5l_decap_8_2689 VPWR VGND sg13cmos5l_decap_8
* cell instance sg13cmos5l_decap_8_2690 r0 *1 0,0
Xsg13cmos5l_decap_8_2690 VPWR VGND sg13cmos5l_decap_8
* cell instance sg13cmos5l_decap_8_2691 r0 *1 0,0
Xsg13cmos5l_decap_8_2691 VPWR VGND sg13cmos5l_decap_8
* cell instance sg13cmos5l_decap_8_2692 r0 *1 0,0
Xsg13cmos5l_decap_8_2692 VPWR VGND sg13cmos5l_decap_8
* cell instance sg13cmos5l_decap_8_2693 r0 *1 0,0
Xsg13cmos5l_decap_8_2693 VPWR VGND sg13cmos5l_decap_8
* cell instance sg13cmos5l_decap_8_2694 r0 *1 0,0
Xsg13cmos5l_decap_8_2694 VPWR VGND sg13cmos5l_decap_8
* cell instance sg13cmos5l_decap_8_2695 r0 *1 0,0
Xsg13cmos5l_decap_8_2695 VPWR VGND sg13cmos5l_decap_8
* cell instance sg13cmos5l_decap_8_2696 r0 *1 0,0
Xsg13cmos5l_decap_8_2696 VPWR VGND sg13cmos5l_decap_8
* cell instance sg13cmos5l_decap_8_2697 r0 *1 0,0
Xsg13cmos5l_decap_8_2697 VPWR VGND sg13cmos5l_decap_8
* cell instance sg13cmos5l_decap_8_2698 r0 *1 0,0
Xsg13cmos5l_decap_8_2698 VPWR VGND sg13cmos5l_decap_8
* cell instance sg13cmos5l_decap_8_2699 r0 *1 0,0
Xsg13cmos5l_decap_8_2699 VPWR VGND sg13cmos5l_decap_8
* cell instance sg13cmos5l_decap_8_2700 r0 *1 0,0
Xsg13cmos5l_decap_8_2700 VPWR VGND sg13cmos5l_decap_8
* cell instance sg13cmos5l_decap_8_2701 r0 *1 0,0
Xsg13cmos5l_decap_8_2701 VPWR VGND sg13cmos5l_decap_8
* cell instance sg13cmos5l_decap_8_2702 r0 *1 0,0
Xsg13cmos5l_decap_8_2702 VPWR VGND sg13cmos5l_decap_8
* cell instance sg13cmos5l_decap_8_2703 r0 *1 0,0
Xsg13cmos5l_decap_8_2703 VPWR VGND sg13cmos5l_decap_8
* cell instance sg13cmos5l_decap_8_2704 r0 *1 0,0
Xsg13cmos5l_decap_8_2704 VPWR VGND sg13cmos5l_decap_8
* cell instance sg13cmos5l_decap_8_2705 r0 *1 0,0
Xsg13cmos5l_decap_8_2705 VPWR VGND sg13cmos5l_decap_8
* cell instance sg13cmos5l_decap_8_2706 r0 *1 0,0
Xsg13cmos5l_decap_8_2706 VPWR VGND sg13cmos5l_decap_8
* cell instance sg13cmos5l_decap_8_2707 r0 *1 0,0
Xsg13cmos5l_decap_8_2707 VPWR VGND sg13cmos5l_decap_8
* cell instance sg13cmos5l_decap_8_2708 r0 *1 0,0
Xsg13cmos5l_decap_8_2708 VPWR VGND sg13cmos5l_decap_8
* cell instance sg13cmos5l_decap_8_2709 r0 *1 0,0
Xsg13cmos5l_decap_8_2709 VPWR VGND sg13cmos5l_decap_8
* cell instance sg13cmos5l_decap_8_2710 r0 *1 0,0
Xsg13cmos5l_decap_8_2710 VPWR VGND sg13cmos5l_decap_8
* cell instance sg13cmos5l_decap_8_2711 r0 *1 0,0
Xsg13cmos5l_decap_8_2711 VPWR VGND sg13cmos5l_decap_8
* cell instance sg13cmos5l_decap_8_2712 r0 *1 0,0
Xsg13cmos5l_decap_8_2712 VPWR VGND sg13cmos5l_decap_8
* cell instance sg13cmos5l_decap_8_2713 r0 *1 0,0
Xsg13cmos5l_decap_8_2713 VPWR VGND sg13cmos5l_decap_8
* cell instance sg13cmos5l_decap_8_2714 r0 *1 0,0
Xsg13cmos5l_decap_8_2714 VPWR VGND sg13cmos5l_decap_8
* cell instance sg13cmos5l_decap_8_2715 r0 *1 0,0
Xsg13cmos5l_decap_8_2715 VPWR VGND sg13cmos5l_decap_8
* cell instance sg13cmos5l_decap_8_2716 r0 *1 0,0
Xsg13cmos5l_decap_8_2716 VPWR VGND sg13cmos5l_decap_8
* cell instance sg13cmos5l_decap_8_2717 r0 *1 0,0
Xsg13cmos5l_decap_8_2717 VPWR VGND sg13cmos5l_decap_8
* cell instance sg13cmos5l_decap_8_2718 r0 *1 0,0
Xsg13cmos5l_decap_8_2718 VPWR VGND sg13cmos5l_decap_8
* cell instance sg13cmos5l_decap_8_2719 r0 *1 0,0
Xsg13cmos5l_decap_8_2719 VPWR VGND sg13cmos5l_decap_8
* cell instance sg13cmos5l_decap_8_2720 r0 *1 0,0
Xsg13cmos5l_decap_8_2720 VPWR VGND sg13cmos5l_decap_8
* cell instance sg13cmos5l_decap_8_2721 r0 *1 0,0
Xsg13cmos5l_decap_8_2721 VPWR VGND sg13cmos5l_decap_8
* cell instance sg13cmos5l_decap_8_2722 r0 *1 0,0
Xsg13cmos5l_decap_8_2722 VPWR VGND sg13cmos5l_decap_8
* cell instance sg13cmos5l_decap_8_2723 r0 *1 0,0
Xsg13cmos5l_decap_8_2723 VPWR VGND sg13cmos5l_decap_8
* cell instance sg13cmos5l_decap_8_2724 r0 *1 0,0
Xsg13cmos5l_decap_8_2724 VPWR VGND sg13cmos5l_decap_8
* cell instance sg13cmos5l_decap_8_2725 r0 *1 0,0
Xsg13cmos5l_decap_8_2725 VPWR VGND sg13cmos5l_decap_8
* cell instance sg13cmos5l_decap_8_2726 r0 *1 0,0
Xsg13cmos5l_decap_8_2726 VPWR VGND sg13cmos5l_decap_8
* cell instance sg13cmos5l_decap_8_2727 r0 *1 0,0
Xsg13cmos5l_decap_8_2727 VPWR VGND sg13cmos5l_decap_8
* cell instance sg13cmos5l_decap_8_2728 r0 *1 0,0
Xsg13cmos5l_decap_8_2728 VPWR VGND sg13cmos5l_decap_8
* cell instance sg13cmos5l_decap_8_2729 r0 *1 0,0
Xsg13cmos5l_decap_8_2729 VPWR VGND sg13cmos5l_decap_8
* cell instance sg13cmos5l_decap_8_2730 r0 *1 0,0
Xsg13cmos5l_decap_8_2730 VPWR VGND sg13cmos5l_decap_8
* cell instance sg13cmos5l_decap_8_2731 r0 *1 0,0
Xsg13cmos5l_decap_8_2731 VPWR VGND sg13cmos5l_decap_8
* cell instance sg13cmos5l_decap_8_2732 r0 *1 0,0
Xsg13cmos5l_decap_8_2732 VPWR VGND sg13cmos5l_decap_8
* cell instance sg13cmos5l_decap_8_2733 r0 *1 0,0
Xsg13cmos5l_decap_8_2733 VPWR VGND sg13cmos5l_decap_8
* cell instance sg13cmos5l_decap_8_2734 r0 *1 0,0
Xsg13cmos5l_decap_8_2734 VPWR VGND sg13cmos5l_decap_8
* cell instance sg13cmos5l_decap_8_2735 r0 *1 0,0
Xsg13cmos5l_decap_8_2735 VPWR VGND sg13cmos5l_decap_8
* cell instance sg13cmos5l_decap_8_2736 r0 *1 0,0
Xsg13cmos5l_decap_8_2736 VPWR VGND sg13cmos5l_decap_8
* cell instance sg13cmos5l_decap_8_2737 r0 *1 0,0
Xsg13cmos5l_decap_8_2737 VPWR VGND sg13cmos5l_decap_8
* cell instance sg13cmos5l_decap_8_2738 r0 *1 0,0
Xsg13cmos5l_decap_8_2738 VPWR VGND sg13cmos5l_decap_8
* cell instance sg13cmos5l_decap_8_2739 r0 *1 0,0
Xsg13cmos5l_decap_8_2739 VPWR VGND sg13cmos5l_decap_8
* cell instance sg13cmos5l_decap_8_2740 r0 *1 0,0
Xsg13cmos5l_decap_8_2740 VPWR VGND sg13cmos5l_decap_8
* cell instance sg13cmos5l_decap_8_2741 r0 *1 0,0
Xsg13cmos5l_decap_8_2741 VPWR VGND sg13cmos5l_decap_8
* cell instance sg13cmos5l_decap_8_2742 r0 *1 0,0
Xsg13cmos5l_decap_8_2742 VPWR VGND sg13cmos5l_decap_8
* cell instance sg13cmos5l_decap_8_2743 r0 *1 0,0
Xsg13cmos5l_decap_8_2743 VPWR VGND sg13cmos5l_decap_8
* cell instance sg13cmos5l_decap_8_2744 r0 *1 0,0
Xsg13cmos5l_decap_8_2744 VPWR VGND sg13cmos5l_decap_8
* cell instance sg13cmos5l_decap_8_2745 r0 *1 0,0
Xsg13cmos5l_decap_8_2745 VPWR VGND sg13cmos5l_decap_8
* cell instance sg13cmos5l_decap_8_2746 r0 *1 0,0
Xsg13cmos5l_decap_8_2746 VPWR VGND sg13cmos5l_decap_8
* cell instance sg13cmos5l_decap_8_2747 r0 *1 0,0
Xsg13cmos5l_decap_8_2747 VPWR VGND sg13cmos5l_decap_8
* cell instance sg13cmos5l_decap_8_2748 r0 *1 0,0
Xsg13cmos5l_decap_8_2748 VPWR VGND sg13cmos5l_decap_8
* cell instance sg13cmos5l_decap_8_2749 r0 *1 0,0
Xsg13cmos5l_decap_8_2749 VPWR VGND sg13cmos5l_decap_8
* cell instance sg13cmos5l_decap_8_2750 r0 *1 0,0
Xsg13cmos5l_decap_8_2750 VPWR VGND sg13cmos5l_decap_8
* cell instance sg13cmos5l_decap_8_2751 r0 *1 0,0
Xsg13cmos5l_decap_8_2751 VPWR VGND sg13cmos5l_decap_8
* cell instance sg13cmos5l_decap_8_2752 r0 *1 0,0
Xsg13cmos5l_decap_8_2752 VPWR VGND sg13cmos5l_decap_8
* cell instance sg13cmos5l_decap_8_2753 r0 *1 0,0
Xsg13cmos5l_decap_8_2753 VPWR VGND sg13cmos5l_decap_8
* cell instance sg13cmos5l_decap_8_2754 r0 *1 0,0
Xsg13cmos5l_decap_8_2754 VPWR VGND sg13cmos5l_decap_8
* cell instance sg13cmos5l_decap_8_2755 r0 *1 0,0
Xsg13cmos5l_decap_8_2755 VPWR VGND sg13cmos5l_decap_8
* cell instance sg13cmos5l_decap_8_2756 r0 *1 0,0
Xsg13cmos5l_decap_8_2756 VPWR VGND sg13cmos5l_decap_8
* cell instance sg13cmos5l_decap_8_2757 r0 *1 0,0
Xsg13cmos5l_decap_8_2757 VPWR VGND sg13cmos5l_decap_8
* cell instance sg13cmos5l_decap_8_2758 r0 *1 0,0
Xsg13cmos5l_decap_8_2758 VPWR VGND sg13cmos5l_decap_8
* cell instance sg13cmos5l_decap_8_2759 r0 *1 0,0
Xsg13cmos5l_decap_8_2759 VPWR VGND sg13cmos5l_decap_8
* cell instance sg13cmos5l_decap_8_2760 r0 *1 0,0
Xsg13cmos5l_decap_8_2760 VPWR VGND sg13cmos5l_decap_8
* cell instance sg13cmos5l_decap_8_2761 r0 *1 0,0
Xsg13cmos5l_decap_8_2761 VPWR VGND sg13cmos5l_decap_8
* cell instance sg13cmos5l_decap_8_2762 r0 *1 0,0
Xsg13cmos5l_decap_8_2762 VPWR VGND sg13cmos5l_decap_8
* cell instance sg13cmos5l_decap_8_2763 r0 *1 0,0
Xsg13cmos5l_decap_8_2763 VPWR VGND sg13cmos5l_decap_8
* cell instance sg13cmos5l_decap_8_2764 r0 *1 0,0
Xsg13cmos5l_decap_8_2764 VPWR VGND sg13cmos5l_decap_8
* cell instance sg13cmos5l_decap_8_2765 r0 *1 0,0
Xsg13cmos5l_decap_8_2765 VPWR VGND sg13cmos5l_decap_8
* cell instance sg13cmos5l_decap_8_2766 r0 *1 0,0
Xsg13cmos5l_decap_8_2766 VPWR VGND sg13cmos5l_decap_8
* cell instance sg13cmos5l_decap_8_2767 r0 *1 0,0
Xsg13cmos5l_decap_8_2767 VPWR VGND sg13cmos5l_decap_8
* cell instance sg13cmos5l_decap_8_2768 r0 *1 0,0
Xsg13cmos5l_decap_8_2768 VPWR VGND sg13cmos5l_decap_8
* cell instance sg13cmos5l_decap_8_2769 r0 *1 0,0
Xsg13cmos5l_decap_8_2769 VPWR VGND sg13cmos5l_decap_8
* cell instance sg13cmos5l_decap_8_2770 r0 *1 0,0
Xsg13cmos5l_decap_8_2770 VPWR VGND sg13cmos5l_decap_8
* cell instance sg13cmos5l_decap_8_2771 r0 *1 0,0
Xsg13cmos5l_decap_8_2771 VPWR VGND sg13cmos5l_decap_8
* cell instance sg13cmos5l_decap_8_2772 r0 *1 0,0
Xsg13cmos5l_decap_8_2772 VPWR VGND sg13cmos5l_decap_8
* cell instance sg13cmos5l_decap_8_2773 r0 *1 0,0
Xsg13cmos5l_decap_8_2773 VPWR VGND sg13cmos5l_decap_8
* cell instance sg13cmos5l_decap_8_2774 r0 *1 0,0
Xsg13cmos5l_decap_8_2774 VPWR VGND sg13cmos5l_decap_8
* cell instance sg13cmos5l_decap_8_2775 r0 *1 0,0
Xsg13cmos5l_decap_8_2775 VPWR VGND sg13cmos5l_decap_8
* cell instance sg13cmos5l_decap_8_2776 r0 *1 0,0
Xsg13cmos5l_decap_8_2776 VPWR VGND sg13cmos5l_decap_8
* cell instance sg13cmos5l_decap_8_2777 r0 *1 0,0
Xsg13cmos5l_decap_8_2777 VPWR VGND sg13cmos5l_decap_8
* cell instance sg13cmos5l_decap_8_2778 r0 *1 0,0
Xsg13cmos5l_decap_8_2778 VPWR VGND sg13cmos5l_decap_8
* cell instance sg13cmos5l_decap_8_2779 r0 *1 0,0
Xsg13cmos5l_decap_8_2779 VPWR VGND sg13cmos5l_decap_8
* cell instance sg13cmos5l_decap_8_2780 r0 *1 0,0
Xsg13cmos5l_decap_8_2780 VPWR VGND sg13cmos5l_decap_8
* cell instance sg13cmos5l_decap_8_2781 r0 *1 0,0
Xsg13cmos5l_decap_8_2781 VPWR VGND sg13cmos5l_decap_8
* cell instance sg13cmos5l_decap_8_2782 r0 *1 0,0
Xsg13cmos5l_decap_8_2782 VPWR VGND sg13cmos5l_decap_8
* cell instance sg13cmos5l_decap_8_2783 r0 *1 0,0
Xsg13cmos5l_decap_8_2783 VPWR VGND sg13cmos5l_decap_8
* cell instance sg13cmos5l_decap_8_2784 r0 *1 0,0
Xsg13cmos5l_decap_8_2784 VPWR VGND sg13cmos5l_decap_8
* cell instance sg13cmos5l_decap_8_2785 r0 *1 0,0
Xsg13cmos5l_decap_8_2785 VPWR VGND sg13cmos5l_decap_8
* cell instance sg13cmos5l_decap_8_2786 r0 *1 0,0
Xsg13cmos5l_decap_8_2786 VPWR VGND sg13cmos5l_decap_8
* cell instance sg13cmos5l_decap_8_2787 r0 *1 0,0
Xsg13cmos5l_decap_8_2787 VPWR VGND sg13cmos5l_decap_8
* cell instance sg13cmos5l_decap_8_2788 r0 *1 0,0
Xsg13cmos5l_decap_8_2788 VPWR VGND sg13cmos5l_decap_8
* cell instance sg13cmos5l_decap_8_2789 r0 *1 0,0
Xsg13cmos5l_decap_8_2789 VPWR VGND sg13cmos5l_decap_8
* cell instance sg13cmos5l_decap_8_2790 r0 *1 0,0
Xsg13cmos5l_decap_8_2790 VPWR VGND sg13cmos5l_decap_8
* cell instance sg13cmos5l_decap_8_2791 r0 *1 0,0
Xsg13cmos5l_decap_8_2791 VPWR VGND sg13cmos5l_decap_8
* cell instance sg13cmos5l_decap_8_2792 r0 *1 0,0
Xsg13cmos5l_decap_8_2792 VPWR VGND sg13cmos5l_decap_8
* cell instance sg13cmos5l_decap_8_2793 r0 *1 0,0
Xsg13cmos5l_decap_8_2793 VPWR VGND sg13cmos5l_decap_8
* cell instance sg13cmos5l_decap_8_2794 r0 *1 0,0
Xsg13cmos5l_decap_8_2794 VPWR VGND sg13cmos5l_decap_8
* cell instance sg13cmos5l_decap_8_2795 r0 *1 0,0
Xsg13cmos5l_decap_8_2795 VPWR VGND sg13cmos5l_decap_8
* cell instance sg13cmos5l_decap_8_2796 r0 *1 0,0
Xsg13cmos5l_decap_8_2796 VPWR VGND sg13cmos5l_decap_8
* cell instance sg13cmos5l_decap_8_2797 r0 *1 0,0
Xsg13cmos5l_decap_8_2797 VPWR VGND sg13cmos5l_decap_8
* cell instance sg13cmos5l_decap_8_2798 r0 *1 0,0
Xsg13cmos5l_decap_8_2798 VPWR VGND sg13cmos5l_decap_8
* cell instance sg13cmos5l_decap_8_2799 r0 *1 0,0
Xsg13cmos5l_decap_8_2799 VPWR VGND sg13cmos5l_decap_8
* cell instance sg13cmos5l_decap_8_2800 r0 *1 0,0
Xsg13cmos5l_decap_8_2800 VPWR VGND sg13cmos5l_decap_8
* cell instance sg13cmos5l_decap_8_2801 r0 *1 0,0
Xsg13cmos5l_decap_8_2801 VPWR VGND sg13cmos5l_decap_8
* cell instance sg13cmos5l_decap_8_2802 r0 *1 0,0
Xsg13cmos5l_decap_8_2802 VPWR VGND sg13cmos5l_decap_8
* cell instance sg13cmos5l_decap_8_2803 r0 *1 0,0
Xsg13cmos5l_decap_8_2803 VPWR VGND sg13cmos5l_decap_8
* cell instance sg13cmos5l_decap_8_2804 r0 *1 0,0
Xsg13cmos5l_decap_8_2804 VPWR VGND sg13cmos5l_decap_8
* cell instance sg13cmos5l_decap_8_2805 r0 *1 0,0
Xsg13cmos5l_decap_8_2805 VPWR VGND sg13cmos5l_decap_8
* cell instance sg13cmos5l_decap_8_2806 r0 *1 0,0
Xsg13cmos5l_decap_8_2806 VPWR VGND sg13cmos5l_decap_8
* cell instance sg13cmos5l_decap_8_2807 r0 *1 0,0
Xsg13cmos5l_decap_8_2807 VPWR VGND sg13cmos5l_decap_8
* cell instance sg13cmos5l_decap_8_2808 r0 *1 0,0
Xsg13cmos5l_decap_8_2808 VPWR VGND sg13cmos5l_decap_8
* cell instance sg13cmos5l_decap_8_2809 r0 *1 0,0
Xsg13cmos5l_decap_8_2809 VPWR VGND sg13cmos5l_decap_8
* cell instance sg13cmos5l_decap_8_2810 r0 *1 0,0
Xsg13cmos5l_decap_8_2810 VPWR VGND sg13cmos5l_decap_8
* cell instance sg13cmos5l_decap_8_2811 r0 *1 0,0
Xsg13cmos5l_decap_8_2811 VPWR VGND sg13cmos5l_decap_8
* cell instance sg13cmos5l_decap_8_2812 r0 *1 0,0
Xsg13cmos5l_decap_8_2812 VPWR VGND sg13cmos5l_decap_8
* cell instance sg13cmos5l_decap_8_2813 r0 *1 0,0
Xsg13cmos5l_decap_8_2813 VPWR VGND sg13cmos5l_decap_8
* cell instance sg13cmos5l_decap_8_2814 r0 *1 0,0
Xsg13cmos5l_decap_8_2814 VPWR VGND sg13cmos5l_decap_8
* cell instance sg13cmos5l_decap_8_2815 r0 *1 0,0
Xsg13cmos5l_decap_8_2815 VPWR VGND sg13cmos5l_decap_8
* cell instance sg13cmos5l_decap_8_2816 r0 *1 0,0
Xsg13cmos5l_decap_8_2816 VPWR VGND sg13cmos5l_decap_8
* cell instance sg13cmos5l_decap_8_2817 r0 *1 0,0
Xsg13cmos5l_decap_8_2817 VPWR VGND sg13cmos5l_decap_8
* cell instance sg13cmos5l_decap_8_2818 r0 *1 0,0
Xsg13cmos5l_decap_8_2818 VPWR VGND sg13cmos5l_decap_8
* cell instance sg13cmos5l_decap_8_2819 r0 *1 0,0
Xsg13cmos5l_decap_8_2819 VPWR VGND sg13cmos5l_decap_8
* cell instance sg13cmos5l_decap_8_2820 r0 *1 0,0
Xsg13cmos5l_decap_8_2820 VPWR VGND sg13cmos5l_decap_8
* cell instance sg13cmos5l_decap_8_2821 r0 *1 0,0
Xsg13cmos5l_decap_8_2821 VPWR VGND sg13cmos5l_decap_8
* cell instance sg13cmos5l_decap_8_2822 r0 *1 0,0
Xsg13cmos5l_decap_8_2822 VPWR VGND sg13cmos5l_decap_8
* cell instance sg13cmos5l_decap_8_2823 r0 *1 0,0
Xsg13cmos5l_decap_8_2823 VPWR VGND sg13cmos5l_decap_8
* cell instance sg13cmos5l_decap_8_2824 r0 *1 0,0
Xsg13cmos5l_decap_8_2824 VPWR VGND sg13cmos5l_decap_8
* cell instance sg13cmos5l_decap_8_2825 r0 *1 0,0
Xsg13cmos5l_decap_8_2825 VPWR VGND sg13cmos5l_decap_8
* cell instance sg13cmos5l_decap_8_2826 r0 *1 0,0
Xsg13cmos5l_decap_8_2826 VPWR VGND sg13cmos5l_decap_8
* cell instance sg13cmos5l_decap_8_2827 r0 *1 0,0
Xsg13cmos5l_decap_8_2827 VPWR VGND sg13cmos5l_decap_8
* cell instance sg13cmos5l_decap_8_2828 r0 *1 0,0
Xsg13cmos5l_decap_8_2828 VPWR VGND sg13cmos5l_decap_8
* cell instance sg13cmos5l_decap_8_2829 r0 *1 0,0
Xsg13cmos5l_decap_8_2829 VPWR VGND sg13cmos5l_decap_8
* cell instance sg13cmos5l_decap_8_2830 r0 *1 0,0
Xsg13cmos5l_decap_8_2830 VPWR VGND sg13cmos5l_decap_8
* cell instance sg13cmos5l_decap_8_2831 r0 *1 0,0
Xsg13cmos5l_decap_8_2831 VPWR VGND sg13cmos5l_decap_8
* cell instance sg13cmos5l_decap_8_2832 r0 *1 0,0
Xsg13cmos5l_decap_8_2832 VPWR VGND sg13cmos5l_decap_8
* cell instance sg13cmos5l_decap_8_2833 r0 *1 0,0
Xsg13cmos5l_decap_8_2833 VPWR VGND sg13cmos5l_decap_8
* cell instance sg13cmos5l_decap_8_2834 r0 *1 0,0
Xsg13cmos5l_decap_8_2834 VPWR VGND sg13cmos5l_decap_8
* cell instance sg13cmos5l_decap_8_2835 r0 *1 0,0
Xsg13cmos5l_decap_8_2835 VPWR VGND sg13cmos5l_decap_8
* cell instance sg13cmos5l_decap_8_2836 r0 *1 0,0
Xsg13cmos5l_decap_8_2836 VPWR VGND sg13cmos5l_decap_8
* cell instance sg13cmos5l_decap_8_2837 r0 *1 0,0
Xsg13cmos5l_decap_8_2837 VPWR VGND sg13cmos5l_decap_8
* cell instance sg13cmos5l_decap_8_2838 r0 *1 0,0
Xsg13cmos5l_decap_8_2838 VPWR VGND sg13cmos5l_decap_8
* cell instance sg13cmos5l_decap_8_2839 r0 *1 0,0
Xsg13cmos5l_decap_8_2839 VPWR VGND sg13cmos5l_decap_8
* cell instance sg13cmos5l_decap_8_2840 r0 *1 0,0
Xsg13cmos5l_decap_8_2840 VPWR VGND sg13cmos5l_decap_8
* cell instance sg13cmos5l_decap_8_2841 r0 *1 0,0
Xsg13cmos5l_decap_8_2841 VPWR VGND sg13cmos5l_decap_8
* cell instance sg13cmos5l_decap_8_2842 r0 *1 0,0
Xsg13cmos5l_decap_8_2842 VPWR VGND sg13cmos5l_decap_8
* cell instance sg13cmos5l_decap_8_2843 r0 *1 0,0
Xsg13cmos5l_decap_8_2843 VPWR VGND sg13cmos5l_decap_8
* cell instance sg13cmos5l_decap_8_2844 r0 *1 0,0
Xsg13cmos5l_decap_8_2844 VPWR VGND sg13cmos5l_decap_8
* cell instance sg13cmos5l_decap_8_2845 r0 *1 0,0
Xsg13cmos5l_decap_8_2845 VPWR VGND sg13cmos5l_decap_8
* cell instance sg13cmos5l_decap_8_2846 r0 *1 0,0
Xsg13cmos5l_decap_8_2846 VPWR VGND sg13cmos5l_decap_8
* cell instance sg13cmos5l_decap_8_2847 r0 *1 0,0
Xsg13cmos5l_decap_8_2847 VPWR VGND sg13cmos5l_decap_8
* cell instance sg13cmos5l_decap_8_2848 r0 *1 0,0
Xsg13cmos5l_decap_8_2848 VPWR VGND sg13cmos5l_decap_8
* cell instance sg13cmos5l_decap_8_2849 r0 *1 0,0
Xsg13cmos5l_decap_8_2849 VPWR VGND sg13cmos5l_decap_8
* cell instance sg13cmos5l_decap_8_2850 r0 *1 0,0
Xsg13cmos5l_decap_8_2850 VPWR VGND sg13cmos5l_decap_8
* cell instance sg13cmos5l_decap_8_2851 r0 *1 0,0
Xsg13cmos5l_decap_8_2851 VPWR VGND sg13cmos5l_decap_8
* cell instance sg13cmos5l_decap_8_2852 r0 *1 0,0
Xsg13cmos5l_decap_8_2852 VPWR VGND sg13cmos5l_decap_8
* cell instance sg13cmos5l_decap_8_2853 r0 *1 0,0
Xsg13cmos5l_decap_8_2853 VPWR VGND sg13cmos5l_decap_8
* cell instance sg13cmos5l_decap_8_2854 r0 *1 0,0
Xsg13cmos5l_decap_8_2854 VPWR VGND sg13cmos5l_decap_8
* cell instance sg13cmos5l_decap_8_2855 r0 *1 0,0
Xsg13cmos5l_decap_8_2855 VPWR VGND sg13cmos5l_decap_8
* cell instance sg13cmos5l_decap_8_2856 r0 *1 0,0
Xsg13cmos5l_decap_8_2856 VPWR VGND sg13cmos5l_decap_8
* cell instance sg13cmos5l_decap_8_2857 r0 *1 0,0
Xsg13cmos5l_decap_8_2857 VPWR VGND sg13cmos5l_decap_8
* cell instance sg13cmos5l_decap_8_2858 r0 *1 0,0
Xsg13cmos5l_decap_8_2858 VPWR VGND sg13cmos5l_decap_8
* cell instance sg13cmos5l_decap_8_2859 r0 *1 0,0
Xsg13cmos5l_decap_8_2859 VPWR VGND sg13cmos5l_decap_8
* cell instance sg13cmos5l_decap_8_2860 r0 *1 0,0
Xsg13cmos5l_decap_8_2860 VPWR VGND sg13cmos5l_decap_8
* cell instance sg13cmos5l_decap_8_2861 r0 *1 0,0
Xsg13cmos5l_decap_8_2861 VPWR VGND sg13cmos5l_decap_8
* cell instance sg13cmos5l_decap_8_2862 r0 *1 0,0
Xsg13cmos5l_decap_8_2862 VPWR VGND sg13cmos5l_decap_8
* cell instance sg13cmos5l_decap_8_2863 r0 *1 0,0
Xsg13cmos5l_decap_8_2863 VPWR VGND sg13cmos5l_decap_8
* cell instance sg13cmos5l_decap_8_2864 r0 *1 0,0
Xsg13cmos5l_decap_8_2864 VPWR VGND sg13cmos5l_decap_8
* cell instance sg13cmos5l_decap_8_2865 r0 *1 0,0
Xsg13cmos5l_decap_8_2865 VPWR VGND sg13cmos5l_decap_8
* cell instance sg13cmos5l_decap_8_2866 r0 *1 0,0
Xsg13cmos5l_decap_8_2866 VPWR VGND sg13cmos5l_decap_8
* cell instance sg13cmos5l_decap_8_2867 r0 *1 0,0
Xsg13cmos5l_decap_8_2867 VPWR VGND sg13cmos5l_decap_8
* cell instance sg13cmos5l_decap_8_2868 r0 *1 0,0
Xsg13cmos5l_decap_8_2868 VPWR VGND sg13cmos5l_decap_8
* cell instance sg13cmos5l_decap_8_2869 r0 *1 0,0
Xsg13cmos5l_decap_8_2869 VPWR VGND sg13cmos5l_decap_8
* cell instance sg13cmos5l_decap_8_2870 r0 *1 0,0
Xsg13cmos5l_decap_8_2870 VPWR VGND sg13cmos5l_decap_8
* cell instance sg13cmos5l_decap_8_2871 r0 *1 0,0
Xsg13cmos5l_decap_8_2871 VPWR VGND sg13cmos5l_decap_8
* cell instance sg13cmos5l_decap_8_2872 r0 *1 0,0
Xsg13cmos5l_decap_8_2872 VPWR VGND sg13cmos5l_decap_8
* cell instance sg13cmos5l_decap_8_2873 r0 *1 0,0
Xsg13cmos5l_decap_8_2873 VPWR VGND sg13cmos5l_decap_8
* cell instance sg13cmos5l_decap_8_2874 r0 *1 0,0
Xsg13cmos5l_decap_8_2874 VPWR VGND sg13cmos5l_decap_8
* cell instance sg13cmos5l_decap_8_2875 r0 *1 0,0
Xsg13cmos5l_decap_8_2875 VPWR VGND sg13cmos5l_decap_8
* cell instance sg13cmos5l_decap_8_2876 r0 *1 0,0
Xsg13cmos5l_decap_8_2876 VPWR VGND sg13cmos5l_decap_8
* cell instance sg13cmos5l_decap_8_2877 r0 *1 0,0
Xsg13cmos5l_decap_8_2877 VPWR VGND sg13cmos5l_decap_8
* cell instance sg13cmos5l_decap_8_2878 r0 *1 0,0
Xsg13cmos5l_decap_8_2878 VPWR VGND sg13cmos5l_decap_8
* cell instance sg13cmos5l_decap_8_2879 r0 *1 0,0
Xsg13cmos5l_decap_8_2879 VPWR VGND sg13cmos5l_decap_8
* cell instance sg13cmos5l_decap_8_2880 r0 *1 0,0
Xsg13cmos5l_decap_8_2880 VPWR VGND sg13cmos5l_decap_8
* cell instance sg13cmos5l_decap_8_2881 r0 *1 0,0
Xsg13cmos5l_decap_8_2881 VPWR VGND sg13cmos5l_decap_8
* cell instance sg13cmos5l_decap_8_2882 r0 *1 0,0
Xsg13cmos5l_decap_8_2882 VPWR VGND sg13cmos5l_decap_8
* cell instance sg13cmos5l_decap_8_2883 r0 *1 0,0
Xsg13cmos5l_decap_8_2883 VPWR VGND sg13cmos5l_decap_8
* cell instance sg13cmos5l_decap_8_2884 r0 *1 0,0
Xsg13cmos5l_decap_8_2884 VPWR VGND sg13cmos5l_decap_8
* cell instance sg13cmos5l_decap_8_2885 r0 *1 0,0
Xsg13cmos5l_decap_8_2885 VPWR VGND sg13cmos5l_decap_8
* cell instance sg13cmos5l_decap_8_2886 r0 *1 0,0
Xsg13cmos5l_decap_8_2886 VPWR VGND sg13cmos5l_decap_8
* cell instance sg13cmos5l_decap_8_2887 r0 *1 0,0
Xsg13cmos5l_decap_8_2887 VPWR VGND sg13cmos5l_decap_8
* cell instance sg13cmos5l_decap_8_2888 r0 *1 0,0
Xsg13cmos5l_decap_8_2888 VPWR VGND sg13cmos5l_decap_8
* cell instance sg13cmos5l_decap_8_2889 r0 *1 0,0
Xsg13cmos5l_decap_8_2889 VPWR VGND sg13cmos5l_decap_8
* cell instance sg13cmos5l_decap_8_2890 r0 *1 0,0
Xsg13cmos5l_decap_8_2890 VPWR VGND sg13cmos5l_decap_8
* cell instance sg13cmos5l_decap_8_2891 r0 *1 0,0
Xsg13cmos5l_decap_8_2891 VPWR VGND sg13cmos5l_decap_8
* cell instance sg13cmos5l_decap_8_2892 r0 *1 0,0
Xsg13cmos5l_decap_8_2892 VPWR VGND sg13cmos5l_decap_8
* cell instance sg13cmos5l_decap_8_2893 r0 *1 0,0
Xsg13cmos5l_decap_8_2893 VPWR VGND sg13cmos5l_decap_8
* cell instance sg13cmos5l_decap_8_2894 r0 *1 0,0
Xsg13cmos5l_decap_8_2894 VPWR VGND sg13cmos5l_decap_8
* cell instance sg13cmos5l_decap_8_2895 r0 *1 0,0
Xsg13cmos5l_decap_8_2895 VPWR VGND sg13cmos5l_decap_8
* cell instance sg13cmos5l_decap_8_2896 r0 *1 0,0
Xsg13cmos5l_decap_8_2896 VPWR VGND sg13cmos5l_decap_8
* cell instance sg13cmos5l_decap_8_2897 r0 *1 0,0
Xsg13cmos5l_decap_8_2897 VPWR VGND sg13cmos5l_decap_8
* cell instance sg13cmos5l_decap_8_2898 r0 *1 0,0
Xsg13cmos5l_decap_8_2898 VPWR VGND sg13cmos5l_decap_8
* cell instance sg13cmos5l_decap_8_2899 r0 *1 0,0
Xsg13cmos5l_decap_8_2899 VPWR VGND sg13cmos5l_decap_8
* cell instance sg13cmos5l_decap_8_2900 r0 *1 0,0
Xsg13cmos5l_decap_8_2900 VPWR VGND sg13cmos5l_decap_8
* cell instance sg13cmos5l_decap_8_2901 r0 *1 0,0
Xsg13cmos5l_decap_8_2901 VPWR VGND sg13cmos5l_decap_8
* cell instance sg13cmos5l_decap_8_2902 r0 *1 0,0
Xsg13cmos5l_decap_8_2902 VPWR VGND sg13cmos5l_decap_8
* cell instance sg13cmos5l_decap_8_2903 r0 *1 0,0
Xsg13cmos5l_decap_8_2903 VPWR VGND sg13cmos5l_decap_8
* cell instance sg13cmos5l_decap_8_2904 r0 *1 0,0
Xsg13cmos5l_decap_8_2904 VPWR VGND sg13cmos5l_decap_8
* cell instance sg13cmos5l_decap_8_2905 r0 *1 0,0
Xsg13cmos5l_decap_8_2905 VPWR VGND sg13cmos5l_decap_8
* cell instance sg13cmos5l_decap_8_2906 r0 *1 0,0
Xsg13cmos5l_decap_8_2906 VPWR VGND sg13cmos5l_decap_8
* cell instance sg13cmos5l_decap_8_2907 r0 *1 0,0
Xsg13cmos5l_decap_8_2907 VPWR VGND sg13cmos5l_decap_8
* cell instance sg13cmos5l_decap_8_2908 r0 *1 0,0
Xsg13cmos5l_decap_8_2908 VPWR VGND sg13cmos5l_decap_8
* cell instance sg13cmos5l_decap_8_2909 r0 *1 0,0
Xsg13cmos5l_decap_8_2909 VPWR VGND sg13cmos5l_decap_8
* cell instance sg13cmos5l_decap_8_2910 r0 *1 0,0
Xsg13cmos5l_decap_8_2910 VPWR VGND sg13cmos5l_decap_8
* cell instance sg13cmos5l_decap_8_2911 r0 *1 0,0
Xsg13cmos5l_decap_8_2911 VPWR VGND sg13cmos5l_decap_8
* cell instance sg13cmos5l_decap_8_2912 r0 *1 0,0
Xsg13cmos5l_decap_8_2912 VPWR VGND sg13cmos5l_decap_8
* cell instance sg13cmos5l_decap_8_2913 r0 *1 0,0
Xsg13cmos5l_decap_8_2913 VPWR VGND sg13cmos5l_decap_8
* cell instance sg13cmos5l_decap_8_2914 r0 *1 0,0
Xsg13cmos5l_decap_8_2914 VPWR VGND sg13cmos5l_decap_8
* cell instance sg13cmos5l_decap_8_2915 r0 *1 0,0
Xsg13cmos5l_decap_8_2915 VPWR VGND sg13cmos5l_decap_8
* cell instance sg13cmos5l_decap_8_2916 r0 *1 0,0
Xsg13cmos5l_decap_8_2916 VPWR VGND sg13cmos5l_decap_8
* cell instance sg13cmos5l_decap_8_2917 r0 *1 0,0
Xsg13cmos5l_decap_8_2917 VPWR VGND sg13cmos5l_decap_8
* cell instance sg13cmos5l_decap_8_2918 r0 *1 0,0
Xsg13cmos5l_decap_8_2918 VPWR VGND sg13cmos5l_decap_8
* cell instance sg13cmos5l_decap_8_2919 r0 *1 0,0
Xsg13cmos5l_decap_8_2919 VPWR VGND sg13cmos5l_decap_8
* cell instance sg13cmos5l_decap_8_2920 r0 *1 0,0
Xsg13cmos5l_decap_8_2920 VPWR VGND sg13cmos5l_decap_8
* cell instance sg13cmos5l_decap_8_2921 r0 *1 0,0
Xsg13cmos5l_decap_8_2921 VPWR VGND sg13cmos5l_decap_8
* cell instance sg13cmos5l_decap_8_2922 r0 *1 0,0
Xsg13cmos5l_decap_8_2922 VPWR VGND sg13cmos5l_decap_8
* cell instance sg13cmos5l_decap_8_2923 r0 *1 0,0
Xsg13cmos5l_decap_8_2923 VPWR VGND sg13cmos5l_decap_8
* cell instance sg13cmos5l_decap_8_2924 r0 *1 0,0
Xsg13cmos5l_decap_8_2924 VPWR VGND sg13cmos5l_decap_8
* cell instance sg13cmos5l_decap_8_2925 r0 *1 0,0
Xsg13cmos5l_decap_8_2925 VPWR VGND sg13cmos5l_decap_8
* cell instance sg13cmos5l_decap_8_2926 r0 *1 0,0
Xsg13cmos5l_decap_8_2926 VPWR VGND sg13cmos5l_decap_8
* cell instance sg13cmos5l_decap_8_2927 r0 *1 0,0
Xsg13cmos5l_decap_8_2927 VPWR VGND sg13cmos5l_decap_8
* cell instance sg13cmos5l_decap_8_2928 r0 *1 0,0
Xsg13cmos5l_decap_8_2928 VPWR VGND sg13cmos5l_decap_8
* cell instance sg13cmos5l_decap_8_2929 r0 *1 0,0
Xsg13cmos5l_decap_8_2929 VPWR VGND sg13cmos5l_decap_8
* cell instance sg13cmos5l_decap_8_2930 r0 *1 0,0
Xsg13cmos5l_decap_8_2930 VPWR VGND sg13cmos5l_decap_8
* cell instance sg13cmos5l_decap_8_2931 r0 *1 0,0
Xsg13cmos5l_decap_8_2931 VPWR VGND sg13cmos5l_decap_8
* cell instance sg13cmos5l_decap_8_2932 r0 *1 0,0
Xsg13cmos5l_decap_8_2932 VPWR VGND sg13cmos5l_decap_8
* cell instance sg13cmos5l_decap_8_2933 r0 *1 0,0
Xsg13cmos5l_decap_8_2933 VPWR VGND sg13cmos5l_decap_8
* cell instance sg13cmos5l_decap_8_2934 r0 *1 0,0
Xsg13cmos5l_decap_8_2934 VPWR VGND sg13cmos5l_decap_8
* cell instance sg13cmos5l_decap_8_2935 r0 *1 0,0
Xsg13cmos5l_decap_8_2935 VPWR VGND sg13cmos5l_decap_8
* cell instance sg13cmos5l_decap_8_2936 r0 *1 0,0
Xsg13cmos5l_decap_8_2936 VPWR VGND sg13cmos5l_decap_8
* cell instance sg13cmos5l_decap_8_2937 r0 *1 0,0
Xsg13cmos5l_decap_8_2937 VPWR VGND sg13cmos5l_decap_8
* cell instance sg13cmos5l_decap_8_2938 r0 *1 0,0
Xsg13cmos5l_decap_8_2938 VPWR VGND sg13cmos5l_decap_8
* cell instance sg13cmos5l_decap_8_2939 r0 *1 0,0
Xsg13cmos5l_decap_8_2939 VPWR VGND sg13cmos5l_decap_8
* cell instance sg13cmos5l_decap_8_2940 r0 *1 0,0
Xsg13cmos5l_decap_8_2940 VPWR VGND sg13cmos5l_decap_8
* cell instance sg13cmos5l_decap_8_2941 r0 *1 0,0
Xsg13cmos5l_decap_8_2941 VPWR VGND sg13cmos5l_decap_8
* cell instance sg13cmos5l_decap_8_2942 r0 *1 0,0
Xsg13cmos5l_decap_8_2942 VPWR VGND sg13cmos5l_decap_8
* cell instance sg13cmos5l_decap_8_2943 r0 *1 0,0
Xsg13cmos5l_decap_8_2943 VPWR VGND sg13cmos5l_decap_8
* cell instance sg13cmos5l_decap_8_2944 r0 *1 0,0
Xsg13cmos5l_decap_8_2944 VPWR VGND sg13cmos5l_decap_8
* cell instance sg13cmos5l_decap_8_2945 r0 *1 0,0
Xsg13cmos5l_decap_8_2945 VPWR VGND sg13cmos5l_decap_8
* cell instance sg13cmos5l_decap_8_2946 r0 *1 0,0
Xsg13cmos5l_decap_8_2946 VPWR VGND sg13cmos5l_decap_8
* cell instance sg13cmos5l_decap_8_2947 r0 *1 0,0
Xsg13cmos5l_decap_8_2947 VPWR VGND sg13cmos5l_decap_8
* cell instance sg13cmos5l_decap_8_2948 r0 *1 0,0
Xsg13cmos5l_decap_8_2948 VPWR VGND sg13cmos5l_decap_8
* cell instance sg13cmos5l_decap_8_2949 r0 *1 0,0
Xsg13cmos5l_decap_8_2949 VPWR VGND sg13cmos5l_decap_8
* cell instance sg13cmos5l_decap_8_2950 r0 *1 0,0
Xsg13cmos5l_decap_8_2950 VPWR VGND sg13cmos5l_decap_8
* cell instance sg13cmos5l_decap_8_2951 r0 *1 0,0
Xsg13cmos5l_decap_8_2951 VPWR VGND sg13cmos5l_decap_8
* cell instance sg13cmos5l_decap_8_2952 r0 *1 0,0
Xsg13cmos5l_decap_8_2952 VPWR VGND sg13cmos5l_decap_8
* cell instance sg13cmos5l_decap_8_2953 r0 *1 0,0
Xsg13cmos5l_decap_8_2953 VPWR VGND sg13cmos5l_decap_8
* cell instance sg13cmos5l_decap_8_2954 r0 *1 0,0
Xsg13cmos5l_decap_8_2954 VPWR VGND sg13cmos5l_decap_8
* cell instance sg13cmos5l_decap_8_2955 r0 *1 0,0
Xsg13cmos5l_decap_8_2955 VPWR VGND sg13cmos5l_decap_8
* cell instance sg13cmos5l_decap_8_2956 r0 *1 0,0
Xsg13cmos5l_decap_8_2956 VPWR VGND sg13cmos5l_decap_8
* cell instance sg13cmos5l_decap_8_2957 r0 *1 0,0
Xsg13cmos5l_decap_8_2957 VPWR VGND sg13cmos5l_decap_8
* cell instance sg13cmos5l_decap_8_2958 r0 *1 0,0
Xsg13cmos5l_decap_8_2958 VPWR VGND sg13cmos5l_decap_8
* cell instance sg13cmos5l_decap_8_2959 r0 *1 0,0
Xsg13cmos5l_decap_8_2959 VPWR VGND sg13cmos5l_decap_8
* cell instance sg13cmos5l_decap_8_2960 r0 *1 0,0
Xsg13cmos5l_decap_8_2960 VPWR VGND sg13cmos5l_decap_8
* cell instance sg13cmos5l_decap_8_2961 r0 *1 0,0
Xsg13cmos5l_decap_8_2961 VPWR VGND sg13cmos5l_decap_8
* cell instance sg13cmos5l_decap_8_2962 r0 *1 0,0
Xsg13cmos5l_decap_8_2962 VPWR VGND sg13cmos5l_decap_8
* cell instance sg13cmos5l_decap_8_2963 r0 *1 0,0
Xsg13cmos5l_decap_8_2963 VPWR VGND sg13cmos5l_decap_8
* cell instance sg13cmos5l_decap_8_2964 r0 *1 0,0
Xsg13cmos5l_decap_8_2964 VPWR VGND sg13cmos5l_decap_8
* cell instance sg13cmos5l_decap_8_2965 r0 *1 0,0
Xsg13cmos5l_decap_8_2965 VPWR VGND sg13cmos5l_decap_8
* cell instance sg13cmos5l_decap_8_2966 r0 *1 0,0
Xsg13cmos5l_decap_8_2966 VPWR VGND sg13cmos5l_decap_8
* cell instance sg13cmos5l_decap_8_2967 r0 *1 0,0
Xsg13cmos5l_decap_8_2967 VPWR VGND sg13cmos5l_decap_8
* cell instance sg13cmos5l_decap_8_2968 r0 *1 0,0
Xsg13cmos5l_decap_8_2968 VPWR VGND sg13cmos5l_decap_8
* cell instance sg13cmos5l_decap_8_2969 r0 *1 0,0
Xsg13cmos5l_decap_8_2969 VPWR VGND sg13cmos5l_decap_8
* cell instance sg13cmos5l_decap_8_2970 r0 *1 0,0
Xsg13cmos5l_decap_8_2970 VPWR VGND sg13cmos5l_decap_8
* cell instance sg13cmos5l_decap_8_2971 r0 *1 0,0
Xsg13cmos5l_decap_8_2971 VPWR VGND sg13cmos5l_decap_8
* cell instance sg13cmos5l_decap_8_2972 r0 *1 0,0
Xsg13cmos5l_decap_8_2972 VPWR VGND sg13cmos5l_decap_8
* cell instance sg13cmos5l_decap_8_2973 r0 *1 0,0
Xsg13cmos5l_decap_8_2973 VPWR VGND sg13cmos5l_decap_8
* cell instance sg13cmos5l_decap_8_2974 r0 *1 0,0
Xsg13cmos5l_decap_8_2974 VPWR VGND sg13cmos5l_decap_8
* cell instance sg13cmos5l_decap_8_2975 r0 *1 0,0
Xsg13cmos5l_decap_8_2975 VPWR VGND sg13cmos5l_decap_8
* cell instance sg13cmos5l_decap_8_2976 r0 *1 0,0
Xsg13cmos5l_decap_8_2976 VPWR VGND sg13cmos5l_decap_8
* cell instance sg13cmos5l_decap_8_2977 r0 *1 0,0
Xsg13cmos5l_decap_8_2977 VPWR VGND sg13cmos5l_decap_8
* cell instance sg13cmos5l_decap_8_2978 r0 *1 0,0
Xsg13cmos5l_decap_8_2978 VPWR VGND sg13cmos5l_decap_8
* cell instance sg13cmos5l_decap_8_2979 r0 *1 0,0
Xsg13cmos5l_decap_8_2979 VPWR VGND sg13cmos5l_decap_8
* cell instance sg13cmos5l_decap_8_2980 r0 *1 0,0
Xsg13cmos5l_decap_8_2980 VPWR VGND sg13cmos5l_decap_8
* cell instance sg13cmos5l_decap_8_2981 r0 *1 0,0
Xsg13cmos5l_decap_8_2981 VPWR VGND sg13cmos5l_decap_8
* cell instance sg13cmos5l_decap_8_2982 r0 *1 0,0
Xsg13cmos5l_decap_8_2982 VPWR VGND sg13cmos5l_decap_8
* cell instance sg13cmos5l_decap_8_2983 r0 *1 0,0
Xsg13cmos5l_decap_8_2983 VPWR VGND sg13cmos5l_decap_8
* cell instance sg13cmos5l_decap_8_2984 r0 *1 0,0
Xsg13cmos5l_decap_8_2984 VPWR VGND sg13cmos5l_decap_8
* cell instance sg13cmos5l_decap_8_2985 r0 *1 0,0
Xsg13cmos5l_decap_8_2985 VPWR VGND sg13cmos5l_decap_8
* cell instance sg13cmos5l_decap_8_2986 r0 *1 0,0
Xsg13cmos5l_decap_8_2986 VPWR VGND sg13cmos5l_decap_8
* cell instance sg13cmos5l_decap_8_2987 r0 *1 0,0
Xsg13cmos5l_decap_8_2987 VPWR VGND sg13cmos5l_decap_8
* cell instance sg13cmos5l_decap_8_2988 r0 *1 0,0
Xsg13cmos5l_decap_8_2988 VPWR VGND sg13cmos5l_decap_8
* cell instance sg13cmos5l_decap_8_2989 r0 *1 0,0
Xsg13cmos5l_decap_8_2989 VPWR VGND sg13cmos5l_decap_8
* cell instance sg13cmos5l_decap_8_2990 r0 *1 0,0
Xsg13cmos5l_decap_8_2990 VPWR VGND sg13cmos5l_decap_8
* cell instance sg13cmos5l_decap_8_2991 r0 *1 0,0
Xsg13cmos5l_decap_8_2991 VPWR VGND sg13cmos5l_decap_8
* cell instance sg13cmos5l_decap_8_2992 r0 *1 0,0
Xsg13cmos5l_decap_8_2992 VPWR VGND sg13cmos5l_decap_8
* cell instance sg13cmos5l_decap_8_2993 r0 *1 0,0
Xsg13cmos5l_decap_8_2993 VPWR VGND sg13cmos5l_decap_8
* cell instance sg13cmos5l_decap_8_2994 r0 *1 0,0
Xsg13cmos5l_decap_8_2994 VPWR VGND sg13cmos5l_decap_8
* cell instance sg13cmos5l_decap_8_2995 r0 *1 0,0
Xsg13cmos5l_decap_8_2995 VPWR VGND sg13cmos5l_decap_8
* cell instance sg13cmos5l_decap_8_2996 r0 *1 0,0
Xsg13cmos5l_decap_8_2996 VPWR VGND sg13cmos5l_decap_8
* cell instance sg13cmos5l_decap_8_2997 r0 *1 0,0
Xsg13cmos5l_decap_8_2997 VPWR VGND sg13cmos5l_decap_8
* cell instance sg13cmos5l_decap_8_2998 r0 *1 0,0
Xsg13cmos5l_decap_8_2998 VPWR VGND sg13cmos5l_decap_8
* cell instance sg13cmos5l_decap_8_2999 r0 *1 0,0
Xsg13cmos5l_decap_8_2999 VPWR VGND sg13cmos5l_decap_8
* cell instance sg13cmos5l_decap_8_3000 r0 *1 0,0
Xsg13cmos5l_decap_8_3000 VPWR VGND sg13cmos5l_decap_8
* cell instance sg13cmos5l_decap_8_3001 r0 *1 0,0
Xsg13cmos5l_decap_8_3001 VPWR VGND sg13cmos5l_decap_8
* cell instance sg13cmos5l_decap_8_3002 r0 *1 0,0
Xsg13cmos5l_decap_8_3002 VPWR VGND sg13cmos5l_decap_8
* cell instance sg13cmos5l_decap_8_3003 r0 *1 0,0
Xsg13cmos5l_decap_8_3003 VPWR VGND sg13cmos5l_decap_8
* cell instance sg13cmos5l_decap_8_3004 r0 *1 0,0
Xsg13cmos5l_decap_8_3004 VPWR VGND sg13cmos5l_decap_8
* cell instance sg13cmos5l_decap_8_3005 r0 *1 0,0
Xsg13cmos5l_decap_8_3005 VPWR VGND sg13cmos5l_decap_8
* cell instance sg13cmos5l_decap_8_3006 r0 *1 0,0
Xsg13cmos5l_decap_8_3006 VPWR VGND sg13cmos5l_decap_8
* cell instance sg13cmos5l_decap_8_3007 r0 *1 0,0
Xsg13cmos5l_decap_8_3007 VPWR VGND sg13cmos5l_decap_8
* cell instance sg13cmos5l_decap_8_3008 r0 *1 0,0
Xsg13cmos5l_decap_8_3008 VPWR VGND sg13cmos5l_decap_8
* cell instance sg13cmos5l_decap_8_3009 r0 *1 0,0
Xsg13cmos5l_decap_8_3009 VPWR VGND sg13cmos5l_decap_8
* cell instance sg13cmos5l_decap_8_3010 r0 *1 0,0
Xsg13cmos5l_decap_8_3010 VPWR VGND sg13cmos5l_decap_8
* cell instance sg13cmos5l_decap_8_3011 r0 *1 0,0
Xsg13cmos5l_decap_8_3011 VPWR VGND sg13cmos5l_decap_8
* cell instance sg13cmos5l_decap_8_3012 r0 *1 0,0
Xsg13cmos5l_decap_8_3012 VPWR VGND sg13cmos5l_decap_8
* cell instance sg13cmos5l_decap_8_3013 r0 *1 0,0
Xsg13cmos5l_decap_8_3013 VPWR VGND sg13cmos5l_decap_8
* cell instance sg13cmos5l_decap_8_3014 r0 *1 0,0
Xsg13cmos5l_decap_8_3014 VPWR VGND sg13cmos5l_decap_8
* cell instance sg13cmos5l_decap_8_3015 r0 *1 0,0
Xsg13cmos5l_decap_8_3015 VPWR VGND sg13cmos5l_decap_8
* cell instance sg13cmos5l_decap_8_3016 r0 *1 0,0
Xsg13cmos5l_decap_8_3016 VPWR VGND sg13cmos5l_decap_8
* cell instance sg13cmos5l_decap_8_3017 r0 *1 0,0
Xsg13cmos5l_decap_8_3017 VPWR VGND sg13cmos5l_decap_8
* cell instance sg13cmos5l_decap_8_3018 r0 *1 0,0
Xsg13cmos5l_decap_8_3018 VPWR VGND sg13cmos5l_decap_8
* cell instance sg13cmos5l_decap_8_3019 r0 *1 0,0
Xsg13cmos5l_decap_8_3019 VPWR VGND sg13cmos5l_decap_8
* cell instance sg13cmos5l_decap_8_3020 r0 *1 0,0
Xsg13cmos5l_decap_8_3020 VPWR VGND sg13cmos5l_decap_8
* cell instance sg13cmos5l_decap_8_3021 r0 *1 0,0
Xsg13cmos5l_decap_8_3021 VPWR VGND sg13cmos5l_decap_8
* cell instance sg13cmos5l_decap_8_3022 r0 *1 0,0
Xsg13cmos5l_decap_8_3022 VPWR VGND sg13cmos5l_decap_8
* cell instance sg13cmos5l_decap_8_3023 r0 *1 0,0
Xsg13cmos5l_decap_8_3023 VPWR VGND sg13cmos5l_decap_8
* cell instance sg13cmos5l_decap_8_3024 r0 *1 0,0
Xsg13cmos5l_decap_8_3024 VPWR VGND sg13cmos5l_decap_8
* cell instance sg13cmos5l_decap_8_3025 r0 *1 0,0
Xsg13cmos5l_decap_8_3025 VPWR VGND sg13cmos5l_decap_8
* cell instance sg13cmos5l_decap_8_3026 r0 *1 0,0
Xsg13cmos5l_decap_8_3026 VPWR VGND sg13cmos5l_decap_8
* cell instance sg13cmos5l_decap_8_3027 r0 *1 0,0
Xsg13cmos5l_decap_8_3027 VPWR VGND sg13cmos5l_decap_8
* cell instance sg13cmos5l_decap_8_3028 r0 *1 0,0
Xsg13cmos5l_decap_8_3028 VPWR VGND sg13cmos5l_decap_8
* cell instance sg13cmos5l_decap_8_3029 r0 *1 0,0
Xsg13cmos5l_decap_8_3029 VPWR VGND sg13cmos5l_decap_8
* cell instance sg13cmos5l_decap_8_3030 r0 *1 0,0
Xsg13cmos5l_decap_8_3030 VPWR VGND sg13cmos5l_decap_8
* cell instance sg13cmos5l_decap_8_3031 r0 *1 0,0
Xsg13cmos5l_decap_8_3031 VPWR VGND sg13cmos5l_decap_8
* cell instance sg13cmos5l_decap_8_3032 r0 *1 0,0
Xsg13cmos5l_decap_8_3032 VPWR VGND sg13cmos5l_decap_8
* cell instance sg13cmos5l_decap_8_3033 r0 *1 0,0
Xsg13cmos5l_decap_8_3033 VPWR VGND sg13cmos5l_decap_8
* cell instance sg13cmos5l_decap_8_3034 r0 *1 0,0
Xsg13cmos5l_decap_8_3034 VPWR VGND sg13cmos5l_decap_8
* cell instance sg13cmos5l_decap_8_3035 r0 *1 0,0
Xsg13cmos5l_decap_8_3035 VPWR VGND sg13cmos5l_decap_8
* cell instance sg13cmos5l_decap_8_3036 r0 *1 0,0
Xsg13cmos5l_decap_8_3036 VPWR VGND sg13cmos5l_decap_8
* cell instance sg13cmos5l_decap_8_3037 r0 *1 0,0
Xsg13cmos5l_decap_8_3037 VPWR VGND sg13cmos5l_decap_8
* cell instance sg13cmos5l_decap_8_3038 r0 *1 0,0
Xsg13cmos5l_decap_8_3038 VPWR VGND sg13cmos5l_decap_8
* cell instance sg13cmos5l_decap_8_3039 r0 *1 0,0
Xsg13cmos5l_decap_8_3039 VPWR VGND sg13cmos5l_decap_8
* cell instance sg13cmos5l_decap_8_3040 r0 *1 0,0
Xsg13cmos5l_decap_8_3040 VPWR VGND sg13cmos5l_decap_8
* cell instance sg13cmos5l_decap_8_3041 r0 *1 0,0
Xsg13cmos5l_decap_8_3041 VPWR VGND sg13cmos5l_decap_8
* cell instance sg13cmos5l_decap_8_3042 r0 *1 0,0
Xsg13cmos5l_decap_8_3042 VPWR VGND sg13cmos5l_decap_8
* cell instance sg13cmos5l_decap_8_3043 r0 *1 0,0
Xsg13cmos5l_decap_8_3043 VPWR VGND sg13cmos5l_decap_8
* cell instance sg13cmos5l_decap_8_3044 r0 *1 0,0
Xsg13cmos5l_decap_8_3044 VPWR VGND sg13cmos5l_decap_8
* cell instance sg13cmos5l_decap_8_3045 r0 *1 0,0
Xsg13cmos5l_decap_8_3045 VPWR VGND sg13cmos5l_decap_8
* cell instance sg13cmos5l_decap_8_3046 r0 *1 0,0
Xsg13cmos5l_decap_8_3046 VPWR VGND sg13cmos5l_decap_8
* cell instance sg13cmos5l_decap_8_3047 r0 *1 0,0
Xsg13cmos5l_decap_8_3047 VPWR VGND sg13cmos5l_decap_8
* cell instance sg13cmos5l_decap_8_3048 r0 *1 0,0
Xsg13cmos5l_decap_8_3048 VPWR VGND sg13cmos5l_decap_8
* cell instance sg13cmos5l_decap_8_3049 r0 *1 0,0
Xsg13cmos5l_decap_8_3049 VPWR VGND sg13cmos5l_decap_8
* cell instance sg13cmos5l_decap_8_3050 r0 *1 0,0
Xsg13cmos5l_decap_8_3050 VPWR VGND sg13cmos5l_decap_8
* cell instance sg13cmos5l_decap_8_3051 r0 *1 0,0
Xsg13cmos5l_decap_8_3051 VPWR VGND sg13cmos5l_decap_8
* cell instance sg13cmos5l_decap_8_3052 r0 *1 0,0
Xsg13cmos5l_decap_8_3052 VPWR VGND sg13cmos5l_decap_8
* cell instance sg13cmos5l_decap_8_3053 r0 *1 0,0
Xsg13cmos5l_decap_8_3053 VPWR VGND sg13cmos5l_decap_8
* cell instance sg13cmos5l_decap_8_3054 r0 *1 0,0
Xsg13cmos5l_decap_8_3054 VPWR VGND sg13cmos5l_decap_8
* cell instance sg13cmos5l_decap_8_3055 r0 *1 0,0
Xsg13cmos5l_decap_8_3055 VPWR VGND sg13cmos5l_decap_8
* cell instance sg13cmos5l_decap_8_3056 r0 *1 0,0
Xsg13cmos5l_decap_8_3056 VPWR VGND sg13cmos5l_decap_8
* cell instance sg13cmos5l_decap_8_3057 r0 *1 0,0
Xsg13cmos5l_decap_8_3057 VPWR VGND sg13cmos5l_decap_8
* cell instance sg13cmos5l_decap_8_3058 r0 *1 0,0
Xsg13cmos5l_decap_8_3058 VPWR VGND sg13cmos5l_decap_8
* cell instance sg13cmos5l_decap_8_3059 r0 *1 0,0
Xsg13cmos5l_decap_8_3059 VPWR VGND sg13cmos5l_decap_8
* cell instance sg13cmos5l_decap_8_3060 r0 *1 0,0
Xsg13cmos5l_decap_8_3060 VPWR VGND sg13cmos5l_decap_8
* cell instance sg13cmos5l_decap_8_3061 r0 *1 0,0
Xsg13cmos5l_decap_8_3061 VPWR VGND sg13cmos5l_decap_8
* cell instance sg13cmos5l_decap_8_3062 r0 *1 0,0
Xsg13cmos5l_decap_8_3062 VPWR VGND sg13cmos5l_decap_8
* cell instance sg13cmos5l_decap_8_3063 r0 *1 0,0
Xsg13cmos5l_decap_8_3063 VPWR VGND sg13cmos5l_decap_8
* cell instance sg13cmos5l_decap_8_3064 r0 *1 0,0
Xsg13cmos5l_decap_8_3064 VPWR VGND sg13cmos5l_decap_8
* cell instance sg13cmos5l_decap_8_3065 r0 *1 0,0
Xsg13cmos5l_decap_8_3065 VPWR VGND sg13cmos5l_decap_8
* cell instance sg13cmos5l_decap_8_3066 r0 *1 0,0
Xsg13cmos5l_decap_8_3066 VPWR VGND sg13cmos5l_decap_8
* cell instance sg13cmos5l_decap_8_3067 r0 *1 0,0
Xsg13cmos5l_decap_8_3067 VPWR VGND sg13cmos5l_decap_8
* cell instance sg13cmos5l_decap_8_3068 r0 *1 0,0
Xsg13cmos5l_decap_8_3068 VPWR VGND sg13cmos5l_decap_8
* cell instance sg13cmos5l_decap_8_3069 r0 *1 0,0
Xsg13cmos5l_decap_8_3069 VPWR VGND sg13cmos5l_decap_8
* cell instance sg13cmos5l_decap_8_3070 r0 *1 0,0
Xsg13cmos5l_decap_8_3070 VPWR VGND sg13cmos5l_decap_8
* cell instance sg13cmos5l_decap_8_3071 r0 *1 0,0
Xsg13cmos5l_decap_8_3071 VPWR VGND sg13cmos5l_decap_8
* cell instance sg13cmos5l_decap_8_3072 r0 *1 0,0
Xsg13cmos5l_decap_8_3072 VPWR VGND sg13cmos5l_decap_8
* cell instance sg13cmos5l_decap_8_3073 r0 *1 0,0
Xsg13cmos5l_decap_8_3073 VPWR VGND sg13cmos5l_decap_8
* cell instance sg13cmos5l_decap_8_3074 r0 *1 0,0
Xsg13cmos5l_decap_8_3074 VPWR VGND sg13cmos5l_decap_8
* cell instance sg13cmos5l_decap_8_3075 r0 *1 0,0
Xsg13cmos5l_decap_8_3075 VPWR VGND sg13cmos5l_decap_8
* cell instance sg13cmos5l_decap_8_3076 r0 *1 0,0
Xsg13cmos5l_decap_8_3076 VPWR VGND sg13cmos5l_decap_8
* cell instance sg13cmos5l_decap_8_3077 r0 *1 0,0
Xsg13cmos5l_decap_8_3077 VPWR VGND sg13cmos5l_decap_8
* cell instance sg13cmos5l_decap_8_3078 r0 *1 0,0
Xsg13cmos5l_decap_8_3078 VPWR VGND sg13cmos5l_decap_8
* cell instance sg13cmos5l_decap_8_3079 r0 *1 0,0
Xsg13cmos5l_decap_8_3079 VPWR VGND sg13cmos5l_decap_8
* cell instance sg13cmos5l_decap_8_3080 r0 *1 0,0
Xsg13cmos5l_decap_8_3080 VPWR VGND sg13cmos5l_decap_8
* cell instance sg13cmos5l_decap_8_3081 r0 *1 0,0
Xsg13cmos5l_decap_8_3081 VPWR VGND sg13cmos5l_decap_8
* cell instance sg13cmos5l_decap_8_3082 r0 *1 0,0
Xsg13cmos5l_decap_8_3082 VPWR VGND sg13cmos5l_decap_8
* cell instance sg13cmos5l_decap_8_3083 r0 *1 0,0
Xsg13cmos5l_decap_8_3083 VPWR VGND sg13cmos5l_decap_8
* cell instance sg13cmos5l_decap_8_3084 r0 *1 0,0
Xsg13cmos5l_decap_8_3084 VPWR VGND sg13cmos5l_decap_8
* cell instance sg13cmos5l_decap_8_3085 r0 *1 0,0
Xsg13cmos5l_decap_8_3085 VPWR VGND sg13cmos5l_decap_8
* cell instance sg13cmos5l_decap_8_3086 r0 *1 0,0
Xsg13cmos5l_decap_8_3086 VPWR VGND sg13cmos5l_decap_8
* cell instance sg13cmos5l_decap_8_3087 r0 *1 0,0
Xsg13cmos5l_decap_8_3087 VPWR VGND sg13cmos5l_decap_8
* cell instance sg13cmos5l_decap_8_3088 r0 *1 0,0
Xsg13cmos5l_decap_8_3088 VPWR VGND sg13cmos5l_decap_8
* cell instance sg13cmos5l_decap_8_3089 r0 *1 0,0
Xsg13cmos5l_decap_8_3089 VPWR VGND sg13cmos5l_decap_8
* cell instance sg13cmos5l_decap_8_3090 r0 *1 0,0
Xsg13cmos5l_decap_8_3090 VPWR VGND sg13cmos5l_decap_8
* cell instance sg13cmos5l_decap_8_3091 r0 *1 0,0
Xsg13cmos5l_decap_8_3091 VPWR VGND sg13cmos5l_decap_8
* cell instance sg13cmos5l_decap_8_3092 r0 *1 0,0
Xsg13cmos5l_decap_8_3092 VPWR VGND sg13cmos5l_decap_8
* cell instance sg13cmos5l_decap_8_3093 r0 *1 0,0
Xsg13cmos5l_decap_8_3093 VPWR VGND sg13cmos5l_decap_8
* cell instance sg13cmos5l_decap_8_3094 r0 *1 0,0
Xsg13cmos5l_decap_8_3094 VPWR VGND sg13cmos5l_decap_8
* cell instance sg13cmos5l_decap_8_3095 r0 *1 0,0
Xsg13cmos5l_decap_8_3095 VPWR VGND sg13cmos5l_decap_8
* cell instance sg13cmos5l_decap_8_3096 r0 *1 0,0
Xsg13cmos5l_decap_8_3096 VPWR VGND sg13cmos5l_decap_8
* cell instance sg13cmos5l_decap_8_3097 r0 *1 0,0
Xsg13cmos5l_decap_8_3097 VPWR VGND sg13cmos5l_decap_8
* cell instance sg13cmos5l_decap_8_3098 r0 *1 0,0
Xsg13cmos5l_decap_8_3098 VPWR VGND sg13cmos5l_decap_8
* cell instance sg13cmos5l_decap_8_3099 r0 *1 0,0
Xsg13cmos5l_decap_8_3099 VPWR VGND sg13cmos5l_decap_8
* cell instance sg13cmos5l_decap_8_3100 r0 *1 0,0
Xsg13cmos5l_decap_8_3100 VPWR VGND sg13cmos5l_decap_8
* cell instance sg13cmos5l_decap_8_3101 r0 *1 0,0
Xsg13cmos5l_decap_8_3101 VPWR VGND sg13cmos5l_decap_8
* cell instance sg13cmos5l_decap_8_3102 r0 *1 0,0
Xsg13cmos5l_decap_8_3102 VPWR VGND sg13cmos5l_decap_8
* cell instance sg13cmos5l_decap_8_3103 r0 *1 0,0
Xsg13cmos5l_decap_8_3103 VPWR VGND sg13cmos5l_decap_8
* cell instance sg13cmos5l_decap_8_3104 r0 *1 0,0
Xsg13cmos5l_decap_8_3104 VPWR VGND sg13cmos5l_decap_8
* cell instance sg13cmos5l_decap_8_3105 r0 *1 0,0
Xsg13cmos5l_decap_8_3105 VPWR VGND sg13cmos5l_decap_8
* cell instance sg13cmos5l_decap_8_3106 r0 *1 0,0
Xsg13cmos5l_decap_8_3106 VPWR VGND sg13cmos5l_decap_8
* cell instance sg13cmos5l_decap_8_3107 r0 *1 0,0
Xsg13cmos5l_decap_8_3107 VPWR VGND sg13cmos5l_decap_8
* cell instance sg13cmos5l_decap_8_3108 r0 *1 0,0
Xsg13cmos5l_decap_8_3108 VPWR VGND sg13cmos5l_decap_8
* cell instance sg13cmos5l_decap_8_3109 r0 *1 0,0
Xsg13cmos5l_decap_8_3109 VPWR VGND sg13cmos5l_decap_8
* cell instance sg13cmos5l_decap_8_3110 r0 *1 0,0
Xsg13cmos5l_decap_8_3110 VPWR VGND sg13cmos5l_decap_8
* cell instance sg13cmos5l_decap_8_3111 r0 *1 0,0
Xsg13cmos5l_decap_8_3111 VPWR VGND sg13cmos5l_decap_8
* cell instance sg13cmos5l_decap_8_3112 r0 *1 0,0
Xsg13cmos5l_decap_8_3112 VPWR VGND sg13cmos5l_decap_8
* cell instance sg13cmos5l_decap_8_3113 r0 *1 0,0
Xsg13cmos5l_decap_8_3113 VPWR VGND sg13cmos5l_decap_8
* cell instance sg13cmos5l_decap_8_3114 r0 *1 0,0
Xsg13cmos5l_decap_8_3114 VPWR VGND sg13cmos5l_decap_8
* cell instance sg13cmos5l_decap_8_3115 r0 *1 0,0
Xsg13cmos5l_decap_8_3115 VPWR VGND sg13cmos5l_decap_8
* cell instance sg13cmos5l_decap_8_3116 r0 *1 0,0
Xsg13cmos5l_decap_8_3116 VPWR VGND sg13cmos5l_decap_8
* cell instance sg13cmos5l_decap_8_3117 r0 *1 0,0
Xsg13cmos5l_decap_8_3117 VPWR VGND sg13cmos5l_decap_8
* cell instance sg13cmos5l_decap_8_3118 r0 *1 0,0
Xsg13cmos5l_decap_8_3118 VPWR VGND sg13cmos5l_decap_8
* cell instance sg13cmos5l_decap_8_3119 r0 *1 0,0
Xsg13cmos5l_decap_8_3119 VPWR VGND sg13cmos5l_decap_8
* cell instance sg13cmos5l_decap_8_3120 r0 *1 0,0
Xsg13cmos5l_decap_8_3120 VPWR VGND sg13cmos5l_decap_8
* cell instance sg13cmos5l_decap_8_3121 r0 *1 0,0
Xsg13cmos5l_decap_8_3121 VPWR VGND sg13cmos5l_decap_8
* cell instance sg13cmos5l_decap_8_3122 r0 *1 0,0
Xsg13cmos5l_decap_8_3122 VPWR VGND sg13cmos5l_decap_8
* cell instance sg13cmos5l_decap_8_3123 r0 *1 0,0
Xsg13cmos5l_decap_8_3123 VPWR VGND sg13cmos5l_decap_8
* cell instance sg13cmos5l_dfrbpq_1_0 r0 *1 0,0
Xsg13cmos5l_dfrbpq_1_0 \$747 \$603 \$751 \$138 VPWR VGND sg13cmos5l_dfrbpq_1
* cell instance sg13cmos5l_dfrbpq_1_1 r0 *1 0,0
Xsg13cmos5l_dfrbpq_1_1 \$747 \$1029 \$1180 \$138 VPWR VGND sg13cmos5l_dfrbpq_1
* cell instance sg13cmos5l_dfrbpq_1_2 r0 *1 0,0
Xsg13cmos5l_dfrbpq_1_2 \$747 \$1427 \$1441 \$1428 VPWR VGND sg13cmos5l_dfrbpq_1
* cell instance sg13cmos5l_dfrbpq_1_3 r0 *1 0,0
Xsg13cmos5l_dfrbpq_1_3 \$747 \$1750 \$1760 \$1428 VPWR VGND sg13cmos5l_dfrbpq_1
* cell instance sg13cmos5l_dfrbpq_1_4 r0 *1 0,0
Xsg13cmos5l_dfrbpq_1_4 \$1771 \$2300 \$2309 \$1457 VPWR VGND sg13cmos5l_dfrbpq_1
* cell instance sg13cmos5l_dfrbpq_1_5 r0 *1 0,0
Xsg13cmos5l_dfrbpq_1_5 \$1771 \$3100 \$2485 \$1457 VPWR VGND sg13cmos5l_dfrbpq_1
* cell instance sg13cmos5l_dfrbpq_1_6 r0 *1 0,0
Xsg13cmos5l_dfrbpq_1_6 \$1771 \$3476 \$3505 \$3498 VPWR VGND sg13cmos5l_dfrbpq_1
* cell instance sg13cmos5l_dfrbpq_1_7 r0 *1 0,0
Xsg13cmos5l_dfrbpq_1_7 \$1771 \$4062 \$3323 \$3498 VPWR VGND sg13cmos5l_dfrbpq_1
* cell instance sg13cmos5l_dfrbpq_1_8 r0 *1 0,0
Xsg13cmos5l_dfrbpq_1_8 \$1771 \$4405 \$4437 \$3498 VPWR VGND sg13cmos5l_dfrbpq_1
* cell instance sg13cmos5l_dfrbpq_1_9 r0 *1 0,0
Xsg13cmos5l_dfrbpq_1_9 \$1771 \$4629 \$3720 \$3498 VPWR VGND sg13cmos5l_dfrbpq_1
* cell instance sg13cmos5l_dfrbpq_1_10 r0 *1 0,0
Xsg13cmos5l_dfrbpq_1_10 \$5101 \$5095 \$3916 \$4935 VPWR VGND
+ sg13cmos5l_dfrbpq_1
* cell instance sg13cmos5l_dfrbpq_1_11 r0 *1 0,0
Xsg13cmos5l_dfrbpq_1_11 \$5101 \$5414 \$2143 \$4935 VPWR VGND
+ sg13cmos5l_dfrbpq_1
* cell instance sg13cmos5l_dfrbpq_1_12 r0 *1 0,0
Xsg13cmos5l_dfrbpq_1_12 \$5101 \$5613 \$5855 \$4935 VPWR VGND
+ sg13cmos5l_dfrbpq_1
* cell instance sg13cmos5l_dfrbpq_1_13 r0 *1 0,0
Xsg13cmos5l_dfrbpq_1_13 \$5101 \$6191 \$6224 \$4935 VPWR VGND
+ sg13cmos5l_dfrbpq_1
* cell instance sg13cmos5l_dfrbpq_1_14 r0 *1 0,0
Xsg13cmos5l_dfrbpq_1_14 \$6845 \$6844 \$6737 \$6430 VPWR VGND
+ sg13cmos5l_dfrbpq_1
* cell instance sg13cmos5l_dfrbpq_1_15 r0 *1 0,0
Xsg13cmos5l_dfrbpq_1_15 \$6845 \$7255 \$6879 \$6430 VPWR VGND
+ sg13cmos5l_dfrbpq_1
* cell instance sg13cmos5l_dfrbpq_1_16 r0 *1 0,0
Xsg13cmos5l_dfrbpq_1_16 \$6845 \$7714 \$7456 \$6430 VPWR VGND
+ sg13cmos5l_dfrbpq_1
* cell instance sg13cmos5l_dfrbpq_1_17 r0 *1 0,0
Xsg13cmos5l_dfrbpq_1_17 \$6845 \$8547 \$8345 \$6430 VPWR VGND
+ sg13cmos5l_dfrbpq_1
* cell instance sg13cmos5l_dfrbpq_1_18 r0 *1 0,0
Xsg13cmos5l_dfrbpq_1_18 \$6845 \$9510 \$9323 \$9083 VPWR VGND
+ sg13cmos5l_dfrbpq_1
* cell instance sg13cmos5l_dfrbpq_1_19 r0 *1 0,0
Xsg13cmos5l_dfrbpq_1_19 \$10296 \$9934 \$10124 \$9083 VPWR VGND
+ sg13cmos5l_dfrbpq_1
* cell instance sg13cmos5l_dfrbpq_1_20 r0 *1 0,0
Xsg13cmos5l_dfrbpq_1_20 \$10296 \$11395 \$6533 \$9083 VPWR VGND
+ sg13cmos5l_dfrbpq_1
* cell instance sg13cmos5l_dfrbpq_1_21 r0 *1 0,0
Xsg13cmos5l_dfrbpq_1_21 \$12926 \$11817 \$11971 \$12308 VPWR VGND
+ sg13cmos5l_dfrbpq_1
* cell instance sg13cmos5l_dfrbpq_1_22 r0 *1 0,0
Xsg13cmos5l_dfrbpq_1_22 \$12926 \$12734 \$9823 \$12308 VPWR VGND
+ sg13cmos5l_dfrbpq_1
* cell instance sg13cmos5l_dfrbpq_1_23 r0 *1 0,0
Xsg13cmos5l_dfrbpq_1_23 \$6845 \$9082 \$6434 \$9083 VPWR VGND
+ sg13cmos5l_dfrbpq_1
* cell instance sg13cmos5l_dfrbpq_1_24 r0 *1 0,0
Xsg13cmos5l_dfrbpq_1_24 \$6845 \$9190 \$6013 \$9083 VPWR VGND
+ sg13cmos5l_dfrbpq_1
* cell instance sg13cmos5l_dfrbpq_1_25 r0 *1 0,0
Xsg13cmos5l_dfrbpq_1_25 \$12926 \$13959 \$12309 \$12308 VPWR VGND
+ sg13cmos5l_dfrbpq_1
* cell instance sg13cmos5l_dfrbpq_1_26 r0 *1 0,0
Xsg13cmos5l_dfrbpq_1_26 \$6845 \$8301 \$7542 \$6430 VPWR VGND
+ sg13cmos5l_dfrbpq_1
* cell instance sg13cmos5l_dfrbpq_1_27 r0 *1 0,0
Xsg13cmos5l_dfrbpq_1_27 \$17989 \$17429 \$17273 \$17987 VPWR VGND
+ sg13cmos5l_dfrbpq_1
* cell instance sg13cmos5l_dfrbpq_1_28 r0 *1 0,0
Xsg13cmos5l_dfrbpq_1_28 \$12926 \$14314 \$7541 \$12308 VPWR VGND
+ sg13cmos5l_dfrbpq_1
* cell instance sg13cmos5l_dfrbpq_1_29 r0 *1 0,0
Xsg13cmos5l_dfrbpq_1_29 \$135 \$356 \$234 \$138 VPWR VGND sg13cmos5l_dfrbpq_1
* cell instance sg13cmos5l_dfrbpq_1_30 r0 *1 0,0
Xsg13cmos5l_dfrbpq_1_30 \$5101 \$5788 \$5152 \$4935 VPWR VGND
+ sg13cmos5l_dfrbpq_1
* cell instance sg13cmos5l_dfrbpq_1_31 r0 *1 0,0
Xsg13cmos5l_dfrbpq_1_31 \$17989 \$16520 \$8556 \$17987 VPWR VGND
+ sg13cmos5l_dfrbpq_1
* cell instance sg13cmos5l_dfrbpq_1_32 r0 *1 0,0
Xsg13cmos5l_dfrbpq_1_32 \$10296 \$9519 \$9143 \$9083 VPWR VGND
+ sg13cmos5l_dfrbpq_1
* cell instance sg13cmos5l_dfrbpq_1_33 r0 *1 0,0
Xsg13cmos5l_dfrbpq_1_33 \$12926 \$15157 \$6746 \$12308 VPWR VGND
+ sg13cmos5l_dfrbpq_1
* cell instance sg13cmos5l_dfrbpq_1_34 r0 *1 0,0
Xsg13cmos5l_dfrbpq_1_34 \$17989 \$19519 uio_out[3] \$17987 VPWR VGND
+ sg13cmos5l_dfrbpq_1
* cell instance sg13cmos5l_dfrbpq_1_35 r0 *1 0,0
Xsg13cmos5l_dfrbpq_1_35 \$10296 \$11381 \$10920 \$9083 VPWR VGND
+ sg13cmos5l_dfrbpq_1
* cell instance sg13cmos5l_dfrbpq_1_36 r0 *1 0,0
Xsg13cmos5l_dfrbpq_1_36 \$6845 \$7829 \$7534 \$6430 VPWR VGND
+ sg13cmos5l_dfrbpq_1
* cell instance sg13cmos5l_dfrbpq_1_37 r0 *1 0,0
Xsg13cmos5l_dfrbpq_1_37 \$12926 \$12563 \$12739 \$12308 VPWR VGND
+ sg13cmos5l_dfrbpq_1
* cell instance sg13cmos5l_dfrbpq_1_38 r0 *1 0,0
Xsg13cmos5l_dfrbpq_1_38 \$5101 \$4930 \$3723 \$4935 VPWR VGND
+ sg13cmos5l_dfrbpq_1
* cell instance sg13cmos5l_dfrbpq_1_39 r0 *1 0,0
Xsg13cmos5l_dfrbpq_1_39 \$10296 \$9636 \$10297 \$9083 VPWR VGND
+ sg13cmos5l_dfrbpq_1
* cell instance sg13cmos5l_dfrbpq_1_40 r0 *1 0,0
Xsg13cmos5l_dfrbpq_1_40 \$5101 \$5111 \$5116 \$4935 VPWR VGND
+ sg13cmos5l_dfrbpq_1
* cell instance sg13cmos5l_dfrbpq_1_41 r0 *1 0,0
Xsg13cmos5l_dfrbpq_1_41 \$747 \$760 \$904 \$138 VPWR VGND sg13cmos5l_dfrbpq_1
* cell instance sg13cmos5l_dfrbpq_1_42 r0 *1 0,0
Xsg13cmos5l_dfrbpq_1_42 \$1771 \$4632 \$4772 \$3498 VPWR VGND
+ sg13cmos5l_dfrbpq_1
* cell instance sg13cmos5l_dfrbpq_1_43 r0 *1 0,0
Xsg13cmos5l_dfrbpq_1_43 \$17989 \$19411 uio_out[7] \$17987 VPWR VGND
+ sg13cmos5l_dfrbpq_1
* cell instance sg13cmos5l_dfrbpq_1_44 r0 *1 0,0
Xsg13cmos5l_dfrbpq_1_44 \$6845 \$6973 \$6888 \$6430 VPWR VGND
+ sg13cmos5l_dfrbpq_1
* cell instance sg13cmos5l_dfrbpq_1_45 r0 *1 0,0
Xsg13cmos5l_dfrbpq_1_45 \$1771 \$3695 \$3336 \$3498 VPWR VGND
+ sg13cmos5l_dfrbpq_1
* cell instance sg13cmos5l_dfrbpq_1_46 r0 *1 0,0
Xsg13cmos5l_dfrbpq_1_46 \$1771 \$4259 \$3134 \$3498 VPWR VGND
+ sg13cmos5l_dfrbpq_1
* cell instance sg13cmos5l_dfrbpq_1_47 r0 *1 0,0
Xsg13cmos5l_dfrbpq_1_47 \$747 \$1310 \$1574 \$1428 VPWR VGND sg13cmos5l_dfrbpq_1
* cell instance sg13cmos5l_dfrbpq_1_48 r0 *1 0,0
Xsg13cmos5l_dfrbpq_1_48 \$17989 \$17247 uio_out[5] \$17987 VPWR VGND
+ sg13cmos5l_dfrbpq_1
* cell instance sg13cmos5l_dfrbpq_1_49 r0 *1 0,0
Xsg13cmos5l_dfrbpq_1_49 \$17989 \$18741 \$7901 \$17987 VPWR VGND
+ sg13cmos5l_dfrbpq_1
* cell instance sg13cmos5l_dfrbpq_1_50 r0 *1 0,0
Xsg13cmos5l_dfrbpq_1_50 \$135 \$241 \$245 \$138 VPWR VGND sg13cmos5l_dfrbpq_1
* cell instance sg13cmos5l_dfrbpq_1_51 r0 *1 0,0
Xsg13cmos5l_dfrbpq_1_51 \$6845 \$8135 \$8039 \$7535 VPWR VGND
+ sg13cmos5l_dfrbpq_1
* cell instance sg13cmos5l_dfrbpq_1_52 r0 *1 0,0
Xsg13cmos5l_dfrbpq_1_52 \$12926 \$14407 \$9664 \$12832 VPWR VGND
+ sg13cmos5l_dfrbpq_1
* cell instance sg13cmos5l_dfrbpq_1_53 r0 *1 0,0
Xsg13cmos5l_dfrbpq_1_53 \$12926 \$16272 \$10923 \$16432 VPWR VGND
+ sg13cmos5l_dfrbpq_1
* cell instance sg13cmos5l_dfrbpq_1_54 r0 *1 0,0
Xsg13cmos5l_dfrbpq_1_54 \$12926 \$13281 \$13289 \$12832 VPWR VGND
+ sg13cmos5l_dfrbpq_1
* cell instance sg13cmos5l_dfrbpq_1_55 r0 *1 0,0
Xsg13cmos5l_dfrbpq_1_55 \$12926 \$15318 \$5633 \$12832 VPWR VGND
+ sg13cmos5l_dfrbpq_1
* cell instance sg13cmos5l_dfrbpq_1_56 r0 *1 0,0
Xsg13cmos5l_dfrbpq_1_56 \$5101 \$5791 \$5147 \$5126 VPWR VGND
+ sg13cmos5l_dfrbpq_1
* cell instance sg13cmos5l_dfrbpq_1_57 r0 *1 0,0
Xsg13cmos5l_dfrbpq_1_57 \$6845 \$7241 \$7457 \$7535 VPWR VGND
+ sg13cmos5l_dfrbpq_1
* cell instance sg13cmos5l_dfrbpq_1_58 r0 *1 0,0
Xsg13cmos5l_dfrbpq_1_58 \$17989 \$19491 uio_out[6] \$16432 VPWR VGND
+ sg13cmos5l_dfrbpq_1
* cell instance sg13cmos5l_dfrbpq_1_59 r0 *1 0,0
Xsg13cmos5l_dfrbpq_1_59 \$1771 \$2686 \$2291 \$1428 VPWR VGND
+ sg13cmos5l_dfrbpq_1
* cell instance sg13cmos5l_dfrbpq_1_60 r0 *1 0,0
Xsg13cmos5l_dfrbpq_1_60 \$5101 \$6743 \$6425 \$7535 VPWR VGND
+ sg13cmos5l_dfrbpq_1
* cell instance sg13cmos5l_dfrbpq_1_61 r0 *1 0,0
Xsg13cmos5l_dfrbpq_1_61 \$135 \$462 \$473 \$1428 VPWR VGND sg13cmos5l_dfrbpq_1
* cell instance sg13cmos5l_dfrbpq_1_62 r0 *1 0,0
Xsg13cmos5l_dfrbpq_1_62 \$10296 \$9534 \$9328 \$6428 VPWR VGND
+ sg13cmos5l_dfrbpq_1
* cell instance sg13cmos5l_dfrbpq_1_63 r0 *1 0,0
Xsg13cmos5l_dfrbpq_1_63 \$5101 \$4943 \$5132 \$4935 VPWR VGND
+ sg13cmos5l_dfrbpq_1
* cell instance sg13cmos5l_dfrbpq_1_64 r0 *1 0,0
Xsg13cmos5l_dfrbpq_1_64 \$5101 \$5259 \$5479 \$5126 VPWR VGND
+ sg13cmos5l_dfrbpq_1
* cell instance sg13cmos5l_dfrbpq_1_65 r0 *1 0,0
Xsg13cmos5l_dfrbpq_1_65 \$6845 \$6892 \$6849 \$7535 VPWR VGND
+ sg13cmos5l_dfrbpq_1
* cell instance sg13cmos5l_dfrbpq_1_66 r0 *1 0,0
Xsg13cmos5l_dfrbpq_1_66 \$17989 \$18320 \$5640 \$17987 VPWR VGND
+ sg13cmos5l_dfrbpq_1
* cell instance sg13cmos5l_dfrbpq_1_67 r0 *1 0,0
Xsg13cmos5l_dfrbpq_1_67 \$5101 \$4796 \$4646 \$4644 VPWR VGND
+ sg13cmos5l_dfrbpq_1
* cell instance sg13cmos5l_dfrbpq_1_68 r0 *1 0,0
Xsg13cmos5l_dfrbpq_1_68 \$135 \$250 \$262 \$138 VPWR VGND sg13cmos5l_dfrbpq_1
* cell instance sg13cmos5l_dfrbpq_1_69 r0 *1 0,0
Xsg13cmos5l_dfrbpq_1_69 \$5101 \$6234 \$6039 \$5126 VPWR VGND
+ sg13cmos5l_dfrbpq_1
* cell instance sg13cmos5l_dfrbpq_1_70 r0 *1 0,0
Xsg13cmos5l_dfrbpq_1_70 \$1771 \$1773 \$1954 \$1428 VPWR VGND
+ sg13cmos5l_dfrbpq_1
* cell instance sg13cmos5l_dfrbpq_1_71 r0 *1 0,0
Xsg13cmos5l_dfrbpq_1_71 \$135 \$764 \$775 \$138 VPWR VGND sg13cmos5l_dfrbpq_1
* cell instance sg13cmos5l_dfrbpq_1_72 r0 *1 0,0
Xsg13cmos5l_dfrbpq_1_72 \$17989 \$19319 uio_out[2] \$16432 VPWR VGND
+ sg13cmos5l_dfrbpq_1
* cell instance sg13cmos5l_dfrbpq_1_73 r0 *1 0,0
Xsg13cmos5l_dfrbpq_1_73 \$12926 \$14323 \$6851 \$12308 VPWR VGND
+ sg13cmos5l_dfrbpq_1
* cell instance sg13cmos5l_dfrbpq_1_74 r0 *1 0,0
Xsg13cmos5l_dfrbpq_1_74 \$17989 \$17025 \$6439 \$17987 VPWR VGND
+ sg13cmos5l_dfrbpq_1
* cell instance sg13cmos5l_dfrbpq_1_75 r0 *1 0,0
Xsg13cmos5l_dfrbpq_1_75 \$12926 \$15324 \$10770 \$12308 VPWR VGND
+ sg13cmos5l_dfrbpq_1
* cell instance sg13cmos5l_dfrbpq_1_76 r0 *1 0,0
Xsg13cmos5l_dfrbpq_1_76 \$1771 \$4266 \$4271 \$3498 VPWR VGND
+ sg13cmos5l_dfrbpq_1
* cell instance sg13cmos5l_dfrbpq_1_77 r0 *1 0,0
Xsg13cmos5l_dfrbpq_1_77 \$12926 \$12924 \$12750 \$12832 VPWR VGND
+ sg13cmos5l_dfrbpq_1
* cell instance sg13cmos5l_dfrbpq_1_78 r0 *1 0,0
Xsg13cmos5l_dfrbpq_1_78 \$5654 \$8139 \$7897 \$7535 VPWR VGND
+ sg13cmos5l_dfrbpq_1
* cell instance sg13cmos5l_dfrbpq_1_79 r0 *1 0,0
Xsg13cmos5l_dfrbpq_1_79 \$12926 \$12125 \$12313 \$12832 VPWR VGND
+ sg13cmos5l_dfrbpq_1
* cell instance sg13cmos5l_dfrbpq_1_80 r0 *1 0,0
Xsg13cmos5l_dfrbpq_1_80 \$135 \$79 \$158 \$138 VPWR VGND sg13cmos5l_dfrbpq_1
* cell instance sg13cmos5l_dfrbpq_1_81 r0 *1 0,0
Xsg13cmos5l_dfrbpq_1_81 \$5101 \$6759 \$6442 \$6430 VPWR VGND
+ sg13cmos5l_dfrbpq_1
* cell instance sg13cmos5l_dfrbpq_1_82 r0 *1 0,0
Xsg13cmos5l_dfrbpq_1_82 \$17989 \$19497 uio_out[1] \$16432 VPWR VGND
+ sg13cmos5l_dfrbpq_1
* cell instance sg13cmos5l_dfrbpq_1_83 r0 *1 0,0
Xsg13cmos5l_dfrbpq_1_83 \$6845 \$6953 \$6908 \$7535 VPWR VGND
+ sg13cmos5l_dfrbpq_1
* cell instance sg13cmos5l_dfrbpq_1_84 r0 *1 0,0
Xsg13cmos5l_dfrbpq_1_84 \$1771 \$1465 \$1476 \$1428 VPWR VGND
+ sg13cmos5l_dfrbpq_1
* cell instance sg13cmos5l_dfrbpq_1_85 r0 *1 0,0
Xsg13cmos5l_dfrbpq_1_85 \$5101 \$4948 \$3527 \$5126 VPWR VGND
+ sg13cmos5l_dfrbpq_1
* cell instance sg13cmos5l_dfrbpq_1_86 r0 *1 0,0
Xsg13cmos5l_dfrbpq_1_86 \$10296 \$10747 \$9504 \$6428 VPWR VGND
+ sg13cmos5l_dfrbpq_1
* cell instance sg13cmos5l_dfrbpq_1_87 r0 *1 0,0
Xsg13cmos5l_dfrbpq_1_87 \$1771 \$4651 \$4275 \$5126 VPWR VGND
+ sg13cmos5l_dfrbpq_1
* cell instance sg13cmos5l_dfrbpq_1_88 r0 *1 0,0
Xsg13cmos5l_dfrbpq_1_88 \$12926 \$13295 \$13303 \$12832 VPWR VGND
+ sg13cmos5l_dfrbpq_1
* cell instance sg13cmos5l_dfrbpq_1_89 r0 *1 0,0
Xsg13cmos5l_dfrbpq_1_89 \$17989 \$19430 uo_out[2] \$17288 VPWR VGND
+ sg13cmos5l_dfrbpq_1
* cell instance sg13cmos5l_dfrbpq_1_90 r0 *1 0,0
Xsg13cmos5l_dfrbpq_1_90 \$17989 \$16805 \$6775 \$17288 VPWR VGND
+ sg13cmos5l_dfrbpq_1
* cell instance sg13cmos5l_dfrbpq_1_91 r0 *1 0,0
Xsg13cmos5l_dfrbpq_1_91 \$10296 \$14328 \$5865 \$13964 VPWR VGND
+ sg13cmos5l_dfrbpq_1
* cell instance sg13cmos5l_dfrbpq_1_92 r0 *1 0,0
Xsg13cmos5l_dfrbpq_1_92 \$12926 \$15165 \$7904 \$13964 VPWR VGND
+ sg13cmos5l_dfrbpq_1
* cell instance sg13cmos5l_dfrbpq_1_93 r0 *1 0,0
Xsg13cmos5l_dfrbpq_1_93 \$17989 \$17724 uio_out[4] \$17288 VPWR VGND
+ sg13cmos5l_dfrbpq_1
* cell instance sg13cmos5l_dfrbpq_1_94 r0 *1 0,0
Xsg13cmos5l_dfrbpq_1_94 \$1771 \$4467 \$4284 \$4471 VPWR VGND
+ sg13cmos5l_dfrbpq_1
* cell instance sg13cmos5l_dfrbpq_1_95 r0 *1 0,0
Xsg13cmos5l_dfrbpq_1_95 \$135 \$384 \$478 \$161 VPWR VGND sg13cmos5l_dfrbpq_1
* cell instance sg13cmos5l_dfrbpq_1_96 r0 *1 0,0
Xsg13cmos5l_dfrbpq_1_96 \$5654 \$8463 \$8539 \$6852 VPWR VGND
+ sg13cmos5l_dfrbpq_1
* cell instance sg13cmos5l_dfrbpq_1_97 r0 *1 0,0
Xsg13cmos5l_dfrbpq_1_97 \$4307 \$5270 \$4481 \$5472 VPWR VGND
+ sg13cmos5l_dfrbpq_1
* cell instance sg13cmos5l_dfrbpq_1_98 r0 *1 0,0
Xsg13cmos5l_dfrbpq_1_98 \$135 \$159 \$85 \$161 VPWR VGND sg13cmos5l_dfrbpq_1
* cell instance sg13cmos5l_dfrbpq_1_99 r0 *1 0,0
Xsg13cmos5l_dfrbpq_1_99 \$5654 \$6829 \$6915 \$6852 VPWR VGND
+ sg13cmos5l_dfrbpq_1
* cell instance sg13cmos5l_dfrbpq_1_100 r0 *1 0,0
Xsg13cmos5l_dfrbpq_1_100 \$10296 \$9646 \$9552 \$6852 VPWR VGND
+ sg13cmos5l_dfrbpq_1
* cell instance sg13cmos5l_dfrbpq_1_101 r0 *1 0,0
Xsg13cmos5l_dfrbpq_1_101 \$16038 \$19509 uo_out[3] \$17288 VPWR VGND
+ sg13cmos5l_dfrbpq_1
* cell instance sg13cmos5l_dfrbpq_1_102 r0 *1 0,0
Xsg13cmos5l_dfrbpq_1_102 \$10296 \$13309 \$13380 \$13964 VPWR VGND
+ sg13cmos5l_dfrbpq_1
* cell instance sg13cmos5l_dfrbpq_1_103 r0 *1 0,0
Xsg13cmos5l_dfrbpq_1_103 \$4307 \$4656 \$4482 \$4471 VPWR VGND
+ sg13cmos5l_dfrbpq_1
* cell instance sg13cmos5l_dfrbpq_1_104 r0 *1 0,0
Xsg13cmos5l_dfrbpq_1_104 \$5654 \$8050 \$5873 \$6852 VPWR VGND
+ sg13cmos5l_dfrbpq_1
* cell instance sg13cmos5l_dfrbpq_1_105 r0 *1 0,0
Xsg13cmos5l_dfrbpq_1_105 \$10296 \$10752 \$10926 \$6852 VPWR VGND
+ sg13cmos5l_dfrbpq_1
* cell instance sg13cmos5l_dfrbpq_1_106 r0 *1 0,0
Xsg13cmos5l_dfrbpq_1_106 \$5654 \$9211 \$6260 \$6852 VPWR VGND
+ sg13cmos5l_dfrbpq_1
* cell instance sg13cmos5l_dfrbpq_1_107 r0 *1 0,0
Xsg13cmos5l_dfrbpq_1_107 \$10296 \$12757 \$12836 \$13964 VPWR VGND
+ sg13cmos5l_dfrbpq_1
* cell instance sg13cmos5l_dfrbpq_1_108 r0 *1 0,0
Xsg13cmos5l_dfrbpq_1_108 \$10296 \$14331 \$11218 \$13964 VPWR VGND
+ sg13cmos5l_dfrbpq_1
* cell instance sg13cmos5l_dfrbpq_1_109 r0 *1 0,0
Xsg13cmos5l_dfrbpq_1_109 \$16038 \$16036 uio_out[0] \$13964 VPWR VGND
+ sg13cmos5l_dfrbpq_1
* cell instance sg13cmos5l_dfrbpq_1_110 r0 *1 0,0
Xsg13cmos5l_dfrbpq_1_110 \$16038 \$16283 uo_out[0] \$17288 VPWR VGND
+ sg13cmos5l_dfrbpq_1
* cell instance sg13cmos5l_dfrbpq_1_111 r0 *1 0,0
Xsg13cmos5l_dfrbpq_1_111 \$16038 \$17259 uo_out[5] \$17288 VPWR VGND
+ sg13cmos5l_dfrbpq_1
* cell instance sg13cmos5l_dfrbpq_1_112 r0 *1 0,0
Xsg13cmos5l_dfrbpq_1_112 \$17989 \$18750 uo_out[4] \$17288 VPWR VGND
+ sg13cmos5l_dfrbpq_1
* cell instance sg13cmos5l_dfrbpq_1_113 r0 *1 0,0
Xsg13cmos5l_dfrbpq_1_113 \$16038 \$19326 uo_out[7] \$17288 VPWR VGND
+ sg13cmos5l_dfrbpq_1
* cell instance sg13cmos5l_dfrbpq_1_114 r0 *1 0,0
Xsg13cmos5l_dfrbpq_1_114 \$135 \$273 \$388 \$161 VPWR VGND sg13cmos5l_dfrbpq_1
* cell instance sg13cmos5l_dfrbpq_1_115 r0 *1 0,0
Xsg13cmos5l_dfrbpq_1_115 \$135 \$788 \$931 \$161 VPWR VGND sg13cmos5l_dfrbpq_1
* cell instance sg13cmos5l_dfrbpq_1_116 r0 *1 0,0
Xsg13cmos5l_dfrbpq_1_116 \$4307 \$5277 \$5278 \$4471 VPWR VGND
+ sg13cmos5l_dfrbpq_1
* cell instance sg13cmos5l_dfrbpq_1_117 r0 *1 0,0
Xsg13cmos5l_dfrbpq_1_117 \$4307 \$6263 \$6047 \$4471 VPWR VGND
+ sg13cmos5l_dfrbpq_1
* cell instance sg13cmos5l_dfrbpq_1_118 r0 *1 0,0
Xsg13cmos5l_dfrbpq_1_118 \$16038 \$19516 uo_out[6] \$13964 VPWR VGND
+ sg13cmos5l_dfrbpq_1
* cell instance sg13cmos5l_dfrbpq_1_119 r0 *1 0,0
Xsg13cmos5l_dfrbpq_1_119 \$135 \$174 \$84 \$161 VPWR VGND sg13cmos5l_dfrbpq_1
* cell instance sg13cmos5l_dfrbpq_1_120 r0 *1 0,0
Xsg13cmos5l_dfrbpq_1_120 \$513 \$1065 \$1203 \$801 VPWR VGND sg13cmos5l_dfrbpq_1
* cell instance sg13cmos5l_dfrbpq_1_121 r0 *1 0,0
Xsg13cmos5l_dfrbpq_1_121 \$4307 \$5079 \$4972 \$5472 VPWR VGND
+ sg13cmos5l_dfrbpq_1
* cell instance sg13cmos5l_dfrbpq_1_122 r0 *1 0,0
Xsg13cmos5l_dfrbpq_1_122 \$135 \$288 \$352 \$161 VPWR VGND sg13cmos5l_dfrbpq_1
* cell instance sg13cmos5l_dfrbpq_1_123 r0 *1 0,0
Xsg13cmos5l_dfrbpq_1_123 \$513 \$502 \$517 \$801 VPWR VGND sg13cmos5l_dfrbpq_1
* cell instance sg13cmos5l_dfrbpq_1_124 r0 *1 0,0
Xsg13cmos5l_dfrbpq_1_124 \$4307 \$5505 \$4976 \$4471 VPWR VGND
+ sg13cmos5l_dfrbpq_1
* cell instance sg13cmos5l_dfrbpq_1_125 r0 *1 0,0
Xsg13cmos5l_dfrbpq_1_125 \$4307 \$6059 \$6259 \$4471 VPWR VGND
+ sg13cmos5l_dfrbpq_1
* cell instance sg13cmos5l_dfrbpq_1_126 r0 *1 0,0
Xsg13cmos5l_dfrbpq_1_126 \$4307 \$4299 \$3927 \$4471 VPWR VGND
+ sg13cmos5l_dfrbpq_1
* cell instance sg13cmos5l_dfrbpq_1_127 r0 *1 0,0
Xsg13cmos5l_dfrbpq_1_127 \$513 \$1630 \$1485 \$801 VPWR VGND sg13cmos5l_dfrbpq_1
* cell instance sg13cmos5l_dfrbpq_1_128 r0 *1 0,0
Xsg13cmos5l_dfrbpq_1_128 \$4307 \$5882 \$6071 \$4471 VPWR VGND
+ sg13cmos5l_dfrbpq_1
* cell instance sg13cmos5l_dfrbpq_1_129 r0 *1 0,0
Xsg13cmos5l_dfrbpq_1_129 \$513 \$187 \$353 \$161 VPWR VGND sg13cmos5l_dfrbpq_1
* cell instance sg13cmos5l_dfrbpq_1_130 r0 *1 0,0
Xsg13cmos5l_dfrbpq_1_130 \$513 \$809 \$881 \$161 VPWR VGND sg13cmos5l_dfrbpq_1
* cell instance sg13cmos5l_dfrbpq_1_131 r0 *1 0,0
Xsg13cmos5l_dfrbpq_1_131 \$5654 \$5798 \$5492 \$3290 VPWR VGND
+ sg13cmos5l_dfrbpq_1
* cell instance sg13cmos5l_dfrbpq_1_132 r0 *1 0,0
Xsg13cmos5l_dfrbpq_1_132 \$513 \$2335 \$2146 \$312 VPWR VGND sg13cmos5l_dfrbpq_1
* cell instance sg13cmos5l_dfrbpq_1_133 r0 *1 0,0
Xsg13cmos5l_dfrbpq_1_133 \$4307 \$3153 \$3362 \$3388 VPWR VGND
+ sg13cmos5l_dfrbpq_1
* cell instance sg13cmos5l_dfrbpq_1_134 r0 *1 0,0
Xsg13cmos5l_dfrbpq_1_134 \$513 \$522 \$588 \$312 VPWR VGND sg13cmos5l_dfrbpq_1
* cell instance sg13cmos5l_dfrbpq_1_135 r0 *1 0,0
Xsg13cmos5l_dfrbpq_1_135 \$4307 \$4312 \$1499 \$3388 VPWR VGND
+ sg13cmos5l_dfrbpq_1
* cell instance sg13cmos5l_dfrbpq_1_136 r0 *1 0,0
Xsg13cmos5l_dfrbpq_1_136 \$16038 \$19581 uo_out[1] \$11403 VPWR VGND
+ sg13cmos5l_dfrbpq_1
* cell instance sg13cmos5l_dfrbpq_1_137 r0 *1 0,0
Xsg13cmos5l_dfrbpq_1_137 \$513 \$194 \$190 \$312 VPWR VGND sg13cmos5l_dfrbpq_1
* cell instance sg13cmos5l_dfrbpq_1_138 r0 *1 0,0
Xsg13cmos5l_dfrbpq_1_138 \$513 \$1339 \$1342 \$1502 VPWR VGND
+ sg13cmos5l_dfrbpq_1
* cell instance sg13cmos5l_dfrbpq_1_139 r0 *1 0,0
Xsg13cmos5l_dfrbpq_1_139 \$5654 \$5290 \$5418 \$3290 VPWR VGND
+ sg13cmos5l_dfrbpq_1
* cell instance sg13cmos5l_dfrbpq_1_140 r0 *1 0,0
Xsg13cmos5l_dfrbpq_1_140 \$5654 \$6074 \$5527 \$3290 VPWR VGND
+ sg13cmos5l_dfrbpq_1
* cell instance sg13cmos5l_dfrbpq_1_141 r0 *1 0,0
Xsg13cmos5l_dfrbpq_1_141 \$4307 \$3931 \$3922 \$3388 VPWR VGND
+ sg13cmos5l_dfrbpq_1
* cell instance sg13cmos5l_dfrbpq_1_142 r0 *1 0,0
Xsg13cmos5l_dfrbpq_1_142 \$1833 \$3745 \$3533 \$3388 VPWR VGND
+ sg13cmos5l_dfrbpq_1
* cell instance sg13cmos5l_dfrbpq_1_143 r0 *1 0,0
Xsg13cmos5l_dfrbpq_1_143 \$1833 \$2510 \$1990 \$1502 VPWR VGND
+ sg13cmos5l_dfrbpq_1
* cell instance sg13cmos5l_dfrbpq_1_144 r0 *1 0,0
Xsg13cmos5l_dfrbpq_1_144 \$1833 \$1997 \$1988 \$1502 VPWR VGND
+ sg13cmos5l_dfrbpq_1
* cell instance sg13cmos5l_dfrbpq_1_145 r0 *1 0,0
Xsg13cmos5l_dfrbpq_1_145 \$513 \$830 \$826 \$312 VPWR VGND sg13cmos5l_dfrbpq_1
* cell instance sg13cmos5l_dfrbpq_1_146 r0 *1 0,0
Xsg13cmos5l_dfrbpq_1_146 \$1833 \$3380 \$3544 \$3388 VPWR VGND
+ sg13cmos5l_dfrbpq_1
* cell instance sg13cmos5l_dfrbpq_1_147 r0 *1 0,0
Xsg13cmos5l_dfrbpq_1_147 \$1833 \$4042 \$3925 \$3388 VPWR VGND
+ sg13cmos5l_dfrbpq_1
* cell instance sg13cmos5l_dfrbpq_1_148 r0 *1 0,0
Xsg13cmos5l_dfrbpq_1_148 \$513 \$1082 \$1085 \$312 VPWR VGND sg13cmos5l_dfrbpq_1
* cell instance sg13cmos5l_dfrbpq_1_149 r0 *1 0,0
Xsg13cmos5l_dfrbpq_1_149 \$513 \$667 \$535 \$312 VPWR VGND sg13cmos5l_dfrbpq_1
* cell instance sg13cmos5l_dfrbpq_1_150 r0 *1 0,0
Xsg13cmos5l_dfrbpq_1_150 \$5654 \$5166 \$5082 \$3290 VPWR VGND
+ sg13cmos5l_dfrbpq_1
* cell instance sg13cmos5l_dfrbpq_1_151 r0 *1 0,0
Xsg13cmos5l_dfrbpq_1_151 \$1833 \$3291 \$2113 \$3290 VPWR VGND
+ sg13cmos5l_dfrbpq_1
* cell instance sg13cmos5l_dfrbpq_1_152 r0 *1 0,0
Xsg13cmos5l_dfrbpq_1_152 \$1833 \$3385 \$3397 \$3388 VPWR VGND
+ sg13cmos5l_dfrbpq_1
* cell instance sg13cmos5l_dfrbpq_1_153 r0 *1 0,0
Xsg13cmos5l_dfrbpq_1_153 \$513 \$544 \$453 \$312 VPWR VGND sg13cmos5l_dfrbpq_1
* cell instance sg13cmos5l_dfrbpq_1_154 r0 *1 0,0
Xsg13cmos5l_dfrbpq_1_154 \$1833 \$3552 \$3297 \$3388 VPWR VGND
+ sg13cmos5l_dfrbpq_1
* cell instance sg13cmos5l_dfrbpq_1_155 r0 *1 0,0
Xsg13cmos5l_dfrbpq_1_155 \$513 \$1087 \$1249 \$312 VPWR VGND sg13cmos5l_dfrbpq_1
* cell instance sg13cmos5l_dfrbpq_1_156 r0 *1 0,0
Xsg13cmos5l_dfrbpq_1_156 \$1833 \$2527 \$2356 \$1502 VPWR VGND
+ sg13cmos5l_dfrbpq_1
* cell instance sg13cmos5l_dfrbpq_1_157 r0 *1 0,0
Xsg13cmos5l_dfrbpq_1_157 \$3181 \$3294 \$2980 \$1525 VPWR VGND
+ sg13cmos5l_dfrbpq_1
* cell instance sg13cmos5l_dfrbpq_1_158 r0 *1 0,0
Xsg13cmos5l_dfrbpq_1_158 \$688 \$680 \$585 \$683 VPWR VGND sg13cmos5l_dfrbpq_1
* cell instance sg13cmos5l_dfrbpq_1_159 r0 *1 0,0
Xsg13cmos5l_dfrbpq_1_159 \$688 \$1517 \$1520 \$1525 VPWR VGND
+ sg13cmos5l_dfrbpq_1
* cell instance sg13cmos5l_dfrbpq_1_160 r0 *1 0,0
Xsg13cmos5l_dfrbpq_1_160 \$1833 \$2005 \$2147 \$1671 VPWR VGND
+ sg13cmos5l_dfrbpq_1
* cell instance sg13cmos5l_dfrbpq_1_161 r0 *1 0,0
Xsg13cmos5l_dfrbpq_1_161 \$3181 \$4994 \$4955 \$3768 VPWR VGND
+ sg13cmos5l_dfrbpq_1
* cell instance sg13cmos5l_dfrbpq_1_162 r0 *1 0,0
Xsg13cmos5l_dfrbpq_1_162 \$3181 \$4521 \$641 \$3768 VPWR VGND
+ sg13cmos5l_dfrbpq_1
* cell instance sg13cmos5l_dfrbpq_1_163 r0 *1 0,0
Xsg13cmos5l_dfrbpq_1_163 \$3181 \$4524 \$4535 \$3768 VPWR VGND
+ sg13cmos5l_dfrbpq_1
* cell instance sg13cmos5l_dfrbpq_1_164 r0 *1 0,0
Xsg13cmos5l_dfrbpq_1_164 \$1833 \$1827 \$1922 \$1525 VPWR VGND
+ sg13cmos5l_dfrbpq_1
* cell instance sg13cmos5l_dfrbpq_1_165 r0 *1 0,0
Xsg13cmos5l_dfrbpq_1_165 \$1833 \$2880 \$2883 \$1525 VPWR VGND
+ sg13cmos5l_dfrbpq_1
* cell instance sg13cmos5l_dfrbpq_1_166 r0 *1 0,0
Xsg13cmos5l_dfrbpq_1_166 \$688 \$970 \$1253 \$683 VPWR VGND sg13cmos5l_dfrbpq_1
* cell instance sg13cmos5l_dfrbpq_1_167 r0 *1 0,0
Xsg13cmos5l_dfrbpq_1_167 \$688 \$1361 \$1417 \$683 VPWR VGND sg13cmos5l_dfrbpq_1
* cell instance sg13cmos5l_dfrbpq_1_168 r0 *1 0,0
Xsg13cmos5l_dfrbpq_1_168 \$1833 \$2011 \$2023 \$1525 VPWR VGND
+ sg13cmos5l_dfrbpq_1
* cell instance sg13cmos5l_dfrbpq_1_169 r0 *1 0,0
Xsg13cmos5l_dfrbpq_1_169 \$1833 \$2364 \$2375 \$1525 VPWR VGND
+ sg13cmos5l_dfrbpq_1
* cell instance sg13cmos5l_dfrbpq_1_170 r0 *1 0,0
Xsg13cmos5l_dfrbpq_1_170 \$688 \$693 \$802 \$683 VPWR VGND sg13cmos5l_dfrbpq_1
* cell instance sg13cmos5l_dfrbpq_1_171 r0 *1 0,0
Xsg13cmos5l_dfrbpq_1_171 \$688 \$1656 \$1667 \$1525 VPWR VGND
+ sg13cmos5l_dfrbpq_1
* cell instance sg13cmos5l_dfrbpq_1_172 r0 *1 0,0
Xsg13cmos5l_dfrbpq_1_172 \$688 \$853 \$983 \$683 VPWR VGND sg13cmos5l_dfrbpq_1
* cell instance sg13cmos5l_dfrbpq_1_173 r0 *1 0,0
Xsg13cmos5l_dfrbpq_1_173 \$5654 \$5901 \$5611 \$3768 VPWR VGND
+ sg13cmos5l_dfrbpq_1
* cell instance sg13cmos5l_dfrbpq_1_174 r0 *1 0,0
Xsg13cmos5l_dfrbpq_1_174 \$688 \$1534 \$4143 \$1525 VPWR VGND
+ sg13cmos5l_dfrbpq_1
* cell instance sg13cmos5l_dfrbpq_1_175 r0 *1 0,0
Xsg13cmos5l_dfrbpq_1_175 \$3181 \$5421 \$5322 \$3768 VPWR VGND
+ sg13cmos5l_dfrbpq_1
* cell instance sg13cmos5l_dfrbpq_1_176 r0 *1 0,0
Xsg13cmos5l_dfrbpq_1_176 \$688 \$1169 \$1385 \$683 VPWR VGND sg13cmos5l_dfrbpq_1
* cell instance sg13cmos5l_dfrbpq_1_177 r0 *1 0,0
Xsg13cmos5l_dfrbpq_1_177 \$688 \$1112 \$1123 \$683 VPWR VGND sg13cmos5l_dfrbpq_1
* cell instance sg13cmos5l_dfrbpq_1_178 r0 *1 0,0
Xsg13cmos5l_dfrbpq_1_178 \$3181 \$5909 \$5304 \$3768 VPWR VGND
+ sg13cmos5l_dfrbpq_1
* cell instance sg13cmos5l_dfrbpq_1_179 r0 *1 0,0
Xsg13cmos5l_dfrbpq_1_179 \$688 \$1258 \$1742 \$1671 VPWR VGND
+ sg13cmos5l_dfrbpq_1
* cell instance sg13cmos5l_dfrbpq_1_180 r0 *1 0,0
Xsg13cmos5l_dfrbpq_1_180 \$688 \$1823 \$2561 \$1671 VPWR VGND
+ sg13cmos5l_dfrbpq_1
* cell instance sg13cmos5l_dfrbpq_1_181 r0 *1 0,0
Xsg13cmos5l_dfrbpq_1_181 \$688 \$864 \$3010 \$1671 VPWR VGND sg13cmos5l_dfrbpq_1
* cell instance sg13cmos5l_dfrbpq_1_182 r0 *1 0,0
Xsg13cmos5l_dfrbpq_1_182 \$3181 \$3408 \$3584 \$3768 VPWR VGND
+ sg13cmos5l_dfrbpq_1
* cell instance sg13cmos5l_dfrbpq_1_183 r0 *1 0,0
Xsg13cmos5l_dfrbpq_1_183 \$688 \$2032 \$2043 \$1671 VPWR VGND
+ sg13cmos5l_dfrbpq_1
* cell instance sg13cmos5l_dfrbpq_1_184 r0 *1 0,0
Xsg13cmos5l_dfrbpq_1_184 \$688 \$210 \$2567 \$1671 VPWR VGND sg13cmos5l_dfrbpq_1
* cell instance sg13cmos5l_dfrbpq_1_185 r0 *1 0,0
Xsg13cmos5l_dfrbpq_1_185 \$1871 \$330 \$1876 \$1870 VPWR VGND
+ sg13cmos5l_dfrbpq_1
* cell instance sg13cmos5l_dfrbpq_1_186 r0 *1 0,0
Xsg13cmos5l_dfrbpq_1_186 \$3181 \$4689 \$4875 \$3797 VPWR VGND
+ sg13cmos5l_dfrbpq_1
* cell instance sg13cmos5l_dfrbpq_1_187 r0 *1 0,0
Xsg13cmos5l_dfrbpq_1_187 \$1871 \$69 \$2049 \$1870 VPWR VGND sg13cmos5l_dfrbpq_1
* cell instance sg13cmos5l_dfrbpq_1_188 r0 *1 0,0
Xsg13cmos5l_dfrbpq_1_188 \$1871 \$105 \$1694 \$1870 VPWR VGND
+ sg13cmos5l_dfrbpq_1
* cell instance sg13cmos5l_dfrbpq_1_189 r0 *1 0,0
Xsg13cmos5l_dfrbpq_1_189 \$5361 \$5568 \$5724 \$3797 VPWR VGND
+ sg13cmos5l_dfrbpq_1
* cell instance sg13cmos5l_dfrbpq_1_190 r0 *1 0,0
Xsg13cmos5l_dfrbpq_1_190 \$3181 \$5344 \$5434 \$3797 VPWR VGND
+ sg13cmos5l_dfrbpq_1
* cell instance sg13cmos5l_dfrbpq_1_191 r0 *1 0,0
Xsg13cmos5l_dfrbpq_1_191 \$3181 \$3968 \$4155 \$3797 VPWR VGND
+ sg13cmos5l_dfrbpq_1
* cell instance sg13cmos5l_dfrbpq_1_192 r0 *1 0,0
Xsg13cmos5l_dfrbpq_1_192 \$1871 \$1553 \$1898 \$1870 VPWR VGND
+ sg13cmos5l_dfrbpq_1
* cell instance sg13cmos5l_dfrbpq_1_193 r0 *1 0,0
Xsg13cmos5l_dfrbpq_1_193 \$3181 \$4553 \$4549 \$3797 VPWR VGND
+ sg13cmos5l_dfrbpq_1
* cell instance sg13cmos5l_dfrbpq_1_194 r0 *1 0,0
Xsg13cmos5l_dfrbpq_1_194 \$5361 \$5198 \$5433 \$3797 VPWR VGND
+ sg13cmos5l_dfrbpq_1
* cell instance sg13cmos5l_dfrbpq_1_195 r0 *1 0,0
Xsg13cmos5l_dfrbpq_1_195 \$3181 \$3791 \$3414 \$3797 VPWR VGND
+ sg13cmos5l_dfrbpq_1
* cell instance sg13cmos5l_dfrbpq_1_196 r0 *1 0,0
Xsg13cmos5l_dfrbpq_1_196 \$1871 \$201 \$2579 \$1870 VPWR VGND
+ sg13cmos5l_dfrbpq_1
* cell instance sg13cmos5l_dfrbpq_1_197 r0 *1 0,0
Xsg13cmos5l_dfrbpq_1_197 \$5361 \$5963 \$6358 \$3808 VPWR VGND
+ sg13cmos5l_dfrbpq_1
* cell instance sg13cmos5l_dfrbpq_1_198 r0 *1 0,0
Xsg13cmos5l_dfrbpq_1_198 \$5361 \$5734 \$5744 \$3808 VPWR VGND
+ sg13cmos5l_dfrbpq_1
* cell instance sg13cmos5l_dfrbpq_1_199 r0 *1 0,0
Xsg13cmos5l_dfrbpq_1_199 \$1871 \$3600 \$3816 \$3808 VPWR VGND
+ sg13cmos5l_dfrbpq_1
* cell instance sg13cmos5l_dfrbpq_1_200 r0 *1 0,0
Xsg13cmos5l_dfrbpq_1_200 \$1871 \$867 \$2060 \$1870 VPWR VGND
+ sg13cmos5l_dfrbpq_1
* cell instance sg13cmos5l_dfrbpq_1_201 r0 *1 0,0
Xsg13cmos5l_dfrbpq_1_201 \$5361 \$5579 \$5754 \$3808 VPWR VGND
+ sg13cmos5l_dfrbpq_1
* cell instance sg13cmos5l_dfrbpq_1_202 r0 *1 0,0
Xsg13cmos5l_dfrbpq_1_202 \$1871 \$1913 \$4181 \$2235 VPWR VGND
+ sg13cmos5l_dfrbpq_1
* cell instance sg13cmos5l_dfrbpq_1_203 r0 *1 0,0
Xsg13cmos5l_dfrbpq_1_203 \$5361 \$6154 \$5976 \$3808 VPWR VGND
+ sg13cmos5l_dfrbpq_1
* cell instance sg13cmos5l_dfrbpq_1_204 r0 *1 0,0
Xsg13cmos5l_dfrbpq_1_204 \$1726 \$213 \$2586 \$2235 VPWR VGND
+ sg13cmos5l_dfrbpq_1
* cell instance sg13cmos5l_dfrbpq_1_205 r0 *1 0,0
Xsg13cmos5l_dfrbpq_1_205 \$1726 \$724 \$2071 \$1870 VPWR VGND
+ sg13cmos5l_dfrbpq_1
* cell instance sg13cmos5l_dfrbpq_1_206 r0 *1 0,0
Xsg13cmos5l_dfrbpq_1_206 \$1871 \$2796 \$2797 \$1870 VPWR VGND
+ sg13cmos5l_dfrbpq_1
* cell instance sg13cmos5l_dfrbpq_1_207 r0 *1 0,0
Xsg13cmos5l_dfrbpq_1_207 \$1726 \$1011 \$2588 \$2235 VPWR VGND
+ sg13cmos5l_dfrbpq_1
* cell instance sg13cmos5l_dfrbpq_1_208 r0 *1 0,0
Xsg13cmos5l_dfrbpq_1_208 \$1726 \$1150 \$4565 \$2235 VPWR VGND
+ sg13cmos5l_dfrbpq_1
* cell instance sg13cmos5l_dfrbpq_1_209 r0 *1 0,0
Xsg13cmos5l_dfrbpq_1_209 \$1871 \$3309 \$3233 \$3797 VPWR VGND
+ sg13cmos5l_dfrbpq_1
* cell instance sg13cmos5l_dfrbpq_1_210 r0 *1 0,0
Xsg13cmos5l_dfrbpq_1_210 \$1726 \$1918 \$2082 \$2235 VPWR VGND
+ sg13cmos5l_dfrbpq_1
* cell instance sg13cmos5l_dfrbpq_1_211 r0 *1 0,0
Xsg13cmos5l_dfrbpq_1_211 \$1726 \$2805 \$3044 \$1721 VPWR VGND
+ sg13cmos5l_dfrbpq_1
* cell instance sg13cmos5l_dfrbpq_1_212 r0 *1 0,0
Xsg13cmos5l_dfrbpq_1_212 \$1726 \$2261 \$2616 \$1721 VPWR VGND
+ sg13cmos5l_dfrbpq_1
* cell instance sg13cmos5l_dfrbpq_1_213 r0 *1 0,0
Xsg13cmos5l_dfrbpq_1_213 \$1726 \$1573 \$3983 \$1721 VPWR VGND
+ sg13cmos5l_dfrbpq_1
* cell instance sg13cmos5l_dfrbpq_1_214 r0 *1 0,0
Xsg13cmos5l_dfrbpq_1_214 \$1726 \$1409 \$4709 \$1721 VPWR VGND
+ sg13cmos5l_dfrbpq_1
* cell instance sg13cmos5l_dfrbpq_1_215 r0 *1 0,0
Xsg13cmos5l_dfrbpq_1_215 \$1726 \$2415 \$2426 \$1721 VPWR VGND
+ sg13cmos5l_dfrbpq_1
* cell instance sg13cmos5l_dfrbpq_1_216 r0 *1 0,0
Xsg13cmos5l_dfrbpq_1_216 \$2270 \$2898 \$2818 \$1721 VPWR VGND
+ sg13cmos5l_dfrbpq_1
* cell instance sg13cmos5l_dfrbpq_1_217 r0 *1 0,0
Xsg13cmos5l_dfrbpq_1_217 \$3838 \$3988 \$4195 \$3891 VPWR VGND
+ sg13cmos5l_dfrbpq_1
* cell instance sg13cmos5l_dfrbpq_1_218 r0 *1 0,0
Xsg13cmos5l_dfrbpq_1_218 \$2270 \$2263 \$2275 \$1721 VPWR VGND
+ sg13cmos5l_dfrbpq_1
* cell instance sg13cmos5l_dfrbpq_1_219 r0 *1 0,0
Xsg13cmos5l_dfrbpq_1_219 \$2270 \$2630 \$2641 \$2613 VPWR VGND
+ sg13cmos5l_dfrbpq_1
* cell instance sg13cmos5l_dfrbpq_1_220 r0 *1 0,0
Xsg13cmos5l_dfrbpq_1_220 \$2270 \$3623 \$3250 \$3891 VPWR VGND
+ sg13cmos5l_dfrbpq_1
* cell instance sg13cmos5l_dfrbpq_1_221 r0 *1 0,0
Xsg13cmos5l_dfrbpq_1_221 \$3838 \$4713 \$4192 \$3891 VPWR VGND
+ sg13cmos5l_dfrbpq_1
* cell instance sg13cmos5l_dfrbpq_1_222 r0 *1 0,0
Xsg13cmos5l_dfrbpq_1_222 \$2270 \$2901 \$2837 \$2613 VPWR VGND
+ sg13cmos5l_dfrbpq_1
* cell instance sg13cmos5l_dfrbpq_1_223 r0 *1 0,0
Xsg13cmos5l_dfrbpq_1_223 \$3838 \$6702 \$4561 \$6796 VPWR VGND
+ sg13cmos5l_dfrbpq_1
* cell instance sg13cmos5l_dfrbpq_1_224 r0 *1 0,0
Xsg13cmos5l_dfrbpq_1_224 \$5361 \$7513 \$7999 \$6796 VPWR VGND
+ sg13cmos5l_dfrbpq_1
* cell instance sg13cmos5l_dfrbpq_1_225 r0 *1 0,0
Xsg13cmos5l_dfrbpq_1_225 \$8197 \$10756 \$10293 \$8832 VPWR VGND
+ sg13cmos5l_dfrbpq_1
* cell instance sg13cmos5l_dfrbpq_1_226 r0 *1 0,0
Xsg13cmos5l_dfrbpq_1_226 \$8197 \$9577 \$9659 \$6796 VPWR VGND
+ sg13cmos5l_dfrbpq_1
* cell instance sg13cmos5l_dfrbpq_1_227 r0 *1 0,0
Xsg13cmos5l_dfrbpq_1_227 \$5361 \$6801 \$6932 \$6796 VPWR VGND
+ sg13cmos5l_dfrbpq_1
* cell instance sg13cmos5l_dfrbpq_1_228 r0 *1 0,0
Xsg13cmos5l_dfrbpq_1_228 \$2270 \$4363 \$4194 \$3891 VPWR VGND
+ sg13cmos5l_dfrbpq_1
* cell instance sg13cmos5l_dfrbpq_1_229 r0 *1 0,0
Xsg13cmos5l_dfrbpq_1_229 \$2270 \$4001 \$4197 \$3891 VPWR VGND
+ sg13cmos5l_dfrbpq_1
* cell instance sg13cmos5l_dfrbpq_1_230 r0 *1 0,0
Xsg13cmos5l_dfrbpq_1_230 \$8197 \$8195 \$8102 \$6796 VPWR VGND
+ sg13cmos5l_dfrbpq_1
* cell instance sg13cmos5l_dfrbpq_1_231 r0 *1 0,0
Xsg13cmos5l_dfrbpq_1_231 \$5361 \$8514 \$8562 \$6796 VPWR VGND
+ sg13cmos5l_dfrbpq_1
* cell instance sg13cmos5l_dfrbpq_1_232 r0 *1 0,0
Xsg13cmos5l_dfrbpq_1_232 \$8197 \$10758 \$10763 \$6796 VPWR VGND
+ sg13cmos5l_dfrbpq_1
* cell instance sg13cmos5l_dfrbpq_1_233 r0 *1 0,0
Xsg13cmos5l_dfrbpq_1_233 \$2270 \$2437 \$2276 \$1721 VPWR VGND
+ sg13cmos5l_dfrbpq_1
* cell instance sg13cmos5l_dfrbpq_1_234 r0 *1 0,0
Xsg13cmos5l_dfrbpq_1_234 \$8197 \$9312 \$9311 \$8832 VPWR VGND
+ sg13cmos5l_dfrbpq_1
* cell instance sg13cmos5l_dfrbpq_1_235 r0 *1 0,0
Xsg13cmos5l_dfrbpq_1_235 \$8197 \$7251 \$7730 \$6796 VPWR VGND
+ sg13cmos5l_dfrbpq_1
* cell instance sg13cmos5l_dfrbpq_1_236 r0 *1 0,0
Xsg13cmos5l_dfrbpq_1_236 \$8197 \$9584 \$9581 \$6944 VPWR VGND
+ sg13cmos5l_dfrbpq_1
* cell instance sg13cmos5l_dfrbpq_1_237 r0 *1 0,0
Xsg13cmos5l_dfrbpq_1_237 \$2270 \$3068 \$2843 \$2613 VPWR VGND
+ sg13cmos5l_dfrbpq_1
* cell instance sg13cmos5l_dfrbpq_1_238 r0 *1 0,0
Xsg13cmos5l_dfrbpq_1_238 \$2270 \$3843 \$3265 \$3847 VPWR VGND
+ sg13cmos5l_dfrbpq_1
* cell instance sg13cmos5l_dfrbpq_1_239 r0 *1 0,0
Xsg13cmos5l_dfrbpq_1_239 \$2270 \$4212 \$4222 \$3847 VPWR VGND
+ sg13cmos5l_dfrbpq_1
* cell instance sg13cmos5l_dfrbpq_1_240 r0 *1 0,0
Xsg13cmos5l_dfrbpq_1_240 \$2270 \$2841 \$2842 \$2613 VPWR VGND
+ sg13cmos5l_dfrbpq_1
* cell instance sg13cmos5l_dfrbpq_1_241 r0 *1 0,0
Xsg13cmos5l_dfrbpq_1_241 \$8197 \$7879 \$8005 \$6944 VPWR VGND
+ sg13cmos5l_dfrbpq_1
* cell instance sg13cmos5l_dfrbpq_1_242 r0 *1 0,0
Xsg13cmos5l_dfrbpq_1_242 \$8197 \$8565 \$8327 \$6944 VPWR VGND
+ sg13cmos5l_dfrbpq_1
* cell instance sg13cmos5l_dfrbpq_1_243 r0 *1 0,0
Xsg13cmos5l_dfrbpq_1_243 \$8197 \$8830 \$8329 \$8832 VPWR VGND
+ sg13cmos5l_dfrbpq_1
* cell instance sg13cmos5l_dfrbpq_1_244 r0 *1 0,0
Xsg13cmos5l_dfrbpq_1_244 \$8197 \$9067 \$9415 \$6944 VPWR VGND
+ sg13cmos5l_dfrbpq_1
* cell instance sg13cmos5l_dfrbpq_1_245 r0 *1 0,0
Xsg13cmos5l_dfrbpq_1_245 \$2270 \$2905 \$2908 \$2613 VPWR VGND
+ sg13cmos5l_dfrbpq_1
* cell instance sg13cmos5l_dfrbpq_1_246 r0 *1 0,0
Xsg13cmos5l_dfrbpq_1_246 \$8197 \$6941 \$6860 \$6944 VPWR VGND
+ sg13cmos5l_dfrbpq_1
* cell instance sg13cmos5l_dfrbpq_1_247 r0 *1 0,0
Xsg13cmos5l_dfrbpq_1_247 \$8197 \$7182 \$7227 \$6944 VPWR VGND
+ sg13cmos5l_dfrbpq_1
* cell instance sg13cmos5l_dfrbpq_1_248 r0 *1 0,0
Xsg13cmos5l_dfrbpq_1_248 \$8197 \$8201 \$8203 \$6944 VPWR VGND
+ sg13cmos5l_dfrbpq_1
* cell instance sg13cmos5l_dfrbpq_1_249 r0 *1 0,0
Xsg13cmos5l_dfrbpq_1_249 \$8197 \$7689 \$7734 \$6944 VPWR VGND
+ sg13cmos5l_dfrbpq_1
* cell instance sg13cmos5l_dfrbpq_1_250 r0 *1 0,0
Xsg13cmos5l_dfrbpq_1_250 \$3838 \$3860 \$3894 \$3459 VPWR VGND
+ sg13cmos5l_dfrbpq_1
* cell instance sg13cmos5l_dfrbpq_1_251 r0 *1 0,0
Xsg13cmos5l_dfrbpq_1_251 \$3838 \$4591 \$4386 \$3459 VPWR VGND
+ sg13cmos5l_dfrbpq_1
* cell instance sg13cmos5l_dfrbpq_1_252 r0 *1 0,0
Xsg13cmos5l_dfrbpq_1_252 \$2270 \$2659 \$2658 \$2613 VPWR VGND
+ sg13cmos5l_dfrbpq_1
* cell instance sg13cmos5l_dfrbpq_1_253 r0 *1 0,0
Xsg13cmos5l_dfrbpq_1_253 \$1726 \$3089 \$3314 \$2613 VPWR VGND
+ sg13cmos5l_dfrbpq_1
* cell instance sg13cmos5l_dfrbpq_1_254 r0 *1 0,0
Xsg13cmos5l_dfrbpq_1_254 \$3838 \$3277 \$3272 \$3459 VPWR VGND
+ sg13cmos5l_dfrbpq_1
* cell instance sg13cmos5l_dfrbpq_1_255 r0 *1 0,0
Xsg13cmos5l_dfrbpq_1_255 \$3838 \$3645 \$3688 \$3459 VPWR VGND
+ sg13cmos5l_dfrbpq_1
* cell instance sg13cmos5l_dfrbpq_1_256 r0 *1 0,0
Xsg13cmos5l_dfrbpq_1_256 \$3838 \$5226 \$5061 \$3891 VPWR VGND
+ sg13cmos5l_dfrbpq_1
* cell instance sg13cmos5l_dfrbpq_1_257 r0 *1 0,0
Xsg13cmos5l_dfrbpq_1_257 \$3838 \$4395 \$4377 \$3847 VPWR VGND
+ sg13cmos5l_dfrbpq_1
* cell instance sg13cmos5l_dfrbpq_1_258 r0 *1 0,0
Xsg13cmos5l_dfrbpq_1_258 \$3838 \$4024 \$4015 \$3459 VPWR VGND
+ sg13cmos5l_dfrbpq_1
* cell instance sg13cmos5l_dfrbpq_1_259 r0 *1 0,0
Xsg13cmos5l_dfrbpq_1_259 \$3838 \$4907 \$4735 \$3459 VPWR VGND
+ sg13cmos5l_dfrbpq_1
* cell instance sg13cmos5l_dfrbpq_1_260 r0 *1 0,0
Xsg13cmos5l_dfrbpq_1_260 \$3838 \$4743 \$4738 \$3847 VPWR VGND
+ sg13cmos5l_dfrbpq_1
* cell instance sg13cmos5l_dfrbpq_1_261 r0 *1 0,0
Xsg13cmos5l_dfrbpq_1_261 \$3838 \$3873 \$4017 \$3459 VPWR VGND
+ sg13cmos5l_dfrbpq_1
* cell instance sg13cmos5l_dfrbpq_1_262 r0 *1 0,0
Xsg13cmos5l_dfrbpq_1_262 \$3838 \$4234 \$4380 \$3459 VPWR VGND
+ sg13cmos5l_dfrbpq_1
* cell instance sg13cmos5l_dfrbpq_1_263 r0 *1 0,0
Xsg13cmos5l_dfrbpq_1_263 \$3838 \$5065 \$5057 \$3891 VPWR VGND
+ sg13cmos5l_dfrbpq_1
* cell instance sg13cmos5l_dlygate4sd3_1_0 r0 *1 0,0
Xsg13cmos5l_dlygate4sd3_1_0 \$1931 VPWR VGND \$1750 sg13cmos5l_dlygate4sd3_1
* cell instance sg13cmos5l_dlygate4sd3_1_1 r0 *1 0,0
Xsg13cmos5l_dlygate4sd3_1_1 \$1590 VPWR VGND \$1427 sg13cmos5l_dlygate4sd3_1
* cell instance sg13cmos5l_dlygate4sd3_1_2 r0 *1 0,0
Xsg13cmos5l_dlygate4sd3_1_2 \$6879 VPWR VGND \$6875 sg13cmos5l_dlygate4sd3_1
* cell instance sg13cmos5l_dlygate4sd3_1_3 r0 *1 0,0
Xsg13cmos5l_dlygate4sd3_1_3 \$6019 VPWR VGND \$6191 sg13cmos5l_dlygate4sd3_1
* cell instance sg13cmos5l_dlygate4sd3_1_4 r0 *1 0,0
Xsg13cmos5l_dlygate4sd3_1_4 \$1180 VPWR VGND \$1302 sg13cmos5l_dlygate4sd3_1
* cell instance sg13cmos5l_dlygate4sd3_1_5 r0 *1 0,0
Xsg13cmos5l_dlygate4sd3_1_5 \$10765 VPWR VGND \$11395 sg13cmos5l_dlygate4sd3_1
* cell instance sg13cmos5l_dlygate4sd3_1_6 r0 *1 0,0
Xsg13cmos5l_dlygate4sd3_1_6 \$12309 VPWR VGND \$12922 sg13cmos5l_dlygate4sd3_1
* cell instance sg13cmos5l_dlygate4sd3_1_7 r0 *1 0,0
Xsg13cmos5l_dlygate4sd3_1_7 \$7456 VPWR VGND \$7533 sg13cmos5l_dlygate4sd3_1
* cell instance sg13cmos5l_dlygate4sd3_1_8 r0 *1 0,0
Xsg13cmos5l_dlygate4sd3_1_8 \$1441 VPWR VGND \$1600 sg13cmos5l_dlygate4sd3_1
* cell instance sg13cmos5l_dlygate4sd3_1_9 r0 *1 0,0
Xsg13cmos5l_dlygate4sd3_1_9 \$2309 VPWR VGND \$2119 sg13cmos5l_dlygate4sd3_1
* cell instance sg13cmos5l_dlygate4sd3_1_10 r0 *1 0,0
Xsg13cmos5l_dlygate4sd3_1_10 \$3505 VPWR VGND \$3322 sg13cmos5l_dlygate4sd3_1
* cell instance sg13cmos5l_dlygate4sd3_1_11 r0 *1 0,0
Xsg13cmos5l_dlygate4sd3_1_11 \$3323 VPWR VGND \$3899 sg13cmos5l_dlygate4sd3_1
* cell instance sg13cmos5l_dlygate4sd3_1_12 r0 *1 0,0
Xsg13cmos5l_dlygate4sd3_1_12 \$6737 VPWR VGND \$6732 sg13cmos5l_dlygate4sd3_1
* cell instance sg13cmos5l_dlygate4sd3_1_13 r0 *1 0,0
Xsg13cmos5l_dlygate4sd3_1_13 \$6966 VPWR VGND \$7255 sg13cmos5l_dlygate4sd3_1
* cell instance sg13cmos5l_dlygate4sd3_1_14 r0 *1 0,0
Xsg13cmos5l_dlygate4sd3_1_14 \$10124 VPWR VGND \$10460 sg13cmos5l_dlygate4sd3_1
* cell instance sg13cmos5l_dlygate4sd3_1_15 r0 *1 0,0
Xsg13cmos5l_dlygate4sd3_1_15 \$751 VPWR VGND \$611 sg13cmos5l_dlygate4sd3_1
* cell instance sg13cmos5l_dlygate4sd3_1_16 r0 *1 0,0
Xsg13cmos5l_dlygate4sd3_1_16 \$1760 VPWR VGND \$1935 sg13cmos5l_dlygate4sd3_1
* cell instance sg13cmos5l_dlygate4sd3_1_17 r0 *1 0,0
Xsg13cmos5l_dlygate4sd3_1_17 \$4437 VPWR VGND \$4257 sg13cmos5l_dlygate4sd3_1
* cell instance sg13cmos5l_dlygate4sd3_1_18 r0 *1 0,0
Xsg13cmos5l_dlygate4sd3_1_18 \$3720 VPWR VGND \$2869 sg13cmos5l_dlygate4sd3_1
* cell instance sg13cmos5l_dlygate4sd3_1_19 r0 *1 0,0
Xsg13cmos5l_dlygate4sd3_1_19 \$2485 VPWR VGND \$2679 sg13cmos5l_dlygate4sd3_1
* cell instance sg13cmos5l_dlygate4sd3_1_20 r0 *1 0,0
Xsg13cmos5l_dlygate4sd3_1_20 \$3916 VPWR VGND \$5109 sg13cmos5l_dlygate4sd3_1
* cell instance sg13cmos5l_dlygate4sd3_1_21 r0 *1 0,0
Xsg13cmos5l_dlygate4sd3_1_21 \$6224 VPWR VGND \$6026 sg13cmos5l_dlygate4sd3_1
* cell instance sg13cmos5l_dlygate4sd3_1_22 r0 *1 0,0
Xsg13cmos5l_dlygate4sd3_1_22 \$6434 VPWR VGND \$8819 sg13cmos5l_dlygate4sd3_1
* cell instance sg13cmos5l_dlygate4sd3_1_23 r0 *1 0,0
Xsg13cmos5l_dlygate4sd3_1_23 \$8345 VPWR VGND \$8549 sg13cmos5l_dlygate4sd3_1
* cell instance sg13cmos5l_dlygate4sd3_1_24 r0 *1 0,0
Xsg13cmos5l_dlygate4sd3_1_24 \$2143 VPWR VGND \$5462 sg13cmos5l_dlygate4sd3_1
* cell instance sg13cmos5l_dlygate4sd3_1_25 r0 *1 0,0
Xsg13cmos5l_dlygate4sd3_1_25 \$9323 VPWR VGND \$9503 sg13cmos5l_dlygate4sd3_1
* cell instance sg13cmos5l_dlygate4sd3_1_26 r0 *1 0,0
Xsg13cmos5l_dlygate4sd3_1_26 \$5843 VPWR VGND \$5788 sg13cmos5l_dlygate4sd3_1
* cell instance sg13cmos5l_dlygate4sd3_1_27 r0 *1 0,0
Xsg13cmos5l_dlygate4sd3_1_27 \$6884 VPWR VGND \$6973 sg13cmos5l_dlygate4sd3_1
* cell instance sg13cmos5l_dlygate4sd3_1_28 r0 *1 0,0
Xsg13cmos5l_dlygate4sd3_1_28 \$6013 VPWR VGND \$9085 sg13cmos5l_dlygate4sd3_1
* cell instance sg13cmos5l_dlygate4sd3_1_29 r0 *1 0,0
Xsg13cmos5l_dlygate4sd3_1_29 \$11971 VPWR VGND \$12310 sg13cmos5l_dlygate4sd3_1
* cell instance sg13cmos5l_dlygate4sd3_1_30 r0 *1 0,0
Xsg13cmos5l_dlygate4sd3_1_30 \$6533 VPWR VGND \$10740 sg13cmos5l_dlygate4sd3_1
* cell instance sg13cmos5l_dlygate4sd3_1_31 r0 *1 0,0
Xsg13cmos5l_dlygate4sd3_1_31 \$234 VPWR VGND \$238 sg13cmos5l_dlygate4sd3_1
* cell instance sg13cmos5l_dlygate4sd3_1_32 r0 *1 0,0
Xsg13cmos5l_dlygate4sd3_1_32 \$7542 VPWR VGND \$8134 sg13cmos5l_dlygate4sd3_1
* cell instance sg13cmos5l_dlygate4sd3_1_33 r0 *1 0,0
Xsg13cmos5l_dlygate4sd3_1_33 \$3505 VPWR VGND \$3664 sg13cmos5l_dlygate4sd3_1
* cell instance sg13cmos5l_dlygate4sd3_1_34 r0 *1 0,0
Xsg13cmos5l_dlygate4sd3_1_34 \$5855 VPWR VGND \$6017 sg13cmos5l_dlygate4sd3_1
* cell instance sg13cmos5l_dlygate4sd3_1_35 r0 *1 0,0
Xsg13cmos5l_dlygate4sd3_1_35 \$754 VPWR VGND \$760 sg13cmos5l_dlygate4sd3_1
* cell instance sg13cmos5l_dlygate4sd3_1_36 r0 *1 0,0
Xsg13cmos5l_dlygate4sd3_1_36 \$9823 VPWR VGND \$10917 sg13cmos5l_dlygate4sd3_1
* cell instance sg13cmos5l_dlygate4sd3_1_37 r0 *1 0,0
Xsg13cmos5l_dlygate4sd3_1_37 \$5152 VPWR VGND \$5467 sg13cmos5l_dlygate4sd3_1
* cell instance sg13cmos5l_dlygate4sd3_1_38 r0 *1 0,0
Xsg13cmos5l_dlygate4sd3_1_38 \$17273 VPWR VGND \$17271 sg13cmos5l_dlygate4sd3_1
* cell instance sg13cmos5l_dlygate4sd3_1_39 r0 *1 0,0
Xsg13cmos5l_dlygate4sd3_1_39 \$4772 VPWR VGND \$3904 sg13cmos5l_dlygate4sd3_1
* cell instance sg13cmos5l_dlygate4sd3_1_40 r0 *1 0,0
Xsg13cmos5l_dlygate4sd3_1_40 \$2485 VPWR VGND \$2129 sg13cmos5l_dlygate4sd3_1
* cell instance sg13cmos5l_dlygate4sd3_1_41 r0 *1 0,0
Xsg13cmos5l_dlygate4sd3_1_41 \$1444 VPWR VGND \$1310 sg13cmos5l_dlygate4sd3_1
* cell instance sg13cmos5l_dlygate4sd3_1_42 r0 *1 0,0
Xsg13cmos5l_dlygate4sd3_1_42 \$7541 VPWR VGND \$14405 sg13cmos5l_dlygate4sd3_1
* cell instance sg13cmos5l_dlygate4sd3_1_43 r0 *1 0,0
Xsg13cmos5l_dlygate4sd3_1_43 \$6746 VPWR VGND \$15431 sg13cmos5l_dlygate4sd3_1
* cell instance sg13cmos5l_dlygate4sd3_1_44 r0 *1 0,0
Xsg13cmos5l_dlygate4sd3_1_44 \$6888 VPWR VGND \$6882 sg13cmos5l_dlygate4sd3_1
* cell instance sg13cmos5l_dlygate4sd3_1_45 r0 *1 0,0
Xsg13cmos5l_dlygate4sd3_1_45 uio_out[3] VPWR VGND \$19486
+ sg13cmos5l_dlygate4sd3_1
* cell instance sg13cmos5l_dlygate4sd3_1_46 r0 *1 0,0
Xsg13cmos5l_dlygate4sd3_1_46 \$7534 VPWR VGND \$7489 sg13cmos5l_dlygate4sd3_1
* cell instance sg13cmos5l_dlygate4sd3_1_47 r0 *1 0,0
Xsg13cmos5l_dlygate4sd3_1_47 \$8556 VPWR VGND \$16429 sg13cmos5l_dlygate4sd3_1
* cell instance sg13cmos5l_dlygate4sd3_1_48 r0 *1 0,0
Xsg13cmos5l_dlygate4sd3_1_48 \$3723 VPWR VGND \$3330 sg13cmos5l_dlygate4sd3_1
* cell instance sg13cmos5l_dlygate4sd3_1_49 r0 *1 0,0
Xsg13cmos5l_dlygate4sd3_1_49 \$9143 VPWR VGND \$9825 sg13cmos5l_dlygate4sd3_1
* cell instance sg13cmos5l_dlygate4sd3_1_50 r0 *1 0,0
Xsg13cmos5l_dlygate4sd3_1_50 uio_out[7] VPWR VGND \$19413
+ sg13cmos5l_dlygate4sd3_1
* cell instance sg13cmos5l_dlygate4sd3_1_51 r0 *1 0,0
Xsg13cmos5l_dlygate4sd3_1_51 \$5116 VPWR VGND \$5114 sg13cmos5l_dlygate4sd3_1
* cell instance sg13cmos5l_dlygate4sd3_1_52 r0 *1 0,0
Xsg13cmos5l_dlygate4sd3_1_52 \$10920 VPWR VGND \$10919 sg13cmos5l_dlygate4sd3_1
* cell instance sg13cmos5l_dlygate4sd3_1_53 r0 *1 0,0
Xsg13cmos5l_dlygate4sd3_1_53 \$12739 VPWR VGND \$12311 sg13cmos5l_dlygate4sd3_1
* cell instance sg13cmos5l_dlygate4sd3_1_54 r0 *1 0,0
Xsg13cmos5l_dlygate4sd3_1_54 \$10297 VPWR VGND \$10134 sg13cmos5l_dlygate4sd3_1
* cell instance sg13cmos5l_dlygate4sd3_1_55 r0 *1 0,0
Xsg13cmos5l_dlygate4sd3_1_55 \$460 VPWR VGND \$462 sg13cmos5l_dlygate4sd3_1
* cell instance sg13cmos5l_dlygate4sd3_1_56 r0 *1 0,0
Xsg13cmos5l_dlygate4sd3_1_56 \$245 VPWR VGND \$244 sg13cmos5l_dlygate4sd3_1
* cell instance sg13cmos5l_dlygate4sd3_1_57 r0 *1 0,0
Xsg13cmos5l_dlygate4sd3_1_57 \$12043 VPWR VGND \$11973 sg13cmos5l_dlygate4sd3_1
* cell instance sg13cmos5l_dlygate4sd3_1_58 r0 *1 0,0
Xsg13cmos5l_dlygate4sd3_1_58 uio_out[5] VPWR VGND \$17277
+ sg13cmos5l_dlygate4sd3_1
* cell instance sg13cmos5l_dlygate4sd3_1_59 r0 *1 0,0
Xsg13cmos5l_dlygate4sd3_1_59 \$7901 VPWR VGND \$18971 sg13cmos5l_dlygate4sd3_1
* cell instance sg13cmos5l_dlygate4sd3_1_60 r0 *1 0,0
Xsg13cmos5l_dlygate4sd3_1_60 \$904 VPWR VGND \$906 sg13cmos5l_dlygate4sd3_1
* cell instance sg13cmos5l_dlygate4sd3_1_61 r0 *1 0,0
Xsg13cmos5l_dlygate4sd3_1_61 \$1574 VPWR VGND \$1606 sg13cmos5l_dlygate4sd3_1
* cell instance sg13cmos5l_dlygate4sd3_1_62 r0 *1 0,0
Xsg13cmos5l_dlygate4sd3_1_62 \$8039 VPWR VGND \$8227 sg13cmos5l_dlygate4sd3_1
* cell instance sg13cmos5l_dlygate4sd3_1_63 r0 *1 0,0
Xsg13cmos5l_dlygate4sd3_1_63 \$12313 VPWR VGND \$11972 sg13cmos5l_dlygate4sd3_1
* cell instance sg13cmos5l_dlygate4sd3_1_64 r0 *1 0,0
Xsg13cmos5l_dlygate4sd3_1_64 \$9664 VPWR VGND \$13962 sg13cmos5l_dlygate4sd3_1
* cell instance sg13cmos5l_dlygate4sd3_1_65 r0 *1 0,0
Xsg13cmos5l_dlygate4sd3_1_65 \$9326 VPWR VGND \$7893 sg13cmos5l_dlygate4sd3_1
* cell instance sg13cmos5l_dlygate4sd3_1_66 r0 *1 0,0
Xsg13cmos5l_dlygate4sd3_1_66 \$751 VPWR VGND \$1949 sg13cmos5l_dlygate4sd3_1
* cell instance sg13cmos5l_dlygate4sd3_1_67 r0 *1 0,0
Xsg13cmos5l_dlygate4sd3_1_67 \$5633 VPWR VGND \$14888 sg13cmos5l_dlygate4sd3_1
* cell instance sg13cmos5l_dlygate4sd3_1_68 r0 *1 0,0
Xsg13cmos5l_dlygate4sd3_1_68 \$3336 VPWR VGND \$3132 sg13cmos5l_dlygate4sd3_1
* cell instance sg13cmos5l_dlygate4sd3_1_69 r0 *1 0,0
Xsg13cmos5l_dlygate4sd3_1_69 \$10923 VPWR VGND \$15929 sg13cmos5l_dlygate4sd3_1
* cell instance sg13cmos5l_dlygate4sd3_1_70 r0 *1 0,0
Xsg13cmos5l_dlygate4sd3_1_70 \$3134 VPWR VGND \$4079 sg13cmos5l_dlygate4sd3_1
* cell instance sg13cmos5l_dlygate4sd3_1_71 r0 *1 0,0
Xsg13cmos5l_dlygate4sd3_1_71 \$5147 VPWR VGND \$5853 sg13cmos5l_dlygate4sd3_1
* cell instance sg13cmos5l_dlygate4sd3_1_72 r0 *1 0,0
Xsg13cmos5l_dlygate4sd3_1_72 \$10743 VPWR VGND \$12312 sg13cmos5l_dlygate4sd3_1
* cell instance sg13cmos5l_dlygate4sd3_1_73 r0 *1 0,0
Xsg13cmos5l_dlygate4sd3_1_73 \$7457 VPWR VGND \$7322 sg13cmos5l_dlygate4sd3_1
* cell instance sg13cmos5l_dlygate4sd3_1_74 r0 *1 0,0
Xsg13cmos5l_dlygate4sd3_1_74 \$11078 VPWR VGND \$9827 sg13cmos5l_dlygate4sd3_1
* cell instance sg13cmos5l_dlygate4sd3_1_75 r0 *1 0,0
Xsg13cmos5l_dlygate4sd3_1_75 \$11822 VPWR VGND \$11401 sg13cmos5l_dlygate4sd3_1
* cell instance sg13cmos5l_dlygate4sd3_1_76 r0 *1 0,0
Xsg13cmos5l_dlygate4sd3_1_76 \$761 VPWR VGND \$764 sg13cmos5l_dlygate4sd3_1
* cell instance sg13cmos5l_dlygate4sd3_1_77 r0 *1 0,0
Xsg13cmos5l_dlygate4sd3_1_77 \$5132 VPWR VGND \$5120 sg13cmos5l_dlygate4sd3_1
* cell instance sg13cmos5l_dlygate4sd3_1_78 r0 *1 0,0
Xsg13cmos5l_dlygate4sd3_1_78 \$6425 VPWR VGND \$6422 sg13cmos5l_dlygate4sd3_1
* cell instance sg13cmos5l_dlygate4sd3_1_79 r0 *1 0,0
Xsg13cmos5l_dlygate4sd3_1_79 uio_out[6] VPWR VGND \$19493
+ sg13cmos5l_dlygate4sd3_1
* cell instance sg13cmos5l_dlygate4sd3_1_80 r0 *1 0,0
Xsg13cmos5l_dlygate4sd3_1_80 \$8821 VPWR VGND \$9147 sg13cmos5l_dlygate4sd3_1
* cell instance sg13cmos5l_dlygate4sd3_1_81 r0 *1 0,0
Xsg13cmos5l_dlygate4sd3_1_81 \$4646 VPWR VGND \$3334 sg13cmos5l_dlygate4sd3_1
* cell instance sg13cmos5l_dlygate4sd3_1_82 r0 *1 0,0
Xsg13cmos5l_dlygate4sd3_1_82 \$3710 VPWR VGND \$3695 sg13cmos5l_dlygate4sd3_1
* cell instance sg13cmos5l_dlygate4sd3_1_83 r0 *1 0,0
Xsg13cmos5l_dlygate4sd3_1_83 \$13289 VPWR VGND \$10921 sg13cmos5l_dlygate4sd3_1
* cell instance sg13cmos5l_dlygate4sd3_1_84 r0 *1 0,0
Xsg13cmos5l_dlygate4sd3_1_84 \$6849 VPWR VGND \$6850 sg13cmos5l_dlygate4sd3_1
* cell instance sg13cmos5l_dlygate4sd3_1_85 r0 *1 0,0
Xsg13cmos5l_dlygate4sd3_1_85 \$8042 VPWR VGND \$8139 sg13cmos5l_dlygate4sd3_1
* cell instance sg13cmos5l_dlygate4sd3_1_86 r0 *1 0,0
Xsg13cmos5l_dlygate4sd3_1_86 \$9328 VPWR VGND \$9426 sg13cmos5l_dlygate4sd3_1
* cell instance sg13cmos5l_dlygate4sd3_1_87 r0 *1 0,0
Xsg13cmos5l_dlygate4sd3_1_87 \$6039 VPWR VGND \$6035 sg13cmos5l_dlygate4sd3_1
* cell instance sg13cmos5l_dlygate4sd3_1_88 r0 *1 0,0
Xsg13cmos5l_dlygate4sd3_1_88 \$262 VPWR VGND \$372 sg13cmos5l_dlygate4sd3_1
* cell instance sg13cmos5l_dlygate4sd3_1_89 r0 *1 0,0
Xsg13cmos5l_dlygate4sd3_1_89 \$1954 VPWR VGND \$1952 sg13cmos5l_dlygate4sd3_1
* cell instance sg13cmos5l_dlygate4sd3_1_90 r0 *1 0,0
Xsg13cmos5l_dlygate4sd3_1_90 \$2291 VPWR VGND \$2699 sg13cmos5l_dlygate4sd3_1
* cell instance sg13cmos5l_dlygate4sd3_1_91 r0 *1 0,0
Xsg13cmos5l_dlygate4sd3_1_91 \$5640 VPWR VGND \$17991 sg13cmos5l_dlygate4sd3_1
* cell instance sg13cmos5l_dlygate4sd3_1_92 r0 *1 0,0
Xsg13cmos5l_dlygate4sd3_1_92 uio_out[2] VPWR VGND \$18972
+ sg13cmos5l_dlygate4sd3_1
* cell instance sg13cmos5l_dlygate4sd3_1_93 r0 *1 0,0
Xsg13cmos5l_dlygate4sd3_1_93 \$4271 VPWR VGND \$4269 sg13cmos5l_dlygate4sd3_1
* cell instance sg13cmos5l_dlygate4sd3_1_94 r0 *1 0,0
Xsg13cmos5l_dlygate4sd3_1_94 \$5479 VPWR VGND \$6005 sg13cmos5l_dlygate4sd3_1
* cell instance sg13cmos5l_dlygate4sd3_1_95 r0 *1 0,0
Xsg13cmos5l_dlygate4sd3_1_95 \$10770 VPWR VGND \$16433 sg13cmos5l_dlygate4sd3_1
* cell instance sg13cmos5l_dlygate4sd3_1_96 r0 *1 0,0
Xsg13cmos5l_dlygate4sd3_1_96 \$775 VPWR VGND \$915 sg13cmos5l_dlygate4sd3_1
* cell instance sg13cmos5l_dlygate4sd3_1_97 r0 *1 0,0
Xsg13cmos5l_dlygate4sd3_1_97 \$6851 VPWR VGND \$14411 sg13cmos5l_dlygate4sd3_1
* cell instance sg13cmos5l_dlygate4sd3_1_98 r0 *1 0,0
Xsg13cmos5l_dlygate4sd3_1_98 \$6439 VPWR VGND \$16954 sg13cmos5l_dlygate4sd3_1
* cell instance sg13cmos5l_dlygate4sd3_1_99 r0 *1 0,0
Xsg13cmos5l_dlygate4sd3_1_99 \$473 VPWR VGND \$377 sg13cmos5l_dlygate4sd3_1
* cell instance sg13cmos5l_dlygate4sd3_1_100 r0 *1 0,0
Xsg13cmos5l_dlygate4sd3_1_100 \$7897 VPWR VGND \$7896 sg13cmos5l_dlygate4sd3_1
* cell instance sg13cmos5l_dlygate4sd3_1_101 r0 *1 0,0
Xsg13cmos5l_dlygate4sd3_1_101 \$158 VPWR VGND \$263 sg13cmos5l_dlygate4sd3_1
* cell instance sg13cmos5l_dlygate4sd3_1_102 r0 *1 0,0
Xsg13cmos5l_dlygate4sd3_1_102 \$9505 VPWR VGND \$7544 sg13cmos5l_dlygate4sd3_1
* cell instance sg13cmos5l_dlygate4sd3_1_103 r0 *1 0,0
Xsg13cmos5l_dlygate4sd3_1_103 \$13814 VPWR VGND \$12315 sg13cmos5l_dlygate4sd3_1
* cell instance sg13cmos5l_dlygate4sd3_1_104 r0 *1 0,0
Xsg13cmos5l_dlygate4sd3_1_104 \$12750 VPWR VGND \$13963 sg13cmos5l_dlygate4sd3_1
* cell instance sg13cmos5l_dlygate4sd3_1_105 r0 *1 0,0
Xsg13cmos5l_dlygate4sd3_1_105 uio_out[1] VPWR VGND \$19472
+ sg13cmos5l_dlygate4sd3_1
* cell instance sg13cmos5l_dlygate4sd3_1_106 r0 *1 0,0
Xsg13cmos5l_dlygate4sd3_1_106 \$11827 VPWR VGND \$11975 sg13cmos5l_dlygate4sd3_1
* cell instance sg13cmos5l_dlygate4sd3_1_107 r0 *1 0,0
Xsg13cmos5l_dlygate4sd3_1_107 \$3527 VPWR VGND \$5266 sg13cmos5l_dlygate4sd3_1
* cell instance sg13cmos5l_dlygate4sd3_1_108 r0 *1 0,0
Xsg13cmos5l_dlygate4sd3_1_108 \$9504 VPWR VGND \$10086 sg13cmos5l_dlygate4sd3_1
* cell instance sg13cmos5l_dlygate4sd3_1_109 r0 *1 0,0
Xsg13cmos5l_dlygate4sd3_1_109 \$8823 VPWR VGND \$7545 sg13cmos5l_dlygate4sd3_1
* cell instance sg13cmos5l_dlygate4sd3_1_110 r0 *1 0,0
Xsg13cmos5l_dlygate4sd3_1_110 \$12836 VPWR VGND \$12314 sg13cmos5l_dlygate4sd3_1
* cell instance sg13cmos5l_dlygate4sd3_1_111 r0 *1 0,0
Xsg13cmos5l_dlygate4sd3_1_111 \$4275 VPWR VGND \$4950 sg13cmos5l_dlygate4sd3_1
* cell instance sg13cmos5l_dlygate4sd3_1_112 r0 *1 0,0
Xsg13cmos5l_dlygate4sd3_1_112 \$6442 VPWR VGND \$6446 sg13cmos5l_dlygate4sd3_1
* cell instance sg13cmos5l_dlygate4sd3_1_113 r0 *1 0,0
Xsg13cmos5l_dlygate4sd3_1_113 uio_out[4] VPWR VGND \$17992
+ sg13cmos5l_dlygate4sd3_1
* cell instance sg13cmos5l_dlygate4sd3_1_114 r0 *1 0,0
Xsg13cmos5l_dlygate4sd3_1_114 \$6908 VPWR VGND \$6911 sg13cmos5l_dlygate4sd3_1
* cell instance sg13cmos5l_dlygate4sd3_1_115 r0 *1 0,0
Xsg13cmos5l_dlygate4sd3_1_115 \$7904 VPWR VGND \$16434 sg13cmos5l_dlygate4sd3_1
* cell instance sg13cmos5l_dlygate4sd3_1_116 r0 *1 0,0
Xsg13cmos5l_dlygate4sd3_1_116 \$13303 VPWR VGND \$13377 sg13cmos5l_dlygate4sd3_1
* cell instance sg13cmos5l_dlygate4sd3_1_117 r0 *1 0,0
Xsg13cmos5l_dlygate4sd3_1_117 \$6775 VPWR VGND \$16955 sg13cmos5l_dlygate4sd3_1
* cell instance sg13cmos5l_dlygate4sd3_1_118 r0 *1 0,0
Xsg13cmos5l_dlygate4sd3_1_118 \$12751 VPWR VGND \$12316 sg13cmos5l_dlygate4sd3_1
* cell instance sg13cmos5l_dlygate4sd3_1_119 r0 *1 0,0
Xsg13cmos5l_dlygate4sd3_1_119 \$5865 VPWR VGND \$15436 sg13cmos5l_dlygate4sd3_1
* cell instance sg13cmos5l_dlygate4sd3_1_120 r0 *1 0,0
Xsg13cmos5l_dlygate4sd3_1_120 \$478 VPWR VGND \$489 sg13cmos5l_dlygate4sd3_1
* cell instance sg13cmos5l_dlygate4sd3_1_121 r0 *1 0,0
Xsg13cmos5l_dlygate4sd3_1_121 uo_out[2] VPWR VGND \$19322
+ sg13cmos5l_dlygate4sd3_1
* cell instance sg13cmos5l_dlygate4sd3_1_122 r0 *1 0,0
Xsg13cmos5l_dlygate4sd3_1_122 \$8860 VPWR VGND \$9211 sg13cmos5l_dlygate4sd3_1
* cell instance sg13cmos5l_dlygate4sd3_1_123 r0 *1 0,0
Xsg13cmos5l_dlygate4sd3_1_123 \$9506 VPWR VGND \$7905 sg13cmos5l_dlygate4sd3_1
* cell instance sg13cmos5l_dlygate4sd3_1_124 r0 *1 0,0
Xsg13cmos5l_dlygate4sd3_1_124 \$1476 VPWR VGND \$1478 sg13cmos5l_dlygate4sd3_1
* cell instance sg13cmos5l_dlygate4sd3_1_125 r0 *1 0,0
Xsg13cmos5l_dlygate4sd3_1_125 \$9552 VPWR VGND \$9547 sg13cmos5l_dlygate4sd3_1
* cell instance sg13cmos5l_dlygate4sd3_1_126 r0 *1 0,0
Xsg13cmos5l_dlygate4sd3_1_126 \$13380 VPWR VGND \$12927 sg13cmos5l_dlygate4sd3_1
* cell instance sg13cmos5l_dlygate4sd3_1_127 r0 *1 0,0
Xsg13cmos5l_dlygate4sd3_1_127 \$85 VPWR VGND \$78 sg13cmos5l_dlygate4sd3_1
* cell instance sg13cmos5l_dlygate4sd3_1_128 r0 *1 0,0
Xsg13cmos5l_dlygate4sd3_1_128 \$4284 VPWR VGND \$4281 sg13cmos5l_dlygate4sd3_1
* cell instance sg13cmos5l_dlygate4sd3_1_129 r0 *1 0,0
Xsg13cmos5l_dlygate4sd3_1_129 \$4481 VPWR VGND \$5273 sg13cmos5l_dlygate4sd3_1
* cell instance sg13cmos5l_dlygate4sd3_1_130 r0 *1 0,0
Xsg13cmos5l_dlygate4sd3_1_130 \$785 VPWR VGND \$788 sg13cmos5l_dlygate4sd3_1
* cell instance sg13cmos5l_dlygate4sd3_1_131 r0 *1 0,0
Xsg13cmos5l_dlygate4sd3_1_131 uo_out[4] VPWR VGND \$18441
+ sg13cmos5l_dlygate4sd3_1
* cell instance sg13cmos5l_dlygate4sd3_1_132 r0 *1 0,0
Xsg13cmos5l_dlygate4sd3_1_132 \$5873 VPWR VGND \$8054 sg13cmos5l_dlygate4sd3_1
* cell instance sg13cmos5l_dlygate4sd3_1_133 r0 *1 0,0
Xsg13cmos5l_dlygate4sd3_1_133 uo_out[3] VPWR VGND \$19511
+ sg13cmos5l_dlygate4sd3_1
* cell instance sg13cmos5l_dlygate4sd3_1_134 r0 *1 0,0
Xsg13cmos5l_dlygate4sd3_1_134 \$8539 VPWR VGND \$9089 sg13cmos5l_dlygate4sd3_1
* cell instance sg13cmos5l_dlygate4sd3_1_135 r0 *1 0,0
Xsg13cmos5l_dlygate4sd3_1_135 \$12219 VPWR VGND \$11976 sg13cmos5l_dlygate4sd3_1
* cell instance sg13cmos5l_dlygate4sd3_1_136 r0 *1 0,0
Xsg13cmos5l_dlygate4sd3_1_136 \$10926 VPWR VGND \$10138 sg13cmos5l_dlygate4sd3_1
* cell instance sg13cmos5l_dlygate4sd3_1_137 r0 *1 0,0
Xsg13cmos5l_dlygate4sd3_1_137 \$6260 VPWR VGND \$9088 sg13cmos5l_dlygate4sd3_1
* cell instance sg13cmos5l_dlygate4sd3_1_138 r0 *1 0,0
Xsg13cmos5l_dlygate4sd3_1_138 \$8554 VPWR VGND \$9557 sg13cmos5l_dlygate4sd3_1
* cell instance sg13cmos5l_dlygate4sd3_1_139 r0 *1 0,0
Xsg13cmos5l_dlygate4sd3_1_139 uo_out[7] VPWR VGND \$18975
+ sg13cmos5l_dlygate4sd3_1
* cell instance sg13cmos5l_dlygate4sd3_1_140 r0 *1 0,0
Xsg13cmos5l_dlygate4sd3_1_140 uo_out[5] VPWR VGND \$17297
+ sg13cmos5l_dlygate4sd3_1
* cell instance sg13cmos5l_dlygate4sd3_1_141 r0 *1 0,0
Xsg13cmos5l_dlygate4sd3_1_141 \$931 VPWR VGND \$924 sg13cmos5l_dlygate4sd3_1
* cell instance sg13cmos5l_dlygate4sd3_1_142 r0 *1 0,0
Xsg13cmos5l_dlygate4sd3_1_142 \$6915 VPWR VGND \$6853 sg13cmos5l_dlygate4sd3_1
* cell instance sg13cmos5l_dlygate4sd3_1_143 r0 *1 0,0
Xsg13cmos5l_dlygate4sd3_1_143 \$11218 VPWR VGND \$14414 sg13cmos5l_dlygate4sd3_1
* cell instance sg13cmos5l_dlygate4sd3_1_144 r0 *1 0,0
Xsg13cmos5l_dlygate4sd3_1_144 uio_out[0] VPWR VGND \$16287
+ sg13cmos5l_dlygate4sd3_1
* cell instance sg13cmos5l_dlygate4sd3_1_145 r0 *1 0,0
Xsg13cmos5l_dlygate4sd3_1_145 uo_out[0] VPWR VGND \$17295
+ sg13cmos5l_dlygate4sd3_1
* cell instance sg13cmos5l_dlygate4sd3_1_146 r0 *1 0,0
Xsg13cmos5l_dlygate4sd3_1_146 \$6047 VPWR VGND \$6053 sg13cmos5l_dlygate4sd3_1
* cell instance sg13cmos5l_dlygate4sd3_1_147 r0 *1 0,0
Xsg13cmos5l_dlygate4sd3_1_147 \$388 VPWR VGND \$390 sg13cmos5l_dlygate4sd3_1
* cell instance sg13cmos5l_dlygate4sd3_1_148 r0 *1 0,0
Xsg13cmos5l_dlygate4sd3_1_148 \$4482 VPWR VGND \$4832 sg13cmos5l_dlygate4sd3_1
* cell instance sg13cmos5l_dlygate4sd3_1_149 r0 *1 0,0
Xsg13cmos5l_dlygate4sd3_1_149 \$5278 VPWR VGND \$5283 sg13cmos5l_dlygate4sd3_1
* cell instance sg13cmos5l_dlygate4sd3_1_150 r0 *1 0,0
Xsg13cmos5l_dlygate4sd3_1_150 \$1211 VPWR VGND \$1065 sg13cmos5l_dlygate4sd3_1
* cell instance sg13cmos5l_dlygate4sd3_1_151 r0 *1 0,0
Xsg13cmos5l_dlygate4sd3_1_151 \$84 VPWR VGND \$92 sg13cmos5l_dlygate4sd3_1
* cell instance sg13cmos5l_dlygate4sd3_1_152 r0 *1 0,0
Xsg13cmos5l_dlygate4sd3_1_152 \$4833 VPWR VGND \$5079 sg13cmos5l_dlygate4sd3_1
* cell instance sg13cmos5l_dlygate4sd3_1_153 r0 *1 0,0
Xsg13cmos5l_dlygate4sd3_1_153 \$1203 VPWR VGND \$935 sg13cmos5l_dlygate4sd3_1
* cell instance sg13cmos5l_dlygate4sd3_1_154 r0 *1 0,0
Xsg13cmos5l_dlygate4sd3_1_154 \$6259 VPWR VGND \$6060 sg13cmos5l_dlygate4sd3_1
* cell instance sg13cmos5l_dlygate4sd3_1_155 r0 *1 0,0
Xsg13cmos5l_dlygate4sd3_1_155 \$352 VPWR VGND \$382 sg13cmos5l_dlygate4sd3_1
* cell instance sg13cmos5l_dlygate4sd3_1_156 r0 *1 0,0
Xsg13cmos5l_dlygate4sd3_1_156 uo_out[6] VPWR VGND \$19561
+ sg13cmos5l_dlygate4sd3_1
* cell instance sg13cmos5l_dlygate4sd3_1_157 r0 *1 0,0
Xsg13cmos5l_dlygate4sd3_1_157 \$1203 VPWR VGND \$1415 sg13cmos5l_dlygate4sd3_1
* cell instance sg13cmos5l_dlygate4sd3_1_158 r0 *1 0,0
Xsg13cmos5l_dlygate4sd3_1_158 \$517 VPWR VGND \$501 sg13cmos5l_dlygate4sd3_1
* cell instance sg13cmos5l_dlygate4sd3_1_159 r0 *1 0,0
Xsg13cmos5l_dlygate4sd3_1_159 \$4972 VPWR VGND \$4666 sg13cmos5l_dlygate4sd3_1
* cell instance sg13cmos5l_dlygate4sd3_1_160 r0 *1 0,0
Xsg13cmos5l_dlygate4sd3_1_160 \$4976 VPWR VGND \$5515 sg13cmos5l_dlygate4sd3_1
* cell instance sg13cmos5l_dlygate4sd3_1_161 r0 *1 0,0
Xsg13cmos5l_dlygate4sd3_1_161 \$517 VPWR VGND \$1069 sg13cmos5l_dlygate4sd3_1
* cell instance sg13cmos5l_dlygate4sd3_1_162 r0 *1 0,0
Xsg13cmos5l_dlygate4sd3_1_162 \$3927 VPWR VGND \$4098 sg13cmos5l_dlygate4sd3_1
* cell instance sg13cmos5l_dlygate4sd3_1_163 r0 *1 0,0
Xsg13cmos5l_dlygate4sd3_1_163 \$3362 VPWR VGND \$3361 sg13cmos5l_dlygate4sd3_1
* cell instance sg13cmos5l_dlygate4sd3_1_164 r0 *1 0,0
Xsg13cmos5l_dlygate4sd3_1_164 \$1485 VPWR VGND \$1494 sg13cmos5l_dlygate4sd3_1
* cell instance sg13cmos5l_dlygate4sd3_1_165 r0 *1 0,0
Xsg13cmos5l_dlygate4sd3_1_165 \$2146 VPWR VGND \$2319 sg13cmos5l_dlygate4sd3_1
* cell instance sg13cmos5l_dlygate4sd3_1_166 r0 *1 0,0
Xsg13cmos5l_dlygate4sd3_1_166 \$353 VPWR VGND \$402 sg13cmos5l_dlygate4sd3_1
* cell instance sg13cmos5l_dlygate4sd3_1_167 r0 *1 0,0
Xsg13cmos5l_dlygate4sd3_1_167 \$881 VPWR VGND \$811 sg13cmos5l_dlygate4sd3_1
* cell instance sg13cmos5l_dlygate4sd3_1_168 r0 *1 0,0
Xsg13cmos5l_dlygate4sd3_1_168 \$1499 VPWR VGND \$1643 sg13cmos5l_dlygate4sd3_1
* cell instance sg13cmos5l_dlygate4sd3_1_169 r0 *1 0,0
Xsg13cmos5l_dlygate4sd3_1_169 uo_out[1] VPWR VGND \$19579
+ sg13cmos5l_dlygate4sd3_1
* cell instance sg13cmos5l_dlygate4sd3_1_170 r0 *1 0,0
Xsg13cmos5l_dlygate4sd3_1_170 \$5492 VPWR VGND \$5522 sg13cmos5l_dlygate4sd3_1
* cell instance sg13cmos5l_dlygate4sd3_1_171 r0 *1 0,0
Xsg13cmos5l_dlygate4sd3_1_171 \$6071 VPWR VGND \$5881 sg13cmos5l_dlygate4sd3_1
* cell instance sg13cmos5l_dlygate4sd3_1_172 r0 *1 0,0
Xsg13cmos5l_dlygate4sd3_1_172 \$5663 VPWR VGND \$6073 sg13cmos5l_dlygate4sd3_1
* cell instance sg13cmos5l_dlygate4sd3_1_173 r0 *1 0,0
Xsg13cmos5l_dlygate4sd3_1_173 \$588 VPWR VGND \$652 sg13cmos5l_dlygate4sd3_1
* cell instance sg13cmos5l_dlygate4sd3_1_174 r0 *1 0,0
Xsg13cmos5l_dlygate4sd3_1_174 \$190 VPWR VGND \$191 sg13cmos5l_dlygate4sd3_1
* cell instance sg13cmos5l_dlygate4sd3_1_175 r0 *1 0,0
Xsg13cmos5l_dlygate4sd3_1_175 \$5671 VPWR VGND \$5798 sg13cmos5l_dlygate4sd3_1
* cell instance sg13cmos5l_dlygate4sd3_1_176 r0 *1 0,0
Xsg13cmos5l_dlygate4sd3_1_176 \$5418 VPWR VGND \$5289 sg13cmos5l_dlygate4sd3_1
* cell instance sg13cmos5l_dlygate4sd3_1_177 r0 *1 0,0
Xsg13cmos5l_dlygate4sd3_1_177 \$6790 VPWR VGND \$6486 sg13cmos5l_dlygate4sd3_1
* cell instance sg13cmos5l_dlygate4sd3_1_178 r0 *1 0,0
Xsg13cmos5l_dlygate4sd3_1_178 \$1990 VPWR VGND \$2722 sg13cmos5l_dlygate4sd3_1
* cell instance sg13cmos5l_dlygate4sd3_1_179 r0 *1 0,0
Xsg13cmos5l_dlygate4sd3_1_179 \$3922 VPWR VGND \$3929 sg13cmos5l_dlygate4sd3_1
* cell instance sg13cmos5l_dlygate4sd3_1_180 r0 *1 0,0
Xsg13cmos5l_dlygate4sd3_1_180 \$3533 VPWR VGND \$3374 sg13cmos5l_dlygate4sd3_1
* cell instance sg13cmos5l_dlygate4sd3_1_181 r0 *1 0,0
Xsg13cmos5l_dlygate4sd3_1_181 \$5527 VPWR VGND \$5665 sg13cmos5l_dlygate4sd3_1
* cell instance sg13cmos5l_dlygate4sd3_1_182 r0 *1 0,0
Xsg13cmos5l_dlygate4sd3_1_182 \$826 VPWR VGND \$654 sg13cmos5l_dlygate4sd3_1
* cell instance sg13cmos5l_dlygate4sd3_1_183 r0 *1 0,0
Xsg13cmos5l_dlygate4sd3_1_183 \$1342 VPWR VGND \$1341 sg13cmos5l_dlygate4sd3_1
* cell instance sg13cmos5l_dlygate4sd3_1_184 r0 *1 0,0
Xsg13cmos5l_dlygate4sd3_1_184 \$535 VPWR VGND \$411 sg13cmos5l_dlygate4sd3_1
* cell instance sg13cmos5l_dlygate4sd3_1_185 r0 *1 0,0
Xsg13cmos5l_dlygate4sd3_1_185 \$2149 VPWR VGND \$1997 sg13cmos5l_dlygate4sd3_1
* cell instance sg13cmos5l_dlygate4sd3_1_186 r0 *1 0,0
Xsg13cmos5l_dlygate4sd3_1_186 \$6441 VPWR VGND \$6353 sg13cmos5l_dlygate4sd3_1
* cell instance sg13cmos5l_dlygate4sd3_1_187 r0 *1 0,0
Xsg13cmos5l_dlygate4sd3_1_187 \$2730 VPWR VGND \$2510 sg13cmos5l_dlygate4sd3_1
* cell instance sg13cmos5l_dlygate4sd3_1_188 r0 *1 0,0
Xsg13cmos5l_dlygate4sd3_1_188 \$1988 VPWR VGND \$2148 sg13cmos5l_dlygate4sd3_1
* cell instance sg13cmos5l_dlygate4sd3_1_189 r0 *1 0,0
Xsg13cmos5l_dlygate4sd3_1_189 \$6466 VPWR VGND \$6354 sg13cmos5l_dlygate4sd3_1
* cell instance sg13cmos5l_dlygate4sd3_1_190 r0 *1 0,0
Xsg13cmos5l_dlygate4sd3_1_190 \$3544 VPWR VGND \$3538 sg13cmos5l_dlygate4sd3_1
* cell instance sg13cmos5l_dlygate4sd3_1_191 r0 *1 0,0
Xsg13cmos5l_dlygate4sd3_1_191 \$2113 VPWR VGND \$1807 sg13cmos5l_dlygate4sd3_1
* cell instance sg13cmos5l_dlygate4sd3_1_192 r0 *1 0,0
Xsg13cmos5l_dlygate4sd3_1_192 \$3925 VPWR VGND \$3937 sg13cmos5l_dlygate4sd3_1
* cell instance sg13cmos5l_dlygate4sd3_1_193 r0 *1 0,0
Xsg13cmos5l_dlygate4sd3_1_193 \$3163 VPWR VGND \$3291 sg13cmos5l_dlygate4sd3_1
* cell instance sg13cmos5l_dlygate4sd3_1_194 r0 *1 0,0
Xsg13cmos5l_dlygate4sd3_1_194 \$5082 VPWR VGND \$5084 sg13cmos5l_dlygate4sd3_1
* cell instance sg13cmos5l_dlygate4sd3_1_195 r0 *1 0,0
Xsg13cmos5l_dlygate4sd3_1_195 \$1085 VPWR VGND \$1079 sg13cmos5l_dlygate4sd3_1
* cell instance sg13cmos5l_dlygate4sd3_1_196 r0 *1 0,0
Xsg13cmos5l_dlygate4sd3_1_196 \$6726 VPWR VGND \$6520 sg13cmos5l_dlygate4sd3_1
* cell instance sg13cmos5l_dlygate4sd3_1_197 r0 *1 0,0
Xsg13cmos5l_dlygate4sd3_1_197 \$1520 VPWR VGND \$1514 sg13cmos5l_dlygate4sd3_1
* cell instance sg13cmos5l_dlygate4sd3_1_198 r0 *1 0,0
Xsg13cmos5l_dlygate4sd3_1_198 \$2147 VPWR VGND \$2168 sg13cmos5l_dlygate4sd3_1
* cell instance sg13cmos5l_dlygate4sd3_1_199 r0 *1 0,0
Xsg13cmos5l_dlygate4sd3_1_199 \$641 VPWR VGND \$2974 sg13cmos5l_dlygate4sd3_1
* cell instance sg13cmos5l_dlygate4sd3_1_200 r0 *1 0,0
Xsg13cmos5l_dlygate4sd3_1_200 \$1249 VPWR VGND \$1243 sg13cmos5l_dlygate4sd3_1
* cell instance sg13cmos5l_dlygate4sd3_1_201 r0 *1 0,0
Xsg13cmos5l_dlygate4sd3_1_201 \$2356 VPWR VGND \$2458 sg13cmos5l_dlygate4sd3_1
* cell instance sg13cmos5l_dlygate4sd3_1_202 r0 *1 0,0
Xsg13cmos5l_dlygate4sd3_1_202 \$4990 VPWR VGND \$4994 sg13cmos5l_dlygate4sd3_1
* cell instance sg13cmos5l_dlygate4sd3_1_203 r0 *1 0,0
Xsg13cmos5l_dlygate4sd3_1_203 \$2980 VPWR VGND \$3104 sg13cmos5l_dlygate4sd3_1
* cell instance sg13cmos5l_dlygate4sd3_1_204 r0 *1 0,0
Xsg13cmos5l_dlygate4sd3_1_204 \$1922 VPWR VGND \$1651 sg13cmos5l_dlygate4sd3_1
* cell instance sg13cmos5l_dlygate4sd3_1_205 r0 *1 0,0
Xsg13cmos5l_dlygate4sd3_1_205 \$1417 VPWR VGND \$1348 sg13cmos5l_dlygate4sd3_1
* cell instance sg13cmos5l_dlygate4sd3_1_206 r0 *1 0,0
Xsg13cmos5l_dlygate4sd3_1_206 \$4955 VPWR VGND \$4988 sg13cmos5l_dlygate4sd3_1
* cell instance sg13cmos5l_dlygate4sd3_1_207 r0 *1 0,0
Xsg13cmos5l_dlygate4sd3_1_207 \$3297 VPWR VGND \$3398 sg13cmos5l_dlygate4sd3_1
* cell instance sg13cmos5l_dlygate4sd3_1_208 r0 *1 0,0
Xsg13cmos5l_dlygate4sd3_1_208 \$1253 VPWR VGND \$1078 sg13cmos5l_dlygate4sd3_1
* cell instance sg13cmos5l_dlygate4sd3_1_209 r0 *1 0,0
Xsg13cmos5l_dlygate4sd3_1_209 \$1824 VPWR VGND \$1827 sg13cmos5l_dlygate4sd3_1
* cell instance sg13cmos5l_dlygate4sd3_1_210 r0 *1 0,0
Xsg13cmos5l_dlygate4sd3_1_210 \$2986 VPWR VGND \$3294 sg13cmos5l_dlygate4sd3_1
* cell instance sg13cmos5l_dlygate4sd3_1_211 r0 *1 0,0
Xsg13cmos5l_dlygate4sd3_1_211 \$3297 VPWR VGND \$3188 sg13cmos5l_dlygate4sd3_1
* cell instance sg13cmos5l_dlygate4sd3_1_212 r0 *1 0,0
Xsg13cmos5l_dlygate4sd3_1_212 \$3397 VPWR VGND \$3567 sg13cmos5l_dlygate4sd3_1
* cell instance sg13cmos5l_dlygate4sd3_1_213 r0 *1 0,0
Xsg13cmos5l_dlygate4sd3_1_213 \$2883 VPWR VGND \$2992 sg13cmos5l_dlygate4sd3_1
* cell instance sg13cmos5l_dlygate4sd3_1_214 r0 *1 0,0
Xsg13cmos5l_dlygate4sd3_1_214 \$6533 VPWR VGND \$6545 sg13cmos5l_dlygate4sd3_1
* cell instance sg13cmos5l_dlygate4sd3_1_215 r0 *1 0,0
Xsg13cmos5l_dlygate4sd3_1_215 \$5805 VPWR VGND \$5900 sg13cmos5l_dlygate4sd3_1
* cell instance sg13cmos5l_dlygate4sd3_1_216 r0 *1 0,0
Xsg13cmos5l_dlygate4sd3_1_216 \$5311 VPWR VGND \$5313 sg13cmos5l_dlygate4sd3_1
* cell instance sg13cmos5l_dlygate4sd3_1_217 r0 *1 0,0
Xsg13cmos5l_dlygate4sd3_1_217 \$2102 VPWR VGND \$2011 sg13cmos5l_dlygate4sd3_1
* cell instance sg13cmos5l_dlygate4sd3_1_218 r0 *1 0,0
Xsg13cmos5l_dlygate4sd3_1_218 \$2756 VPWR VGND \$2880 sg13cmos5l_dlygate4sd3_1
* cell instance sg13cmos5l_dlygate4sd3_1_219 r0 *1 0,0
Xsg13cmos5l_dlygate4sd3_1_219 \$5806 VPWR VGND \$5909 sg13cmos5l_dlygate4sd3_1
* cell instance sg13cmos5l_dlygate4sd3_1_220 r0 *1 0,0
Xsg13cmos5l_dlygate4sd3_1_220 \$5314 VPWR VGND \$5421 sg13cmos5l_dlygate4sd3_1
* cell instance sg13cmos5l_dlygate4sd3_1_221 r0 *1 0,0
Xsg13cmos5l_dlygate4sd3_1_221 \$2023 VPWR VGND \$2189 sg13cmos5l_dlygate4sd3_1
* cell instance sg13cmos5l_dlygate4sd3_1_222 r0 *1 0,0
Xsg13cmos5l_dlygate4sd3_1_222 \$5611 VPWR VGND \$5686 sg13cmos5l_dlygate4sd3_1
* cell instance sg13cmos5l_dlygate4sd3_1_223 r0 *1 0,0
Xsg13cmos5l_dlygate4sd3_1_223 \$1847 VPWR VGND \$1841 sg13cmos5l_dlygate4sd3_1
* cell instance sg13cmos5l_dlygate4sd3_1_224 r0 *1 0,0
Xsg13cmos5l_dlygate4sd3_1_224 \$2375 VPWR VGND \$2545 sg13cmos5l_dlygate4sd3_1
* cell instance sg13cmos5l_dlygate4sd3_1_225 r0 *1 0,0
Xsg13cmos5l_dlygate4sd3_1_225 \$5322 VPWR VGND \$5306 sg13cmos5l_dlygate4sd3_1
* cell instance sg13cmos5l_dlygate4sd3_1_226 r0 *1 0,0
Xsg13cmos5l_dlygate4sd3_1_226 \$2190 VPWR VGND \$2026 sg13cmos5l_dlygate4sd3_1
* cell instance sg13cmos5l_dlygate4sd3_1_227 r0 *1 0,0
Xsg13cmos5l_dlygate4sd3_1_227 \$1667 VPWR VGND \$1846 sg13cmos5l_dlygate4sd3_1
* cell instance sg13cmos5l_dlygate4sd3_1_228 r0 *1 0,0
Xsg13cmos5l_dlygate4sd3_1_228 \$5304 VPWR VGND \$5529 sg13cmos5l_dlygate4sd3_1
* cell instance sg13cmos5l_dlygate4sd3_1_229 r0 *1 0,0
Xsg13cmos5l_dlygate4sd3_1_229 \$6105 VPWR VGND \$6320 sg13cmos5l_dlygate4sd3_1
* cell instance sg13cmos5l_dlygate4sd3_1_230 r0 *1 0,0
Xsg13cmos5l_dlygate4sd3_1_230 \$6104 VPWR VGND \$6111 sg13cmos5l_dlygate4sd3_1
* cell instance sg13cmos5l_dlygate4sd3_1_231 r0 *1 0,0
Xsg13cmos5l_dlygate4sd3_1_231 \$5917 VPWR VGND \$6316 sg13cmos5l_dlygate4sd3_1
* cell instance sg13cmos5l_dlygate4sd3_1_232 r0 *1 0,0
Xsg13cmos5l_dlygate4sd3_1_232 \$5698 VPWR VGND \$6107 sg13cmos5l_dlygate4sd3_1
* cell instance sg13cmos5l_dlygate4sd3_1_233 r0 *1 0,0
Xsg13cmos5l_dlygate4sd3_1_233 \$1857 VPWR VGND \$2032 sg13cmos5l_dlygate4sd3_1
* cell instance sg13cmos5l_dlygate4sd3_1_234 r0 *1 0,0
Xsg13cmos5l_dlygate4sd3_1_234 \$5700 VPWR VGND \$6328 sg13cmos5l_dlygate4sd3_1
* cell instance sg13cmos5l_dlygate4sd3_1_235 r0 *1 0,0
Xsg13cmos5l_dlygate4sd3_1_235 \$4535 VPWR VGND \$4150 sg13cmos5l_dlygate4sd3_1
* cell instance sg13cmos5l_dlygate4sd3_1_236 r0 *1 0,0
Xsg13cmos5l_dlygate4sd3_1_236 \$2043 VPWR VGND \$2027 sg13cmos5l_dlygate4sd3_1
* cell instance sg13cmos5l_dlygate4sd3_1_237 r0 *1 0,0
Xsg13cmos5l_dlygate4sd3_1_237 \$6112 VPWR VGND \$5701 sg13cmos5l_dlygate4sd3_1
* cell instance sg13cmos5l_dlygate4sd3_1_238 r0 *1 0,0
Xsg13cmos5l_dlygate4sd3_1_238 \$2561 VPWR VGND \$2380 sg13cmos5l_dlygate4sd3_1
* cell instance sg13cmos5l_dlygate4sd3_1_239 r0 *1 0,0
Xsg13cmos5l_dlygate4sd3_1_239 \$5549 VPWR VGND \$6121 sg13cmos5l_dlygate4sd3_1
* cell instance sg13cmos5l_dlygate4sd3_1_240 r0 *1 0,0
Xsg13cmos5l_dlygate4sd3_1_240 \$3010 VPWR VGND \$2765 sg13cmos5l_dlygate4sd3_1
* cell instance sg13cmos5l_dlygate4sd3_1_241 r0 *1 0,0
Xsg13cmos5l_dlygate4sd3_1_241 \$3584 VPWR VGND \$3413 sg13cmos5l_dlygate4sd3_1
* cell instance sg13cmos5l_dlygate4sd3_1_242 r0 *1 0,0
Xsg13cmos5l_dlygate4sd3_1_242 \$5704 VPWR VGND \$5551 sg13cmos5l_dlygate4sd3_1
* cell instance sg13cmos5l_dlygate4sd3_1_243 r0 *1 0,0
Xsg13cmos5l_dlygate4sd3_1_243 \$5717 VPWR VGND \$5699 sg13cmos5l_dlygate4sd3_1
* cell instance sg13cmos5l_dlygate4sd3_1_244 r0 *1 0,0
Xsg13cmos5l_dlygate4sd3_1_244 \$5708 VPWR VGND \$6338 sg13cmos5l_dlygate4sd3_1
* cell instance sg13cmos5l_dlygate4sd3_1_245 r0 *1 0,0
Xsg13cmos5l_dlygate4sd3_1_245 \$5553 VPWR VGND \$6127 sg13cmos5l_dlygate4sd3_1
* cell instance sg13cmos5l_dlygate4sd3_1_246 r0 *1 0,0
Xsg13cmos5l_dlygate4sd3_1_246 \$5335 VPWR VGND \$5555 sg13cmos5l_dlygate4sd3_1
* cell instance sg13cmos5l_dlygate4sd3_1_247 r0 *1 0,0
Xsg13cmos5l_dlygate4sd3_1_247 \$5338 VPWR VGND \$5709 sg13cmos5l_dlygate4sd3_1
* cell instance sg13cmos5l_dlygate4sd3_1_248 r0 *1 0,0
Xsg13cmos5l_dlygate4sd3_1_248 \$6128 VPWR VGND \$6132 sg13cmos5l_dlygate4sd3_1
* cell instance sg13cmos5l_dlygate4sd3_1_249 r0 *1 0,0
Xsg13cmos5l_dlygate4sd3_1_249 \$5560 VPWR VGND \$5558 sg13cmos5l_dlygate4sd3_1
* cell instance sg13cmos5l_dlygate4sd3_1_250 r0 *1 0,0
Xsg13cmos5l_dlygate4sd3_1_250 \$5713 VPWR VGND \$5336 sg13cmos5l_dlygate4sd3_1
* cell instance sg13cmos5l_dlygate4sd3_1_251 r0 *1 0,0
Xsg13cmos5l_dlygate4sd3_1_251 \$6133 VPWR VGND \$6123 sg13cmos5l_dlygate4sd3_1
* cell instance sg13cmos5l_dlygate4sd3_1_252 r0 *1 0,0
Xsg13cmos5l_dlygate4sd3_1_252 \$5556 VPWR VGND \$6587 sg13cmos5l_dlygate4sd3_1
* cell instance sg13cmos5l_dlygate4sd3_1_253 r0 *1 0,0
Xsg13cmos5l_dlygate4sd3_1_253 \$5562 VPWR VGND \$5561 sg13cmos5l_dlygate4sd3_1
* cell instance sg13cmos5l_dlygate4sd3_1_254 r0 *1 0,0
Xsg13cmos5l_dlygate4sd3_1_254 \$5944 VPWR VGND \$6135 sg13cmos5l_dlygate4sd3_1
* cell instance sg13cmos5l_dlygate4sd3_1_255 r0 *1 0,0
Xsg13cmos5l_dlygate4sd3_1_255 \$4875 VPWR VGND \$5014 sg13cmos5l_dlygate4sd3_1
* cell instance sg13cmos5l_dlygate4sd3_1_256 r0 *1 0,0
Xsg13cmos5l_dlygate4sd3_1_256 \$5718 VPWR VGND \$5339 sg13cmos5l_dlygate4sd3_1
* cell instance sg13cmos5l_dlygate4sd3_1_257 r0 *1 0,0
Xsg13cmos5l_dlygate4sd3_1_257 \$4155 VPWR VGND \$2576 sg13cmos5l_dlygate4sd3_1
* cell instance sg13cmos5l_dlygate4sd3_1_258 r0 *1 0,0
Xsg13cmos5l_dlygate4sd3_1_258 \$6011 VPWR VGND \$6113 sg13cmos5l_dlygate4sd3_1
* cell instance sg13cmos5l_dlygate4sd3_1_259 r0 *1 0,0
Xsg13cmos5l_dlygate4sd3_1_259 \$6347 VPWR VGND \$5945 sg13cmos5l_dlygate4sd3_1
* cell instance sg13cmos5l_dlygate4sd3_1_260 r0 *1 0,0
Xsg13cmos5l_dlygate4sd3_1_260 \$5724 VPWR VGND \$5565 sg13cmos5l_dlygate4sd3_1
* cell instance sg13cmos5l_dlygate4sd3_1_261 r0 *1 0,0
Xsg13cmos5l_dlygate4sd3_1_261 \$5433 VPWR VGND \$5571 sg13cmos5l_dlygate4sd3_1
* cell instance sg13cmos5l_dlygate4sd3_1_262 r0 *1 0,0
Xsg13cmos5l_dlygate4sd3_1_262 \$5434 VPWR VGND \$5570 sg13cmos5l_dlygate4sd3_1
* cell instance sg13cmos5l_dlygate4sd3_1_263 r0 *1 0,0
Xsg13cmos5l_dlygate4sd3_1_263 \$6351 VPWR VGND \$6615 sg13cmos5l_dlygate4sd3_1
* cell instance sg13cmos5l_dlygate4sd3_1_264 r0 *1 0,0
Xsg13cmos5l_dlygate4sd3_1_264 \$5754 VPWR VGND \$5723 sg13cmos5l_dlygate4sd3_1
* cell instance sg13cmos5l_dlygate4sd3_1_265 r0 *1 0,0
Xsg13cmos5l_dlygate4sd3_1_265 \$4549 VPWR VGND \$4550 sg13cmos5l_dlygate4sd3_1
* cell instance sg13cmos5l_dlygate4sd3_1_266 r0 *1 0,0
Xsg13cmos5l_dlygate4sd3_1_266 \$6355 VPWR VGND \$6631 sg13cmos5l_dlygate4sd3_1
* cell instance sg13cmos5l_dlygate4sd3_1_267 r0 *1 0,0
Xsg13cmos5l_dlygate4sd3_1_267 \$3414 VPWR VGND \$3678 sg13cmos5l_dlygate4sd3_1
* cell instance sg13cmos5l_dlygate4sd3_1_268 r0 *1 0,0
Xsg13cmos5l_dlygate4sd3_1_268 \$6358 VPWR VGND \$5961 sg13cmos5l_dlygate4sd3_1
* cell instance sg13cmos5l_dlygate4sd3_1_269 r0 *1 0,0
Xsg13cmos5l_dlygate4sd3_1_269 \$5744 VPWR VGND \$5576 sg13cmos5l_dlygate4sd3_1
* cell instance sg13cmos5l_dlygate4sd3_1_270 r0 *1 0,0
Xsg13cmos5l_dlygate4sd3_1_270 \$6645 VPWR VGND \$5810 sg13cmos5l_dlygate4sd3_1
* cell instance sg13cmos5l_dlygate4sd3_1_271 r0 *1 0,0
Xsg13cmos5l_dlygate4sd3_1_271 \$5976 VPWR VGND \$5970 sg13cmos5l_dlygate4sd3_1
* cell instance sg13cmos5l_dlygate4sd3_1_272 r0 *1 0,0
Xsg13cmos5l_dlygate4sd3_1_272 \$2586 VPWR VGND \$2592 sg13cmos5l_dlygate4sd3_1
* cell instance sg13cmos5l_dlygate4sd3_1_273 r0 *1 0,0
Xsg13cmos5l_dlygate4sd3_1_273 \$2588 VPWR VGND \$2787 sg13cmos5l_dlygate4sd3_1
* cell instance sg13cmos5l_dlygate4sd3_1_274 r0 *1 0,0
Xsg13cmos5l_dlygate4sd3_1_274 \$2893 VPWR VGND \$2796 sg13cmos5l_dlygate4sd3_1
* cell instance sg13cmos5l_dlygate4sd3_1_275 r0 *1 0,0
Xsg13cmos5l_dlygate4sd3_1_275 \$3221 VPWR VGND \$3309 sg13cmos5l_dlygate4sd3_1
* cell instance sg13cmos5l_dlygate4sd3_1_276 r0 *1 0,0
Xsg13cmos5l_dlygate4sd3_1_276 \$2797 VPWR VGND \$2801 sg13cmos5l_dlygate4sd3_1
* cell instance sg13cmos5l_dlygate4sd3_1_277 r0 *1 0,0
Xsg13cmos5l_dlygate4sd3_1_277 \$3233 VPWR VGND \$3219 sg13cmos5l_dlygate4sd3_1
* cell instance sg13cmos5l_dlygate4sd3_1_278 r0 *1 0,0
Xsg13cmos5l_dlygate4sd3_1_278 \$3044 VPWR VGND \$2894 sg13cmos5l_dlygate4sd3_1
* cell instance sg13cmos5l_dlygate4sd3_1_279 r0 *1 0,0
Xsg13cmos5l_dlygate4sd3_1_279 \$2616 VPWR VGND \$2259 sg13cmos5l_dlygate4sd3_1
* cell instance sg13cmos5l_dlygate4sd3_1_280 r0 *1 0,0
Xsg13cmos5l_dlygate4sd3_1_280 \$2818 VPWR VGND \$2911 sg13cmos5l_dlygate4sd3_1
* cell instance sg13cmos5l_dlygate4sd3_1_281 r0 *1 0,0
Xsg13cmos5l_dlygate4sd3_1_281 \$2426 VPWR VGND \$2622 sg13cmos5l_dlygate4sd3_1
* cell instance sg13cmos5l_dlygate4sd3_1_282 r0 *1 0,0
Xsg13cmos5l_dlygate4sd3_1_282 \$4195 VPWR VGND \$3829 sg13cmos5l_dlygate4sd3_1
* cell instance sg13cmos5l_dlygate4sd3_1_283 r0 *1 0,0
Xsg13cmos5l_dlygate4sd3_1_283 \$7448 VPWR VGND \$6920 sg13cmos5l_dlygate4sd3_1
* cell instance sg13cmos5l_dlygate4sd3_1_284 r0 *1 0,0
Xsg13cmos5l_dlygate4sd3_1_284 \$7994 VPWR VGND \$6956 sg13cmos5l_dlygate4sd3_1
* cell instance sg13cmos5l_dlygate4sd3_1_285 r0 *1 0,0
Xsg13cmos5l_dlygate4sd3_1_285 \$8194 VPWR VGND \$6872 sg13cmos5l_dlygate4sd3_1
* cell instance sg13cmos5l_dlygate4sd3_1_286 r0 *1 0,0
Xsg13cmos5l_dlygate4sd3_1_286 \$8320 VPWR VGND \$6792 sg13cmos5l_dlygate4sd3_1
* cell instance sg13cmos5l_dlygate4sd3_1_287 r0 *1 0,0
Xsg13cmos5l_dlygate4sd3_1_287 \$2641 VPWR VGND \$2433 sg13cmos5l_dlygate4sd3_1
* cell instance sg13cmos5l_dlygate4sd3_1_288 r0 *1 0,0
Xsg13cmos5l_dlygate4sd3_1_288 \$3250 VPWR VGND \$3682 sg13cmos5l_dlygate4sd3_1
* cell instance sg13cmos5l_dlygate4sd3_1_289 r0 *1 0,0
Xsg13cmos5l_dlygate4sd3_1_289 \$4561 VPWR VGND \$6706 sg13cmos5l_dlygate4sd3_1
* cell instance sg13cmos5l_dlygate4sd3_1_290 r0 *1 0,0
Xsg13cmos5l_dlygate4sd3_1_290 \$2837 VPWR VGND \$3059 sg13cmos5l_dlygate4sd3_1
* cell instance sg13cmos5l_dlygate4sd3_1_291 r0 *1 0,0
Xsg13cmos5l_dlygate4sd3_1_291 \$4192 VPWR VGND \$4572 sg13cmos5l_dlygate4sd3_1
* cell instance sg13cmos5l_dlygate4sd3_1_292 r0 *1 0,0
Xsg13cmos5l_dlygate4sd3_1_292 \$7996 VPWR VGND \$6960 sg13cmos5l_dlygate4sd3_1
* cell instance sg13cmos5l_dlygate4sd3_1_293 r0 *1 0,0
Xsg13cmos5l_dlygate4sd3_1_293 \$4197 VPWR VGND \$4000 sg13cmos5l_dlygate4sd3_1
* cell instance sg13cmos5l_dlygate4sd3_1_294 r0 *1 0,0
Xsg13cmos5l_dlygate4sd3_1_294 \$6919 VPWR VGND \$9341 sg13cmos5l_dlygate4sd3_1
* cell instance sg13cmos5l_dlygate4sd3_1_295 r0 *1 0,0
Xsg13cmos5l_dlygate4sd3_1_295 \$6839 VPWR VGND \$8323 sg13cmos5l_dlygate4sd3_1
* cell instance sg13cmos5l_dlygate4sd3_1_296 r0 *1 0,0
Xsg13cmos5l_dlygate4sd3_1_296 \$2275 VPWR VGND \$2429 sg13cmos5l_dlygate4sd3_1
* cell instance sg13cmos5l_dlygate4sd3_1_297 r0 *1 0,0
Xsg13cmos5l_dlygate4sd3_1_297 \$6832 VPWR VGND \$9091 sg13cmos5l_dlygate4sd3_1
* cell instance sg13cmos5l_dlygate4sd3_1_298 r0 *1 0,0
Xsg13cmos5l_dlygate4sd3_1_298 \$4194 VPWR VGND \$4574 sg13cmos5l_dlygate4sd3_1
* cell instance sg13cmos5l_dlygate4sd3_1_299 r0 *1 0,0
Xsg13cmos5l_dlygate4sd3_1_299 \$6870 VPWR VGND \$8561 sg13cmos5l_dlygate4sd3_1
* cell instance sg13cmos5l_dlygate4sd3_1_300 r0 *1 0,0
Xsg13cmos5l_dlygate4sd3_1_300 \$6932 VPWR VGND \$6856 sg13cmos5l_dlygate4sd3_1
* cell instance sg13cmos5l_dlygate4sd3_1_301 r0 *1 0,0
Xsg13cmos5l_dlygate4sd3_1_301 \$2523 VPWR VGND \$6809 sg13cmos5l_dlygate4sd3_1
* cell instance sg13cmos5l_dlygate4sd3_1_302 r0 *1 0,0
Xsg13cmos5l_dlygate4sd3_1_302 \$9581 VPWR VGND \$9310 sg13cmos5l_dlygate4sd3_1
* cell instance sg13cmos5l_dlygate4sd3_1_303 r0 *1 0,0
Xsg13cmos5l_dlygate4sd3_1_303 \$9327 VPWR VGND \$8827 sg13cmos5l_dlygate4sd3_1
* cell instance sg13cmos5l_dlygate4sd3_1_304 r0 *1 0,0
Xsg13cmos5l_dlygate4sd3_1_304 \$9659 VPWR VGND \$9580 sg13cmos5l_dlygate4sd3_1
* cell instance sg13cmos5l_dlygate4sd3_1_305 r0 *1 0,0
Xsg13cmos5l_dlygate4sd3_1_305 \$9178 VPWR VGND \$9312 sg13cmos5l_dlygate4sd3_1
* cell instance sg13cmos5l_dlygate4sd3_1_306 r0 *1 0,0
Xsg13cmos5l_dlygate4sd3_1_306 \$10763 VPWR VGND \$10305 sg13cmos5l_dlygate4sd3_1
* cell instance sg13cmos5l_dlygate4sd3_1_307 r0 *1 0,0
Xsg13cmos5l_dlygate4sd3_1_307 \$8562 VPWR VGND \$8324 sg13cmos5l_dlygate4sd3_1
* cell instance sg13cmos5l_dlygate4sd3_1_308 r0 *1 0,0
Xsg13cmos5l_dlygate4sd3_1_308 \$7999 VPWR VGND \$5898 sg13cmos5l_dlygate4sd3_1
* cell instance sg13cmos5l_dlygate4sd3_1_309 r0 *1 0,0
Xsg13cmos5l_dlygate4sd3_1_309 \$6934 VPWR VGND \$6873 sg13cmos5l_dlygate4sd3_1
* cell instance sg13cmos5l_dlygate4sd3_1_310 r0 *1 0,0
Xsg13cmos5l_dlygate4sd3_1_310 \$10293 VPWR VGND \$10600 sg13cmos5l_dlygate4sd3_1
* cell instance sg13cmos5l_dlygate4sd3_1_311 r0 *1 0,0
Xsg13cmos5l_dlygate4sd3_1_311 \$2276 VPWR VGND \$2290 sg13cmos5l_dlygate4sd3_1
* cell instance sg13cmos5l_dlygate4sd3_1_312 r0 *1 0,0
Xsg13cmos5l_dlygate4sd3_1_312 \$8102 VPWR VGND \$8003 sg13cmos5l_dlygate4sd3_1
* cell instance sg13cmos5l_dlygate4sd3_1_313 r0 *1 0,0
Xsg13cmos5l_dlygate4sd3_1_313 \$2843 VPWR VGND \$2847 sg13cmos5l_dlygate4sd3_1
* cell instance sg13cmos5l_dlygate4sd3_1_314 r0 *1 0,0
Xsg13cmos5l_dlygate4sd3_1_314 \$7874 VPWR VGND \$7879 sg13cmos5l_dlygate4sd3_1
* cell instance sg13cmos5l_dlygate4sd3_1_315 r0 *1 0,0
Xsg13cmos5l_dlygate4sd3_1_315 \$8327 VPWR VGND \$8564 sg13cmos5l_dlygate4sd3_1
* cell instance sg13cmos5l_dlygate4sd3_1_316 r0 *1 0,0
Xsg13cmos5l_dlygate4sd3_1_316 \$3265 VPWR VGND \$3686 sg13cmos5l_dlygate4sd3_1
* cell instance sg13cmos5l_dlygate4sd3_1_317 r0 *1 0,0
Xsg13cmos5l_dlygate4sd3_1_317 \$7730 VPWR VGND \$8007 sg13cmos5l_dlygate4sd3_1
* cell instance sg13cmos5l_dlygate4sd3_1_318 r0 *1 0,0
Xsg13cmos5l_dlygate4sd3_1_318 \$2842 VPWR VGND \$2904 sg13cmos5l_dlygate4sd3_1
* cell instance sg13cmos5l_dlygate4sd3_1_319 r0 *1 0,0
Xsg13cmos5l_dlygate4sd3_1_319 \$8005 VPWR VGND \$7455 sg13cmos5l_dlygate4sd3_1
* cell instance sg13cmos5l_dlygate4sd3_1_320 r0 *1 0,0
Xsg13cmos5l_dlygate4sd3_1_320 \$9415 VPWR VGND \$9093 sg13cmos5l_dlygate4sd3_1
* cell instance sg13cmos5l_dlygate4sd3_1_321 r0 *1 0,0
Xsg13cmos5l_dlygate4sd3_1_321 \$8329 VPWR VGND \$8296 sg13cmos5l_dlygate4sd3_1
* cell instance sg13cmos5l_dlygate4sd3_1_322 r0 *1 0,0
Xsg13cmos5l_dlygate4sd3_1_322 \$4222 VPWR VGND \$4056 sg13cmos5l_dlygate4sd3_1
* cell instance sg13cmos5l_dlygate4sd3_1_323 r0 *1 0,0
Xsg13cmos5l_dlygate4sd3_1_323 \$8805 VPWR VGND \$8830 sg13cmos5l_dlygate4sd3_1
* cell instance sg13cmos5l_dlygate4sd3_1_324 r0 *1 0,0
Xsg13cmos5l_dlygate4sd3_1_324 \$6860 VPWR VGND \$6857 sg13cmos5l_dlygate4sd3_1
* cell instance sg13cmos5l_dlygate4sd3_1_325 r0 *1 0,0
Xsg13cmos5l_dlygate4sd3_1_325 \$7732 VPWR VGND \$8201 sg13cmos5l_dlygate4sd3_1
* cell instance sg13cmos5l_dlygate4sd3_1_326 r0 *1 0,0
Xsg13cmos5l_dlygate4sd3_1_326 \$7227 VPWR VGND \$6938 sg13cmos5l_dlygate4sd3_1
* cell instance sg13cmos5l_dlygate4sd3_1_327 r0 *1 0,0
Xsg13cmos5l_dlygate4sd3_1_327 \$7526 VPWR VGND \$7689 sg13cmos5l_dlygate4sd3_1
* cell instance sg13cmos5l_dlygate4sd3_1_328 r0 *1 0,0
Xsg13cmos5l_dlygate4sd3_1_328 \$2908 VPWR VGND \$3082 sg13cmos5l_dlygate4sd3_1
* cell instance sg13cmos5l_dlygate4sd3_1_329 r0 *1 0,0
Xsg13cmos5l_dlygate4sd3_1_329 \$8526 VPWR VGND \$8565 sg13cmos5l_dlygate4sd3_1
* cell instance sg13cmos5l_dlygate4sd3_1_330 r0 *1 0,0
Xsg13cmos5l_dlygate4sd3_1_330 \$8203 VPWR VGND \$7454 sg13cmos5l_dlygate4sd3_1
* cell instance sg13cmos5l_dlygate4sd3_1_331 r0 *1 0,0
Xsg13cmos5l_dlygate4sd3_1_331 \$4386 VPWR VGND \$4590 sg13cmos5l_dlygate4sd3_1
* cell instance sg13cmos5l_dlygate4sd3_1_332 r0 *1 0,0
Xsg13cmos5l_dlygate4sd3_1_332 \$7734 VPWR VGND \$7453 sg13cmos5l_dlygate4sd3_1
* cell instance sg13cmos5l_dlygate4sd3_1_333 r0 *1 0,0
Xsg13cmos5l_dlygate4sd3_1_333 \$3272 VPWR VGND \$3315 sg13cmos5l_dlygate4sd3_1
* cell instance sg13cmos5l_dlygate4sd3_1_334 r0 *1 0,0
Xsg13cmos5l_dlygate4sd3_1_334 \$3894 VPWR VGND \$3859 sg13cmos5l_dlygate4sd3_1
* cell instance sg13cmos5l_dlygate4sd3_1_335 r0 *1 0,0
Xsg13cmos5l_dlygate4sd3_1_335 \$2658 VPWR VGND \$2657 sg13cmos5l_dlygate4sd3_1
* cell instance sg13cmos5l_dlygate4sd3_1_336 r0 *1 0,0
Xsg13cmos5l_dlygate4sd3_1_336 \$3314 VPWR VGND \$3088 sg13cmos5l_dlygate4sd3_1
* cell instance sg13cmos5l_dlygate4sd3_1_337 r0 *1 0,0
Xsg13cmos5l_dlygate4sd3_1_337 \$5061 VPWR VGND \$5225 sg13cmos5l_dlygate4sd3_1
* cell instance sg13cmos5l_dlygate4sd3_1_338 r0 *1 0,0
Xsg13cmos5l_dlygate4sd3_1_338 \$4015 VPWR VGND \$4058 sg13cmos5l_dlygate4sd3_1
* cell instance sg13cmos5l_dlygate4sd3_1_339 r0 *1 0,0
Xsg13cmos5l_dlygate4sd3_1_339 \$4735 VPWR VGND \$4906 sg13cmos5l_dlygate4sd3_1
* cell instance sg13cmos5l_dlygate4sd3_1_340 r0 *1 0,0
Xsg13cmos5l_dlygate4sd3_1_340 \$3688 VPWR VGND \$3486 sg13cmos5l_dlygate4sd3_1
* cell instance sg13cmos5l_dlygate4sd3_1_341 r0 *1 0,0
Xsg13cmos5l_dlygate4sd3_1_341 \$4380 VPWR VGND \$4233 sg13cmos5l_dlygate4sd3_1
* cell instance sg13cmos5l_dlygate4sd3_1_342 r0 *1 0,0
Xsg13cmos5l_dlygate4sd3_1_342 \$5057 VPWR VGND \$5064 sg13cmos5l_dlygate4sd3_1
* cell instance sg13cmos5l_dlygate4sd3_1_343 r0 *1 0,0
Xsg13cmos5l_dlygate4sd3_1_343 \$4017 VPWR VGND \$3649 sg13cmos5l_dlygate4sd3_1
* cell instance sg13cmos5l_dlygate4sd3_1_344 r0 *1 0,0
Xsg13cmos5l_dlygate4sd3_1_344 \$4738 VPWR VGND \$4742 sg13cmos5l_dlygate4sd3_1
* cell instance sg13cmos5l_dlygate4sd3_1_345 r0 *1 0,0
Xsg13cmos5l_dlygate4sd3_1_345 \$4377 VPWR VGND \$4424 sg13cmos5l_dlygate4sd3_1
* cell instance sg13cmos5l_fill_1_0 r0 *1 0,0
Xsg13cmos5l_fill_1_0 VPWR VGND sg13cmos5l_fill_1
* cell instance sg13cmos5l_fill_1_1 r0 *1 0,0
Xsg13cmos5l_fill_1_1 VPWR VGND sg13cmos5l_fill_1
* cell instance sg13cmos5l_fill_1_2 r0 *1 0,0
Xsg13cmos5l_fill_1_2 VPWR VGND sg13cmos5l_fill_1
* cell instance sg13cmos5l_fill_1_3 r0 *1 0,0
Xsg13cmos5l_fill_1_3 VPWR VGND sg13cmos5l_fill_1
* cell instance sg13cmos5l_fill_1_4 r0 *1 0,0
Xsg13cmos5l_fill_1_4 VPWR VGND sg13cmos5l_fill_1
* cell instance sg13cmos5l_fill_1_5 r0 *1 0,0
Xsg13cmos5l_fill_1_5 VPWR VGND sg13cmos5l_fill_1
* cell instance sg13cmos5l_fill_1_6 r0 *1 0,0
Xsg13cmos5l_fill_1_6 VPWR VGND sg13cmos5l_fill_1
* cell instance sg13cmos5l_fill_1_7 r0 *1 0,0
Xsg13cmos5l_fill_1_7 VPWR VGND sg13cmos5l_fill_1
* cell instance sg13cmos5l_fill_1_8 r0 *1 0,0
Xsg13cmos5l_fill_1_8 VPWR VGND sg13cmos5l_fill_1
* cell instance sg13cmos5l_fill_1_9 r0 *1 0,0
Xsg13cmos5l_fill_1_9 VPWR VGND sg13cmos5l_fill_1
* cell instance sg13cmos5l_fill_1_10 r0 *1 0,0
Xsg13cmos5l_fill_1_10 VPWR VGND sg13cmos5l_fill_1
* cell instance sg13cmos5l_fill_1_11 r0 *1 0,0
Xsg13cmos5l_fill_1_11 VPWR VGND sg13cmos5l_fill_1
* cell instance sg13cmos5l_fill_1_12 r0 *1 0,0
Xsg13cmos5l_fill_1_12 VPWR VGND sg13cmos5l_fill_1
* cell instance sg13cmos5l_fill_1_13 r0 *1 0,0
Xsg13cmos5l_fill_1_13 VPWR VGND sg13cmos5l_fill_1
* cell instance sg13cmos5l_fill_1_14 r0 *1 0,0
Xsg13cmos5l_fill_1_14 VPWR VGND sg13cmos5l_fill_1
* cell instance sg13cmos5l_fill_1_15 r0 *1 0,0
Xsg13cmos5l_fill_1_15 VPWR VGND sg13cmos5l_fill_1
* cell instance sg13cmos5l_fill_1_16 r0 *1 0,0
Xsg13cmos5l_fill_1_16 VPWR VGND sg13cmos5l_fill_1
* cell instance sg13cmos5l_fill_1_17 r0 *1 0,0
Xsg13cmos5l_fill_1_17 VPWR VGND sg13cmos5l_fill_1
* cell instance sg13cmos5l_fill_1_18 r0 *1 0,0
Xsg13cmos5l_fill_1_18 VPWR VGND sg13cmos5l_fill_1
* cell instance sg13cmos5l_fill_1_19 r0 *1 0,0
Xsg13cmos5l_fill_1_19 VPWR VGND sg13cmos5l_fill_1
* cell instance sg13cmos5l_fill_1_20 r0 *1 0,0
Xsg13cmos5l_fill_1_20 VPWR VGND sg13cmos5l_fill_1
* cell instance sg13cmos5l_fill_1_21 r0 *1 0,0
Xsg13cmos5l_fill_1_21 VPWR VGND sg13cmos5l_fill_1
* cell instance sg13cmos5l_fill_1_22 r0 *1 0,0
Xsg13cmos5l_fill_1_22 VPWR VGND sg13cmos5l_fill_1
* cell instance sg13cmos5l_fill_1_23 r0 *1 0,0
Xsg13cmos5l_fill_1_23 VPWR VGND sg13cmos5l_fill_1
* cell instance sg13cmos5l_fill_1_24 r0 *1 0,0
Xsg13cmos5l_fill_1_24 VPWR VGND sg13cmos5l_fill_1
* cell instance sg13cmos5l_fill_1_25 r0 *1 0,0
Xsg13cmos5l_fill_1_25 VPWR VGND sg13cmos5l_fill_1
* cell instance sg13cmos5l_fill_1_26 r0 *1 0,0
Xsg13cmos5l_fill_1_26 VPWR VGND sg13cmos5l_fill_1
* cell instance sg13cmos5l_fill_1_27 r0 *1 0,0
Xsg13cmos5l_fill_1_27 VPWR VGND sg13cmos5l_fill_1
* cell instance sg13cmos5l_fill_1_28 r0 *1 0,0
Xsg13cmos5l_fill_1_28 VPWR VGND sg13cmos5l_fill_1
* cell instance sg13cmos5l_fill_1_29 r0 *1 0,0
Xsg13cmos5l_fill_1_29 VPWR VGND sg13cmos5l_fill_1
* cell instance sg13cmos5l_fill_1_30 r0 *1 0,0
Xsg13cmos5l_fill_1_30 VPWR VGND sg13cmos5l_fill_1
* cell instance sg13cmos5l_fill_1_31 r0 *1 0,0
Xsg13cmos5l_fill_1_31 VPWR VGND sg13cmos5l_fill_1
* cell instance sg13cmos5l_fill_1_32 r0 *1 0,0
Xsg13cmos5l_fill_1_32 VPWR VGND sg13cmos5l_fill_1
* cell instance sg13cmos5l_fill_1_33 r0 *1 0,0
Xsg13cmos5l_fill_1_33 VPWR VGND sg13cmos5l_fill_1
* cell instance sg13cmos5l_fill_1_34 r0 *1 0,0
Xsg13cmos5l_fill_1_34 VPWR VGND sg13cmos5l_fill_1
* cell instance sg13cmos5l_fill_1_35 r0 *1 0,0
Xsg13cmos5l_fill_1_35 VPWR VGND sg13cmos5l_fill_1
* cell instance sg13cmos5l_fill_1_36 r0 *1 0,0
Xsg13cmos5l_fill_1_36 VPWR VGND sg13cmos5l_fill_1
* cell instance sg13cmos5l_fill_1_37 r0 *1 0,0
Xsg13cmos5l_fill_1_37 VPWR VGND sg13cmos5l_fill_1
* cell instance sg13cmos5l_fill_1_38 r0 *1 0,0
Xsg13cmos5l_fill_1_38 VPWR VGND sg13cmos5l_fill_1
* cell instance sg13cmos5l_fill_1_39 r0 *1 0,0
Xsg13cmos5l_fill_1_39 VPWR VGND sg13cmos5l_fill_1
* cell instance sg13cmos5l_fill_1_40 r0 *1 0,0
Xsg13cmos5l_fill_1_40 VPWR VGND sg13cmos5l_fill_1
* cell instance sg13cmos5l_fill_1_41 r0 *1 0,0
Xsg13cmos5l_fill_1_41 VPWR VGND sg13cmos5l_fill_1
* cell instance sg13cmos5l_fill_1_42 r0 *1 0,0
Xsg13cmos5l_fill_1_42 VPWR VGND sg13cmos5l_fill_1
* cell instance sg13cmos5l_fill_1_43 r0 *1 0,0
Xsg13cmos5l_fill_1_43 VPWR VGND sg13cmos5l_fill_1
* cell instance sg13cmos5l_fill_1_44 r0 *1 0,0
Xsg13cmos5l_fill_1_44 VPWR VGND sg13cmos5l_fill_1
* cell instance sg13cmos5l_fill_1_45 r0 *1 0,0
Xsg13cmos5l_fill_1_45 VPWR VGND sg13cmos5l_fill_1
* cell instance sg13cmos5l_fill_1_46 r0 *1 0,0
Xsg13cmos5l_fill_1_46 VPWR VGND sg13cmos5l_fill_1
* cell instance sg13cmos5l_fill_1_47 r0 *1 0,0
Xsg13cmos5l_fill_1_47 VPWR VGND sg13cmos5l_fill_1
* cell instance sg13cmos5l_fill_1_48 r0 *1 0,0
Xsg13cmos5l_fill_1_48 VPWR VGND sg13cmos5l_fill_1
* cell instance sg13cmos5l_fill_1_49 r0 *1 0,0
Xsg13cmos5l_fill_1_49 VPWR VGND sg13cmos5l_fill_1
* cell instance sg13cmos5l_fill_1_50 r0 *1 0,0
Xsg13cmos5l_fill_1_50 VPWR VGND sg13cmos5l_fill_1
* cell instance sg13cmos5l_fill_1_51 r0 *1 0,0
Xsg13cmos5l_fill_1_51 VPWR VGND sg13cmos5l_fill_1
* cell instance sg13cmos5l_fill_1_52 r0 *1 0,0
Xsg13cmos5l_fill_1_52 VPWR VGND sg13cmos5l_fill_1
* cell instance sg13cmos5l_fill_1_53 r0 *1 0,0
Xsg13cmos5l_fill_1_53 VPWR VGND sg13cmos5l_fill_1
* cell instance sg13cmos5l_fill_1_54 r0 *1 0,0
Xsg13cmos5l_fill_1_54 VPWR VGND sg13cmos5l_fill_1
* cell instance sg13cmos5l_fill_1_55 r0 *1 0,0
Xsg13cmos5l_fill_1_55 VPWR VGND sg13cmos5l_fill_1
* cell instance sg13cmos5l_fill_1_56 r0 *1 0,0
Xsg13cmos5l_fill_1_56 VPWR VGND sg13cmos5l_fill_1
* cell instance sg13cmos5l_fill_1_57 r0 *1 0,0
Xsg13cmos5l_fill_1_57 VPWR VGND sg13cmos5l_fill_1
* cell instance sg13cmos5l_fill_1_58 r0 *1 0,0
Xsg13cmos5l_fill_1_58 VPWR VGND sg13cmos5l_fill_1
* cell instance sg13cmos5l_fill_1_59 r0 *1 0,0
Xsg13cmos5l_fill_1_59 VPWR VGND sg13cmos5l_fill_1
* cell instance sg13cmos5l_fill_1_60 r0 *1 0,0
Xsg13cmos5l_fill_1_60 VPWR VGND sg13cmos5l_fill_1
* cell instance sg13cmos5l_fill_1_61 r0 *1 0,0
Xsg13cmos5l_fill_1_61 VPWR VGND sg13cmos5l_fill_1
* cell instance sg13cmos5l_fill_1_62 r0 *1 0,0
Xsg13cmos5l_fill_1_62 VPWR VGND sg13cmos5l_fill_1
* cell instance sg13cmos5l_fill_1_63 r0 *1 0,0
Xsg13cmos5l_fill_1_63 VPWR VGND sg13cmos5l_fill_1
* cell instance sg13cmos5l_fill_1_64 r0 *1 0,0
Xsg13cmos5l_fill_1_64 VPWR VGND sg13cmos5l_fill_1
* cell instance sg13cmos5l_fill_1_65 r0 *1 0,0
Xsg13cmos5l_fill_1_65 VPWR VGND sg13cmos5l_fill_1
* cell instance sg13cmos5l_fill_1_66 r0 *1 0,0
Xsg13cmos5l_fill_1_66 VPWR VGND sg13cmos5l_fill_1
* cell instance sg13cmos5l_fill_1_67 r0 *1 0,0
Xsg13cmos5l_fill_1_67 VPWR VGND sg13cmos5l_fill_1
* cell instance sg13cmos5l_fill_1_68 r0 *1 0,0
Xsg13cmos5l_fill_1_68 VPWR VGND sg13cmos5l_fill_1
* cell instance sg13cmos5l_fill_1_69 r0 *1 0,0
Xsg13cmos5l_fill_1_69 VPWR VGND sg13cmos5l_fill_1
* cell instance sg13cmos5l_fill_1_70 r0 *1 0,0
Xsg13cmos5l_fill_1_70 VPWR VGND sg13cmos5l_fill_1
* cell instance sg13cmos5l_fill_1_71 r0 *1 0,0
Xsg13cmos5l_fill_1_71 VPWR VGND sg13cmos5l_fill_1
* cell instance sg13cmos5l_fill_1_72 r0 *1 0,0
Xsg13cmos5l_fill_1_72 VPWR VGND sg13cmos5l_fill_1
* cell instance sg13cmos5l_fill_1_73 r0 *1 0,0
Xsg13cmos5l_fill_1_73 VPWR VGND sg13cmos5l_fill_1
* cell instance sg13cmos5l_fill_1_74 r0 *1 0,0
Xsg13cmos5l_fill_1_74 VPWR VGND sg13cmos5l_fill_1
* cell instance sg13cmos5l_fill_1_75 r0 *1 0,0
Xsg13cmos5l_fill_1_75 VPWR VGND sg13cmos5l_fill_1
* cell instance sg13cmos5l_fill_1_76 r0 *1 0,0
Xsg13cmos5l_fill_1_76 VPWR VGND sg13cmos5l_fill_1
* cell instance sg13cmos5l_fill_1_77 r0 *1 0,0
Xsg13cmos5l_fill_1_77 VPWR VGND sg13cmos5l_fill_1
* cell instance sg13cmos5l_fill_1_78 r0 *1 0,0
Xsg13cmos5l_fill_1_78 VPWR VGND sg13cmos5l_fill_1
* cell instance sg13cmos5l_fill_1_79 r0 *1 0,0
Xsg13cmos5l_fill_1_79 VPWR VGND sg13cmos5l_fill_1
* cell instance sg13cmos5l_fill_1_80 r0 *1 0,0
Xsg13cmos5l_fill_1_80 VPWR VGND sg13cmos5l_fill_1
* cell instance sg13cmos5l_fill_1_81 r0 *1 0,0
Xsg13cmos5l_fill_1_81 VPWR VGND sg13cmos5l_fill_1
* cell instance sg13cmos5l_fill_1_82 r0 *1 0,0
Xsg13cmos5l_fill_1_82 VPWR VGND sg13cmos5l_fill_1
* cell instance sg13cmos5l_fill_1_83 r0 *1 0,0
Xsg13cmos5l_fill_1_83 VPWR VGND sg13cmos5l_fill_1
* cell instance sg13cmos5l_fill_1_84 r0 *1 0,0
Xsg13cmos5l_fill_1_84 VPWR VGND sg13cmos5l_fill_1
* cell instance sg13cmos5l_fill_1_85 r0 *1 0,0
Xsg13cmos5l_fill_1_85 VPWR VGND sg13cmos5l_fill_1
* cell instance sg13cmos5l_fill_1_86 r0 *1 0,0
Xsg13cmos5l_fill_1_86 VPWR VGND sg13cmos5l_fill_1
* cell instance sg13cmos5l_fill_1_87 r0 *1 0,0
Xsg13cmos5l_fill_1_87 VPWR VGND sg13cmos5l_fill_1
* cell instance sg13cmos5l_fill_1_88 r0 *1 0,0
Xsg13cmos5l_fill_1_88 VPWR VGND sg13cmos5l_fill_1
* cell instance sg13cmos5l_fill_1_89 r0 *1 0,0
Xsg13cmos5l_fill_1_89 VPWR VGND sg13cmos5l_fill_1
* cell instance sg13cmos5l_fill_1_90 r0 *1 0,0
Xsg13cmos5l_fill_1_90 VPWR VGND sg13cmos5l_fill_1
* cell instance sg13cmos5l_fill_1_91 r0 *1 0,0
Xsg13cmos5l_fill_1_91 VPWR VGND sg13cmos5l_fill_1
* cell instance sg13cmos5l_fill_1_92 r0 *1 0,0
Xsg13cmos5l_fill_1_92 VPWR VGND sg13cmos5l_fill_1
* cell instance sg13cmos5l_fill_1_93 r0 *1 0,0
Xsg13cmos5l_fill_1_93 VPWR VGND sg13cmos5l_fill_1
* cell instance sg13cmos5l_fill_1_94 r0 *1 0,0
Xsg13cmos5l_fill_1_94 VPWR VGND sg13cmos5l_fill_1
* cell instance sg13cmos5l_fill_1_95 r0 *1 0,0
Xsg13cmos5l_fill_1_95 VPWR VGND sg13cmos5l_fill_1
* cell instance sg13cmos5l_fill_1_96 r0 *1 0,0
Xsg13cmos5l_fill_1_96 VPWR VGND sg13cmos5l_fill_1
* cell instance sg13cmos5l_fill_1_97 r0 *1 0,0
Xsg13cmos5l_fill_1_97 VPWR VGND sg13cmos5l_fill_1
* cell instance sg13cmos5l_fill_1_98 r0 *1 0,0
Xsg13cmos5l_fill_1_98 VPWR VGND sg13cmos5l_fill_1
* cell instance sg13cmos5l_fill_1_99 r0 *1 0,0
Xsg13cmos5l_fill_1_99 VPWR VGND sg13cmos5l_fill_1
* cell instance sg13cmos5l_fill_1_100 r0 *1 0,0
Xsg13cmos5l_fill_1_100 VPWR VGND sg13cmos5l_fill_1
* cell instance sg13cmos5l_fill_1_101 r0 *1 0,0
Xsg13cmos5l_fill_1_101 VPWR VGND sg13cmos5l_fill_1
* cell instance sg13cmos5l_fill_1_102 r0 *1 0,0
Xsg13cmos5l_fill_1_102 VPWR VGND sg13cmos5l_fill_1
* cell instance sg13cmos5l_fill_1_103 r0 *1 0,0
Xsg13cmos5l_fill_1_103 VPWR VGND sg13cmos5l_fill_1
* cell instance sg13cmos5l_fill_1_104 r0 *1 0,0
Xsg13cmos5l_fill_1_104 VPWR VGND sg13cmos5l_fill_1
* cell instance sg13cmos5l_fill_1_105 r0 *1 0,0
Xsg13cmos5l_fill_1_105 VPWR VGND sg13cmos5l_fill_1
* cell instance sg13cmos5l_fill_1_106 r0 *1 0,0
Xsg13cmos5l_fill_1_106 VPWR VGND sg13cmos5l_fill_1
* cell instance sg13cmos5l_fill_1_107 r0 *1 0,0
Xsg13cmos5l_fill_1_107 VPWR VGND sg13cmos5l_fill_1
* cell instance sg13cmos5l_fill_1_108 r0 *1 0,0
Xsg13cmos5l_fill_1_108 VPWR VGND sg13cmos5l_fill_1
* cell instance sg13cmos5l_fill_1_109 r0 *1 0,0
Xsg13cmos5l_fill_1_109 VPWR VGND sg13cmos5l_fill_1
* cell instance sg13cmos5l_fill_1_110 r0 *1 0,0
Xsg13cmos5l_fill_1_110 VPWR VGND sg13cmos5l_fill_1
* cell instance sg13cmos5l_fill_1_111 r0 *1 0,0
Xsg13cmos5l_fill_1_111 VPWR VGND sg13cmos5l_fill_1
* cell instance sg13cmos5l_fill_1_112 r0 *1 0,0
Xsg13cmos5l_fill_1_112 VPWR VGND sg13cmos5l_fill_1
* cell instance sg13cmos5l_fill_1_113 r0 *1 0,0
Xsg13cmos5l_fill_1_113 VPWR VGND sg13cmos5l_fill_1
* cell instance sg13cmos5l_fill_1_114 r0 *1 0,0
Xsg13cmos5l_fill_1_114 VPWR VGND sg13cmos5l_fill_1
* cell instance sg13cmos5l_fill_1_115 r0 *1 0,0
Xsg13cmos5l_fill_1_115 VPWR VGND sg13cmos5l_fill_1
* cell instance sg13cmos5l_fill_1_116 r0 *1 0,0
Xsg13cmos5l_fill_1_116 VPWR VGND sg13cmos5l_fill_1
* cell instance sg13cmos5l_fill_1_117 r0 *1 0,0
Xsg13cmos5l_fill_1_117 VPWR VGND sg13cmos5l_fill_1
* cell instance sg13cmos5l_fill_1_118 r0 *1 0,0
Xsg13cmos5l_fill_1_118 VPWR VGND sg13cmos5l_fill_1
* cell instance sg13cmos5l_fill_1_119 r0 *1 0,0
Xsg13cmos5l_fill_1_119 VPWR VGND sg13cmos5l_fill_1
* cell instance sg13cmos5l_fill_1_120 r0 *1 0,0
Xsg13cmos5l_fill_1_120 VPWR VGND sg13cmos5l_fill_1
* cell instance sg13cmos5l_fill_1_121 r0 *1 0,0
Xsg13cmos5l_fill_1_121 VPWR VGND sg13cmos5l_fill_1
* cell instance sg13cmos5l_fill_1_122 r0 *1 0,0
Xsg13cmos5l_fill_1_122 VPWR VGND sg13cmos5l_fill_1
* cell instance sg13cmos5l_fill_1_123 r0 *1 0,0
Xsg13cmos5l_fill_1_123 VPWR VGND sg13cmos5l_fill_1
* cell instance sg13cmos5l_fill_1_124 r0 *1 0,0
Xsg13cmos5l_fill_1_124 VPWR VGND sg13cmos5l_fill_1
* cell instance sg13cmos5l_fill_1_125 r0 *1 0,0
Xsg13cmos5l_fill_1_125 VPWR VGND sg13cmos5l_fill_1
* cell instance sg13cmos5l_fill_1_126 r0 *1 0,0
Xsg13cmos5l_fill_1_126 VPWR VGND sg13cmos5l_fill_1
* cell instance sg13cmos5l_fill_1_127 r0 *1 0,0
Xsg13cmos5l_fill_1_127 VPWR VGND sg13cmos5l_fill_1
* cell instance sg13cmos5l_fill_1_128 r0 *1 0,0
Xsg13cmos5l_fill_1_128 VPWR VGND sg13cmos5l_fill_1
* cell instance sg13cmos5l_fill_1_129 r0 *1 0,0
Xsg13cmos5l_fill_1_129 VPWR VGND sg13cmos5l_fill_1
* cell instance sg13cmos5l_fill_1_130 r0 *1 0,0
Xsg13cmos5l_fill_1_130 VPWR VGND sg13cmos5l_fill_1
* cell instance sg13cmos5l_fill_1_131 r0 *1 0,0
Xsg13cmos5l_fill_1_131 VPWR VGND sg13cmos5l_fill_1
* cell instance sg13cmos5l_fill_1_132 r0 *1 0,0
Xsg13cmos5l_fill_1_132 VPWR VGND sg13cmos5l_fill_1
* cell instance sg13cmos5l_fill_1_133 r0 *1 0,0
Xsg13cmos5l_fill_1_133 VPWR VGND sg13cmos5l_fill_1
* cell instance sg13cmos5l_fill_1_134 r0 *1 0,0
Xsg13cmos5l_fill_1_134 VPWR VGND sg13cmos5l_fill_1
* cell instance sg13cmos5l_fill_1_135 r0 *1 0,0
Xsg13cmos5l_fill_1_135 VPWR VGND sg13cmos5l_fill_1
* cell instance sg13cmos5l_fill_1_136 r0 *1 0,0
Xsg13cmos5l_fill_1_136 VPWR VGND sg13cmos5l_fill_1
* cell instance sg13cmos5l_fill_1_137 r0 *1 0,0
Xsg13cmos5l_fill_1_137 VPWR VGND sg13cmos5l_fill_1
* cell instance sg13cmos5l_fill_1_138 r0 *1 0,0
Xsg13cmos5l_fill_1_138 VPWR VGND sg13cmos5l_fill_1
* cell instance sg13cmos5l_fill_1_139 r0 *1 0,0
Xsg13cmos5l_fill_1_139 VPWR VGND sg13cmos5l_fill_1
* cell instance sg13cmos5l_fill_1_140 r0 *1 0,0
Xsg13cmos5l_fill_1_140 VPWR VGND sg13cmos5l_fill_1
* cell instance sg13cmos5l_fill_1_141 r0 *1 0,0
Xsg13cmos5l_fill_1_141 VPWR VGND sg13cmos5l_fill_1
* cell instance sg13cmos5l_fill_1_142 r0 *1 0,0
Xsg13cmos5l_fill_1_142 VPWR VGND sg13cmos5l_fill_1
* cell instance sg13cmos5l_fill_1_143 r0 *1 0,0
Xsg13cmos5l_fill_1_143 VPWR VGND sg13cmos5l_fill_1
* cell instance sg13cmos5l_fill_1_144 r0 *1 0,0
Xsg13cmos5l_fill_1_144 VPWR VGND sg13cmos5l_fill_1
* cell instance sg13cmos5l_fill_1_145 r0 *1 0,0
Xsg13cmos5l_fill_1_145 VPWR VGND sg13cmos5l_fill_1
* cell instance sg13cmos5l_fill_1_146 r0 *1 0,0
Xsg13cmos5l_fill_1_146 VPWR VGND sg13cmos5l_fill_1
* cell instance sg13cmos5l_fill_1_147 r0 *1 0,0
Xsg13cmos5l_fill_1_147 VPWR VGND sg13cmos5l_fill_1
* cell instance sg13cmos5l_fill_1_148 r0 *1 0,0
Xsg13cmos5l_fill_1_148 VPWR VGND sg13cmos5l_fill_1
* cell instance sg13cmos5l_fill_1_149 r0 *1 0,0
Xsg13cmos5l_fill_1_149 VPWR VGND sg13cmos5l_fill_1
* cell instance sg13cmos5l_fill_1_150 r0 *1 0,0
Xsg13cmos5l_fill_1_150 VPWR VGND sg13cmos5l_fill_1
* cell instance sg13cmos5l_fill_1_151 r0 *1 0,0
Xsg13cmos5l_fill_1_151 VPWR VGND sg13cmos5l_fill_1
* cell instance sg13cmos5l_fill_1_152 r0 *1 0,0
Xsg13cmos5l_fill_1_152 VPWR VGND sg13cmos5l_fill_1
* cell instance sg13cmos5l_fill_1_153 r0 *1 0,0
Xsg13cmos5l_fill_1_153 VPWR VGND sg13cmos5l_fill_1
* cell instance sg13cmos5l_fill_1_154 r0 *1 0,0
Xsg13cmos5l_fill_1_154 VPWR VGND sg13cmos5l_fill_1
* cell instance sg13cmos5l_fill_1_155 r0 *1 0,0
Xsg13cmos5l_fill_1_155 VPWR VGND sg13cmos5l_fill_1
* cell instance sg13cmos5l_fill_1_156 r0 *1 0,0
Xsg13cmos5l_fill_1_156 VPWR VGND sg13cmos5l_fill_1
* cell instance sg13cmos5l_fill_1_157 r0 *1 0,0
Xsg13cmos5l_fill_1_157 VPWR VGND sg13cmos5l_fill_1
* cell instance sg13cmos5l_fill_1_158 r0 *1 0,0
Xsg13cmos5l_fill_1_158 VPWR VGND sg13cmos5l_fill_1
* cell instance sg13cmos5l_fill_1_159 r0 *1 0,0
Xsg13cmos5l_fill_1_159 VPWR VGND sg13cmos5l_fill_1
* cell instance sg13cmos5l_fill_1_160 r0 *1 0,0
Xsg13cmos5l_fill_1_160 VPWR VGND sg13cmos5l_fill_1
* cell instance sg13cmos5l_fill_1_161 r0 *1 0,0
Xsg13cmos5l_fill_1_161 VPWR VGND sg13cmos5l_fill_1
* cell instance sg13cmos5l_fill_1_162 r0 *1 0,0
Xsg13cmos5l_fill_1_162 VPWR VGND sg13cmos5l_fill_1
* cell instance sg13cmos5l_fill_1_163 r0 *1 0,0
Xsg13cmos5l_fill_1_163 VPWR VGND sg13cmos5l_fill_1
* cell instance sg13cmos5l_fill_1_164 r0 *1 0,0
Xsg13cmos5l_fill_1_164 VPWR VGND sg13cmos5l_fill_1
* cell instance sg13cmos5l_fill_1_165 r0 *1 0,0
Xsg13cmos5l_fill_1_165 VPWR VGND sg13cmos5l_fill_1
* cell instance sg13cmos5l_fill_1_166 r0 *1 0,0
Xsg13cmos5l_fill_1_166 VPWR VGND sg13cmos5l_fill_1
* cell instance sg13cmos5l_fill_1_167 r0 *1 0,0
Xsg13cmos5l_fill_1_167 VPWR VGND sg13cmos5l_fill_1
* cell instance sg13cmos5l_fill_1_168 r0 *1 0,0
Xsg13cmos5l_fill_1_168 VPWR VGND sg13cmos5l_fill_1
* cell instance sg13cmos5l_fill_1_169 r0 *1 0,0
Xsg13cmos5l_fill_1_169 VPWR VGND sg13cmos5l_fill_1
* cell instance sg13cmos5l_fill_1_170 r0 *1 0,0
Xsg13cmos5l_fill_1_170 VPWR VGND sg13cmos5l_fill_1
* cell instance sg13cmos5l_fill_1_171 r0 *1 0,0
Xsg13cmos5l_fill_1_171 VPWR VGND sg13cmos5l_fill_1
* cell instance sg13cmos5l_fill_1_172 r0 *1 0,0
Xsg13cmos5l_fill_1_172 VPWR VGND sg13cmos5l_fill_1
* cell instance sg13cmos5l_fill_1_173 r0 *1 0,0
Xsg13cmos5l_fill_1_173 VPWR VGND sg13cmos5l_fill_1
* cell instance sg13cmos5l_fill_1_174 r0 *1 0,0
Xsg13cmos5l_fill_1_174 VPWR VGND sg13cmos5l_fill_1
* cell instance sg13cmos5l_fill_1_175 r0 *1 0,0
Xsg13cmos5l_fill_1_175 VPWR VGND sg13cmos5l_fill_1
* cell instance sg13cmos5l_fill_1_176 r0 *1 0,0
Xsg13cmos5l_fill_1_176 VPWR VGND sg13cmos5l_fill_1
* cell instance sg13cmos5l_fill_1_177 r0 *1 0,0
Xsg13cmos5l_fill_1_177 VPWR VGND sg13cmos5l_fill_1
* cell instance sg13cmos5l_fill_1_178 r0 *1 0,0
Xsg13cmos5l_fill_1_178 VPWR VGND sg13cmos5l_fill_1
* cell instance sg13cmos5l_fill_1_179 r0 *1 0,0
Xsg13cmos5l_fill_1_179 VPWR VGND sg13cmos5l_fill_1
* cell instance sg13cmos5l_fill_1_180 r0 *1 0,0
Xsg13cmos5l_fill_1_180 VPWR VGND sg13cmos5l_fill_1
* cell instance sg13cmos5l_fill_1_181 r0 *1 0,0
Xsg13cmos5l_fill_1_181 VPWR VGND sg13cmos5l_fill_1
* cell instance sg13cmos5l_fill_1_182 r0 *1 0,0
Xsg13cmos5l_fill_1_182 VPWR VGND sg13cmos5l_fill_1
* cell instance sg13cmos5l_fill_1_183 r0 *1 0,0
Xsg13cmos5l_fill_1_183 VPWR VGND sg13cmos5l_fill_1
* cell instance sg13cmos5l_fill_1_184 r0 *1 0,0
Xsg13cmos5l_fill_1_184 VPWR VGND sg13cmos5l_fill_1
* cell instance sg13cmos5l_fill_1_185 r0 *1 0,0
Xsg13cmos5l_fill_1_185 VPWR VGND sg13cmos5l_fill_1
* cell instance sg13cmos5l_fill_1_186 r0 *1 0,0
Xsg13cmos5l_fill_1_186 VPWR VGND sg13cmos5l_fill_1
* cell instance sg13cmos5l_fill_1_187 r0 *1 0,0
Xsg13cmos5l_fill_1_187 VPWR VGND sg13cmos5l_fill_1
* cell instance sg13cmos5l_fill_1_188 r0 *1 0,0
Xsg13cmos5l_fill_1_188 VPWR VGND sg13cmos5l_fill_1
* cell instance sg13cmos5l_fill_1_189 r0 *1 0,0
Xsg13cmos5l_fill_1_189 VPWR VGND sg13cmos5l_fill_1
* cell instance sg13cmos5l_fill_1_190 r0 *1 0,0
Xsg13cmos5l_fill_1_190 VPWR VGND sg13cmos5l_fill_1
* cell instance sg13cmos5l_fill_1_191 r0 *1 0,0
Xsg13cmos5l_fill_1_191 VPWR VGND sg13cmos5l_fill_1
* cell instance sg13cmos5l_fill_1_192 r0 *1 0,0
Xsg13cmos5l_fill_1_192 VPWR VGND sg13cmos5l_fill_1
* cell instance sg13cmos5l_fill_1_193 r0 *1 0,0
Xsg13cmos5l_fill_1_193 VPWR VGND sg13cmos5l_fill_1
* cell instance sg13cmos5l_fill_1_194 r0 *1 0,0
Xsg13cmos5l_fill_1_194 VPWR VGND sg13cmos5l_fill_1
* cell instance sg13cmos5l_fill_1_195 r0 *1 0,0
Xsg13cmos5l_fill_1_195 VPWR VGND sg13cmos5l_fill_1
* cell instance sg13cmos5l_fill_1_196 r0 *1 0,0
Xsg13cmos5l_fill_1_196 VPWR VGND sg13cmos5l_fill_1
* cell instance sg13cmos5l_fill_1_197 r0 *1 0,0
Xsg13cmos5l_fill_1_197 VPWR VGND sg13cmos5l_fill_1
* cell instance sg13cmos5l_fill_1_198 r0 *1 0,0
Xsg13cmos5l_fill_1_198 VPWR VGND sg13cmos5l_fill_1
* cell instance sg13cmos5l_fill_1_199 r0 *1 0,0
Xsg13cmos5l_fill_1_199 VPWR VGND sg13cmos5l_fill_1
* cell instance sg13cmos5l_fill_1_200 r0 *1 0,0
Xsg13cmos5l_fill_1_200 VPWR VGND sg13cmos5l_fill_1
* cell instance sg13cmos5l_fill_1_201 r0 *1 0,0
Xsg13cmos5l_fill_1_201 VPWR VGND sg13cmos5l_fill_1
* cell instance sg13cmos5l_fill_1_202 r0 *1 0,0
Xsg13cmos5l_fill_1_202 VPWR VGND sg13cmos5l_fill_1
* cell instance sg13cmos5l_fill_1_203 r0 *1 0,0
Xsg13cmos5l_fill_1_203 VPWR VGND sg13cmos5l_fill_1
* cell instance sg13cmos5l_fill_1_204 r0 *1 0,0
Xsg13cmos5l_fill_1_204 VPWR VGND sg13cmos5l_fill_1
* cell instance sg13cmos5l_fill_1_205 r0 *1 0,0
Xsg13cmos5l_fill_1_205 VPWR VGND sg13cmos5l_fill_1
* cell instance sg13cmos5l_fill_1_206 r0 *1 0,0
Xsg13cmos5l_fill_1_206 VPWR VGND sg13cmos5l_fill_1
* cell instance sg13cmos5l_fill_1_207 r0 *1 0,0
Xsg13cmos5l_fill_1_207 VPWR VGND sg13cmos5l_fill_1
* cell instance sg13cmos5l_fill_1_208 r0 *1 0,0
Xsg13cmos5l_fill_1_208 VPWR VGND sg13cmos5l_fill_1
* cell instance sg13cmos5l_fill_1_209 r0 *1 0,0
Xsg13cmos5l_fill_1_209 VPWR VGND sg13cmos5l_fill_1
* cell instance sg13cmos5l_fill_1_210 r0 *1 0,0
Xsg13cmos5l_fill_1_210 VPWR VGND sg13cmos5l_fill_1
* cell instance sg13cmos5l_fill_1_211 r0 *1 0,0
Xsg13cmos5l_fill_1_211 VPWR VGND sg13cmos5l_fill_1
* cell instance sg13cmos5l_fill_1_212 r0 *1 0,0
Xsg13cmos5l_fill_1_212 VPWR VGND sg13cmos5l_fill_1
* cell instance sg13cmos5l_fill_1_213 r0 *1 0,0
Xsg13cmos5l_fill_1_213 VPWR VGND sg13cmos5l_fill_1
* cell instance sg13cmos5l_fill_1_214 r0 *1 0,0
Xsg13cmos5l_fill_1_214 VPWR VGND sg13cmos5l_fill_1
* cell instance sg13cmos5l_fill_1_215 r0 *1 0,0
Xsg13cmos5l_fill_1_215 VPWR VGND sg13cmos5l_fill_1
* cell instance sg13cmos5l_fill_1_216 r0 *1 0,0
Xsg13cmos5l_fill_1_216 VPWR VGND sg13cmos5l_fill_1
* cell instance sg13cmos5l_fill_1_217 r0 *1 0,0
Xsg13cmos5l_fill_1_217 VPWR VGND sg13cmos5l_fill_1
* cell instance sg13cmos5l_fill_1_218 r0 *1 0,0
Xsg13cmos5l_fill_1_218 VPWR VGND sg13cmos5l_fill_1
* cell instance sg13cmos5l_fill_1_219 r0 *1 0,0
Xsg13cmos5l_fill_1_219 VPWR VGND sg13cmos5l_fill_1
* cell instance sg13cmos5l_fill_1_220 r0 *1 0,0
Xsg13cmos5l_fill_1_220 VPWR VGND sg13cmos5l_fill_1
* cell instance sg13cmos5l_fill_1_221 r0 *1 0,0
Xsg13cmos5l_fill_1_221 VPWR VGND sg13cmos5l_fill_1
* cell instance sg13cmos5l_fill_1_222 r0 *1 0,0
Xsg13cmos5l_fill_1_222 VPWR VGND sg13cmos5l_fill_1
* cell instance sg13cmos5l_fill_1_223 r0 *1 0,0
Xsg13cmos5l_fill_1_223 VPWR VGND sg13cmos5l_fill_1
* cell instance sg13cmos5l_fill_1_224 r0 *1 0,0
Xsg13cmos5l_fill_1_224 VPWR VGND sg13cmos5l_fill_1
* cell instance sg13cmos5l_fill_1_225 r0 *1 0,0
Xsg13cmos5l_fill_1_225 VPWR VGND sg13cmos5l_fill_1
* cell instance sg13cmos5l_fill_1_226 r0 *1 0,0
Xsg13cmos5l_fill_1_226 VPWR VGND sg13cmos5l_fill_1
* cell instance sg13cmos5l_fill_1_227 r0 *1 0,0
Xsg13cmos5l_fill_1_227 VPWR VGND sg13cmos5l_fill_1
* cell instance sg13cmos5l_fill_1_228 r0 *1 0,0
Xsg13cmos5l_fill_1_228 VPWR VGND sg13cmos5l_fill_1
* cell instance sg13cmos5l_fill_1_229 r0 *1 0,0
Xsg13cmos5l_fill_1_229 VPWR VGND sg13cmos5l_fill_1
* cell instance sg13cmos5l_fill_1_230 r0 *1 0,0
Xsg13cmos5l_fill_1_230 VPWR VGND sg13cmos5l_fill_1
* cell instance sg13cmos5l_fill_1_231 r0 *1 0,0
Xsg13cmos5l_fill_1_231 VPWR VGND sg13cmos5l_fill_1
* cell instance sg13cmos5l_fill_1_232 r0 *1 0,0
Xsg13cmos5l_fill_1_232 VPWR VGND sg13cmos5l_fill_1
* cell instance sg13cmos5l_fill_1_233 r0 *1 0,0
Xsg13cmos5l_fill_1_233 VPWR VGND sg13cmos5l_fill_1
* cell instance sg13cmos5l_fill_1_234 r0 *1 0,0
Xsg13cmos5l_fill_1_234 VPWR VGND sg13cmos5l_fill_1
* cell instance sg13cmos5l_fill_1_235 r0 *1 0,0
Xsg13cmos5l_fill_1_235 VPWR VGND sg13cmos5l_fill_1
* cell instance sg13cmos5l_fill_1_236 r0 *1 0,0
Xsg13cmos5l_fill_1_236 VPWR VGND sg13cmos5l_fill_1
* cell instance sg13cmos5l_fill_1_237 r0 *1 0,0
Xsg13cmos5l_fill_1_237 VPWR VGND sg13cmos5l_fill_1
* cell instance sg13cmos5l_fill_1_238 r0 *1 0,0
Xsg13cmos5l_fill_1_238 VPWR VGND sg13cmos5l_fill_1
* cell instance sg13cmos5l_fill_1_239 r0 *1 0,0
Xsg13cmos5l_fill_1_239 VPWR VGND sg13cmos5l_fill_1
* cell instance sg13cmos5l_fill_1_240 r0 *1 0,0
Xsg13cmos5l_fill_1_240 VPWR VGND sg13cmos5l_fill_1
* cell instance sg13cmos5l_fill_1_241 r0 *1 0,0
Xsg13cmos5l_fill_1_241 VPWR VGND sg13cmos5l_fill_1
* cell instance sg13cmos5l_fill_1_242 r0 *1 0,0
Xsg13cmos5l_fill_1_242 VPWR VGND sg13cmos5l_fill_1
* cell instance sg13cmos5l_fill_1_243 r0 *1 0,0
Xsg13cmos5l_fill_1_243 VPWR VGND sg13cmos5l_fill_1
* cell instance sg13cmos5l_fill_1_244 r0 *1 0,0
Xsg13cmos5l_fill_1_244 VPWR VGND sg13cmos5l_fill_1
* cell instance sg13cmos5l_fill_1_245 r0 *1 0,0
Xsg13cmos5l_fill_1_245 VPWR VGND sg13cmos5l_fill_1
* cell instance sg13cmos5l_fill_1_246 r0 *1 0,0
Xsg13cmos5l_fill_1_246 VPWR VGND sg13cmos5l_fill_1
* cell instance sg13cmos5l_fill_1_247 r0 *1 0,0
Xsg13cmos5l_fill_1_247 VPWR VGND sg13cmos5l_fill_1
* cell instance sg13cmos5l_fill_1_248 r0 *1 0,0
Xsg13cmos5l_fill_1_248 VPWR VGND sg13cmos5l_fill_1
* cell instance sg13cmos5l_fill_1_249 r0 *1 0,0
Xsg13cmos5l_fill_1_249 VPWR VGND sg13cmos5l_fill_1
* cell instance sg13cmos5l_fill_1_250 r0 *1 0,0
Xsg13cmos5l_fill_1_250 VPWR VGND sg13cmos5l_fill_1
* cell instance sg13cmos5l_fill_1_251 r0 *1 0,0
Xsg13cmos5l_fill_1_251 VPWR VGND sg13cmos5l_fill_1
* cell instance sg13cmos5l_fill_1_252 r0 *1 0,0
Xsg13cmos5l_fill_1_252 VPWR VGND sg13cmos5l_fill_1
* cell instance sg13cmos5l_fill_1_253 r0 *1 0,0
Xsg13cmos5l_fill_1_253 VPWR VGND sg13cmos5l_fill_1
* cell instance sg13cmos5l_fill_1_254 r0 *1 0,0
Xsg13cmos5l_fill_1_254 VPWR VGND sg13cmos5l_fill_1
* cell instance sg13cmos5l_fill_1_255 r0 *1 0,0
Xsg13cmos5l_fill_1_255 VPWR VGND sg13cmos5l_fill_1
* cell instance sg13cmos5l_fill_1_256 r0 *1 0,0
Xsg13cmos5l_fill_1_256 VPWR VGND sg13cmos5l_fill_1
* cell instance sg13cmos5l_fill_1_257 r0 *1 0,0
Xsg13cmos5l_fill_1_257 VPWR VGND sg13cmos5l_fill_1
* cell instance sg13cmos5l_fill_1_258 r0 *1 0,0
Xsg13cmos5l_fill_1_258 VPWR VGND sg13cmos5l_fill_1
* cell instance sg13cmos5l_fill_1_259 r0 *1 0,0
Xsg13cmos5l_fill_1_259 VPWR VGND sg13cmos5l_fill_1
* cell instance sg13cmos5l_fill_1_260 r0 *1 0,0
Xsg13cmos5l_fill_1_260 VPWR VGND sg13cmos5l_fill_1
* cell instance sg13cmos5l_fill_1_261 r0 *1 0,0
Xsg13cmos5l_fill_1_261 VPWR VGND sg13cmos5l_fill_1
* cell instance sg13cmos5l_fill_1_262 r0 *1 0,0
Xsg13cmos5l_fill_1_262 VPWR VGND sg13cmos5l_fill_1
* cell instance sg13cmos5l_fill_1_263 r0 *1 0,0
Xsg13cmos5l_fill_1_263 VPWR VGND sg13cmos5l_fill_1
* cell instance sg13cmos5l_fill_1_264 r0 *1 0,0
Xsg13cmos5l_fill_1_264 VPWR VGND sg13cmos5l_fill_1
* cell instance sg13cmos5l_fill_1_265 r0 *1 0,0
Xsg13cmos5l_fill_1_265 VPWR VGND sg13cmos5l_fill_1
* cell instance sg13cmos5l_fill_1_266 r0 *1 0,0
Xsg13cmos5l_fill_1_266 VPWR VGND sg13cmos5l_fill_1
* cell instance sg13cmos5l_fill_1_267 r0 *1 0,0
Xsg13cmos5l_fill_1_267 VPWR VGND sg13cmos5l_fill_1
* cell instance sg13cmos5l_fill_1_268 r0 *1 0,0
Xsg13cmos5l_fill_1_268 VPWR VGND sg13cmos5l_fill_1
* cell instance sg13cmos5l_fill_1_269 r0 *1 0,0
Xsg13cmos5l_fill_1_269 VPWR VGND sg13cmos5l_fill_1
* cell instance sg13cmos5l_fill_1_270 r0 *1 0,0
Xsg13cmos5l_fill_1_270 VPWR VGND sg13cmos5l_fill_1
* cell instance sg13cmos5l_fill_1_271 r0 *1 0,0
Xsg13cmos5l_fill_1_271 VPWR VGND sg13cmos5l_fill_1
* cell instance sg13cmos5l_fill_1_272 r0 *1 0,0
Xsg13cmos5l_fill_1_272 VPWR VGND sg13cmos5l_fill_1
* cell instance sg13cmos5l_fill_1_273 r0 *1 0,0
Xsg13cmos5l_fill_1_273 VPWR VGND sg13cmos5l_fill_1
* cell instance sg13cmos5l_fill_1_274 r0 *1 0,0
Xsg13cmos5l_fill_1_274 VPWR VGND sg13cmos5l_fill_1
* cell instance sg13cmos5l_fill_1_275 r0 *1 0,0
Xsg13cmos5l_fill_1_275 VPWR VGND sg13cmos5l_fill_1
* cell instance sg13cmos5l_fill_1_276 r0 *1 0,0
Xsg13cmos5l_fill_1_276 VPWR VGND sg13cmos5l_fill_1
* cell instance sg13cmos5l_fill_1_277 r0 *1 0,0
Xsg13cmos5l_fill_1_277 VPWR VGND sg13cmos5l_fill_1
* cell instance sg13cmos5l_fill_1_278 r0 *1 0,0
Xsg13cmos5l_fill_1_278 VPWR VGND sg13cmos5l_fill_1
* cell instance sg13cmos5l_fill_1_279 r0 *1 0,0
Xsg13cmos5l_fill_1_279 VPWR VGND sg13cmos5l_fill_1
* cell instance sg13cmos5l_fill_1_280 r0 *1 0,0
Xsg13cmos5l_fill_1_280 VPWR VGND sg13cmos5l_fill_1
* cell instance sg13cmos5l_fill_1_281 r0 *1 0,0
Xsg13cmos5l_fill_1_281 VPWR VGND sg13cmos5l_fill_1
* cell instance sg13cmos5l_fill_1_282 r0 *1 0,0
Xsg13cmos5l_fill_1_282 VPWR VGND sg13cmos5l_fill_1
* cell instance sg13cmos5l_fill_1_283 r0 *1 0,0
Xsg13cmos5l_fill_1_283 VPWR VGND sg13cmos5l_fill_1
* cell instance sg13cmos5l_fill_1_284 r0 *1 0,0
Xsg13cmos5l_fill_1_284 VPWR VGND sg13cmos5l_fill_1
* cell instance sg13cmos5l_fill_1_285 r0 *1 0,0
Xsg13cmos5l_fill_1_285 VPWR VGND sg13cmos5l_fill_1
* cell instance sg13cmos5l_fill_1_286 r0 *1 0,0
Xsg13cmos5l_fill_1_286 VPWR VGND sg13cmos5l_fill_1
* cell instance sg13cmos5l_fill_1_287 r0 *1 0,0
Xsg13cmos5l_fill_1_287 VPWR VGND sg13cmos5l_fill_1
* cell instance sg13cmos5l_fill_1_288 r0 *1 0,0
Xsg13cmos5l_fill_1_288 VPWR VGND sg13cmos5l_fill_1
* cell instance sg13cmos5l_fill_1_289 r0 *1 0,0
Xsg13cmos5l_fill_1_289 VPWR VGND sg13cmos5l_fill_1
* cell instance sg13cmos5l_fill_1_290 r0 *1 0,0
Xsg13cmos5l_fill_1_290 VPWR VGND sg13cmos5l_fill_1
* cell instance sg13cmos5l_fill_1_291 r0 *1 0,0
Xsg13cmos5l_fill_1_291 VPWR VGND sg13cmos5l_fill_1
* cell instance sg13cmos5l_fill_1_292 r0 *1 0,0
Xsg13cmos5l_fill_1_292 VPWR VGND sg13cmos5l_fill_1
* cell instance sg13cmos5l_fill_1_293 r0 *1 0,0
Xsg13cmos5l_fill_1_293 VPWR VGND sg13cmos5l_fill_1
* cell instance sg13cmos5l_fill_1_294 r0 *1 0,0
Xsg13cmos5l_fill_1_294 VPWR VGND sg13cmos5l_fill_1
* cell instance sg13cmos5l_fill_1_295 r0 *1 0,0
Xsg13cmos5l_fill_1_295 VPWR VGND sg13cmos5l_fill_1
* cell instance sg13cmos5l_fill_1_296 r0 *1 0,0
Xsg13cmos5l_fill_1_296 VPWR VGND sg13cmos5l_fill_1
* cell instance sg13cmos5l_fill_1_297 r0 *1 0,0
Xsg13cmos5l_fill_1_297 VPWR VGND sg13cmos5l_fill_1
* cell instance sg13cmos5l_fill_1_298 r0 *1 0,0
Xsg13cmos5l_fill_1_298 VPWR VGND sg13cmos5l_fill_1
* cell instance sg13cmos5l_fill_1_299 r0 *1 0,0
Xsg13cmos5l_fill_1_299 VPWR VGND sg13cmos5l_fill_1
* cell instance sg13cmos5l_fill_1_300 r0 *1 0,0
Xsg13cmos5l_fill_1_300 VPWR VGND sg13cmos5l_fill_1
* cell instance sg13cmos5l_fill_1_301 r0 *1 0,0
Xsg13cmos5l_fill_1_301 VPWR VGND sg13cmos5l_fill_1
* cell instance sg13cmos5l_fill_1_302 r0 *1 0,0
Xsg13cmos5l_fill_1_302 VPWR VGND sg13cmos5l_fill_1
* cell instance sg13cmos5l_fill_1_303 r0 *1 0,0
Xsg13cmos5l_fill_1_303 VPWR VGND sg13cmos5l_fill_1
* cell instance sg13cmos5l_fill_1_304 r0 *1 0,0
Xsg13cmos5l_fill_1_304 VPWR VGND sg13cmos5l_fill_1
* cell instance sg13cmos5l_fill_1_305 r0 *1 0,0
Xsg13cmos5l_fill_1_305 VPWR VGND sg13cmos5l_fill_1
* cell instance sg13cmos5l_fill_1_306 r0 *1 0,0
Xsg13cmos5l_fill_1_306 VPWR VGND sg13cmos5l_fill_1
* cell instance sg13cmos5l_fill_1_307 r0 *1 0,0
Xsg13cmos5l_fill_1_307 VPWR VGND sg13cmos5l_fill_1
* cell instance sg13cmos5l_fill_1_308 r0 *1 0,0
Xsg13cmos5l_fill_1_308 VPWR VGND sg13cmos5l_fill_1
* cell instance sg13cmos5l_fill_1_309 r0 *1 0,0
Xsg13cmos5l_fill_1_309 VPWR VGND sg13cmos5l_fill_1
* cell instance sg13cmos5l_fill_1_310 r0 *1 0,0
Xsg13cmos5l_fill_1_310 VPWR VGND sg13cmos5l_fill_1
* cell instance sg13cmos5l_fill_1_311 r0 *1 0,0
Xsg13cmos5l_fill_1_311 VPWR VGND sg13cmos5l_fill_1
* cell instance sg13cmos5l_fill_1_312 r0 *1 0,0
Xsg13cmos5l_fill_1_312 VPWR VGND sg13cmos5l_fill_1
* cell instance sg13cmos5l_fill_1_313 r0 *1 0,0
Xsg13cmos5l_fill_1_313 VPWR VGND sg13cmos5l_fill_1
* cell instance sg13cmos5l_fill_1_314 r0 *1 0,0
Xsg13cmos5l_fill_1_314 VPWR VGND sg13cmos5l_fill_1
* cell instance sg13cmos5l_fill_1_315 r0 *1 0,0
Xsg13cmos5l_fill_1_315 VPWR VGND sg13cmos5l_fill_1
* cell instance sg13cmos5l_fill_1_316 r0 *1 0,0
Xsg13cmos5l_fill_1_316 VPWR VGND sg13cmos5l_fill_1
* cell instance sg13cmos5l_fill_1_317 r0 *1 0,0
Xsg13cmos5l_fill_1_317 VPWR VGND sg13cmos5l_fill_1
* cell instance sg13cmos5l_fill_1_318 r0 *1 0,0
Xsg13cmos5l_fill_1_318 VPWR VGND sg13cmos5l_fill_1
* cell instance sg13cmos5l_fill_1_319 r0 *1 0,0
Xsg13cmos5l_fill_1_319 VPWR VGND sg13cmos5l_fill_1
* cell instance sg13cmos5l_fill_1_320 r0 *1 0,0
Xsg13cmos5l_fill_1_320 VPWR VGND sg13cmos5l_fill_1
* cell instance sg13cmos5l_fill_1_321 r0 *1 0,0
Xsg13cmos5l_fill_1_321 VPWR VGND sg13cmos5l_fill_1
* cell instance sg13cmos5l_fill_1_322 r0 *1 0,0
Xsg13cmos5l_fill_1_322 VPWR VGND sg13cmos5l_fill_1
* cell instance sg13cmos5l_fill_1_323 r0 *1 0,0
Xsg13cmos5l_fill_1_323 VPWR VGND sg13cmos5l_fill_1
* cell instance sg13cmos5l_fill_1_324 r0 *1 0,0
Xsg13cmos5l_fill_1_324 VPWR VGND sg13cmos5l_fill_1
* cell instance sg13cmos5l_fill_1_325 r0 *1 0,0
Xsg13cmos5l_fill_1_325 VPWR VGND sg13cmos5l_fill_1
* cell instance sg13cmos5l_fill_1_326 r0 *1 0,0
Xsg13cmos5l_fill_1_326 VPWR VGND sg13cmos5l_fill_1
* cell instance sg13cmos5l_fill_1_327 r0 *1 0,0
Xsg13cmos5l_fill_1_327 VPWR VGND sg13cmos5l_fill_1
* cell instance sg13cmos5l_fill_1_328 r0 *1 0,0
Xsg13cmos5l_fill_1_328 VPWR VGND sg13cmos5l_fill_1
* cell instance sg13cmos5l_fill_1_329 r0 *1 0,0
Xsg13cmos5l_fill_1_329 VPWR VGND sg13cmos5l_fill_1
* cell instance sg13cmos5l_fill_1_330 r0 *1 0,0
Xsg13cmos5l_fill_1_330 VPWR VGND sg13cmos5l_fill_1
* cell instance sg13cmos5l_fill_1_331 r0 *1 0,0
Xsg13cmos5l_fill_1_331 VPWR VGND sg13cmos5l_fill_1
* cell instance sg13cmos5l_fill_1_332 r0 *1 0,0
Xsg13cmos5l_fill_1_332 VPWR VGND sg13cmos5l_fill_1
* cell instance sg13cmos5l_fill_1_333 r0 *1 0,0
Xsg13cmos5l_fill_1_333 VPWR VGND sg13cmos5l_fill_1
* cell instance sg13cmos5l_fill_1_334 r0 *1 0,0
Xsg13cmos5l_fill_1_334 VPWR VGND sg13cmos5l_fill_1
* cell instance sg13cmos5l_fill_1_335 r0 *1 0,0
Xsg13cmos5l_fill_1_335 VPWR VGND sg13cmos5l_fill_1
* cell instance sg13cmos5l_fill_1_336 r0 *1 0,0
Xsg13cmos5l_fill_1_336 VPWR VGND sg13cmos5l_fill_1
* cell instance sg13cmos5l_fill_1_337 r0 *1 0,0
Xsg13cmos5l_fill_1_337 VPWR VGND sg13cmos5l_fill_1
* cell instance sg13cmos5l_fill_1_338 r0 *1 0,0
Xsg13cmos5l_fill_1_338 VPWR VGND sg13cmos5l_fill_1
* cell instance sg13cmos5l_fill_1_339 r0 *1 0,0
Xsg13cmos5l_fill_1_339 VPWR VGND sg13cmos5l_fill_1
* cell instance sg13cmos5l_fill_1_340 r0 *1 0,0
Xsg13cmos5l_fill_1_340 VPWR VGND sg13cmos5l_fill_1
* cell instance sg13cmos5l_fill_1_341 r0 *1 0,0
Xsg13cmos5l_fill_1_341 VPWR VGND sg13cmos5l_fill_1
* cell instance sg13cmos5l_fill_1_342 r0 *1 0,0
Xsg13cmos5l_fill_1_342 VPWR VGND sg13cmos5l_fill_1
* cell instance sg13cmos5l_fill_1_343 r0 *1 0,0
Xsg13cmos5l_fill_1_343 VPWR VGND sg13cmos5l_fill_1
* cell instance sg13cmos5l_fill_1_344 r0 *1 0,0
Xsg13cmos5l_fill_1_344 VPWR VGND sg13cmos5l_fill_1
* cell instance sg13cmos5l_fill_1_345 r0 *1 0,0
Xsg13cmos5l_fill_1_345 VPWR VGND sg13cmos5l_fill_1
* cell instance sg13cmos5l_fill_1_346 r0 *1 0,0
Xsg13cmos5l_fill_1_346 VPWR VGND sg13cmos5l_fill_1
* cell instance sg13cmos5l_fill_1_347 r0 *1 0,0
Xsg13cmos5l_fill_1_347 VPWR VGND sg13cmos5l_fill_1
* cell instance sg13cmos5l_fill_1_348 r0 *1 0,0
Xsg13cmos5l_fill_1_348 VPWR VGND sg13cmos5l_fill_1
* cell instance sg13cmos5l_fill_1_349 r0 *1 0,0
Xsg13cmos5l_fill_1_349 VPWR VGND sg13cmos5l_fill_1
* cell instance sg13cmos5l_fill_1_350 r0 *1 0,0
Xsg13cmos5l_fill_1_350 VPWR VGND sg13cmos5l_fill_1
* cell instance sg13cmos5l_fill_1_351 r0 *1 0,0
Xsg13cmos5l_fill_1_351 VPWR VGND sg13cmos5l_fill_1
* cell instance sg13cmos5l_fill_1_352 r0 *1 0,0
Xsg13cmos5l_fill_1_352 VPWR VGND sg13cmos5l_fill_1
* cell instance sg13cmos5l_fill_1_353 r0 *1 0,0
Xsg13cmos5l_fill_1_353 VPWR VGND sg13cmos5l_fill_1
* cell instance sg13cmos5l_fill_1_354 r0 *1 0,0
Xsg13cmos5l_fill_1_354 VPWR VGND sg13cmos5l_fill_1
* cell instance sg13cmos5l_fill_1_355 r0 *1 0,0
Xsg13cmos5l_fill_1_355 VPWR VGND sg13cmos5l_fill_1
* cell instance sg13cmos5l_fill_1_356 r0 *1 0,0
Xsg13cmos5l_fill_1_356 VPWR VGND sg13cmos5l_fill_1
* cell instance sg13cmos5l_fill_1_357 r0 *1 0,0
Xsg13cmos5l_fill_1_357 VPWR VGND sg13cmos5l_fill_1
* cell instance sg13cmos5l_fill_1_358 r0 *1 0,0
Xsg13cmos5l_fill_1_358 VPWR VGND sg13cmos5l_fill_1
* cell instance sg13cmos5l_fill_1_359 r0 *1 0,0
Xsg13cmos5l_fill_1_359 VPWR VGND sg13cmos5l_fill_1
* cell instance sg13cmos5l_fill_1_360 r0 *1 0,0
Xsg13cmos5l_fill_1_360 VPWR VGND sg13cmos5l_fill_1
* cell instance sg13cmos5l_fill_1_361 r0 *1 0,0
Xsg13cmos5l_fill_1_361 VPWR VGND sg13cmos5l_fill_1
* cell instance sg13cmos5l_fill_1_362 r0 *1 0,0
Xsg13cmos5l_fill_1_362 VPWR VGND sg13cmos5l_fill_1
* cell instance sg13cmos5l_fill_1_363 r0 *1 0,0
Xsg13cmos5l_fill_1_363 VPWR VGND sg13cmos5l_fill_1
* cell instance sg13cmos5l_fill_1_364 r0 *1 0,0
Xsg13cmos5l_fill_1_364 VPWR VGND sg13cmos5l_fill_1
* cell instance sg13cmos5l_fill_1_365 r0 *1 0,0
Xsg13cmos5l_fill_1_365 VPWR VGND sg13cmos5l_fill_1
* cell instance sg13cmos5l_fill_1_366 r0 *1 0,0
Xsg13cmos5l_fill_1_366 VPWR VGND sg13cmos5l_fill_1
* cell instance sg13cmos5l_fill_1_367 r0 *1 0,0
Xsg13cmos5l_fill_1_367 VPWR VGND sg13cmos5l_fill_1
* cell instance sg13cmos5l_fill_1_368 r0 *1 0,0
Xsg13cmos5l_fill_1_368 VPWR VGND sg13cmos5l_fill_1
* cell instance sg13cmos5l_fill_1_369 r0 *1 0,0
Xsg13cmos5l_fill_1_369 VPWR VGND sg13cmos5l_fill_1
* cell instance sg13cmos5l_fill_1_370 r0 *1 0,0
Xsg13cmos5l_fill_1_370 VPWR VGND sg13cmos5l_fill_1
* cell instance sg13cmos5l_fill_1_371 r0 *1 0,0
Xsg13cmos5l_fill_1_371 VPWR VGND sg13cmos5l_fill_1
* cell instance sg13cmos5l_fill_1_372 r0 *1 0,0
Xsg13cmos5l_fill_1_372 VPWR VGND sg13cmos5l_fill_1
* cell instance sg13cmos5l_fill_1_373 r0 *1 0,0
Xsg13cmos5l_fill_1_373 VPWR VGND sg13cmos5l_fill_1
* cell instance sg13cmos5l_fill_1_374 r0 *1 0,0
Xsg13cmos5l_fill_1_374 VPWR VGND sg13cmos5l_fill_1
* cell instance sg13cmos5l_fill_1_375 r0 *1 0,0
Xsg13cmos5l_fill_1_375 VPWR VGND sg13cmos5l_fill_1
* cell instance sg13cmos5l_fill_1_376 r0 *1 0,0
Xsg13cmos5l_fill_1_376 VPWR VGND sg13cmos5l_fill_1
* cell instance sg13cmos5l_fill_1_377 r0 *1 0,0
Xsg13cmos5l_fill_1_377 VPWR VGND sg13cmos5l_fill_1
* cell instance sg13cmos5l_fill_1_378 r0 *1 0,0
Xsg13cmos5l_fill_1_378 VPWR VGND sg13cmos5l_fill_1
* cell instance sg13cmos5l_fill_1_379 r0 *1 0,0
Xsg13cmos5l_fill_1_379 VPWR VGND sg13cmos5l_fill_1
* cell instance sg13cmos5l_fill_1_380 r0 *1 0,0
Xsg13cmos5l_fill_1_380 VPWR VGND sg13cmos5l_fill_1
* cell instance sg13cmos5l_fill_1_381 r0 *1 0,0
Xsg13cmos5l_fill_1_381 VPWR VGND sg13cmos5l_fill_1
* cell instance sg13cmos5l_fill_1_382 r0 *1 0,0
Xsg13cmos5l_fill_1_382 VPWR VGND sg13cmos5l_fill_1
* cell instance sg13cmos5l_fill_1_383 r0 *1 0,0
Xsg13cmos5l_fill_1_383 VPWR VGND sg13cmos5l_fill_1
* cell instance sg13cmos5l_fill_1_384 r0 *1 0,0
Xsg13cmos5l_fill_1_384 VPWR VGND sg13cmos5l_fill_1
* cell instance sg13cmos5l_fill_1_385 r0 *1 0,0
Xsg13cmos5l_fill_1_385 VPWR VGND sg13cmos5l_fill_1
* cell instance sg13cmos5l_fill_1_386 r0 *1 0,0
Xsg13cmos5l_fill_1_386 VPWR VGND sg13cmos5l_fill_1
* cell instance sg13cmos5l_fill_1_387 r0 *1 0,0
Xsg13cmos5l_fill_1_387 VPWR VGND sg13cmos5l_fill_1
* cell instance sg13cmos5l_fill_1_388 r0 *1 0,0
Xsg13cmos5l_fill_1_388 VPWR VGND sg13cmos5l_fill_1
* cell instance sg13cmos5l_fill_1_389 r0 *1 0,0
Xsg13cmos5l_fill_1_389 VPWR VGND sg13cmos5l_fill_1
* cell instance sg13cmos5l_fill_1_390 r0 *1 0,0
Xsg13cmos5l_fill_1_390 VPWR VGND sg13cmos5l_fill_1
* cell instance sg13cmos5l_fill_1_391 r0 *1 0,0
Xsg13cmos5l_fill_1_391 VPWR VGND sg13cmos5l_fill_1
* cell instance sg13cmos5l_fill_1_392 r0 *1 0,0
Xsg13cmos5l_fill_1_392 VPWR VGND sg13cmos5l_fill_1
* cell instance sg13cmos5l_fill_1_393 r0 *1 0,0
Xsg13cmos5l_fill_1_393 VPWR VGND sg13cmos5l_fill_1
* cell instance sg13cmos5l_fill_1_394 r0 *1 0,0
Xsg13cmos5l_fill_1_394 VPWR VGND sg13cmos5l_fill_1
* cell instance sg13cmos5l_fill_1_395 r0 *1 0,0
Xsg13cmos5l_fill_1_395 VPWR VGND sg13cmos5l_fill_1
* cell instance sg13cmos5l_fill_1_396 r0 *1 0,0
Xsg13cmos5l_fill_1_396 VPWR VGND sg13cmos5l_fill_1
* cell instance sg13cmos5l_fill_1_397 r0 *1 0,0
Xsg13cmos5l_fill_1_397 VPWR VGND sg13cmos5l_fill_1
* cell instance sg13cmos5l_fill_1_398 r0 *1 0,0
Xsg13cmos5l_fill_1_398 VPWR VGND sg13cmos5l_fill_1
* cell instance sg13cmos5l_fill_1_399 r0 *1 0,0
Xsg13cmos5l_fill_1_399 VPWR VGND sg13cmos5l_fill_1
* cell instance sg13cmos5l_fill_1_400 r0 *1 0,0
Xsg13cmos5l_fill_1_400 VPWR VGND sg13cmos5l_fill_1
* cell instance sg13cmos5l_fill_1_401 r0 *1 0,0
Xsg13cmos5l_fill_1_401 VPWR VGND sg13cmos5l_fill_1
* cell instance sg13cmos5l_fill_1_402 r0 *1 0,0
Xsg13cmos5l_fill_1_402 VPWR VGND sg13cmos5l_fill_1
* cell instance sg13cmos5l_fill_1_403 r0 *1 0,0
Xsg13cmos5l_fill_1_403 VPWR VGND sg13cmos5l_fill_1
* cell instance sg13cmos5l_fill_1_404 r0 *1 0,0
Xsg13cmos5l_fill_1_404 VPWR VGND sg13cmos5l_fill_1
* cell instance sg13cmos5l_fill_1_405 r0 *1 0,0
Xsg13cmos5l_fill_1_405 VPWR VGND sg13cmos5l_fill_1
* cell instance sg13cmos5l_fill_1_406 r0 *1 0,0
Xsg13cmos5l_fill_1_406 VPWR VGND sg13cmos5l_fill_1
* cell instance sg13cmos5l_fill_1_407 r0 *1 0,0
Xsg13cmos5l_fill_1_407 VPWR VGND sg13cmos5l_fill_1
* cell instance sg13cmos5l_fill_1_408 r0 *1 0,0
Xsg13cmos5l_fill_1_408 VPWR VGND sg13cmos5l_fill_1
* cell instance sg13cmos5l_fill_1_409 r0 *1 0,0
Xsg13cmos5l_fill_1_409 VPWR VGND sg13cmos5l_fill_1
* cell instance sg13cmos5l_fill_1_410 r0 *1 0,0
Xsg13cmos5l_fill_1_410 VPWR VGND sg13cmos5l_fill_1
* cell instance sg13cmos5l_fill_1_411 r0 *1 0,0
Xsg13cmos5l_fill_1_411 VPWR VGND sg13cmos5l_fill_1
* cell instance sg13cmos5l_fill_1_412 r0 *1 0,0
Xsg13cmos5l_fill_1_412 VPWR VGND sg13cmos5l_fill_1
* cell instance sg13cmos5l_fill_1_413 r0 *1 0,0
Xsg13cmos5l_fill_1_413 VPWR VGND sg13cmos5l_fill_1
* cell instance sg13cmos5l_fill_1_414 r0 *1 0,0
Xsg13cmos5l_fill_1_414 VPWR VGND sg13cmos5l_fill_1
* cell instance sg13cmos5l_fill_1_415 r0 *1 0,0
Xsg13cmos5l_fill_1_415 VPWR VGND sg13cmos5l_fill_1
* cell instance sg13cmos5l_fill_1_416 r0 *1 0,0
Xsg13cmos5l_fill_1_416 VPWR VGND sg13cmos5l_fill_1
* cell instance sg13cmos5l_fill_1_417 r0 *1 0,0
Xsg13cmos5l_fill_1_417 VPWR VGND sg13cmos5l_fill_1
* cell instance sg13cmos5l_fill_1_418 r0 *1 0,0
Xsg13cmos5l_fill_1_418 VPWR VGND sg13cmos5l_fill_1
* cell instance sg13cmos5l_fill_1_419 r0 *1 0,0
Xsg13cmos5l_fill_1_419 VPWR VGND sg13cmos5l_fill_1
* cell instance sg13cmos5l_fill_1_420 r0 *1 0,0
Xsg13cmos5l_fill_1_420 VPWR VGND sg13cmos5l_fill_1
* cell instance sg13cmos5l_fill_1_421 r0 *1 0,0
Xsg13cmos5l_fill_1_421 VPWR VGND sg13cmos5l_fill_1
* cell instance sg13cmos5l_fill_1_422 r0 *1 0,0
Xsg13cmos5l_fill_1_422 VPWR VGND sg13cmos5l_fill_1
* cell instance sg13cmos5l_fill_1_423 r0 *1 0,0
Xsg13cmos5l_fill_1_423 VPWR VGND sg13cmos5l_fill_1
* cell instance sg13cmos5l_fill_1_424 r0 *1 0,0
Xsg13cmos5l_fill_1_424 VPWR VGND sg13cmos5l_fill_1
* cell instance sg13cmos5l_fill_1_425 r0 *1 0,0
Xsg13cmos5l_fill_1_425 VPWR VGND sg13cmos5l_fill_1
* cell instance sg13cmos5l_fill_1_426 r0 *1 0,0
Xsg13cmos5l_fill_1_426 VPWR VGND sg13cmos5l_fill_1
* cell instance sg13cmos5l_fill_1_427 r0 *1 0,0
Xsg13cmos5l_fill_1_427 VPWR VGND sg13cmos5l_fill_1
* cell instance sg13cmos5l_fill_1_428 r0 *1 0,0
Xsg13cmos5l_fill_1_428 VPWR VGND sg13cmos5l_fill_1
* cell instance sg13cmos5l_fill_1_429 r0 *1 0,0
Xsg13cmos5l_fill_1_429 VPWR VGND sg13cmos5l_fill_1
* cell instance sg13cmos5l_fill_1_430 r0 *1 0,0
Xsg13cmos5l_fill_1_430 VPWR VGND sg13cmos5l_fill_1
* cell instance sg13cmos5l_fill_1_431 r0 *1 0,0
Xsg13cmos5l_fill_1_431 VPWR VGND sg13cmos5l_fill_1
* cell instance sg13cmos5l_fill_1_432 r0 *1 0,0
Xsg13cmos5l_fill_1_432 VPWR VGND sg13cmos5l_fill_1
* cell instance sg13cmos5l_fill_1_433 r0 *1 0,0
Xsg13cmos5l_fill_1_433 VPWR VGND sg13cmos5l_fill_1
* cell instance sg13cmos5l_fill_1_434 r0 *1 0,0
Xsg13cmos5l_fill_1_434 VPWR VGND sg13cmos5l_fill_1
* cell instance sg13cmos5l_fill_1_435 r0 *1 0,0
Xsg13cmos5l_fill_1_435 VPWR VGND sg13cmos5l_fill_1
* cell instance sg13cmos5l_fill_1_436 r0 *1 0,0
Xsg13cmos5l_fill_1_436 VPWR VGND sg13cmos5l_fill_1
* cell instance sg13cmos5l_fill_1_437 r0 *1 0,0
Xsg13cmos5l_fill_1_437 VPWR VGND sg13cmos5l_fill_1
* cell instance sg13cmos5l_fill_1_438 r0 *1 0,0
Xsg13cmos5l_fill_1_438 VPWR VGND sg13cmos5l_fill_1
* cell instance sg13cmos5l_fill_1_439 r0 *1 0,0
Xsg13cmos5l_fill_1_439 VPWR VGND sg13cmos5l_fill_1
* cell instance sg13cmos5l_fill_1_440 r0 *1 0,0
Xsg13cmos5l_fill_1_440 VPWR VGND sg13cmos5l_fill_1
* cell instance sg13cmos5l_fill_1_441 r0 *1 0,0
Xsg13cmos5l_fill_1_441 VPWR VGND sg13cmos5l_fill_1
* cell instance sg13cmos5l_fill_1_442 r0 *1 0,0
Xsg13cmos5l_fill_1_442 VPWR VGND sg13cmos5l_fill_1
* cell instance sg13cmos5l_fill_1_443 r0 *1 0,0
Xsg13cmos5l_fill_1_443 VPWR VGND sg13cmos5l_fill_1
* cell instance sg13cmos5l_fill_1_444 r0 *1 0,0
Xsg13cmos5l_fill_1_444 VPWR VGND sg13cmos5l_fill_1
* cell instance sg13cmos5l_fill_1_445 r0 *1 0,0
Xsg13cmos5l_fill_1_445 VPWR VGND sg13cmos5l_fill_1
* cell instance sg13cmos5l_fill_1_446 r0 *1 0,0
Xsg13cmos5l_fill_1_446 VPWR VGND sg13cmos5l_fill_1
* cell instance sg13cmos5l_fill_1_447 r0 *1 0,0
Xsg13cmos5l_fill_1_447 VPWR VGND sg13cmos5l_fill_1
* cell instance sg13cmos5l_fill_1_448 r0 *1 0,0
Xsg13cmos5l_fill_1_448 VPWR VGND sg13cmos5l_fill_1
* cell instance sg13cmos5l_fill_1_449 r0 *1 0,0
Xsg13cmos5l_fill_1_449 VPWR VGND sg13cmos5l_fill_1
* cell instance sg13cmos5l_fill_1_450 r0 *1 0,0
Xsg13cmos5l_fill_1_450 VPWR VGND sg13cmos5l_fill_1
* cell instance sg13cmos5l_fill_1_451 r0 *1 0,0
Xsg13cmos5l_fill_1_451 VPWR VGND sg13cmos5l_fill_1
* cell instance sg13cmos5l_fill_1_452 r0 *1 0,0
Xsg13cmos5l_fill_1_452 VPWR VGND sg13cmos5l_fill_1
* cell instance sg13cmos5l_fill_1_453 r0 *1 0,0
Xsg13cmos5l_fill_1_453 VPWR VGND sg13cmos5l_fill_1
* cell instance sg13cmos5l_fill_1_454 r0 *1 0,0
Xsg13cmos5l_fill_1_454 VPWR VGND sg13cmos5l_fill_1
* cell instance sg13cmos5l_fill_1_455 r0 *1 0,0
Xsg13cmos5l_fill_1_455 VPWR VGND sg13cmos5l_fill_1
* cell instance sg13cmos5l_fill_1_456 r0 *1 0,0
Xsg13cmos5l_fill_1_456 VPWR VGND sg13cmos5l_fill_1
* cell instance sg13cmos5l_fill_1_457 r0 *1 0,0
Xsg13cmos5l_fill_1_457 VPWR VGND sg13cmos5l_fill_1
* cell instance sg13cmos5l_fill_1_458 r0 *1 0,0
Xsg13cmos5l_fill_1_458 VPWR VGND sg13cmos5l_fill_1
* cell instance sg13cmos5l_fill_1_459 r0 *1 0,0
Xsg13cmos5l_fill_1_459 VPWR VGND sg13cmos5l_fill_1
* cell instance sg13cmos5l_fill_1_460 r0 *1 0,0
Xsg13cmos5l_fill_1_460 VPWR VGND sg13cmos5l_fill_1
* cell instance sg13cmos5l_fill_1_461 r0 *1 0,0
Xsg13cmos5l_fill_1_461 VPWR VGND sg13cmos5l_fill_1
* cell instance sg13cmos5l_fill_1_462 r0 *1 0,0
Xsg13cmos5l_fill_1_462 VPWR VGND sg13cmos5l_fill_1
* cell instance sg13cmos5l_fill_1_463 r0 *1 0,0
Xsg13cmos5l_fill_1_463 VPWR VGND sg13cmos5l_fill_1
* cell instance sg13cmos5l_fill_1_464 r0 *1 0,0
Xsg13cmos5l_fill_1_464 VPWR VGND sg13cmos5l_fill_1
* cell instance sg13cmos5l_fill_1_465 r0 *1 0,0
Xsg13cmos5l_fill_1_465 VPWR VGND sg13cmos5l_fill_1
* cell instance sg13cmos5l_fill_1_466 r0 *1 0,0
Xsg13cmos5l_fill_1_466 VPWR VGND sg13cmos5l_fill_1
* cell instance sg13cmos5l_fill_1_467 r0 *1 0,0
Xsg13cmos5l_fill_1_467 VPWR VGND sg13cmos5l_fill_1
* cell instance sg13cmos5l_fill_1_468 r0 *1 0,0
Xsg13cmos5l_fill_1_468 VPWR VGND sg13cmos5l_fill_1
* cell instance sg13cmos5l_fill_1_469 r0 *1 0,0
Xsg13cmos5l_fill_1_469 VPWR VGND sg13cmos5l_fill_1
* cell instance sg13cmos5l_fill_1_470 r0 *1 0,0
Xsg13cmos5l_fill_1_470 VPWR VGND sg13cmos5l_fill_1
* cell instance sg13cmos5l_fill_1_471 r0 *1 0,0
Xsg13cmos5l_fill_1_471 VPWR VGND sg13cmos5l_fill_1
* cell instance sg13cmos5l_fill_1_472 r0 *1 0,0
Xsg13cmos5l_fill_1_472 VPWR VGND sg13cmos5l_fill_1
* cell instance sg13cmos5l_fill_1_473 r0 *1 0,0
Xsg13cmos5l_fill_1_473 VPWR VGND sg13cmos5l_fill_1
* cell instance sg13cmos5l_fill_1_474 r0 *1 0,0
Xsg13cmos5l_fill_1_474 VPWR VGND sg13cmos5l_fill_1
* cell instance sg13cmos5l_fill_1_475 r0 *1 0,0
Xsg13cmos5l_fill_1_475 VPWR VGND sg13cmos5l_fill_1
* cell instance sg13cmos5l_fill_1_476 r0 *1 0,0
Xsg13cmos5l_fill_1_476 VPWR VGND sg13cmos5l_fill_1
* cell instance sg13cmos5l_fill_1_477 r0 *1 0,0
Xsg13cmos5l_fill_1_477 VPWR VGND sg13cmos5l_fill_1
* cell instance sg13cmos5l_fill_1_478 r0 *1 0,0
Xsg13cmos5l_fill_1_478 VPWR VGND sg13cmos5l_fill_1
* cell instance sg13cmos5l_fill_1_479 r0 *1 0,0
Xsg13cmos5l_fill_1_479 VPWR VGND sg13cmos5l_fill_1
* cell instance sg13cmos5l_fill_1_480 r0 *1 0,0
Xsg13cmos5l_fill_1_480 VPWR VGND sg13cmos5l_fill_1
* cell instance sg13cmos5l_fill_1_481 r0 *1 0,0
Xsg13cmos5l_fill_1_481 VPWR VGND sg13cmos5l_fill_1
* cell instance sg13cmos5l_fill_1_482 r0 *1 0,0
Xsg13cmos5l_fill_1_482 VPWR VGND sg13cmos5l_fill_1
* cell instance sg13cmos5l_fill_1_483 r0 *1 0,0
Xsg13cmos5l_fill_1_483 VPWR VGND sg13cmos5l_fill_1
* cell instance sg13cmos5l_fill_1_484 r0 *1 0,0
Xsg13cmos5l_fill_1_484 VPWR VGND sg13cmos5l_fill_1
* cell instance sg13cmos5l_fill_1_485 r0 *1 0,0
Xsg13cmos5l_fill_1_485 VPWR VGND sg13cmos5l_fill_1
* cell instance sg13cmos5l_fill_1_486 r0 *1 0,0
Xsg13cmos5l_fill_1_486 VPWR VGND sg13cmos5l_fill_1
* cell instance sg13cmos5l_fill_1_487 r0 *1 0,0
Xsg13cmos5l_fill_1_487 VPWR VGND sg13cmos5l_fill_1
* cell instance sg13cmos5l_fill_1_488 r0 *1 0,0
Xsg13cmos5l_fill_1_488 VPWR VGND sg13cmos5l_fill_1
* cell instance sg13cmos5l_fill_1_489 r0 *1 0,0
Xsg13cmos5l_fill_1_489 VPWR VGND sg13cmos5l_fill_1
* cell instance sg13cmos5l_fill_1_490 r0 *1 0,0
Xsg13cmos5l_fill_1_490 VPWR VGND sg13cmos5l_fill_1
* cell instance sg13cmos5l_fill_1_491 r0 *1 0,0
Xsg13cmos5l_fill_1_491 VPWR VGND sg13cmos5l_fill_1
* cell instance sg13cmos5l_fill_1_492 r0 *1 0,0
Xsg13cmos5l_fill_1_492 VPWR VGND sg13cmos5l_fill_1
* cell instance sg13cmos5l_fill_1_493 r0 *1 0,0
Xsg13cmos5l_fill_1_493 VPWR VGND sg13cmos5l_fill_1
* cell instance sg13cmos5l_fill_1_494 r0 *1 0,0
Xsg13cmos5l_fill_1_494 VPWR VGND sg13cmos5l_fill_1
* cell instance sg13cmos5l_fill_1_495 r0 *1 0,0
Xsg13cmos5l_fill_1_495 VPWR VGND sg13cmos5l_fill_1
* cell instance sg13cmos5l_fill_1_496 r0 *1 0,0
Xsg13cmos5l_fill_1_496 VPWR VGND sg13cmos5l_fill_1
* cell instance sg13cmos5l_fill_1_497 r0 *1 0,0
Xsg13cmos5l_fill_1_497 VPWR VGND sg13cmos5l_fill_1
* cell instance sg13cmos5l_fill_1_498 r0 *1 0,0
Xsg13cmos5l_fill_1_498 VPWR VGND sg13cmos5l_fill_1
* cell instance sg13cmos5l_fill_1_499 r0 *1 0,0
Xsg13cmos5l_fill_1_499 VPWR VGND sg13cmos5l_fill_1
* cell instance sg13cmos5l_fill_1_500 r0 *1 0,0
Xsg13cmos5l_fill_1_500 VPWR VGND sg13cmos5l_fill_1
* cell instance sg13cmos5l_fill_1_501 r0 *1 0,0
Xsg13cmos5l_fill_1_501 VPWR VGND sg13cmos5l_fill_1
* cell instance sg13cmos5l_fill_1_502 r0 *1 0,0
Xsg13cmos5l_fill_1_502 VPWR VGND sg13cmos5l_fill_1
* cell instance sg13cmos5l_fill_1_503 r0 *1 0,0
Xsg13cmos5l_fill_1_503 VPWR VGND sg13cmos5l_fill_1
* cell instance sg13cmos5l_fill_1_504 r0 *1 0,0
Xsg13cmos5l_fill_1_504 VPWR VGND sg13cmos5l_fill_1
* cell instance sg13cmos5l_fill_1_505 r0 *1 0,0
Xsg13cmos5l_fill_1_505 VPWR VGND sg13cmos5l_fill_1
* cell instance sg13cmos5l_fill_1_506 r0 *1 0,0
Xsg13cmos5l_fill_1_506 VPWR VGND sg13cmos5l_fill_1
* cell instance sg13cmos5l_fill_1_507 r0 *1 0,0
Xsg13cmos5l_fill_1_507 VPWR VGND sg13cmos5l_fill_1
* cell instance sg13cmos5l_fill_1_508 r0 *1 0,0
Xsg13cmos5l_fill_1_508 VPWR VGND sg13cmos5l_fill_1
* cell instance sg13cmos5l_fill_1_509 r0 *1 0,0
Xsg13cmos5l_fill_1_509 VPWR VGND sg13cmos5l_fill_1
* cell instance sg13cmos5l_fill_1_510 r0 *1 0,0
Xsg13cmos5l_fill_1_510 VPWR VGND sg13cmos5l_fill_1
* cell instance sg13cmos5l_fill_1_511 r0 *1 0,0
Xsg13cmos5l_fill_1_511 VPWR VGND sg13cmos5l_fill_1
* cell instance sg13cmos5l_fill_1_512 r0 *1 0,0
Xsg13cmos5l_fill_1_512 VPWR VGND sg13cmos5l_fill_1
* cell instance sg13cmos5l_fill_1_513 r0 *1 0,0
Xsg13cmos5l_fill_1_513 VPWR VGND sg13cmos5l_fill_1
* cell instance sg13cmos5l_fill_1_514 r0 *1 0,0
Xsg13cmos5l_fill_1_514 VPWR VGND sg13cmos5l_fill_1
* cell instance sg13cmos5l_fill_1_515 r0 *1 0,0
Xsg13cmos5l_fill_1_515 VPWR VGND sg13cmos5l_fill_1
* cell instance sg13cmos5l_fill_1_516 r0 *1 0,0
Xsg13cmos5l_fill_1_516 VPWR VGND sg13cmos5l_fill_1
* cell instance sg13cmos5l_fill_1_517 r0 *1 0,0
Xsg13cmos5l_fill_1_517 VPWR VGND sg13cmos5l_fill_1
* cell instance sg13cmos5l_fill_1_518 r0 *1 0,0
Xsg13cmos5l_fill_1_518 VPWR VGND sg13cmos5l_fill_1
* cell instance sg13cmos5l_fill_1_519 r0 *1 0,0
Xsg13cmos5l_fill_1_519 VPWR VGND sg13cmos5l_fill_1
* cell instance sg13cmos5l_fill_1_520 r0 *1 0,0
Xsg13cmos5l_fill_1_520 VPWR VGND sg13cmos5l_fill_1
* cell instance sg13cmos5l_fill_1_521 r0 *1 0,0
Xsg13cmos5l_fill_1_521 VPWR VGND sg13cmos5l_fill_1
* cell instance sg13cmos5l_fill_1_522 r0 *1 0,0
Xsg13cmos5l_fill_1_522 VPWR VGND sg13cmos5l_fill_1
* cell instance sg13cmos5l_fill_1_523 r0 *1 0,0
Xsg13cmos5l_fill_1_523 VPWR VGND sg13cmos5l_fill_1
* cell instance sg13cmos5l_fill_1_524 r0 *1 0,0
Xsg13cmos5l_fill_1_524 VPWR VGND sg13cmos5l_fill_1
* cell instance sg13cmos5l_fill_1_525 r0 *1 0,0
Xsg13cmos5l_fill_1_525 VPWR VGND sg13cmos5l_fill_1
* cell instance sg13cmos5l_fill_1_526 r0 *1 0,0
Xsg13cmos5l_fill_1_526 VPWR VGND sg13cmos5l_fill_1
* cell instance sg13cmos5l_fill_1_527 r0 *1 0,0
Xsg13cmos5l_fill_1_527 VPWR VGND sg13cmos5l_fill_1
* cell instance sg13cmos5l_fill_1_528 r0 *1 0,0
Xsg13cmos5l_fill_1_528 VPWR VGND sg13cmos5l_fill_1
* cell instance sg13cmos5l_fill_1_529 r0 *1 0,0
Xsg13cmos5l_fill_1_529 VPWR VGND sg13cmos5l_fill_1
* cell instance sg13cmos5l_fill_1_530 r0 *1 0,0
Xsg13cmos5l_fill_1_530 VPWR VGND sg13cmos5l_fill_1
* cell instance sg13cmos5l_fill_1_531 r0 *1 0,0
Xsg13cmos5l_fill_1_531 VPWR VGND sg13cmos5l_fill_1
* cell instance sg13cmos5l_fill_1_532 r0 *1 0,0
Xsg13cmos5l_fill_1_532 VPWR VGND sg13cmos5l_fill_1
* cell instance sg13cmos5l_fill_1_533 r0 *1 0,0
Xsg13cmos5l_fill_1_533 VPWR VGND sg13cmos5l_fill_1
* cell instance sg13cmos5l_fill_1_534 r0 *1 0,0
Xsg13cmos5l_fill_1_534 VPWR VGND sg13cmos5l_fill_1
* cell instance sg13cmos5l_fill_1_535 r0 *1 0,0
Xsg13cmos5l_fill_1_535 VPWR VGND sg13cmos5l_fill_1
* cell instance sg13cmos5l_fill_1_536 r0 *1 0,0
Xsg13cmos5l_fill_1_536 VPWR VGND sg13cmos5l_fill_1
* cell instance sg13cmos5l_fill_1_537 r0 *1 0,0
Xsg13cmos5l_fill_1_537 VPWR VGND sg13cmos5l_fill_1
* cell instance sg13cmos5l_fill_1_538 r0 *1 0,0
Xsg13cmos5l_fill_1_538 VPWR VGND sg13cmos5l_fill_1
* cell instance sg13cmos5l_fill_1_539 r0 *1 0,0
Xsg13cmos5l_fill_1_539 VPWR VGND sg13cmos5l_fill_1
* cell instance sg13cmos5l_fill_1_540 r0 *1 0,0
Xsg13cmos5l_fill_1_540 VPWR VGND sg13cmos5l_fill_1
* cell instance sg13cmos5l_fill_1_541 r0 *1 0,0
Xsg13cmos5l_fill_1_541 VPWR VGND sg13cmos5l_fill_1
* cell instance sg13cmos5l_fill_1_542 r0 *1 0,0
Xsg13cmos5l_fill_1_542 VPWR VGND sg13cmos5l_fill_1
* cell instance sg13cmos5l_fill_1_543 r0 *1 0,0
Xsg13cmos5l_fill_1_543 VPWR VGND sg13cmos5l_fill_1
* cell instance sg13cmos5l_fill_1_544 r0 *1 0,0
Xsg13cmos5l_fill_1_544 VPWR VGND sg13cmos5l_fill_1
* cell instance sg13cmos5l_fill_1_545 r0 *1 0,0
Xsg13cmos5l_fill_1_545 VPWR VGND sg13cmos5l_fill_1
* cell instance sg13cmos5l_fill_1_546 r0 *1 0,0
Xsg13cmos5l_fill_1_546 VPWR VGND sg13cmos5l_fill_1
* cell instance sg13cmos5l_fill_1_547 r0 *1 0,0
Xsg13cmos5l_fill_1_547 VPWR VGND sg13cmos5l_fill_1
* cell instance sg13cmos5l_fill_1_548 r0 *1 0,0
Xsg13cmos5l_fill_1_548 VPWR VGND sg13cmos5l_fill_1
* cell instance sg13cmos5l_fill_1_549 r0 *1 0,0
Xsg13cmos5l_fill_1_549 VPWR VGND sg13cmos5l_fill_1
* cell instance sg13cmos5l_fill_1_550 r0 *1 0,0
Xsg13cmos5l_fill_1_550 VPWR VGND sg13cmos5l_fill_1
* cell instance sg13cmos5l_fill_1_551 r0 *1 0,0
Xsg13cmos5l_fill_1_551 VPWR VGND sg13cmos5l_fill_1
* cell instance sg13cmos5l_fill_1_552 r0 *1 0,0
Xsg13cmos5l_fill_1_552 VPWR VGND sg13cmos5l_fill_1
* cell instance sg13cmos5l_fill_1_553 r0 *1 0,0
Xsg13cmos5l_fill_1_553 VPWR VGND sg13cmos5l_fill_1
* cell instance sg13cmos5l_fill_1_554 r0 *1 0,0
Xsg13cmos5l_fill_1_554 VPWR VGND sg13cmos5l_fill_1
* cell instance sg13cmos5l_fill_1_555 r0 *1 0,0
Xsg13cmos5l_fill_1_555 VPWR VGND sg13cmos5l_fill_1
* cell instance sg13cmos5l_fill_1_556 r0 *1 0,0
Xsg13cmos5l_fill_1_556 VPWR VGND sg13cmos5l_fill_1
* cell instance sg13cmos5l_fill_1_557 r0 *1 0,0
Xsg13cmos5l_fill_1_557 VPWR VGND sg13cmos5l_fill_1
* cell instance sg13cmos5l_fill_1_558 r0 *1 0,0
Xsg13cmos5l_fill_1_558 VPWR VGND sg13cmos5l_fill_1
* cell instance sg13cmos5l_fill_1_559 r0 *1 0,0
Xsg13cmos5l_fill_1_559 VPWR VGND sg13cmos5l_fill_1
* cell instance sg13cmos5l_fill_1_560 r0 *1 0,0
Xsg13cmos5l_fill_1_560 VPWR VGND sg13cmos5l_fill_1
* cell instance sg13cmos5l_fill_1_561 r0 *1 0,0
Xsg13cmos5l_fill_1_561 VPWR VGND sg13cmos5l_fill_1
* cell instance sg13cmos5l_fill_1_562 r0 *1 0,0
Xsg13cmos5l_fill_1_562 VPWR VGND sg13cmos5l_fill_1
* cell instance sg13cmos5l_fill_1_563 r0 *1 0,0
Xsg13cmos5l_fill_1_563 VPWR VGND sg13cmos5l_fill_1
* cell instance sg13cmos5l_fill_1_564 r0 *1 0,0
Xsg13cmos5l_fill_1_564 VPWR VGND sg13cmos5l_fill_1
* cell instance sg13cmos5l_fill_1_565 r0 *1 0,0
Xsg13cmos5l_fill_1_565 VPWR VGND sg13cmos5l_fill_1
* cell instance sg13cmos5l_fill_1_566 r0 *1 0,0
Xsg13cmos5l_fill_1_566 VPWR VGND sg13cmos5l_fill_1
* cell instance sg13cmos5l_fill_1_567 r0 *1 0,0
Xsg13cmos5l_fill_1_567 VPWR VGND sg13cmos5l_fill_1
* cell instance sg13cmos5l_fill_1_568 r0 *1 0,0
Xsg13cmos5l_fill_1_568 VPWR VGND sg13cmos5l_fill_1
* cell instance sg13cmos5l_fill_1_569 r0 *1 0,0
Xsg13cmos5l_fill_1_569 VPWR VGND sg13cmos5l_fill_1
* cell instance sg13cmos5l_fill_1_570 r0 *1 0,0
Xsg13cmos5l_fill_1_570 VPWR VGND sg13cmos5l_fill_1
* cell instance sg13cmos5l_fill_1_571 r0 *1 0,0
Xsg13cmos5l_fill_1_571 VPWR VGND sg13cmos5l_fill_1
* cell instance sg13cmos5l_fill_1_572 r0 *1 0,0
Xsg13cmos5l_fill_1_572 VPWR VGND sg13cmos5l_fill_1
* cell instance sg13cmos5l_fill_1_573 r0 *1 0,0
Xsg13cmos5l_fill_1_573 VPWR VGND sg13cmos5l_fill_1
* cell instance sg13cmos5l_fill_1_574 r0 *1 0,0
Xsg13cmos5l_fill_1_574 VPWR VGND sg13cmos5l_fill_1
* cell instance sg13cmos5l_fill_1_575 r0 *1 0,0
Xsg13cmos5l_fill_1_575 VPWR VGND sg13cmos5l_fill_1
* cell instance sg13cmos5l_fill_1_576 r0 *1 0,0
Xsg13cmos5l_fill_1_576 VPWR VGND sg13cmos5l_fill_1
* cell instance sg13cmos5l_fill_1_577 r0 *1 0,0
Xsg13cmos5l_fill_1_577 VPWR VGND sg13cmos5l_fill_1
* cell instance sg13cmos5l_fill_1_578 r0 *1 0,0
Xsg13cmos5l_fill_1_578 VPWR VGND sg13cmos5l_fill_1
* cell instance sg13cmos5l_fill_1_579 r0 *1 0,0
Xsg13cmos5l_fill_1_579 VPWR VGND sg13cmos5l_fill_1
* cell instance sg13cmos5l_fill_1_580 r0 *1 0,0
Xsg13cmos5l_fill_1_580 VPWR VGND sg13cmos5l_fill_1
* cell instance sg13cmos5l_fill_1_581 r0 *1 0,0
Xsg13cmos5l_fill_1_581 VPWR VGND sg13cmos5l_fill_1
* cell instance sg13cmos5l_fill_1_582 r0 *1 0,0
Xsg13cmos5l_fill_1_582 VPWR VGND sg13cmos5l_fill_1
* cell instance sg13cmos5l_fill_1_583 r0 *1 0,0
Xsg13cmos5l_fill_1_583 VPWR VGND sg13cmos5l_fill_1
* cell instance sg13cmos5l_fill_1_584 r0 *1 0,0
Xsg13cmos5l_fill_1_584 VPWR VGND sg13cmos5l_fill_1
* cell instance sg13cmos5l_fill_1_585 r0 *1 0,0
Xsg13cmos5l_fill_1_585 VPWR VGND sg13cmos5l_fill_1
* cell instance sg13cmos5l_fill_1_586 r0 *1 0,0
Xsg13cmos5l_fill_1_586 VPWR VGND sg13cmos5l_fill_1
* cell instance sg13cmos5l_fill_1_587 r0 *1 0,0
Xsg13cmos5l_fill_1_587 VPWR VGND sg13cmos5l_fill_1
* cell instance sg13cmos5l_fill_1_588 r0 *1 0,0
Xsg13cmos5l_fill_1_588 VPWR VGND sg13cmos5l_fill_1
* cell instance sg13cmos5l_fill_1_589 r0 *1 0,0
Xsg13cmos5l_fill_1_589 VPWR VGND sg13cmos5l_fill_1
* cell instance sg13cmos5l_fill_1_590 r0 *1 0,0
Xsg13cmos5l_fill_1_590 VPWR VGND sg13cmos5l_fill_1
* cell instance sg13cmos5l_fill_1_591 r0 *1 0,0
Xsg13cmos5l_fill_1_591 VPWR VGND sg13cmos5l_fill_1
* cell instance sg13cmos5l_fill_1_592 r0 *1 0,0
Xsg13cmos5l_fill_1_592 VPWR VGND sg13cmos5l_fill_1
* cell instance sg13cmos5l_fill_1_593 r0 *1 0,0
Xsg13cmos5l_fill_1_593 VPWR VGND sg13cmos5l_fill_1
* cell instance sg13cmos5l_fill_1_594 r0 *1 0,0
Xsg13cmos5l_fill_1_594 VPWR VGND sg13cmos5l_fill_1
* cell instance sg13cmos5l_fill_1_595 r0 *1 0,0
Xsg13cmos5l_fill_1_595 VPWR VGND sg13cmos5l_fill_1
* cell instance sg13cmos5l_fill_1_596 r0 *1 0,0
Xsg13cmos5l_fill_1_596 VPWR VGND sg13cmos5l_fill_1
* cell instance sg13cmos5l_fill_1_597 r0 *1 0,0
Xsg13cmos5l_fill_1_597 VPWR VGND sg13cmos5l_fill_1
* cell instance sg13cmos5l_fill_1_598 r0 *1 0,0
Xsg13cmos5l_fill_1_598 VPWR VGND sg13cmos5l_fill_1
* cell instance sg13cmos5l_fill_1_599 r0 *1 0,0
Xsg13cmos5l_fill_1_599 VPWR VGND sg13cmos5l_fill_1
* cell instance sg13cmos5l_fill_1_600 r0 *1 0,0
Xsg13cmos5l_fill_1_600 VPWR VGND sg13cmos5l_fill_1
* cell instance sg13cmos5l_fill_1_601 r0 *1 0,0
Xsg13cmos5l_fill_1_601 VPWR VGND sg13cmos5l_fill_1
* cell instance sg13cmos5l_fill_1_602 r0 *1 0,0
Xsg13cmos5l_fill_1_602 VPWR VGND sg13cmos5l_fill_1
* cell instance sg13cmos5l_fill_1_603 r0 *1 0,0
Xsg13cmos5l_fill_1_603 VPWR VGND sg13cmos5l_fill_1
* cell instance sg13cmos5l_fill_1_604 r0 *1 0,0
Xsg13cmos5l_fill_1_604 VPWR VGND sg13cmos5l_fill_1
* cell instance sg13cmos5l_fill_1_605 r0 *1 0,0
Xsg13cmos5l_fill_1_605 VPWR VGND sg13cmos5l_fill_1
* cell instance sg13cmos5l_fill_1_606 r0 *1 0,0
Xsg13cmos5l_fill_1_606 VPWR VGND sg13cmos5l_fill_1
* cell instance sg13cmos5l_fill_1_607 r0 *1 0,0
Xsg13cmos5l_fill_1_607 VPWR VGND sg13cmos5l_fill_1
* cell instance sg13cmos5l_fill_1_608 r0 *1 0,0
Xsg13cmos5l_fill_1_608 VPWR VGND sg13cmos5l_fill_1
* cell instance sg13cmos5l_fill_1_609 r0 *1 0,0
Xsg13cmos5l_fill_1_609 VPWR VGND sg13cmos5l_fill_1
* cell instance sg13cmos5l_fill_1_610 r0 *1 0,0
Xsg13cmos5l_fill_1_610 VPWR VGND sg13cmos5l_fill_1
* cell instance sg13cmos5l_fill_1_611 r0 *1 0,0
Xsg13cmos5l_fill_1_611 VPWR VGND sg13cmos5l_fill_1
* cell instance sg13cmos5l_fill_1_612 r0 *1 0,0
Xsg13cmos5l_fill_1_612 VPWR VGND sg13cmos5l_fill_1
* cell instance sg13cmos5l_fill_1_613 r0 *1 0,0
Xsg13cmos5l_fill_1_613 VPWR VGND sg13cmos5l_fill_1
* cell instance sg13cmos5l_fill_1_614 r0 *1 0,0
Xsg13cmos5l_fill_1_614 VPWR VGND sg13cmos5l_fill_1
* cell instance sg13cmos5l_fill_1_615 r0 *1 0,0
Xsg13cmos5l_fill_1_615 VPWR VGND sg13cmos5l_fill_1
* cell instance sg13cmos5l_fill_1_616 r0 *1 0,0
Xsg13cmos5l_fill_1_616 VPWR VGND sg13cmos5l_fill_1
* cell instance sg13cmos5l_fill_1_617 r0 *1 0,0
Xsg13cmos5l_fill_1_617 VPWR VGND sg13cmos5l_fill_1
* cell instance sg13cmos5l_fill_1_618 r0 *1 0,0
Xsg13cmos5l_fill_1_618 VPWR VGND sg13cmos5l_fill_1
* cell instance sg13cmos5l_fill_1_619 r0 *1 0,0
Xsg13cmos5l_fill_1_619 VPWR VGND sg13cmos5l_fill_1
* cell instance sg13cmos5l_fill_1_620 r0 *1 0,0
Xsg13cmos5l_fill_1_620 VPWR VGND sg13cmos5l_fill_1
* cell instance sg13cmos5l_fill_1_621 r0 *1 0,0
Xsg13cmos5l_fill_1_621 VPWR VGND sg13cmos5l_fill_1
* cell instance sg13cmos5l_fill_1_622 r0 *1 0,0
Xsg13cmos5l_fill_1_622 VPWR VGND sg13cmos5l_fill_1
* cell instance sg13cmos5l_fill_1_623 r0 *1 0,0
Xsg13cmos5l_fill_1_623 VPWR VGND sg13cmos5l_fill_1
* cell instance sg13cmos5l_fill_1_624 r0 *1 0,0
Xsg13cmos5l_fill_1_624 VPWR VGND sg13cmos5l_fill_1
* cell instance sg13cmos5l_fill_1_625 r0 *1 0,0
Xsg13cmos5l_fill_1_625 VPWR VGND sg13cmos5l_fill_1
* cell instance sg13cmos5l_fill_1_626 r0 *1 0,0
Xsg13cmos5l_fill_1_626 VPWR VGND sg13cmos5l_fill_1
* cell instance sg13cmos5l_fill_1_627 r0 *1 0,0
Xsg13cmos5l_fill_1_627 VPWR VGND sg13cmos5l_fill_1
* cell instance sg13cmos5l_fill_1_628 r0 *1 0,0
Xsg13cmos5l_fill_1_628 VPWR VGND sg13cmos5l_fill_1
* cell instance sg13cmos5l_fill_1_629 r0 *1 0,0
Xsg13cmos5l_fill_1_629 VPWR VGND sg13cmos5l_fill_1
* cell instance sg13cmos5l_fill_1_630 r0 *1 0,0
Xsg13cmos5l_fill_1_630 VPWR VGND sg13cmos5l_fill_1
* cell instance sg13cmos5l_fill_1_631 r0 *1 0,0
Xsg13cmos5l_fill_1_631 VPWR VGND sg13cmos5l_fill_1
* cell instance sg13cmos5l_fill_1_632 r0 *1 0,0
Xsg13cmos5l_fill_1_632 VPWR VGND sg13cmos5l_fill_1
* cell instance sg13cmos5l_fill_1_633 r0 *1 0,0
Xsg13cmos5l_fill_1_633 VPWR VGND sg13cmos5l_fill_1
* cell instance sg13cmos5l_fill_1_634 r0 *1 0,0
Xsg13cmos5l_fill_1_634 VPWR VGND sg13cmos5l_fill_1
* cell instance sg13cmos5l_fill_1_635 r0 *1 0,0
Xsg13cmos5l_fill_1_635 VPWR VGND sg13cmos5l_fill_1
* cell instance sg13cmos5l_fill_1_636 r0 *1 0,0
Xsg13cmos5l_fill_1_636 VPWR VGND sg13cmos5l_fill_1
* cell instance sg13cmos5l_fill_1_637 r0 *1 0,0
Xsg13cmos5l_fill_1_637 VPWR VGND sg13cmos5l_fill_1
* cell instance sg13cmos5l_fill_1_638 r0 *1 0,0
Xsg13cmos5l_fill_1_638 VPWR VGND sg13cmos5l_fill_1
* cell instance sg13cmos5l_fill_1_639 r0 *1 0,0
Xsg13cmos5l_fill_1_639 VPWR VGND sg13cmos5l_fill_1
* cell instance sg13cmos5l_fill_1_640 r0 *1 0,0
Xsg13cmos5l_fill_1_640 VPWR VGND sg13cmos5l_fill_1
* cell instance sg13cmos5l_fill_1_641 r0 *1 0,0
Xsg13cmos5l_fill_1_641 VPWR VGND sg13cmos5l_fill_1
* cell instance sg13cmos5l_fill_1_642 r0 *1 0,0
Xsg13cmos5l_fill_1_642 VPWR VGND sg13cmos5l_fill_1
* cell instance sg13cmos5l_fill_1_643 r0 *1 0,0
Xsg13cmos5l_fill_1_643 VPWR VGND sg13cmos5l_fill_1
* cell instance sg13cmos5l_fill_1_644 r0 *1 0,0
Xsg13cmos5l_fill_1_644 VPWR VGND sg13cmos5l_fill_1
* cell instance sg13cmos5l_fill_1_645 r0 *1 0,0
Xsg13cmos5l_fill_1_645 VPWR VGND sg13cmos5l_fill_1
* cell instance sg13cmos5l_fill_1_646 r0 *1 0,0
Xsg13cmos5l_fill_1_646 VPWR VGND sg13cmos5l_fill_1
* cell instance sg13cmos5l_fill_1_647 r0 *1 0,0
Xsg13cmos5l_fill_1_647 VPWR VGND sg13cmos5l_fill_1
* cell instance sg13cmos5l_fill_1_648 r0 *1 0,0
Xsg13cmos5l_fill_1_648 VPWR VGND sg13cmos5l_fill_1
* cell instance sg13cmos5l_fill_1_649 r0 *1 0,0
Xsg13cmos5l_fill_1_649 VPWR VGND sg13cmos5l_fill_1
* cell instance sg13cmos5l_fill_1_650 r0 *1 0,0
Xsg13cmos5l_fill_1_650 VPWR VGND sg13cmos5l_fill_1
* cell instance sg13cmos5l_fill_1_651 r0 *1 0,0
Xsg13cmos5l_fill_1_651 VPWR VGND sg13cmos5l_fill_1
* cell instance sg13cmos5l_fill_1_652 r0 *1 0,0
Xsg13cmos5l_fill_1_652 VPWR VGND sg13cmos5l_fill_1
* cell instance sg13cmos5l_fill_1_653 r0 *1 0,0
Xsg13cmos5l_fill_1_653 VPWR VGND sg13cmos5l_fill_1
* cell instance sg13cmos5l_fill_1_654 r0 *1 0,0
Xsg13cmos5l_fill_1_654 VPWR VGND sg13cmos5l_fill_1
* cell instance sg13cmos5l_fill_1_655 r0 *1 0,0
Xsg13cmos5l_fill_1_655 VPWR VGND sg13cmos5l_fill_1
* cell instance sg13cmos5l_fill_1_656 r0 *1 0,0
Xsg13cmos5l_fill_1_656 VPWR VGND sg13cmos5l_fill_1
* cell instance sg13cmos5l_fill_1_657 r0 *1 0,0
Xsg13cmos5l_fill_1_657 VPWR VGND sg13cmos5l_fill_1
* cell instance sg13cmos5l_fill_1_658 r0 *1 0,0
Xsg13cmos5l_fill_1_658 VPWR VGND sg13cmos5l_fill_1
* cell instance sg13cmos5l_fill_1_659 r0 *1 0,0
Xsg13cmos5l_fill_1_659 VPWR VGND sg13cmos5l_fill_1
* cell instance sg13cmos5l_fill_1_660 r0 *1 0,0
Xsg13cmos5l_fill_1_660 VPWR VGND sg13cmos5l_fill_1
* cell instance sg13cmos5l_fill_1_661 r0 *1 0,0
Xsg13cmos5l_fill_1_661 VPWR VGND sg13cmos5l_fill_1
* cell instance sg13cmos5l_fill_1_662 r0 *1 0,0
Xsg13cmos5l_fill_1_662 VPWR VGND sg13cmos5l_fill_1
* cell instance sg13cmos5l_fill_1_663 r0 *1 0,0
Xsg13cmos5l_fill_1_663 VPWR VGND sg13cmos5l_fill_1
* cell instance sg13cmos5l_fill_1_664 r0 *1 0,0
Xsg13cmos5l_fill_1_664 VPWR VGND sg13cmos5l_fill_1
* cell instance sg13cmos5l_fill_1_665 r0 *1 0,0
Xsg13cmos5l_fill_1_665 VPWR VGND sg13cmos5l_fill_1
* cell instance sg13cmos5l_fill_1_666 r0 *1 0,0
Xsg13cmos5l_fill_1_666 VPWR VGND sg13cmos5l_fill_1
* cell instance sg13cmos5l_fill_1_667 r0 *1 0,0
Xsg13cmos5l_fill_1_667 VPWR VGND sg13cmos5l_fill_1
* cell instance sg13cmos5l_fill_1_668 r0 *1 0,0
Xsg13cmos5l_fill_1_668 VPWR VGND sg13cmos5l_fill_1
* cell instance sg13cmos5l_fill_1_669 r0 *1 0,0
Xsg13cmos5l_fill_1_669 VPWR VGND sg13cmos5l_fill_1
* cell instance sg13cmos5l_fill_1_670 r0 *1 0,0
Xsg13cmos5l_fill_1_670 VPWR VGND sg13cmos5l_fill_1
* cell instance sg13cmos5l_fill_1_671 r0 *1 0,0
Xsg13cmos5l_fill_1_671 VPWR VGND sg13cmos5l_fill_1
* cell instance sg13cmos5l_fill_1_672 r0 *1 0,0
Xsg13cmos5l_fill_1_672 VPWR VGND sg13cmos5l_fill_1
* cell instance sg13cmos5l_fill_1_673 r0 *1 0,0
Xsg13cmos5l_fill_1_673 VPWR VGND sg13cmos5l_fill_1
* cell instance sg13cmos5l_fill_1_674 r0 *1 0,0
Xsg13cmos5l_fill_1_674 VPWR VGND sg13cmos5l_fill_1
* cell instance sg13cmos5l_fill_1_675 r0 *1 0,0
Xsg13cmos5l_fill_1_675 VPWR VGND sg13cmos5l_fill_1
* cell instance sg13cmos5l_fill_1_676 r0 *1 0,0
Xsg13cmos5l_fill_1_676 VPWR VGND sg13cmos5l_fill_1
* cell instance sg13cmos5l_fill_1_677 r0 *1 0,0
Xsg13cmos5l_fill_1_677 VPWR VGND sg13cmos5l_fill_1
* cell instance sg13cmos5l_fill_1_678 r0 *1 0,0
Xsg13cmos5l_fill_1_678 VPWR VGND sg13cmos5l_fill_1
* cell instance sg13cmos5l_fill_1_679 r0 *1 0,0
Xsg13cmos5l_fill_1_679 VPWR VGND sg13cmos5l_fill_1
* cell instance sg13cmos5l_fill_1_680 r0 *1 0,0
Xsg13cmos5l_fill_1_680 VPWR VGND sg13cmos5l_fill_1
* cell instance sg13cmos5l_fill_1_681 r0 *1 0,0
Xsg13cmos5l_fill_1_681 VPWR VGND sg13cmos5l_fill_1
* cell instance sg13cmos5l_fill_1_682 r0 *1 0,0
Xsg13cmos5l_fill_1_682 VPWR VGND sg13cmos5l_fill_1
* cell instance sg13cmos5l_fill_1_683 r0 *1 0,0
Xsg13cmos5l_fill_1_683 VPWR VGND sg13cmos5l_fill_1
* cell instance sg13cmos5l_fill_1_684 r0 *1 0,0
Xsg13cmos5l_fill_1_684 VPWR VGND sg13cmos5l_fill_1
* cell instance sg13cmos5l_fill_1_685 r0 *1 0,0
Xsg13cmos5l_fill_1_685 VPWR VGND sg13cmos5l_fill_1
* cell instance sg13cmos5l_fill_1_686 r0 *1 0,0
Xsg13cmos5l_fill_1_686 VPWR VGND sg13cmos5l_fill_1
* cell instance sg13cmos5l_fill_1_687 r0 *1 0,0
Xsg13cmos5l_fill_1_687 VPWR VGND sg13cmos5l_fill_1
* cell instance sg13cmos5l_fill_1_688 r0 *1 0,0
Xsg13cmos5l_fill_1_688 VPWR VGND sg13cmos5l_fill_1
* cell instance sg13cmos5l_fill_1_689 r0 *1 0,0
Xsg13cmos5l_fill_1_689 VPWR VGND sg13cmos5l_fill_1
* cell instance sg13cmos5l_fill_1_690 r0 *1 0,0
Xsg13cmos5l_fill_1_690 VPWR VGND sg13cmos5l_fill_1
* cell instance sg13cmos5l_fill_1_691 r0 *1 0,0
Xsg13cmos5l_fill_1_691 VPWR VGND sg13cmos5l_fill_1
* cell instance sg13cmos5l_fill_1_692 r0 *1 0,0
Xsg13cmos5l_fill_1_692 VPWR VGND sg13cmos5l_fill_1
* cell instance sg13cmos5l_fill_1_693 r0 *1 0,0
Xsg13cmos5l_fill_1_693 VPWR VGND sg13cmos5l_fill_1
* cell instance sg13cmos5l_fill_1_694 r0 *1 0,0
Xsg13cmos5l_fill_1_694 VPWR VGND sg13cmos5l_fill_1
* cell instance sg13cmos5l_fill_1_695 r0 *1 0,0
Xsg13cmos5l_fill_1_695 VPWR VGND sg13cmos5l_fill_1
* cell instance sg13cmos5l_fill_1_696 r0 *1 0,0
Xsg13cmos5l_fill_1_696 VPWR VGND sg13cmos5l_fill_1
* cell instance sg13cmos5l_fill_1_697 r0 *1 0,0
Xsg13cmos5l_fill_1_697 VPWR VGND sg13cmos5l_fill_1
* cell instance sg13cmos5l_fill_1_698 r0 *1 0,0
Xsg13cmos5l_fill_1_698 VPWR VGND sg13cmos5l_fill_1
* cell instance sg13cmos5l_fill_1_699 r0 *1 0,0
Xsg13cmos5l_fill_1_699 VPWR VGND sg13cmos5l_fill_1
* cell instance sg13cmos5l_fill_1_700 r0 *1 0,0
Xsg13cmos5l_fill_1_700 VPWR VGND sg13cmos5l_fill_1
* cell instance sg13cmos5l_fill_1_701 r0 *1 0,0
Xsg13cmos5l_fill_1_701 VPWR VGND sg13cmos5l_fill_1
* cell instance sg13cmos5l_fill_1_702 r0 *1 0,0
Xsg13cmos5l_fill_1_702 VPWR VGND sg13cmos5l_fill_1
* cell instance sg13cmos5l_fill_1_703 r0 *1 0,0
Xsg13cmos5l_fill_1_703 VPWR VGND sg13cmos5l_fill_1
* cell instance sg13cmos5l_fill_1_704 r0 *1 0,0
Xsg13cmos5l_fill_1_704 VPWR VGND sg13cmos5l_fill_1
* cell instance sg13cmos5l_fill_1_705 r0 *1 0,0
Xsg13cmos5l_fill_1_705 VPWR VGND sg13cmos5l_fill_1
* cell instance sg13cmos5l_fill_1_706 r0 *1 0,0
Xsg13cmos5l_fill_1_706 VPWR VGND sg13cmos5l_fill_1
* cell instance sg13cmos5l_fill_1_707 r0 *1 0,0
Xsg13cmos5l_fill_1_707 VPWR VGND sg13cmos5l_fill_1
* cell instance sg13cmos5l_fill_1_708 r0 *1 0,0
Xsg13cmos5l_fill_1_708 VPWR VGND sg13cmos5l_fill_1
* cell instance sg13cmos5l_fill_1_709 r0 *1 0,0
Xsg13cmos5l_fill_1_709 VPWR VGND sg13cmos5l_fill_1
* cell instance sg13cmos5l_fill_1_710 r0 *1 0,0
Xsg13cmos5l_fill_1_710 VPWR VGND sg13cmos5l_fill_1
* cell instance sg13cmos5l_fill_1_711 r0 *1 0,0
Xsg13cmos5l_fill_1_711 VPWR VGND sg13cmos5l_fill_1
* cell instance sg13cmos5l_fill_1_712 r0 *1 0,0
Xsg13cmos5l_fill_1_712 VPWR VGND sg13cmos5l_fill_1
* cell instance sg13cmos5l_fill_1_713 r0 *1 0,0
Xsg13cmos5l_fill_1_713 VPWR VGND sg13cmos5l_fill_1
* cell instance sg13cmos5l_fill_1_714 r0 *1 0,0
Xsg13cmos5l_fill_1_714 VPWR VGND sg13cmos5l_fill_1
* cell instance sg13cmos5l_fill_1_715 r0 *1 0,0
Xsg13cmos5l_fill_1_715 VPWR VGND sg13cmos5l_fill_1
* cell instance sg13cmos5l_fill_1_716 r0 *1 0,0
Xsg13cmos5l_fill_1_716 VPWR VGND sg13cmos5l_fill_1
* cell instance sg13cmos5l_fill_1_717 r0 *1 0,0
Xsg13cmos5l_fill_1_717 VPWR VGND sg13cmos5l_fill_1
* cell instance sg13cmos5l_fill_1_718 r0 *1 0,0
Xsg13cmos5l_fill_1_718 VPWR VGND sg13cmos5l_fill_1
* cell instance sg13cmos5l_fill_1_719 r0 *1 0,0
Xsg13cmos5l_fill_1_719 VPWR VGND sg13cmos5l_fill_1
* cell instance sg13cmos5l_fill_1_720 r0 *1 0,0
Xsg13cmos5l_fill_1_720 VPWR VGND sg13cmos5l_fill_1
* cell instance sg13cmos5l_fill_1_721 r0 *1 0,0
Xsg13cmos5l_fill_1_721 VPWR VGND sg13cmos5l_fill_1
* cell instance sg13cmos5l_fill_1_722 r0 *1 0,0
Xsg13cmos5l_fill_1_722 VPWR VGND sg13cmos5l_fill_1
* cell instance sg13cmos5l_fill_1_723 r0 *1 0,0
Xsg13cmos5l_fill_1_723 VPWR VGND sg13cmos5l_fill_1
* cell instance sg13cmos5l_fill_1_724 r0 *1 0,0
Xsg13cmos5l_fill_1_724 VPWR VGND sg13cmos5l_fill_1
* cell instance sg13cmos5l_fill_1_725 r0 *1 0,0
Xsg13cmos5l_fill_1_725 VPWR VGND sg13cmos5l_fill_1
* cell instance sg13cmos5l_fill_1_726 r0 *1 0,0
Xsg13cmos5l_fill_1_726 VPWR VGND sg13cmos5l_fill_1
* cell instance sg13cmos5l_fill_1_727 r0 *1 0,0
Xsg13cmos5l_fill_1_727 VPWR VGND sg13cmos5l_fill_1
* cell instance sg13cmos5l_fill_1_728 r0 *1 0,0
Xsg13cmos5l_fill_1_728 VPWR VGND sg13cmos5l_fill_1
* cell instance sg13cmos5l_fill_1_729 r0 *1 0,0
Xsg13cmos5l_fill_1_729 VPWR VGND sg13cmos5l_fill_1
* cell instance sg13cmos5l_fill_1_730 r0 *1 0,0
Xsg13cmos5l_fill_1_730 VPWR VGND sg13cmos5l_fill_1
* cell instance sg13cmos5l_fill_1_731 r0 *1 0,0
Xsg13cmos5l_fill_1_731 VPWR VGND sg13cmos5l_fill_1
* cell instance sg13cmos5l_fill_1_732 r0 *1 0,0
Xsg13cmos5l_fill_1_732 VPWR VGND sg13cmos5l_fill_1
* cell instance sg13cmos5l_fill_1_733 r0 *1 0,0
Xsg13cmos5l_fill_1_733 VPWR VGND sg13cmos5l_fill_1
* cell instance sg13cmos5l_fill_1_734 r0 *1 0,0
Xsg13cmos5l_fill_1_734 VPWR VGND sg13cmos5l_fill_1
* cell instance sg13cmos5l_fill_1_735 r0 *1 0,0
Xsg13cmos5l_fill_1_735 VPWR VGND sg13cmos5l_fill_1
* cell instance sg13cmos5l_fill_1_736 r0 *1 0,0
Xsg13cmos5l_fill_1_736 VPWR VGND sg13cmos5l_fill_1
* cell instance sg13cmos5l_fill_1_737 r0 *1 0,0
Xsg13cmos5l_fill_1_737 VPWR VGND sg13cmos5l_fill_1
* cell instance sg13cmos5l_fill_1_738 r0 *1 0,0
Xsg13cmos5l_fill_1_738 VPWR VGND sg13cmos5l_fill_1
* cell instance sg13cmos5l_fill_1_739 r0 *1 0,0
Xsg13cmos5l_fill_1_739 VPWR VGND sg13cmos5l_fill_1
* cell instance sg13cmos5l_fill_1_740 r0 *1 0,0
Xsg13cmos5l_fill_1_740 VPWR VGND sg13cmos5l_fill_1
* cell instance sg13cmos5l_fill_1_741 r0 *1 0,0
Xsg13cmos5l_fill_1_741 VPWR VGND sg13cmos5l_fill_1
* cell instance sg13cmos5l_fill_1_742 r0 *1 0,0
Xsg13cmos5l_fill_1_742 VPWR VGND sg13cmos5l_fill_1
* cell instance sg13cmos5l_fill_1_743 r0 *1 0,0
Xsg13cmos5l_fill_1_743 VPWR VGND sg13cmos5l_fill_1
* cell instance sg13cmos5l_fill_1_744 r0 *1 0,0
Xsg13cmos5l_fill_1_744 VPWR VGND sg13cmos5l_fill_1
* cell instance sg13cmos5l_fill_1_745 r0 *1 0,0
Xsg13cmos5l_fill_1_745 VPWR VGND sg13cmos5l_fill_1
* cell instance sg13cmos5l_fill_1_746 r0 *1 0,0
Xsg13cmos5l_fill_1_746 VPWR VGND sg13cmos5l_fill_1
* cell instance sg13cmos5l_fill_1_747 r0 *1 0,0
Xsg13cmos5l_fill_1_747 VPWR VGND sg13cmos5l_fill_1
* cell instance sg13cmos5l_fill_1_748 r0 *1 0,0
Xsg13cmos5l_fill_1_748 VPWR VGND sg13cmos5l_fill_1
* cell instance sg13cmos5l_fill_1_749 r0 *1 0,0
Xsg13cmos5l_fill_1_749 VPWR VGND sg13cmos5l_fill_1
* cell instance sg13cmos5l_fill_1_750 r0 *1 0,0
Xsg13cmos5l_fill_1_750 VPWR VGND sg13cmos5l_fill_1
* cell instance sg13cmos5l_fill_1_751 r0 *1 0,0
Xsg13cmos5l_fill_1_751 VPWR VGND sg13cmos5l_fill_1
* cell instance sg13cmos5l_fill_1_752 r0 *1 0,0
Xsg13cmos5l_fill_1_752 VPWR VGND sg13cmos5l_fill_1
* cell instance sg13cmos5l_fill_1_753 r0 *1 0,0
Xsg13cmos5l_fill_1_753 VPWR VGND sg13cmos5l_fill_1
* cell instance sg13cmos5l_fill_1_754 r0 *1 0,0
Xsg13cmos5l_fill_1_754 VPWR VGND sg13cmos5l_fill_1
* cell instance sg13cmos5l_fill_1_755 r0 *1 0,0
Xsg13cmos5l_fill_1_755 VPWR VGND sg13cmos5l_fill_1
* cell instance sg13cmos5l_fill_1_756 r0 *1 0,0
Xsg13cmos5l_fill_1_756 VPWR VGND sg13cmos5l_fill_1
* cell instance sg13cmos5l_fill_1_757 r0 *1 0,0
Xsg13cmos5l_fill_1_757 VPWR VGND sg13cmos5l_fill_1
* cell instance sg13cmos5l_fill_1_758 r0 *1 0,0
Xsg13cmos5l_fill_1_758 VPWR VGND sg13cmos5l_fill_1
* cell instance sg13cmos5l_fill_1_759 r0 *1 0,0
Xsg13cmos5l_fill_1_759 VPWR VGND sg13cmos5l_fill_1
* cell instance sg13cmos5l_fill_1_760 r0 *1 0,0
Xsg13cmos5l_fill_1_760 VPWR VGND sg13cmos5l_fill_1
* cell instance sg13cmos5l_fill_1_761 r0 *1 0,0
Xsg13cmos5l_fill_1_761 VPWR VGND sg13cmos5l_fill_1
* cell instance sg13cmos5l_fill_1_762 r0 *1 0,0
Xsg13cmos5l_fill_1_762 VPWR VGND sg13cmos5l_fill_1
* cell instance sg13cmos5l_fill_1_763 r0 *1 0,0
Xsg13cmos5l_fill_1_763 VPWR VGND sg13cmos5l_fill_1
* cell instance sg13cmos5l_fill_1_764 r0 *1 0,0
Xsg13cmos5l_fill_1_764 VPWR VGND sg13cmos5l_fill_1
* cell instance sg13cmos5l_fill_1_765 r0 *1 0,0
Xsg13cmos5l_fill_1_765 VPWR VGND sg13cmos5l_fill_1
* cell instance sg13cmos5l_fill_1_766 r0 *1 0,0
Xsg13cmos5l_fill_1_766 VPWR VGND sg13cmos5l_fill_1
* cell instance sg13cmos5l_fill_1_767 r0 *1 0,0
Xsg13cmos5l_fill_1_767 VPWR VGND sg13cmos5l_fill_1
* cell instance sg13cmos5l_fill_1_768 r0 *1 0,0
Xsg13cmos5l_fill_1_768 VPWR VGND sg13cmos5l_fill_1
* cell instance sg13cmos5l_fill_1_769 r0 *1 0,0
Xsg13cmos5l_fill_1_769 VPWR VGND sg13cmos5l_fill_1
* cell instance sg13cmos5l_fill_1_770 r0 *1 0,0
Xsg13cmos5l_fill_1_770 VPWR VGND sg13cmos5l_fill_1
* cell instance sg13cmos5l_fill_1_771 r0 *1 0,0
Xsg13cmos5l_fill_1_771 VPWR VGND sg13cmos5l_fill_1
* cell instance sg13cmos5l_fill_1_772 r0 *1 0,0
Xsg13cmos5l_fill_1_772 VPWR VGND sg13cmos5l_fill_1
* cell instance sg13cmos5l_fill_1_773 r0 *1 0,0
Xsg13cmos5l_fill_1_773 VPWR VGND sg13cmos5l_fill_1
* cell instance sg13cmos5l_fill_1_774 r0 *1 0,0
Xsg13cmos5l_fill_1_774 VPWR VGND sg13cmos5l_fill_1
* cell instance sg13cmos5l_fill_1_775 r0 *1 0,0
Xsg13cmos5l_fill_1_775 VPWR VGND sg13cmos5l_fill_1
* cell instance sg13cmos5l_fill_1_776 r0 *1 0,0
Xsg13cmos5l_fill_1_776 VPWR VGND sg13cmos5l_fill_1
* cell instance sg13cmos5l_fill_1_777 r0 *1 0,0
Xsg13cmos5l_fill_1_777 VPWR VGND sg13cmos5l_fill_1
* cell instance sg13cmos5l_fill_1_778 r0 *1 0,0
Xsg13cmos5l_fill_1_778 VPWR VGND sg13cmos5l_fill_1
* cell instance sg13cmos5l_fill_1_779 r0 *1 0,0
Xsg13cmos5l_fill_1_779 VPWR VGND sg13cmos5l_fill_1
* cell instance sg13cmos5l_fill_1_780 r0 *1 0,0
Xsg13cmos5l_fill_1_780 VPWR VGND sg13cmos5l_fill_1
* cell instance sg13cmos5l_fill_2_0 r0 *1 0,0
Xsg13cmos5l_fill_2_0 VPWR VGND sg13cmos5l_fill_2
* cell instance sg13cmos5l_fill_2_1 r0 *1 0,0
Xsg13cmos5l_fill_2_1 VPWR VGND sg13cmos5l_fill_2
* cell instance sg13cmos5l_fill_2_2 r0 *1 0,0
Xsg13cmos5l_fill_2_2 VPWR VGND sg13cmos5l_fill_2
* cell instance sg13cmos5l_fill_2_3 r0 *1 0,0
Xsg13cmos5l_fill_2_3 VPWR VGND sg13cmos5l_fill_2
* cell instance sg13cmos5l_fill_2_4 r0 *1 0,0
Xsg13cmos5l_fill_2_4 VPWR VGND sg13cmos5l_fill_2
* cell instance sg13cmos5l_fill_2_5 r0 *1 0,0
Xsg13cmos5l_fill_2_5 VPWR VGND sg13cmos5l_fill_2
* cell instance sg13cmos5l_fill_2_6 r0 *1 0,0
Xsg13cmos5l_fill_2_6 VPWR VGND sg13cmos5l_fill_2
* cell instance sg13cmos5l_fill_2_7 r0 *1 0,0
Xsg13cmos5l_fill_2_7 VPWR VGND sg13cmos5l_fill_2
* cell instance sg13cmos5l_fill_2_8 r0 *1 0,0
Xsg13cmos5l_fill_2_8 VPWR VGND sg13cmos5l_fill_2
* cell instance sg13cmos5l_fill_2_9 r0 *1 0,0
Xsg13cmos5l_fill_2_9 VPWR VGND sg13cmos5l_fill_2
* cell instance sg13cmos5l_fill_2_10 r0 *1 0,0
Xsg13cmos5l_fill_2_10 VPWR VGND sg13cmos5l_fill_2
* cell instance sg13cmos5l_fill_2_11 r0 *1 0,0
Xsg13cmos5l_fill_2_11 VPWR VGND sg13cmos5l_fill_2
* cell instance sg13cmos5l_fill_2_12 r0 *1 0,0
Xsg13cmos5l_fill_2_12 VPWR VGND sg13cmos5l_fill_2
* cell instance sg13cmos5l_fill_2_13 r0 *1 0,0
Xsg13cmos5l_fill_2_13 VPWR VGND sg13cmos5l_fill_2
* cell instance sg13cmos5l_fill_2_14 r0 *1 0,0
Xsg13cmos5l_fill_2_14 VPWR VGND sg13cmos5l_fill_2
* cell instance sg13cmos5l_fill_2_15 r0 *1 0,0
Xsg13cmos5l_fill_2_15 VPWR VGND sg13cmos5l_fill_2
* cell instance sg13cmos5l_fill_2_16 r0 *1 0,0
Xsg13cmos5l_fill_2_16 VPWR VGND sg13cmos5l_fill_2
* cell instance sg13cmos5l_fill_2_17 r0 *1 0,0
Xsg13cmos5l_fill_2_17 VPWR VGND sg13cmos5l_fill_2
* cell instance sg13cmos5l_fill_2_18 r0 *1 0,0
Xsg13cmos5l_fill_2_18 VPWR VGND sg13cmos5l_fill_2
* cell instance sg13cmos5l_fill_2_19 r0 *1 0,0
Xsg13cmos5l_fill_2_19 VPWR VGND sg13cmos5l_fill_2
* cell instance sg13cmos5l_fill_2_20 r0 *1 0,0
Xsg13cmos5l_fill_2_20 VPWR VGND sg13cmos5l_fill_2
* cell instance sg13cmos5l_fill_2_21 r0 *1 0,0
Xsg13cmos5l_fill_2_21 VPWR VGND sg13cmos5l_fill_2
* cell instance sg13cmos5l_fill_2_22 r0 *1 0,0
Xsg13cmos5l_fill_2_22 VPWR VGND sg13cmos5l_fill_2
* cell instance sg13cmos5l_fill_2_23 r0 *1 0,0
Xsg13cmos5l_fill_2_23 VPWR VGND sg13cmos5l_fill_2
* cell instance sg13cmos5l_fill_2_24 r0 *1 0,0
Xsg13cmos5l_fill_2_24 VPWR VGND sg13cmos5l_fill_2
* cell instance sg13cmos5l_fill_2_25 r0 *1 0,0
Xsg13cmos5l_fill_2_25 VPWR VGND sg13cmos5l_fill_2
* cell instance sg13cmos5l_fill_2_26 r0 *1 0,0
Xsg13cmos5l_fill_2_26 VPWR VGND sg13cmos5l_fill_2
* cell instance sg13cmos5l_fill_2_27 r0 *1 0,0
Xsg13cmos5l_fill_2_27 VPWR VGND sg13cmos5l_fill_2
* cell instance sg13cmos5l_fill_2_28 r0 *1 0,0
Xsg13cmos5l_fill_2_28 VPWR VGND sg13cmos5l_fill_2
* cell instance sg13cmos5l_fill_2_29 r0 *1 0,0
Xsg13cmos5l_fill_2_29 VPWR VGND sg13cmos5l_fill_2
* cell instance sg13cmos5l_fill_2_30 r0 *1 0,0
Xsg13cmos5l_fill_2_30 VPWR VGND sg13cmos5l_fill_2
* cell instance sg13cmos5l_fill_2_31 r0 *1 0,0
Xsg13cmos5l_fill_2_31 VPWR VGND sg13cmos5l_fill_2
* cell instance sg13cmos5l_fill_2_32 r0 *1 0,0
Xsg13cmos5l_fill_2_32 VPWR VGND sg13cmos5l_fill_2
* cell instance sg13cmos5l_fill_2_33 r0 *1 0,0
Xsg13cmos5l_fill_2_33 VPWR VGND sg13cmos5l_fill_2
* cell instance sg13cmos5l_fill_2_34 r0 *1 0,0
Xsg13cmos5l_fill_2_34 VPWR VGND sg13cmos5l_fill_2
* cell instance sg13cmos5l_fill_2_35 r0 *1 0,0
Xsg13cmos5l_fill_2_35 VPWR VGND sg13cmos5l_fill_2
* cell instance sg13cmos5l_fill_2_36 r0 *1 0,0
Xsg13cmos5l_fill_2_36 VPWR VGND sg13cmos5l_fill_2
* cell instance sg13cmos5l_fill_2_37 r0 *1 0,0
Xsg13cmos5l_fill_2_37 VPWR VGND sg13cmos5l_fill_2
* cell instance sg13cmos5l_fill_2_38 r0 *1 0,0
Xsg13cmos5l_fill_2_38 VPWR VGND sg13cmos5l_fill_2
* cell instance sg13cmos5l_fill_2_39 r0 *1 0,0
Xsg13cmos5l_fill_2_39 VPWR VGND sg13cmos5l_fill_2
* cell instance sg13cmos5l_fill_2_40 r0 *1 0,0
Xsg13cmos5l_fill_2_40 VPWR VGND sg13cmos5l_fill_2
* cell instance sg13cmos5l_fill_2_41 r0 *1 0,0
Xsg13cmos5l_fill_2_41 VPWR VGND sg13cmos5l_fill_2
* cell instance sg13cmos5l_fill_2_42 r0 *1 0,0
Xsg13cmos5l_fill_2_42 VPWR VGND sg13cmos5l_fill_2
* cell instance sg13cmos5l_fill_2_43 r0 *1 0,0
Xsg13cmos5l_fill_2_43 VPWR VGND sg13cmos5l_fill_2
* cell instance sg13cmos5l_fill_2_44 r0 *1 0,0
Xsg13cmos5l_fill_2_44 VPWR VGND sg13cmos5l_fill_2
* cell instance sg13cmos5l_fill_2_45 r0 *1 0,0
Xsg13cmos5l_fill_2_45 VPWR VGND sg13cmos5l_fill_2
* cell instance sg13cmos5l_fill_2_46 r0 *1 0,0
Xsg13cmos5l_fill_2_46 VPWR VGND sg13cmos5l_fill_2
* cell instance sg13cmos5l_fill_2_47 r0 *1 0,0
Xsg13cmos5l_fill_2_47 VPWR VGND sg13cmos5l_fill_2
* cell instance sg13cmos5l_fill_2_48 r0 *1 0,0
Xsg13cmos5l_fill_2_48 VPWR VGND sg13cmos5l_fill_2
* cell instance sg13cmos5l_fill_2_49 r0 *1 0,0
Xsg13cmos5l_fill_2_49 VPWR VGND sg13cmos5l_fill_2
* cell instance sg13cmos5l_fill_2_50 r0 *1 0,0
Xsg13cmos5l_fill_2_50 VPWR VGND sg13cmos5l_fill_2
* cell instance sg13cmos5l_fill_2_51 r0 *1 0,0
Xsg13cmos5l_fill_2_51 VPWR VGND sg13cmos5l_fill_2
* cell instance sg13cmos5l_fill_2_52 r0 *1 0,0
Xsg13cmos5l_fill_2_52 VPWR VGND sg13cmos5l_fill_2
* cell instance sg13cmos5l_fill_2_53 r0 *1 0,0
Xsg13cmos5l_fill_2_53 VPWR VGND sg13cmos5l_fill_2
* cell instance sg13cmos5l_fill_2_54 r0 *1 0,0
Xsg13cmos5l_fill_2_54 VPWR VGND sg13cmos5l_fill_2
* cell instance sg13cmos5l_fill_2_55 r0 *1 0,0
Xsg13cmos5l_fill_2_55 VPWR VGND sg13cmos5l_fill_2
* cell instance sg13cmos5l_fill_2_56 r0 *1 0,0
Xsg13cmos5l_fill_2_56 VPWR VGND sg13cmos5l_fill_2
* cell instance sg13cmos5l_fill_2_57 r0 *1 0,0
Xsg13cmos5l_fill_2_57 VPWR VGND sg13cmos5l_fill_2
* cell instance sg13cmos5l_fill_2_58 r0 *1 0,0
Xsg13cmos5l_fill_2_58 VPWR VGND sg13cmos5l_fill_2
* cell instance sg13cmos5l_fill_2_59 r0 *1 0,0
Xsg13cmos5l_fill_2_59 VPWR VGND sg13cmos5l_fill_2
* cell instance sg13cmos5l_fill_2_60 r0 *1 0,0
Xsg13cmos5l_fill_2_60 VPWR VGND sg13cmos5l_fill_2
* cell instance sg13cmos5l_fill_2_61 r0 *1 0,0
Xsg13cmos5l_fill_2_61 VPWR VGND sg13cmos5l_fill_2
* cell instance sg13cmos5l_fill_2_62 r0 *1 0,0
Xsg13cmos5l_fill_2_62 VPWR VGND sg13cmos5l_fill_2
* cell instance sg13cmos5l_fill_2_63 r0 *1 0,0
Xsg13cmos5l_fill_2_63 VPWR VGND sg13cmos5l_fill_2
* cell instance sg13cmos5l_fill_2_64 r0 *1 0,0
Xsg13cmos5l_fill_2_64 VPWR VGND sg13cmos5l_fill_2
* cell instance sg13cmos5l_fill_2_65 r0 *1 0,0
Xsg13cmos5l_fill_2_65 VPWR VGND sg13cmos5l_fill_2
* cell instance sg13cmos5l_fill_2_66 r0 *1 0,0
Xsg13cmos5l_fill_2_66 VPWR VGND sg13cmos5l_fill_2
* cell instance sg13cmos5l_fill_2_67 r0 *1 0,0
Xsg13cmos5l_fill_2_67 VPWR VGND sg13cmos5l_fill_2
* cell instance sg13cmos5l_fill_2_68 r0 *1 0,0
Xsg13cmos5l_fill_2_68 VPWR VGND sg13cmos5l_fill_2
* cell instance sg13cmos5l_fill_2_69 r0 *1 0,0
Xsg13cmos5l_fill_2_69 VPWR VGND sg13cmos5l_fill_2
* cell instance sg13cmos5l_fill_2_70 r0 *1 0,0
Xsg13cmos5l_fill_2_70 VPWR VGND sg13cmos5l_fill_2
* cell instance sg13cmos5l_fill_2_71 r0 *1 0,0
Xsg13cmos5l_fill_2_71 VPWR VGND sg13cmos5l_fill_2
* cell instance sg13cmos5l_fill_2_72 r0 *1 0,0
Xsg13cmos5l_fill_2_72 VPWR VGND sg13cmos5l_fill_2
* cell instance sg13cmos5l_fill_2_73 r0 *1 0,0
Xsg13cmos5l_fill_2_73 VPWR VGND sg13cmos5l_fill_2
* cell instance sg13cmos5l_fill_2_74 r0 *1 0,0
Xsg13cmos5l_fill_2_74 VPWR VGND sg13cmos5l_fill_2
* cell instance sg13cmos5l_fill_2_75 r0 *1 0,0
Xsg13cmos5l_fill_2_75 VPWR VGND sg13cmos5l_fill_2
* cell instance sg13cmos5l_fill_2_76 r0 *1 0,0
Xsg13cmos5l_fill_2_76 VPWR VGND sg13cmos5l_fill_2
* cell instance sg13cmos5l_fill_2_77 r0 *1 0,0
Xsg13cmos5l_fill_2_77 VPWR VGND sg13cmos5l_fill_2
* cell instance sg13cmos5l_fill_2_78 r0 *1 0,0
Xsg13cmos5l_fill_2_78 VPWR VGND sg13cmos5l_fill_2
* cell instance sg13cmos5l_fill_2_79 r0 *1 0,0
Xsg13cmos5l_fill_2_79 VPWR VGND sg13cmos5l_fill_2
* cell instance sg13cmos5l_fill_2_80 r0 *1 0,0
Xsg13cmos5l_fill_2_80 VPWR VGND sg13cmos5l_fill_2
* cell instance sg13cmos5l_fill_2_81 r0 *1 0,0
Xsg13cmos5l_fill_2_81 VPWR VGND sg13cmos5l_fill_2
* cell instance sg13cmos5l_fill_2_82 r0 *1 0,0
Xsg13cmos5l_fill_2_82 VPWR VGND sg13cmos5l_fill_2
* cell instance sg13cmos5l_fill_2_83 r0 *1 0,0
Xsg13cmos5l_fill_2_83 VPWR VGND sg13cmos5l_fill_2
* cell instance sg13cmos5l_fill_2_84 r0 *1 0,0
Xsg13cmos5l_fill_2_84 VPWR VGND sg13cmos5l_fill_2
* cell instance sg13cmos5l_fill_2_85 r0 *1 0,0
Xsg13cmos5l_fill_2_85 VPWR VGND sg13cmos5l_fill_2
* cell instance sg13cmos5l_fill_2_86 r0 *1 0,0
Xsg13cmos5l_fill_2_86 VPWR VGND sg13cmos5l_fill_2
* cell instance sg13cmos5l_fill_2_87 r0 *1 0,0
Xsg13cmos5l_fill_2_87 VPWR VGND sg13cmos5l_fill_2
* cell instance sg13cmos5l_fill_2_88 r0 *1 0,0
Xsg13cmos5l_fill_2_88 VPWR VGND sg13cmos5l_fill_2
* cell instance sg13cmos5l_fill_2_89 r0 *1 0,0
Xsg13cmos5l_fill_2_89 VPWR VGND sg13cmos5l_fill_2
* cell instance sg13cmos5l_fill_2_90 r0 *1 0,0
Xsg13cmos5l_fill_2_90 VPWR VGND sg13cmos5l_fill_2
* cell instance sg13cmos5l_fill_2_91 r0 *1 0,0
Xsg13cmos5l_fill_2_91 VPWR VGND sg13cmos5l_fill_2
* cell instance sg13cmos5l_fill_2_92 r0 *1 0,0
Xsg13cmos5l_fill_2_92 VPWR VGND sg13cmos5l_fill_2
* cell instance sg13cmos5l_fill_2_93 r0 *1 0,0
Xsg13cmos5l_fill_2_93 VPWR VGND sg13cmos5l_fill_2
* cell instance sg13cmos5l_fill_2_94 r0 *1 0,0
Xsg13cmos5l_fill_2_94 VPWR VGND sg13cmos5l_fill_2
* cell instance sg13cmos5l_fill_2_95 r0 *1 0,0
Xsg13cmos5l_fill_2_95 VPWR VGND sg13cmos5l_fill_2
* cell instance sg13cmos5l_fill_2_96 r0 *1 0,0
Xsg13cmos5l_fill_2_96 VPWR VGND sg13cmos5l_fill_2
* cell instance sg13cmos5l_fill_2_97 r0 *1 0,0
Xsg13cmos5l_fill_2_97 VPWR VGND sg13cmos5l_fill_2
* cell instance sg13cmos5l_fill_2_98 r0 *1 0,0
Xsg13cmos5l_fill_2_98 VPWR VGND sg13cmos5l_fill_2
* cell instance sg13cmos5l_fill_2_99 r0 *1 0,0
Xsg13cmos5l_fill_2_99 VPWR VGND sg13cmos5l_fill_2
* cell instance sg13cmos5l_fill_2_100 r0 *1 0,0
Xsg13cmos5l_fill_2_100 VPWR VGND sg13cmos5l_fill_2
* cell instance sg13cmos5l_fill_2_101 r0 *1 0,0
Xsg13cmos5l_fill_2_101 VPWR VGND sg13cmos5l_fill_2
* cell instance sg13cmos5l_fill_2_102 r0 *1 0,0
Xsg13cmos5l_fill_2_102 VPWR VGND sg13cmos5l_fill_2
* cell instance sg13cmos5l_fill_2_103 r0 *1 0,0
Xsg13cmos5l_fill_2_103 VPWR VGND sg13cmos5l_fill_2
* cell instance sg13cmos5l_fill_2_104 r0 *1 0,0
Xsg13cmos5l_fill_2_104 VPWR VGND sg13cmos5l_fill_2
* cell instance sg13cmos5l_fill_2_105 r0 *1 0,0
Xsg13cmos5l_fill_2_105 VPWR VGND sg13cmos5l_fill_2
* cell instance sg13cmos5l_fill_2_106 r0 *1 0,0
Xsg13cmos5l_fill_2_106 VPWR VGND sg13cmos5l_fill_2
* cell instance sg13cmos5l_fill_2_107 r0 *1 0,0
Xsg13cmos5l_fill_2_107 VPWR VGND sg13cmos5l_fill_2
* cell instance sg13cmos5l_fill_2_108 r0 *1 0,0
Xsg13cmos5l_fill_2_108 VPWR VGND sg13cmos5l_fill_2
* cell instance sg13cmos5l_fill_2_109 r0 *1 0,0
Xsg13cmos5l_fill_2_109 VPWR VGND sg13cmos5l_fill_2
* cell instance sg13cmos5l_fill_2_110 r0 *1 0,0
Xsg13cmos5l_fill_2_110 VPWR VGND sg13cmos5l_fill_2
* cell instance sg13cmos5l_fill_2_111 r0 *1 0,0
Xsg13cmos5l_fill_2_111 VPWR VGND sg13cmos5l_fill_2
* cell instance sg13cmos5l_fill_2_112 r0 *1 0,0
Xsg13cmos5l_fill_2_112 VPWR VGND sg13cmos5l_fill_2
* cell instance sg13cmos5l_fill_2_113 r0 *1 0,0
Xsg13cmos5l_fill_2_113 VPWR VGND sg13cmos5l_fill_2
* cell instance sg13cmos5l_fill_2_114 r0 *1 0,0
Xsg13cmos5l_fill_2_114 VPWR VGND sg13cmos5l_fill_2
* cell instance sg13cmos5l_fill_2_115 r0 *1 0,0
Xsg13cmos5l_fill_2_115 VPWR VGND sg13cmos5l_fill_2
* cell instance sg13cmos5l_fill_2_116 r0 *1 0,0
Xsg13cmos5l_fill_2_116 VPWR VGND sg13cmos5l_fill_2
* cell instance sg13cmos5l_fill_2_117 r0 *1 0,0
Xsg13cmos5l_fill_2_117 VPWR VGND sg13cmos5l_fill_2
* cell instance sg13cmos5l_fill_2_118 r0 *1 0,0
Xsg13cmos5l_fill_2_118 VPWR VGND sg13cmos5l_fill_2
* cell instance sg13cmos5l_fill_2_119 r0 *1 0,0
Xsg13cmos5l_fill_2_119 VPWR VGND sg13cmos5l_fill_2
* cell instance sg13cmos5l_fill_2_120 r0 *1 0,0
Xsg13cmos5l_fill_2_120 VPWR VGND sg13cmos5l_fill_2
* cell instance sg13cmos5l_fill_2_121 r0 *1 0,0
Xsg13cmos5l_fill_2_121 VPWR VGND sg13cmos5l_fill_2
* cell instance sg13cmos5l_fill_2_122 r0 *1 0,0
Xsg13cmos5l_fill_2_122 VPWR VGND sg13cmos5l_fill_2
* cell instance sg13cmos5l_fill_2_123 r0 *1 0,0
Xsg13cmos5l_fill_2_123 VPWR VGND sg13cmos5l_fill_2
* cell instance sg13cmos5l_fill_2_124 r0 *1 0,0
Xsg13cmos5l_fill_2_124 VPWR VGND sg13cmos5l_fill_2
* cell instance sg13cmos5l_fill_2_125 r0 *1 0,0
Xsg13cmos5l_fill_2_125 VPWR VGND sg13cmos5l_fill_2
* cell instance sg13cmos5l_fill_2_126 r0 *1 0,0
Xsg13cmos5l_fill_2_126 VPWR VGND sg13cmos5l_fill_2
* cell instance sg13cmos5l_fill_2_127 r0 *1 0,0
Xsg13cmos5l_fill_2_127 VPWR VGND sg13cmos5l_fill_2
* cell instance sg13cmos5l_fill_2_128 r0 *1 0,0
Xsg13cmos5l_fill_2_128 VPWR VGND sg13cmos5l_fill_2
* cell instance sg13cmos5l_fill_2_129 r0 *1 0,0
Xsg13cmos5l_fill_2_129 VPWR VGND sg13cmos5l_fill_2
* cell instance sg13cmos5l_fill_2_130 r0 *1 0,0
Xsg13cmos5l_fill_2_130 VPWR VGND sg13cmos5l_fill_2
* cell instance sg13cmos5l_fill_2_131 r0 *1 0,0
Xsg13cmos5l_fill_2_131 VPWR VGND sg13cmos5l_fill_2
* cell instance sg13cmos5l_fill_2_132 r0 *1 0,0
Xsg13cmos5l_fill_2_132 VPWR VGND sg13cmos5l_fill_2
* cell instance sg13cmos5l_fill_2_133 r0 *1 0,0
Xsg13cmos5l_fill_2_133 VPWR VGND sg13cmos5l_fill_2
* cell instance sg13cmos5l_fill_2_134 r0 *1 0,0
Xsg13cmos5l_fill_2_134 VPWR VGND sg13cmos5l_fill_2
* cell instance sg13cmos5l_fill_2_135 r0 *1 0,0
Xsg13cmos5l_fill_2_135 VPWR VGND sg13cmos5l_fill_2
* cell instance sg13cmos5l_fill_2_136 r0 *1 0,0
Xsg13cmos5l_fill_2_136 VPWR VGND sg13cmos5l_fill_2
* cell instance sg13cmos5l_fill_2_137 r0 *1 0,0
Xsg13cmos5l_fill_2_137 VPWR VGND sg13cmos5l_fill_2
* cell instance sg13cmos5l_fill_2_138 r0 *1 0,0
Xsg13cmos5l_fill_2_138 VPWR VGND sg13cmos5l_fill_2
* cell instance sg13cmos5l_fill_2_139 r0 *1 0,0
Xsg13cmos5l_fill_2_139 VPWR VGND sg13cmos5l_fill_2
* cell instance sg13cmos5l_fill_2_140 r0 *1 0,0
Xsg13cmos5l_fill_2_140 VPWR VGND sg13cmos5l_fill_2
* cell instance sg13cmos5l_fill_2_141 r0 *1 0,0
Xsg13cmos5l_fill_2_141 VPWR VGND sg13cmos5l_fill_2
* cell instance sg13cmos5l_fill_2_142 r0 *1 0,0
Xsg13cmos5l_fill_2_142 VPWR VGND sg13cmos5l_fill_2
* cell instance sg13cmos5l_fill_2_143 r0 *1 0,0
Xsg13cmos5l_fill_2_143 VPWR VGND sg13cmos5l_fill_2
* cell instance sg13cmos5l_fill_2_144 r0 *1 0,0
Xsg13cmos5l_fill_2_144 VPWR VGND sg13cmos5l_fill_2
* cell instance sg13cmos5l_fill_2_145 r0 *1 0,0
Xsg13cmos5l_fill_2_145 VPWR VGND sg13cmos5l_fill_2
* cell instance sg13cmos5l_fill_2_146 r0 *1 0,0
Xsg13cmos5l_fill_2_146 VPWR VGND sg13cmos5l_fill_2
* cell instance sg13cmos5l_fill_2_147 r0 *1 0,0
Xsg13cmos5l_fill_2_147 VPWR VGND sg13cmos5l_fill_2
* cell instance sg13cmos5l_fill_2_148 r0 *1 0,0
Xsg13cmos5l_fill_2_148 VPWR VGND sg13cmos5l_fill_2
* cell instance sg13cmos5l_fill_2_149 r0 *1 0,0
Xsg13cmos5l_fill_2_149 VPWR VGND sg13cmos5l_fill_2
* cell instance sg13cmos5l_fill_2_150 r0 *1 0,0
Xsg13cmos5l_fill_2_150 VPWR VGND sg13cmos5l_fill_2
* cell instance sg13cmos5l_fill_2_151 r0 *1 0,0
Xsg13cmos5l_fill_2_151 VPWR VGND sg13cmos5l_fill_2
* cell instance sg13cmos5l_fill_2_152 r0 *1 0,0
Xsg13cmos5l_fill_2_152 VPWR VGND sg13cmos5l_fill_2
* cell instance sg13cmos5l_fill_2_153 r0 *1 0,0
Xsg13cmos5l_fill_2_153 VPWR VGND sg13cmos5l_fill_2
* cell instance sg13cmos5l_fill_2_154 r0 *1 0,0
Xsg13cmos5l_fill_2_154 VPWR VGND sg13cmos5l_fill_2
* cell instance sg13cmos5l_fill_2_155 r0 *1 0,0
Xsg13cmos5l_fill_2_155 VPWR VGND sg13cmos5l_fill_2
* cell instance sg13cmos5l_fill_2_156 r0 *1 0,0
Xsg13cmos5l_fill_2_156 VPWR VGND sg13cmos5l_fill_2
* cell instance sg13cmos5l_fill_2_157 r0 *1 0,0
Xsg13cmos5l_fill_2_157 VPWR VGND sg13cmos5l_fill_2
* cell instance sg13cmos5l_fill_2_158 r0 *1 0,0
Xsg13cmos5l_fill_2_158 VPWR VGND sg13cmos5l_fill_2
* cell instance sg13cmos5l_fill_2_159 r0 *1 0,0
Xsg13cmos5l_fill_2_159 VPWR VGND sg13cmos5l_fill_2
* cell instance sg13cmos5l_fill_2_160 r0 *1 0,0
Xsg13cmos5l_fill_2_160 VPWR VGND sg13cmos5l_fill_2
* cell instance sg13cmos5l_fill_2_161 r0 *1 0,0
Xsg13cmos5l_fill_2_161 VPWR VGND sg13cmos5l_fill_2
* cell instance sg13cmos5l_fill_2_162 r0 *1 0,0
Xsg13cmos5l_fill_2_162 VPWR VGND sg13cmos5l_fill_2
* cell instance sg13cmos5l_fill_2_163 r0 *1 0,0
Xsg13cmos5l_fill_2_163 VPWR VGND sg13cmos5l_fill_2
* cell instance sg13cmos5l_fill_2_164 r0 *1 0,0
Xsg13cmos5l_fill_2_164 VPWR VGND sg13cmos5l_fill_2
* cell instance sg13cmos5l_fill_2_165 r0 *1 0,0
Xsg13cmos5l_fill_2_165 VPWR VGND sg13cmos5l_fill_2
* cell instance sg13cmos5l_fill_2_166 r0 *1 0,0
Xsg13cmos5l_fill_2_166 VPWR VGND sg13cmos5l_fill_2
* cell instance sg13cmos5l_fill_2_167 r0 *1 0,0
Xsg13cmos5l_fill_2_167 VPWR VGND sg13cmos5l_fill_2
* cell instance sg13cmos5l_fill_2_168 r0 *1 0,0
Xsg13cmos5l_fill_2_168 VPWR VGND sg13cmos5l_fill_2
* cell instance sg13cmos5l_fill_2_169 r0 *1 0,0
Xsg13cmos5l_fill_2_169 VPWR VGND sg13cmos5l_fill_2
* cell instance sg13cmos5l_fill_2_170 r0 *1 0,0
Xsg13cmos5l_fill_2_170 VPWR VGND sg13cmos5l_fill_2
* cell instance sg13cmos5l_fill_2_171 r0 *1 0,0
Xsg13cmos5l_fill_2_171 VPWR VGND sg13cmos5l_fill_2
* cell instance sg13cmos5l_fill_2_172 r0 *1 0,0
Xsg13cmos5l_fill_2_172 VPWR VGND sg13cmos5l_fill_2
* cell instance sg13cmos5l_fill_2_173 r0 *1 0,0
Xsg13cmos5l_fill_2_173 VPWR VGND sg13cmos5l_fill_2
* cell instance sg13cmos5l_fill_2_174 r0 *1 0,0
Xsg13cmos5l_fill_2_174 VPWR VGND sg13cmos5l_fill_2
* cell instance sg13cmos5l_fill_2_175 r0 *1 0,0
Xsg13cmos5l_fill_2_175 VPWR VGND sg13cmos5l_fill_2
* cell instance sg13cmos5l_fill_2_176 r0 *1 0,0
Xsg13cmos5l_fill_2_176 VPWR VGND sg13cmos5l_fill_2
* cell instance sg13cmos5l_fill_2_177 r0 *1 0,0
Xsg13cmos5l_fill_2_177 VPWR VGND sg13cmos5l_fill_2
* cell instance sg13cmos5l_fill_2_178 r0 *1 0,0
Xsg13cmos5l_fill_2_178 VPWR VGND sg13cmos5l_fill_2
* cell instance sg13cmos5l_fill_2_179 r0 *1 0,0
Xsg13cmos5l_fill_2_179 VPWR VGND sg13cmos5l_fill_2
* cell instance sg13cmos5l_fill_2_180 r0 *1 0,0
Xsg13cmos5l_fill_2_180 VPWR VGND sg13cmos5l_fill_2
* cell instance sg13cmos5l_fill_2_181 r0 *1 0,0
Xsg13cmos5l_fill_2_181 VPWR VGND sg13cmos5l_fill_2
* cell instance sg13cmos5l_fill_2_182 r0 *1 0,0
Xsg13cmos5l_fill_2_182 VPWR VGND sg13cmos5l_fill_2
* cell instance sg13cmos5l_fill_2_183 r0 *1 0,0
Xsg13cmos5l_fill_2_183 VPWR VGND sg13cmos5l_fill_2
* cell instance sg13cmos5l_fill_2_184 r0 *1 0,0
Xsg13cmos5l_fill_2_184 VPWR VGND sg13cmos5l_fill_2
* cell instance sg13cmos5l_fill_2_185 r0 *1 0,0
Xsg13cmos5l_fill_2_185 VPWR VGND sg13cmos5l_fill_2
* cell instance sg13cmos5l_fill_2_186 r0 *1 0,0
Xsg13cmos5l_fill_2_186 VPWR VGND sg13cmos5l_fill_2
* cell instance sg13cmos5l_fill_2_187 r0 *1 0,0
Xsg13cmos5l_fill_2_187 VPWR VGND sg13cmos5l_fill_2
* cell instance sg13cmos5l_fill_2_188 r0 *1 0,0
Xsg13cmos5l_fill_2_188 VPWR VGND sg13cmos5l_fill_2
* cell instance sg13cmos5l_fill_2_189 r0 *1 0,0
Xsg13cmos5l_fill_2_189 VPWR VGND sg13cmos5l_fill_2
* cell instance sg13cmos5l_fill_2_190 r0 *1 0,0
Xsg13cmos5l_fill_2_190 VPWR VGND sg13cmos5l_fill_2
* cell instance sg13cmos5l_fill_2_191 r0 *1 0,0
Xsg13cmos5l_fill_2_191 VPWR VGND sg13cmos5l_fill_2
* cell instance sg13cmos5l_fill_2_192 r0 *1 0,0
Xsg13cmos5l_fill_2_192 VPWR VGND sg13cmos5l_fill_2
* cell instance sg13cmos5l_fill_2_193 r0 *1 0,0
Xsg13cmos5l_fill_2_193 VPWR VGND sg13cmos5l_fill_2
* cell instance sg13cmos5l_fill_2_194 r0 *1 0,0
Xsg13cmos5l_fill_2_194 VPWR VGND sg13cmos5l_fill_2
* cell instance sg13cmos5l_fill_2_195 r0 *1 0,0
Xsg13cmos5l_fill_2_195 VPWR VGND sg13cmos5l_fill_2
* cell instance sg13cmos5l_fill_2_196 r0 *1 0,0
Xsg13cmos5l_fill_2_196 VPWR VGND sg13cmos5l_fill_2
* cell instance sg13cmos5l_fill_2_197 r0 *1 0,0
Xsg13cmos5l_fill_2_197 VPWR VGND sg13cmos5l_fill_2
* cell instance sg13cmos5l_fill_2_198 r0 *1 0,0
Xsg13cmos5l_fill_2_198 VPWR VGND sg13cmos5l_fill_2
* cell instance sg13cmos5l_fill_2_199 r0 *1 0,0
Xsg13cmos5l_fill_2_199 VPWR VGND sg13cmos5l_fill_2
* cell instance sg13cmos5l_fill_2_200 r0 *1 0,0
Xsg13cmos5l_fill_2_200 VPWR VGND sg13cmos5l_fill_2
* cell instance sg13cmos5l_fill_2_201 r0 *1 0,0
Xsg13cmos5l_fill_2_201 VPWR VGND sg13cmos5l_fill_2
* cell instance sg13cmos5l_fill_2_202 r0 *1 0,0
Xsg13cmos5l_fill_2_202 VPWR VGND sg13cmos5l_fill_2
* cell instance sg13cmos5l_fill_2_203 r0 *1 0,0
Xsg13cmos5l_fill_2_203 VPWR VGND sg13cmos5l_fill_2
* cell instance sg13cmos5l_fill_2_204 r0 *1 0,0
Xsg13cmos5l_fill_2_204 VPWR VGND sg13cmos5l_fill_2
* cell instance sg13cmos5l_fill_2_205 r0 *1 0,0
Xsg13cmos5l_fill_2_205 VPWR VGND sg13cmos5l_fill_2
* cell instance sg13cmos5l_fill_2_206 r0 *1 0,0
Xsg13cmos5l_fill_2_206 VPWR VGND sg13cmos5l_fill_2
* cell instance sg13cmos5l_fill_2_207 r0 *1 0,0
Xsg13cmos5l_fill_2_207 VPWR VGND sg13cmos5l_fill_2
* cell instance sg13cmos5l_fill_2_208 r0 *1 0,0
Xsg13cmos5l_fill_2_208 VPWR VGND sg13cmos5l_fill_2
* cell instance sg13cmos5l_fill_2_209 r0 *1 0,0
Xsg13cmos5l_fill_2_209 VPWR VGND sg13cmos5l_fill_2
* cell instance sg13cmos5l_fill_2_210 r0 *1 0,0
Xsg13cmos5l_fill_2_210 VPWR VGND sg13cmos5l_fill_2
* cell instance sg13cmos5l_fill_2_211 r0 *1 0,0
Xsg13cmos5l_fill_2_211 VPWR VGND sg13cmos5l_fill_2
* cell instance sg13cmos5l_fill_2_212 r0 *1 0,0
Xsg13cmos5l_fill_2_212 VPWR VGND sg13cmos5l_fill_2
* cell instance sg13cmos5l_fill_2_213 r0 *1 0,0
Xsg13cmos5l_fill_2_213 VPWR VGND sg13cmos5l_fill_2
* cell instance sg13cmos5l_fill_2_214 r0 *1 0,0
Xsg13cmos5l_fill_2_214 VPWR VGND sg13cmos5l_fill_2
* cell instance sg13cmos5l_fill_2_215 r0 *1 0,0
Xsg13cmos5l_fill_2_215 VPWR VGND sg13cmos5l_fill_2
* cell instance sg13cmos5l_fill_2_216 r0 *1 0,0
Xsg13cmos5l_fill_2_216 VPWR VGND sg13cmos5l_fill_2
* cell instance sg13cmos5l_fill_2_217 r0 *1 0,0
Xsg13cmos5l_fill_2_217 VPWR VGND sg13cmos5l_fill_2
* cell instance sg13cmos5l_fill_2_218 r0 *1 0,0
Xsg13cmos5l_fill_2_218 VPWR VGND sg13cmos5l_fill_2
* cell instance sg13cmos5l_fill_2_219 r0 *1 0,0
Xsg13cmos5l_fill_2_219 VPWR VGND sg13cmos5l_fill_2
* cell instance sg13cmos5l_fill_2_220 r0 *1 0,0
Xsg13cmos5l_fill_2_220 VPWR VGND sg13cmos5l_fill_2
* cell instance sg13cmos5l_fill_2_221 r0 *1 0,0
Xsg13cmos5l_fill_2_221 VPWR VGND sg13cmos5l_fill_2
* cell instance sg13cmos5l_fill_2_222 r0 *1 0,0
Xsg13cmos5l_fill_2_222 VPWR VGND sg13cmos5l_fill_2
* cell instance sg13cmos5l_fill_2_223 r0 *1 0,0
Xsg13cmos5l_fill_2_223 VPWR VGND sg13cmos5l_fill_2
* cell instance sg13cmos5l_fill_2_224 r0 *1 0,0
Xsg13cmos5l_fill_2_224 VPWR VGND sg13cmos5l_fill_2
* cell instance sg13cmos5l_fill_2_225 r0 *1 0,0
Xsg13cmos5l_fill_2_225 VPWR VGND sg13cmos5l_fill_2
* cell instance sg13cmos5l_fill_2_226 r0 *1 0,0
Xsg13cmos5l_fill_2_226 VPWR VGND sg13cmos5l_fill_2
* cell instance sg13cmos5l_fill_2_227 r0 *1 0,0
Xsg13cmos5l_fill_2_227 VPWR VGND sg13cmos5l_fill_2
* cell instance sg13cmos5l_fill_2_228 r0 *1 0,0
Xsg13cmos5l_fill_2_228 VPWR VGND sg13cmos5l_fill_2
* cell instance sg13cmos5l_fill_2_229 r0 *1 0,0
Xsg13cmos5l_fill_2_229 VPWR VGND sg13cmos5l_fill_2
* cell instance sg13cmos5l_fill_2_230 r0 *1 0,0
Xsg13cmos5l_fill_2_230 VPWR VGND sg13cmos5l_fill_2
* cell instance sg13cmos5l_fill_2_231 r0 *1 0,0
Xsg13cmos5l_fill_2_231 VPWR VGND sg13cmos5l_fill_2
* cell instance sg13cmos5l_fill_2_232 r0 *1 0,0
Xsg13cmos5l_fill_2_232 VPWR VGND sg13cmos5l_fill_2
* cell instance sg13cmos5l_fill_2_233 r0 *1 0,0
Xsg13cmos5l_fill_2_233 VPWR VGND sg13cmos5l_fill_2
* cell instance sg13cmos5l_fill_2_234 r0 *1 0,0
Xsg13cmos5l_fill_2_234 VPWR VGND sg13cmos5l_fill_2
* cell instance sg13cmos5l_fill_2_235 r0 *1 0,0
Xsg13cmos5l_fill_2_235 VPWR VGND sg13cmos5l_fill_2
* cell instance sg13cmos5l_fill_2_236 r0 *1 0,0
Xsg13cmos5l_fill_2_236 VPWR VGND sg13cmos5l_fill_2
* cell instance sg13cmos5l_fill_2_237 r0 *1 0,0
Xsg13cmos5l_fill_2_237 VPWR VGND sg13cmos5l_fill_2
* cell instance sg13cmos5l_fill_2_238 r0 *1 0,0
Xsg13cmos5l_fill_2_238 VPWR VGND sg13cmos5l_fill_2
* cell instance sg13cmos5l_fill_2_239 r0 *1 0,0
Xsg13cmos5l_fill_2_239 VPWR VGND sg13cmos5l_fill_2
* cell instance sg13cmos5l_fill_2_240 r0 *1 0,0
Xsg13cmos5l_fill_2_240 VPWR VGND sg13cmos5l_fill_2
* cell instance sg13cmos5l_fill_2_241 r0 *1 0,0
Xsg13cmos5l_fill_2_241 VPWR VGND sg13cmos5l_fill_2
* cell instance sg13cmos5l_fill_2_242 r0 *1 0,0
Xsg13cmos5l_fill_2_242 VPWR VGND sg13cmos5l_fill_2
* cell instance sg13cmos5l_fill_2_243 r0 *1 0,0
Xsg13cmos5l_fill_2_243 VPWR VGND sg13cmos5l_fill_2
* cell instance sg13cmos5l_fill_2_244 r0 *1 0,0
Xsg13cmos5l_fill_2_244 VPWR VGND sg13cmos5l_fill_2
* cell instance sg13cmos5l_fill_2_245 r0 *1 0,0
Xsg13cmos5l_fill_2_245 VPWR VGND sg13cmos5l_fill_2
* cell instance sg13cmos5l_fill_2_246 r0 *1 0,0
Xsg13cmos5l_fill_2_246 VPWR VGND sg13cmos5l_fill_2
* cell instance sg13cmos5l_fill_2_247 r0 *1 0,0
Xsg13cmos5l_fill_2_247 VPWR VGND sg13cmos5l_fill_2
* cell instance sg13cmos5l_fill_2_248 r0 *1 0,0
Xsg13cmos5l_fill_2_248 VPWR VGND sg13cmos5l_fill_2
* cell instance sg13cmos5l_fill_2_249 r0 *1 0,0
Xsg13cmos5l_fill_2_249 VPWR VGND sg13cmos5l_fill_2
* cell instance sg13cmos5l_fill_2_250 r0 *1 0,0
Xsg13cmos5l_fill_2_250 VPWR VGND sg13cmos5l_fill_2
* cell instance sg13cmos5l_fill_2_251 r0 *1 0,0
Xsg13cmos5l_fill_2_251 VPWR VGND sg13cmos5l_fill_2
* cell instance sg13cmos5l_fill_2_252 r0 *1 0,0
Xsg13cmos5l_fill_2_252 VPWR VGND sg13cmos5l_fill_2
* cell instance sg13cmos5l_fill_2_253 r0 *1 0,0
Xsg13cmos5l_fill_2_253 VPWR VGND sg13cmos5l_fill_2
* cell instance sg13cmos5l_fill_2_254 r0 *1 0,0
Xsg13cmos5l_fill_2_254 VPWR VGND sg13cmos5l_fill_2
* cell instance sg13cmos5l_fill_2_255 r0 *1 0,0
Xsg13cmos5l_fill_2_255 VPWR VGND sg13cmos5l_fill_2
* cell instance sg13cmos5l_fill_2_256 r0 *1 0,0
Xsg13cmos5l_fill_2_256 VPWR VGND sg13cmos5l_fill_2
* cell instance sg13cmos5l_fill_2_257 r0 *1 0,0
Xsg13cmos5l_fill_2_257 VPWR VGND sg13cmos5l_fill_2
* cell instance sg13cmos5l_fill_2_258 r0 *1 0,0
Xsg13cmos5l_fill_2_258 VPWR VGND sg13cmos5l_fill_2
* cell instance sg13cmos5l_fill_2_259 r0 *1 0,0
Xsg13cmos5l_fill_2_259 VPWR VGND sg13cmos5l_fill_2
* cell instance sg13cmos5l_fill_2_260 r0 *1 0,0
Xsg13cmos5l_fill_2_260 VPWR VGND sg13cmos5l_fill_2
* cell instance sg13cmos5l_fill_2_261 r0 *1 0,0
Xsg13cmos5l_fill_2_261 VPWR VGND sg13cmos5l_fill_2
* cell instance sg13cmos5l_fill_2_262 r0 *1 0,0
Xsg13cmos5l_fill_2_262 VPWR VGND sg13cmos5l_fill_2
* cell instance sg13cmos5l_fill_2_263 r0 *1 0,0
Xsg13cmos5l_fill_2_263 VPWR VGND sg13cmos5l_fill_2
* cell instance sg13cmos5l_fill_2_264 r0 *1 0,0
Xsg13cmos5l_fill_2_264 VPWR VGND sg13cmos5l_fill_2
* cell instance sg13cmos5l_fill_2_265 r0 *1 0,0
Xsg13cmos5l_fill_2_265 VPWR VGND sg13cmos5l_fill_2
* cell instance sg13cmos5l_fill_2_266 r0 *1 0,0
Xsg13cmos5l_fill_2_266 VPWR VGND sg13cmos5l_fill_2
* cell instance sg13cmos5l_fill_2_267 r0 *1 0,0
Xsg13cmos5l_fill_2_267 VPWR VGND sg13cmos5l_fill_2
* cell instance sg13cmos5l_fill_2_268 r0 *1 0,0
Xsg13cmos5l_fill_2_268 VPWR VGND sg13cmos5l_fill_2
* cell instance sg13cmos5l_fill_2_269 r0 *1 0,0
Xsg13cmos5l_fill_2_269 VPWR VGND sg13cmos5l_fill_2
* cell instance sg13cmos5l_fill_2_270 r0 *1 0,0
Xsg13cmos5l_fill_2_270 VPWR VGND sg13cmos5l_fill_2
* cell instance sg13cmos5l_fill_2_271 r0 *1 0,0
Xsg13cmos5l_fill_2_271 VPWR VGND sg13cmos5l_fill_2
* cell instance sg13cmos5l_fill_2_272 r0 *1 0,0
Xsg13cmos5l_fill_2_272 VPWR VGND sg13cmos5l_fill_2
* cell instance sg13cmos5l_fill_2_273 r0 *1 0,0
Xsg13cmos5l_fill_2_273 VPWR VGND sg13cmos5l_fill_2
* cell instance sg13cmos5l_fill_2_274 r0 *1 0,0
Xsg13cmos5l_fill_2_274 VPWR VGND sg13cmos5l_fill_2
* cell instance sg13cmos5l_fill_2_275 r0 *1 0,0
Xsg13cmos5l_fill_2_275 VPWR VGND sg13cmos5l_fill_2
* cell instance sg13cmos5l_fill_2_276 r0 *1 0,0
Xsg13cmos5l_fill_2_276 VPWR VGND sg13cmos5l_fill_2
* cell instance sg13cmos5l_fill_2_277 r0 *1 0,0
Xsg13cmos5l_fill_2_277 VPWR VGND sg13cmos5l_fill_2
* cell instance sg13cmos5l_fill_2_278 r0 *1 0,0
Xsg13cmos5l_fill_2_278 VPWR VGND sg13cmos5l_fill_2
* cell instance sg13cmos5l_fill_2_279 r0 *1 0,0
Xsg13cmos5l_fill_2_279 VPWR VGND sg13cmos5l_fill_2
* cell instance sg13cmos5l_fill_2_280 r0 *1 0,0
Xsg13cmos5l_fill_2_280 VPWR VGND sg13cmos5l_fill_2
* cell instance sg13cmos5l_fill_2_281 r0 *1 0,0
Xsg13cmos5l_fill_2_281 VPWR VGND sg13cmos5l_fill_2
* cell instance sg13cmos5l_fill_2_282 r0 *1 0,0
Xsg13cmos5l_fill_2_282 VPWR VGND sg13cmos5l_fill_2
* cell instance sg13cmos5l_fill_2_283 r0 *1 0,0
Xsg13cmos5l_fill_2_283 VPWR VGND sg13cmos5l_fill_2
* cell instance sg13cmos5l_fill_2_284 r0 *1 0,0
Xsg13cmos5l_fill_2_284 VPWR VGND sg13cmos5l_fill_2
* cell instance sg13cmos5l_fill_2_285 r0 *1 0,0
Xsg13cmos5l_fill_2_285 VPWR VGND sg13cmos5l_fill_2
* cell instance sg13cmos5l_fill_2_286 r0 *1 0,0
Xsg13cmos5l_fill_2_286 VPWR VGND sg13cmos5l_fill_2
* cell instance sg13cmos5l_fill_2_287 r0 *1 0,0
Xsg13cmos5l_fill_2_287 VPWR VGND sg13cmos5l_fill_2
* cell instance sg13cmos5l_fill_2_288 r0 *1 0,0
Xsg13cmos5l_fill_2_288 VPWR VGND sg13cmos5l_fill_2
* cell instance sg13cmos5l_fill_2_289 r0 *1 0,0
Xsg13cmos5l_fill_2_289 VPWR VGND sg13cmos5l_fill_2
* cell instance sg13cmos5l_fill_2_290 r0 *1 0,0
Xsg13cmos5l_fill_2_290 VPWR VGND sg13cmos5l_fill_2
* cell instance sg13cmos5l_fill_2_291 r0 *1 0,0
Xsg13cmos5l_fill_2_291 VPWR VGND sg13cmos5l_fill_2
* cell instance sg13cmos5l_fill_2_292 r0 *1 0,0
Xsg13cmos5l_fill_2_292 VPWR VGND sg13cmos5l_fill_2
* cell instance sg13cmos5l_fill_2_293 r0 *1 0,0
Xsg13cmos5l_fill_2_293 VPWR VGND sg13cmos5l_fill_2
* cell instance sg13cmos5l_fill_2_294 r0 *1 0,0
Xsg13cmos5l_fill_2_294 VPWR VGND sg13cmos5l_fill_2
* cell instance sg13cmos5l_fill_2_295 r0 *1 0,0
Xsg13cmos5l_fill_2_295 VPWR VGND sg13cmos5l_fill_2
* cell instance sg13cmos5l_fill_2_296 r0 *1 0,0
Xsg13cmos5l_fill_2_296 VPWR VGND sg13cmos5l_fill_2
* cell instance sg13cmos5l_fill_2_297 r0 *1 0,0
Xsg13cmos5l_fill_2_297 VPWR VGND sg13cmos5l_fill_2
* cell instance sg13cmos5l_fill_2_298 r0 *1 0,0
Xsg13cmos5l_fill_2_298 VPWR VGND sg13cmos5l_fill_2
* cell instance sg13cmos5l_fill_2_299 r0 *1 0,0
Xsg13cmos5l_fill_2_299 VPWR VGND sg13cmos5l_fill_2
* cell instance sg13cmos5l_fill_2_300 r0 *1 0,0
Xsg13cmos5l_fill_2_300 VPWR VGND sg13cmos5l_fill_2
* cell instance sg13cmos5l_fill_2_301 r0 *1 0,0
Xsg13cmos5l_fill_2_301 VPWR VGND sg13cmos5l_fill_2
* cell instance sg13cmos5l_fill_2_302 r0 *1 0,0
Xsg13cmos5l_fill_2_302 VPWR VGND sg13cmos5l_fill_2
* cell instance sg13cmos5l_fill_2_303 r0 *1 0,0
Xsg13cmos5l_fill_2_303 VPWR VGND sg13cmos5l_fill_2
* cell instance sg13cmos5l_fill_2_304 r0 *1 0,0
Xsg13cmos5l_fill_2_304 VPWR VGND sg13cmos5l_fill_2
* cell instance sg13cmos5l_fill_2_305 r0 *1 0,0
Xsg13cmos5l_fill_2_305 VPWR VGND sg13cmos5l_fill_2
* cell instance sg13cmos5l_fill_2_306 r0 *1 0,0
Xsg13cmos5l_fill_2_306 VPWR VGND sg13cmos5l_fill_2
* cell instance sg13cmos5l_fill_2_307 r0 *1 0,0
Xsg13cmos5l_fill_2_307 VPWR VGND sg13cmos5l_fill_2
* cell instance sg13cmos5l_fill_2_308 r0 *1 0,0
Xsg13cmos5l_fill_2_308 VPWR VGND sg13cmos5l_fill_2
* cell instance sg13cmos5l_fill_2_309 r0 *1 0,0
Xsg13cmos5l_fill_2_309 VPWR VGND sg13cmos5l_fill_2
* cell instance sg13cmos5l_fill_2_310 r0 *1 0,0
Xsg13cmos5l_fill_2_310 VPWR VGND sg13cmos5l_fill_2
* cell instance sg13cmos5l_fill_2_311 r0 *1 0,0
Xsg13cmos5l_fill_2_311 VPWR VGND sg13cmos5l_fill_2
* cell instance sg13cmos5l_fill_2_312 r0 *1 0,0
Xsg13cmos5l_fill_2_312 VPWR VGND sg13cmos5l_fill_2
* cell instance sg13cmos5l_fill_2_313 r0 *1 0,0
Xsg13cmos5l_fill_2_313 VPWR VGND sg13cmos5l_fill_2
* cell instance sg13cmos5l_fill_2_314 r0 *1 0,0
Xsg13cmos5l_fill_2_314 VPWR VGND sg13cmos5l_fill_2
* cell instance sg13cmos5l_fill_2_315 r0 *1 0,0
Xsg13cmos5l_fill_2_315 VPWR VGND sg13cmos5l_fill_2
* cell instance sg13cmos5l_fill_2_316 r0 *1 0,0
Xsg13cmos5l_fill_2_316 VPWR VGND sg13cmos5l_fill_2
* cell instance sg13cmos5l_fill_2_317 r0 *1 0,0
Xsg13cmos5l_fill_2_317 VPWR VGND sg13cmos5l_fill_2
* cell instance sg13cmos5l_fill_2_318 r0 *1 0,0
Xsg13cmos5l_fill_2_318 VPWR VGND sg13cmos5l_fill_2
* cell instance sg13cmos5l_fill_2_319 r0 *1 0,0
Xsg13cmos5l_fill_2_319 VPWR VGND sg13cmos5l_fill_2
* cell instance sg13cmos5l_fill_2_320 r0 *1 0,0
Xsg13cmos5l_fill_2_320 VPWR VGND sg13cmos5l_fill_2
* cell instance sg13cmos5l_fill_2_321 r0 *1 0,0
Xsg13cmos5l_fill_2_321 VPWR VGND sg13cmos5l_fill_2
* cell instance sg13cmos5l_fill_2_322 r0 *1 0,0
Xsg13cmos5l_fill_2_322 VPWR VGND sg13cmos5l_fill_2
* cell instance sg13cmos5l_fill_2_323 r0 *1 0,0
Xsg13cmos5l_fill_2_323 VPWR VGND sg13cmos5l_fill_2
* cell instance sg13cmos5l_fill_2_324 r0 *1 0,0
Xsg13cmos5l_fill_2_324 VPWR VGND sg13cmos5l_fill_2
* cell instance sg13cmos5l_fill_2_325 r0 *1 0,0
Xsg13cmos5l_fill_2_325 VPWR VGND sg13cmos5l_fill_2
* cell instance sg13cmos5l_fill_2_326 r0 *1 0,0
Xsg13cmos5l_fill_2_326 VPWR VGND sg13cmos5l_fill_2
* cell instance sg13cmos5l_fill_2_327 r0 *1 0,0
Xsg13cmos5l_fill_2_327 VPWR VGND sg13cmos5l_fill_2
* cell instance sg13cmos5l_fill_2_328 r0 *1 0,0
Xsg13cmos5l_fill_2_328 VPWR VGND sg13cmos5l_fill_2
* cell instance sg13cmos5l_fill_2_329 r0 *1 0,0
Xsg13cmos5l_fill_2_329 VPWR VGND sg13cmos5l_fill_2
* cell instance sg13cmos5l_fill_2_330 r0 *1 0,0
Xsg13cmos5l_fill_2_330 VPWR VGND sg13cmos5l_fill_2
* cell instance sg13cmos5l_fill_2_331 r0 *1 0,0
Xsg13cmos5l_fill_2_331 VPWR VGND sg13cmos5l_fill_2
* cell instance sg13cmos5l_fill_2_332 r0 *1 0,0
Xsg13cmos5l_fill_2_332 VPWR VGND sg13cmos5l_fill_2
* cell instance sg13cmos5l_fill_2_333 r0 *1 0,0
Xsg13cmos5l_fill_2_333 VPWR VGND sg13cmos5l_fill_2
* cell instance sg13cmos5l_fill_2_334 r0 *1 0,0
Xsg13cmos5l_fill_2_334 VPWR VGND sg13cmos5l_fill_2
* cell instance sg13cmos5l_fill_2_335 r0 *1 0,0
Xsg13cmos5l_fill_2_335 VPWR VGND sg13cmos5l_fill_2
* cell instance sg13cmos5l_fill_2_336 r0 *1 0,0
Xsg13cmos5l_fill_2_336 VPWR VGND sg13cmos5l_fill_2
* cell instance sg13cmos5l_fill_2_337 r0 *1 0,0
Xsg13cmos5l_fill_2_337 VPWR VGND sg13cmos5l_fill_2
* cell instance sg13cmos5l_fill_2_338 r0 *1 0,0
Xsg13cmos5l_fill_2_338 VPWR VGND sg13cmos5l_fill_2
* cell instance sg13cmos5l_fill_2_339 r0 *1 0,0
Xsg13cmos5l_fill_2_339 VPWR VGND sg13cmos5l_fill_2
* cell instance sg13cmos5l_fill_2_340 r0 *1 0,0
Xsg13cmos5l_fill_2_340 VPWR VGND sg13cmos5l_fill_2
* cell instance sg13cmos5l_fill_2_341 r0 *1 0,0
Xsg13cmos5l_fill_2_341 VPWR VGND sg13cmos5l_fill_2
* cell instance sg13cmos5l_fill_2_342 r0 *1 0,0
Xsg13cmos5l_fill_2_342 VPWR VGND sg13cmos5l_fill_2
* cell instance sg13cmos5l_fill_2_343 r0 *1 0,0
Xsg13cmos5l_fill_2_343 VPWR VGND sg13cmos5l_fill_2
* cell instance sg13cmos5l_fill_2_344 r0 *1 0,0
Xsg13cmos5l_fill_2_344 VPWR VGND sg13cmos5l_fill_2
* cell instance sg13cmos5l_fill_2_345 r0 *1 0,0
Xsg13cmos5l_fill_2_345 VPWR VGND sg13cmos5l_fill_2
* cell instance sg13cmos5l_fill_2_346 r0 *1 0,0
Xsg13cmos5l_fill_2_346 VPWR VGND sg13cmos5l_fill_2
* cell instance sg13cmos5l_fill_2_347 r0 *1 0,0
Xsg13cmos5l_fill_2_347 VPWR VGND sg13cmos5l_fill_2
* cell instance sg13cmos5l_fill_2_348 r0 *1 0,0
Xsg13cmos5l_fill_2_348 VPWR VGND sg13cmos5l_fill_2
* cell instance sg13cmos5l_fill_2_349 r0 *1 0,0
Xsg13cmos5l_fill_2_349 VPWR VGND sg13cmos5l_fill_2
* cell instance sg13cmos5l_fill_2_350 r0 *1 0,0
Xsg13cmos5l_fill_2_350 VPWR VGND sg13cmos5l_fill_2
* cell instance sg13cmos5l_fill_2_351 r0 *1 0,0
Xsg13cmos5l_fill_2_351 VPWR VGND sg13cmos5l_fill_2
* cell instance sg13cmos5l_fill_2_352 r0 *1 0,0
Xsg13cmos5l_fill_2_352 VPWR VGND sg13cmos5l_fill_2
* cell instance sg13cmos5l_fill_2_353 r0 *1 0,0
Xsg13cmos5l_fill_2_353 VPWR VGND sg13cmos5l_fill_2
* cell instance sg13cmos5l_fill_2_354 r0 *1 0,0
Xsg13cmos5l_fill_2_354 VPWR VGND sg13cmos5l_fill_2
* cell instance sg13cmos5l_fill_2_355 r0 *1 0,0
Xsg13cmos5l_fill_2_355 VPWR VGND sg13cmos5l_fill_2
* cell instance sg13cmos5l_fill_2_356 r0 *1 0,0
Xsg13cmos5l_fill_2_356 VPWR VGND sg13cmos5l_fill_2
* cell instance sg13cmos5l_fill_2_357 r0 *1 0,0
Xsg13cmos5l_fill_2_357 VPWR VGND sg13cmos5l_fill_2
* cell instance sg13cmos5l_fill_2_358 r0 *1 0,0
Xsg13cmos5l_fill_2_358 VPWR VGND sg13cmos5l_fill_2
* cell instance sg13cmos5l_fill_2_359 r0 *1 0,0
Xsg13cmos5l_fill_2_359 VPWR VGND sg13cmos5l_fill_2
* cell instance sg13cmos5l_fill_2_360 r0 *1 0,0
Xsg13cmos5l_fill_2_360 VPWR VGND sg13cmos5l_fill_2
* cell instance sg13cmos5l_fill_2_361 r0 *1 0,0
Xsg13cmos5l_fill_2_361 VPWR VGND sg13cmos5l_fill_2
* cell instance sg13cmos5l_fill_2_362 r0 *1 0,0
Xsg13cmos5l_fill_2_362 VPWR VGND sg13cmos5l_fill_2
* cell instance sg13cmos5l_fill_2_363 r0 *1 0,0
Xsg13cmos5l_fill_2_363 VPWR VGND sg13cmos5l_fill_2
* cell instance sg13cmos5l_fill_2_364 r0 *1 0,0
Xsg13cmos5l_fill_2_364 VPWR VGND sg13cmos5l_fill_2
* cell instance sg13cmos5l_fill_2_365 r0 *1 0,0
Xsg13cmos5l_fill_2_365 VPWR VGND sg13cmos5l_fill_2
* cell instance sg13cmos5l_fill_2_366 r0 *1 0,0
Xsg13cmos5l_fill_2_366 VPWR VGND sg13cmos5l_fill_2
* cell instance sg13cmos5l_fill_2_367 r0 *1 0,0
Xsg13cmos5l_fill_2_367 VPWR VGND sg13cmos5l_fill_2
* cell instance sg13cmos5l_fill_2_368 r0 *1 0,0
Xsg13cmos5l_fill_2_368 VPWR VGND sg13cmos5l_fill_2
* cell instance sg13cmos5l_fill_2_369 r0 *1 0,0
Xsg13cmos5l_fill_2_369 VPWR VGND sg13cmos5l_fill_2
* cell instance sg13cmos5l_fill_2_370 r0 *1 0,0
Xsg13cmos5l_fill_2_370 VPWR VGND sg13cmos5l_fill_2
* cell instance sg13cmos5l_fill_2_371 r0 *1 0,0
Xsg13cmos5l_fill_2_371 VPWR VGND sg13cmos5l_fill_2
* cell instance sg13cmos5l_fill_2_372 r0 *1 0,0
Xsg13cmos5l_fill_2_372 VPWR VGND sg13cmos5l_fill_2
* cell instance sg13cmos5l_fill_2_373 r0 *1 0,0
Xsg13cmos5l_fill_2_373 VPWR VGND sg13cmos5l_fill_2
* cell instance sg13cmos5l_fill_2_374 r0 *1 0,0
Xsg13cmos5l_fill_2_374 VPWR VGND sg13cmos5l_fill_2
* cell instance sg13cmos5l_fill_2_375 r0 *1 0,0
Xsg13cmos5l_fill_2_375 VPWR VGND sg13cmos5l_fill_2
* cell instance sg13cmos5l_fill_2_376 r0 *1 0,0
Xsg13cmos5l_fill_2_376 VPWR VGND sg13cmos5l_fill_2
* cell instance sg13cmos5l_fill_2_377 r0 *1 0,0
Xsg13cmos5l_fill_2_377 VPWR VGND sg13cmos5l_fill_2
* cell instance sg13cmos5l_fill_2_378 r0 *1 0,0
Xsg13cmos5l_fill_2_378 VPWR VGND sg13cmos5l_fill_2
* cell instance sg13cmos5l_fill_2_379 r0 *1 0,0
Xsg13cmos5l_fill_2_379 VPWR VGND sg13cmos5l_fill_2
* cell instance sg13cmos5l_fill_2_380 r0 *1 0,0
Xsg13cmos5l_fill_2_380 VPWR VGND sg13cmos5l_fill_2
* cell instance sg13cmos5l_fill_2_381 r0 *1 0,0
Xsg13cmos5l_fill_2_381 VPWR VGND sg13cmos5l_fill_2
* cell instance sg13cmos5l_fill_2_382 r0 *1 0,0
Xsg13cmos5l_fill_2_382 VPWR VGND sg13cmos5l_fill_2
* cell instance sg13cmos5l_fill_2_383 r0 *1 0,0
Xsg13cmos5l_fill_2_383 VPWR VGND sg13cmos5l_fill_2
* cell instance sg13cmos5l_fill_2_384 r0 *1 0,0
Xsg13cmos5l_fill_2_384 VPWR VGND sg13cmos5l_fill_2
* cell instance sg13cmos5l_fill_2_385 r0 *1 0,0
Xsg13cmos5l_fill_2_385 VPWR VGND sg13cmos5l_fill_2
* cell instance sg13cmos5l_fill_2_386 r0 *1 0,0
Xsg13cmos5l_fill_2_386 VPWR VGND sg13cmos5l_fill_2
* cell instance sg13cmos5l_fill_2_387 r0 *1 0,0
Xsg13cmos5l_fill_2_387 VPWR VGND sg13cmos5l_fill_2
* cell instance sg13cmos5l_fill_2_388 r0 *1 0,0
Xsg13cmos5l_fill_2_388 VPWR VGND sg13cmos5l_fill_2
* cell instance sg13cmos5l_fill_2_389 r0 *1 0,0
Xsg13cmos5l_fill_2_389 VPWR VGND sg13cmos5l_fill_2
* cell instance sg13cmos5l_fill_2_390 r0 *1 0,0
Xsg13cmos5l_fill_2_390 VPWR VGND sg13cmos5l_fill_2
* cell instance sg13cmos5l_fill_2_391 r0 *1 0,0
Xsg13cmos5l_fill_2_391 VPWR VGND sg13cmos5l_fill_2
* cell instance sg13cmos5l_fill_2_392 r0 *1 0,0
Xsg13cmos5l_fill_2_392 VPWR VGND sg13cmos5l_fill_2
* cell instance sg13cmos5l_fill_2_393 r0 *1 0,0
Xsg13cmos5l_fill_2_393 VPWR VGND sg13cmos5l_fill_2
* cell instance sg13cmos5l_fill_2_394 r0 *1 0,0
Xsg13cmos5l_fill_2_394 VPWR VGND sg13cmos5l_fill_2
* cell instance sg13cmos5l_fill_2_395 r0 *1 0,0
Xsg13cmos5l_fill_2_395 VPWR VGND sg13cmos5l_fill_2
* cell instance sg13cmos5l_fill_2_396 r0 *1 0,0
Xsg13cmos5l_fill_2_396 VPWR VGND sg13cmos5l_fill_2
* cell instance sg13cmos5l_fill_2_397 r0 *1 0,0
Xsg13cmos5l_fill_2_397 VPWR VGND sg13cmos5l_fill_2
* cell instance sg13cmos5l_fill_2_398 r0 *1 0,0
Xsg13cmos5l_fill_2_398 VPWR VGND sg13cmos5l_fill_2
* cell instance sg13cmos5l_fill_2_399 r0 *1 0,0
Xsg13cmos5l_fill_2_399 VPWR VGND sg13cmos5l_fill_2
* cell instance sg13cmos5l_fill_2_400 r0 *1 0,0
Xsg13cmos5l_fill_2_400 VPWR VGND sg13cmos5l_fill_2
* cell instance sg13cmos5l_fill_2_401 r0 *1 0,0
Xsg13cmos5l_fill_2_401 VPWR VGND sg13cmos5l_fill_2
* cell instance sg13cmos5l_fill_2_402 r0 *1 0,0
Xsg13cmos5l_fill_2_402 VPWR VGND sg13cmos5l_fill_2
* cell instance sg13cmos5l_fill_2_403 r0 *1 0,0
Xsg13cmos5l_fill_2_403 VPWR VGND sg13cmos5l_fill_2
* cell instance sg13cmos5l_fill_2_404 r0 *1 0,0
Xsg13cmos5l_fill_2_404 VPWR VGND sg13cmos5l_fill_2
* cell instance sg13cmos5l_fill_2_405 r0 *1 0,0
Xsg13cmos5l_fill_2_405 VPWR VGND sg13cmos5l_fill_2
* cell instance sg13cmos5l_fill_2_406 r0 *1 0,0
Xsg13cmos5l_fill_2_406 VPWR VGND sg13cmos5l_fill_2
* cell instance sg13cmos5l_fill_2_407 r0 *1 0,0
Xsg13cmos5l_fill_2_407 VPWR VGND sg13cmos5l_fill_2
* cell instance sg13cmos5l_fill_2_408 r0 *1 0,0
Xsg13cmos5l_fill_2_408 VPWR VGND sg13cmos5l_fill_2
* cell instance sg13cmos5l_fill_2_409 r0 *1 0,0
Xsg13cmos5l_fill_2_409 VPWR VGND sg13cmos5l_fill_2
* cell instance sg13cmos5l_fill_2_410 r0 *1 0,0
Xsg13cmos5l_fill_2_410 VPWR VGND sg13cmos5l_fill_2
* cell instance sg13cmos5l_fill_2_411 r0 *1 0,0
Xsg13cmos5l_fill_2_411 VPWR VGND sg13cmos5l_fill_2
* cell instance sg13cmos5l_fill_2_412 r0 *1 0,0
Xsg13cmos5l_fill_2_412 VPWR VGND sg13cmos5l_fill_2
* cell instance sg13cmos5l_fill_2_413 r0 *1 0,0
Xsg13cmos5l_fill_2_413 VPWR VGND sg13cmos5l_fill_2
* cell instance sg13cmos5l_fill_2_414 r0 *1 0,0
Xsg13cmos5l_fill_2_414 VPWR VGND sg13cmos5l_fill_2
* cell instance sg13cmos5l_fill_2_415 r0 *1 0,0
Xsg13cmos5l_fill_2_415 VPWR VGND sg13cmos5l_fill_2
* cell instance sg13cmos5l_fill_2_416 r0 *1 0,0
Xsg13cmos5l_fill_2_416 VPWR VGND sg13cmos5l_fill_2
* cell instance sg13cmos5l_fill_2_417 r0 *1 0,0
Xsg13cmos5l_fill_2_417 VPWR VGND sg13cmos5l_fill_2
* cell instance sg13cmos5l_fill_2_418 r0 *1 0,0
Xsg13cmos5l_fill_2_418 VPWR VGND sg13cmos5l_fill_2
* cell instance sg13cmos5l_fill_2_419 r0 *1 0,0
Xsg13cmos5l_fill_2_419 VPWR VGND sg13cmos5l_fill_2
* cell instance sg13cmos5l_fill_2_420 r0 *1 0,0
Xsg13cmos5l_fill_2_420 VPWR VGND sg13cmos5l_fill_2
* cell instance sg13cmos5l_fill_2_421 r0 *1 0,0
Xsg13cmos5l_fill_2_421 VPWR VGND sg13cmos5l_fill_2
* cell instance sg13cmos5l_fill_2_422 r0 *1 0,0
Xsg13cmos5l_fill_2_422 VPWR VGND sg13cmos5l_fill_2
* cell instance sg13cmos5l_fill_2_423 r0 *1 0,0
Xsg13cmos5l_fill_2_423 VPWR VGND sg13cmos5l_fill_2
* cell instance sg13cmos5l_fill_2_424 r0 *1 0,0
Xsg13cmos5l_fill_2_424 VPWR VGND sg13cmos5l_fill_2
* cell instance sg13cmos5l_fill_2_425 r0 *1 0,0
Xsg13cmos5l_fill_2_425 VPWR VGND sg13cmos5l_fill_2
* cell instance sg13cmos5l_fill_2_426 r0 *1 0,0
Xsg13cmos5l_fill_2_426 VPWR VGND sg13cmos5l_fill_2
* cell instance sg13cmos5l_fill_2_427 r0 *1 0,0
Xsg13cmos5l_fill_2_427 VPWR VGND sg13cmos5l_fill_2
* cell instance sg13cmos5l_fill_2_428 r0 *1 0,0
Xsg13cmos5l_fill_2_428 VPWR VGND sg13cmos5l_fill_2
* cell instance sg13cmos5l_fill_2_429 r0 *1 0,0
Xsg13cmos5l_fill_2_429 VPWR VGND sg13cmos5l_fill_2
* cell instance sg13cmos5l_fill_2_430 r0 *1 0,0
Xsg13cmos5l_fill_2_430 VPWR VGND sg13cmos5l_fill_2
* cell instance sg13cmos5l_fill_2_431 r0 *1 0,0
Xsg13cmos5l_fill_2_431 VPWR VGND sg13cmos5l_fill_2
* cell instance sg13cmos5l_fill_2_432 r0 *1 0,0
Xsg13cmos5l_fill_2_432 VPWR VGND sg13cmos5l_fill_2
* cell instance sg13cmos5l_fill_2_433 r0 *1 0,0
Xsg13cmos5l_fill_2_433 VPWR VGND sg13cmos5l_fill_2
* cell instance sg13cmos5l_fill_2_434 r0 *1 0,0
Xsg13cmos5l_fill_2_434 VPWR VGND sg13cmos5l_fill_2
* cell instance sg13cmos5l_fill_2_435 r0 *1 0,0
Xsg13cmos5l_fill_2_435 VPWR VGND sg13cmos5l_fill_2
* cell instance sg13cmos5l_fill_2_436 r0 *1 0,0
Xsg13cmos5l_fill_2_436 VPWR VGND sg13cmos5l_fill_2
* cell instance sg13cmos5l_fill_2_437 r0 *1 0,0
Xsg13cmos5l_fill_2_437 VPWR VGND sg13cmos5l_fill_2
* cell instance sg13cmos5l_fill_2_438 r0 *1 0,0
Xsg13cmos5l_fill_2_438 VPWR VGND sg13cmos5l_fill_2
* cell instance sg13cmos5l_fill_2_439 r0 *1 0,0
Xsg13cmos5l_fill_2_439 VPWR VGND sg13cmos5l_fill_2
* cell instance sg13cmos5l_fill_2_440 r0 *1 0,0
Xsg13cmos5l_fill_2_440 VPWR VGND sg13cmos5l_fill_2
* cell instance sg13cmos5l_fill_2_441 r0 *1 0,0
Xsg13cmos5l_fill_2_441 VPWR VGND sg13cmos5l_fill_2
* cell instance sg13cmos5l_fill_2_442 r0 *1 0,0
Xsg13cmos5l_fill_2_442 VPWR VGND sg13cmos5l_fill_2
* cell instance sg13cmos5l_fill_2_443 r0 *1 0,0
Xsg13cmos5l_fill_2_443 VPWR VGND sg13cmos5l_fill_2
* cell instance sg13cmos5l_fill_2_444 r0 *1 0,0
Xsg13cmos5l_fill_2_444 VPWR VGND sg13cmos5l_fill_2
* cell instance sg13cmos5l_fill_2_445 r0 *1 0,0
Xsg13cmos5l_fill_2_445 VPWR VGND sg13cmos5l_fill_2
* cell instance sg13cmos5l_fill_2_446 r0 *1 0,0
Xsg13cmos5l_fill_2_446 VPWR VGND sg13cmos5l_fill_2
* cell instance sg13cmos5l_fill_2_447 r0 *1 0,0
Xsg13cmos5l_fill_2_447 VPWR VGND sg13cmos5l_fill_2
* cell instance sg13cmos5l_fill_2_448 r0 *1 0,0
Xsg13cmos5l_fill_2_448 VPWR VGND sg13cmos5l_fill_2
* cell instance sg13cmos5l_fill_2_449 r0 *1 0,0
Xsg13cmos5l_fill_2_449 VPWR VGND sg13cmos5l_fill_2
* cell instance sg13cmos5l_fill_2_450 r0 *1 0,0
Xsg13cmos5l_fill_2_450 VPWR VGND sg13cmos5l_fill_2
* cell instance sg13cmos5l_fill_2_451 r0 *1 0,0
Xsg13cmos5l_fill_2_451 VPWR VGND sg13cmos5l_fill_2
* cell instance sg13cmos5l_fill_2_452 r0 *1 0,0
Xsg13cmos5l_fill_2_452 VPWR VGND sg13cmos5l_fill_2
* cell instance sg13cmos5l_fill_2_453 r0 *1 0,0
Xsg13cmos5l_fill_2_453 VPWR VGND sg13cmos5l_fill_2
* cell instance sg13cmos5l_fill_2_454 r0 *1 0,0
Xsg13cmos5l_fill_2_454 VPWR VGND sg13cmos5l_fill_2
* cell instance sg13cmos5l_fill_2_455 r0 *1 0,0
Xsg13cmos5l_fill_2_455 VPWR VGND sg13cmos5l_fill_2
* cell instance sg13cmos5l_fill_2_456 r0 *1 0,0
Xsg13cmos5l_fill_2_456 VPWR VGND sg13cmos5l_fill_2
* cell instance sg13cmos5l_fill_2_457 r0 *1 0,0
Xsg13cmos5l_fill_2_457 VPWR VGND sg13cmos5l_fill_2
* cell instance sg13cmos5l_fill_2_458 r0 *1 0,0
Xsg13cmos5l_fill_2_458 VPWR VGND sg13cmos5l_fill_2
* cell instance sg13cmos5l_fill_2_459 r0 *1 0,0
Xsg13cmos5l_fill_2_459 VPWR VGND sg13cmos5l_fill_2
* cell instance sg13cmos5l_fill_2_460 r0 *1 0,0
Xsg13cmos5l_fill_2_460 VPWR VGND sg13cmos5l_fill_2
* cell instance sg13cmos5l_fill_2_461 r0 *1 0,0
Xsg13cmos5l_fill_2_461 VPWR VGND sg13cmos5l_fill_2
* cell instance sg13cmos5l_fill_2_462 r0 *1 0,0
Xsg13cmos5l_fill_2_462 VPWR VGND sg13cmos5l_fill_2
* cell instance sg13cmos5l_fill_2_463 r0 *1 0,0
Xsg13cmos5l_fill_2_463 VPWR VGND sg13cmos5l_fill_2
* cell instance sg13cmos5l_fill_2_464 r0 *1 0,0
Xsg13cmos5l_fill_2_464 VPWR VGND sg13cmos5l_fill_2
* cell instance sg13cmos5l_fill_2_465 r0 *1 0,0
Xsg13cmos5l_fill_2_465 VPWR VGND sg13cmos5l_fill_2
* cell instance sg13cmos5l_fill_2_466 r0 *1 0,0
Xsg13cmos5l_fill_2_466 VPWR VGND sg13cmos5l_fill_2
* cell instance sg13cmos5l_fill_2_467 r0 *1 0,0
Xsg13cmos5l_fill_2_467 VPWR VGND sg13cmos5l_fill_2
* cell instance sg13cmos5l_fill_2_468 r0 *1 0,0
Xsg13cmos5l_fill_2_468 VPWR VGND sg13cmos5l_fill_2
* cell instance sg13cmos5l_fill_2_469 r0 *1 0,0
Xsg13cmos5l_fill_2_469 VPWR VGND sg13cmos5l_fill_2
* cell instance sg13cmos5l_fill_2_470 r0 *1 0,0
Xsg13cmos5l_fill_2_470 VPWR VGND sg13cmos5l_fill_2
* cell instance sg13cmos5l_fill_2_471 r0 *1 0,0
Xsg13cmos5l_fill_2_471 VPWR VGND sg13cmos5l_fill_2
* cell instance sg13cmos5l_fill_2_472 r0 *1 0,0
Xsg13cmos5l_fill_2_472 VPWR VGND sg13cmos5l_fill_2
* cell instance sg13cmos5l_fill_2_473 r0 *1 0,0
Xsg13cmos5l_fill_2_473 VPWR VGND sg13cmos5l_fill_2
* cell instance sg13cmos5l_fill_2_474 r0 *1 0,0
Xsg13cmos5l_fill_2_474 VPWR VGND sg13cmos5l_fill_2
* cell instance sg13cmos5l_fill_2_475 r0 *1 0,0
Xsg13cmos5l_fill_2_475 VPWR VGND sg13cmos5l_fill_2
* cell instance sg13cmos5l_fill_2_476 r0 *1 0,0
Xsg13cmos5l_fill_2_476 VPWR VGND sg13cmos5l_fill_2
* cell instance sg13cmos5l_fill_2_477 r0 *1 0,0
Xsg13cmos5l_fill_2_477 VPWR VGND sg13cmos5l_fill_2
* cell instance sg13cmos5l_fill_2_478 r0 *1 0,0
Xsg13cmos5l_fill_2_478 VPWR VGND sg13cmos5l_fill_2
* cell instance sg13cmos5l_fill_2_479 r0 *1 0,0
Xsg13cmos5l_fill_2_479 VPWR VGND sg13cmos5l_fill_2
* cell instance sg13cmos5l_fill_2_480 r0 *1 0,0
Xsg13cmos5l_fill_2_480 VPWR VGND sg13cmos5l_fill_2
* cell instance sg13cmos5l_fill_2_481 r0 *1 0,0
Xsg13cmos5l_fill_2_481 VPWR VGND sg13cmos5l_fill_2
* cell instance sg13cmos5l_fill_2_482 r0 *1 0,0
Xsg13cmos5l_fill_2_482 VPWR VGND sg13cmos5l_fill_2
* cell instance sg13cmos5l_fill_2_483 r0 *1 0,0
Xsg13cmos5l_fill_2_483 VPWR VGND sg13cmos5l_fill_2
* cell instance sg13cmos5l_fill_2_484 r0 *1 0,0
Xsg13cmos5l_fill_2_484 VPWR VGND sg13cmos5l_fill_2
* cell instance sg13cmos5l_fill_2_485 r0 *1 0,0
Xsg13cmos5l_fill_2_485 VPWR VGND sg13cmos5l_fill_2
* cell instance sg13cmos5l_fill_2_486 r0 *1 0,0
Xsg13cmos5l_fill_2_486 VPWR VGND sg13cmos5l_fill_2
* cell instance sg13cmos5l_fill_2_487 r0 *1 0,0
Xsg13cmos5l_fill_2_487 VPWR VGND sg13cmos5l_fill_2
* cell instance sg13cmos5l_fill_2_488 r0 *1 0,0
Xsg13cmos5l_fill_2_488 VPWR VGND sg13cmos5l_fill_2
* cell instance sg13cmos5l_fill_2_489 r0 *1 0,0
Xsg13cmos5l_fill_2_489 VPWR VGND sg13cmos5l_fill_2
* cell instance sg13cmos5l_fill_2_490 r0 *1 0,0
Xsg13cmos5l_fill_2_490 VPWR VGND sg13cmos5l_fill_2
* cell instance sg13cmos5l_fill_2_491 r0 *1 0,0
Xsg13cmos5l_fill_2_491 VPWR VGND sg13cmos5l_fill_2
* cell instance sg13cmos5l_fill_2_492 r0 *1 0,0
Xsg13cmos5l_fill_2_492 VPWR VGND sg13cmos5l_fill_2
* cell instance sg13cmos5l_fill_2_493 r0 *1 0,0
Xsg13cmos5l_fill_2_493 VPWR VGND sg13cmos5l_fill_2
* cell instance sg13cmos5l_fill_2_494 r0 *1 0,0
Xsg13cmos5l_fill_2_494 VPWR VGND sg13cmos5l_fill_2
* cell instance sg13cmos5l_fill_2_495 r0 *1 0,0
Xsg13cmos5l_fill_2_495 VPWR VGND sg13cmos5l_fill_2
* cell instance sg13cmos5l_fill_2_496 r0 *1 0,0
Xsg13cmos5l_fill_2_496 VPWR VGND sg13cmos5l_fill_2
* cell instance sg13cmos5l_fill_2_497 r0 *1 0,0
Xsg13cmos5l_fill_2_497 VPWR VGND sg13cmos5l_fill_2
* cell instance sg13cmos5l_fill_2_498 r0 *1 0,0
Xsg13cmos5l_fill_2_498 VPWR VGND sg13cmos5l_fill_2
* cell instance sg13cmos5l_fill_2_499 r0 *1 0,0
Xsg13cmos5l_fill_2_499 VPWR VGND sg13cmos5l_fill_2
* cell instance sg13cmos5l_fill_2_500 r0 *1 0,0
Xsg13cmos5l_fill_2_500 VPWR VGND sg13cmos5l_fill_2
* cell instance sg13cmos5l_fill_2_501 r0 *1 0,0
Xsg13cmos5l_fill_2_501 VPWR VGND sg13cmos5l_fill_2
* cell instance sg13cmos5l_fill_2_502 r0 *1 0,0
Xsg13cmos5l_fill_2_502 VPWR VGND sg13cmos5l_fill_2
* cell instance sg13cmos5l_fill_2_503 r0 *1 0,0
Xsg13cmos5l_fill_2_503 VPWR VGND sg13cmos5l_fill_2
* cell instance sg13cmos5l_fill_2_504 r0 *1 0,0
Xsg13cmos5l_fill_2_504 VPWR VGND sg13cmos5l_fill_2
* cell instance sg13cmos5l_fill_2_505 r0 *1 0,0
Xsg13cmos5l_fill_2_505 VPWR VGND sg13cmos5l_fill_2
* cell instance sg13cmos5l_fill_2_506 r0 *1 0,0
Xsg13cmos5l_fill_2_506 VPWR VGND sg13cmos5l_fill_2
* cell instance sg13cmos5l_fill_2_507 r0 *1 0,0
Xsg13cmos5l_fill_2_507 VPWR VGND sg13cmos5l_fill_2
* cell instance sg13cmos5l_fill_2_508 r0 *1 0,0
Xsg13cmos5l_fill_2_508 VPWR VGND sg13cmos5l_fill_2
* cell instance sg13cmos5l_fill_2_509 r0 *1 0,0
Xsg13cmos5l_fill_2_509 VPWR VGND sg13cmos5l_fill_2
* cell instance sg13cmos5l_fill_2_510 r0 *1 0,0
Xsg13cmos5l_fill_2_510 VPWR VGND sg13cmos5l_fill_2
* cell instance sg13cmos5l_fill_2_511 r0 *1 0,0
Xsg13cmos5l_fill_2_511 VPWR VGND sg13cmos5l_fill_2
* cell instance sg13cmos5l_fill_2_512 r0 *1 0,0
Xsg13cmos5l_fill_2_512 VPWR VGND sg13cmos5l_fill_2
* cell instance sg13cmos5l_fill_2_513 r0 *1 0,0
Xsg13cmos5l_fill_2_513 VPWR VGND sg13cmos5l_fill_2
* cell instance sg13cmos5l_fill_2_514 r0 *1 0,0
Xsg13cmos5l_fill_2_514 VPWR VGND sg13cmos5l_fill_2
* cell instance sg13cmos5l_fill_2_515 r0 *1 0,0
Xsg13cmos5l_fill_2_515 VPWR VGND sg13cmos5l_fill_2
* cell instance sg13cmos5l_fill_2_516 r0 *1 0,0
Xsg13cmos5l_fill_2_516 VPWR VGND sg13cmos5l_fill_2
* cell instance sg13cmos5l_fill_2_517 r0 *1 0,0
Xsg13cmos5l_fill_2_517 VPWR VGND sg13cmos5l_fill_2
* cell instance sg13cmos5l_fill_2_518 r0 *1 0,0
Xsg13cmos5l_fill_2_518 VPWR VGND sg13cmos5l_fill_2
* cell instance sg13cmos5l_fill_2_519 r0 *1 0,0
Xsg13cmos5l_fill_2_519 VPWR VGND sg13cmos5l_fill_2
* cell instance sg13cmos5l_fill_2_520 r0 *1 0,0
Xsg13cmos5l_fill_2_520 VPWR VGND sg13cmos5l_fill_2
* cell instance sg13cmos5l_fill_2_521 r0 *1 0,0
Xsg13cmos5l_fill_2_521 VPWR VGND sg13cmos5l_fill_2
* cell instance sg13cmos5l_fill_2_522 r0 *1 0,0
Xsg13cmos5l_fill_2_522 VPWR VGND sg13cmos5l_fill_2
* cell instance sg13cmos5l_fill_2_523 r0 *1 0,0
Xsg13cmos5l_fill_2_523 VPWR VGND sg13cmos5l_fill_2
* cell instance sg13cmos5l_fill_2_524 r0 *1 0,0
Xsg13cmos5l_fill_2_524 VPWR VGND sg13cmos5l_fill_2
* cell instance sg13cmos5l_fill_2_525 r0 *1 0,0
Xsg13cmos5l_fill_2_525 VPWR VGND sg13cmos5l_fill_2
* cell instance sg13cmos5l_fill_2_526 r0 *1 0,0
Xsg13cmos5l_fill_2_526 VPWR VGND sg13cmos5l_fill_2
* cell instance sg13cmos5l_fill_2_527 r0 *1 0,0
Xsg13cmos5l_fill_2_527 VPWR VGND sg13cmos5l_fill_2
* cell instance sg13cmos5l_fill_2_528 r0 *1 0,0
Xsg13cmos5l_fill_2_528 VPWR VGND sg13cmos5l_fill_2
* cell instance sg13cmos5l_fill_2_529 r0 *1 0,0
Xsg13cmos5l_fill_2_529 VPWR VGND sg13cmos5l_fill_2
* cell instance sg13cmos5l_fill_2_530 r0 *1 0,0
Xsg13cmos5l_fill_2_530 VPWR VGND sg13cmos5l_fill_2
* cell instance sg13cmos5l_fill_2_531 r0 *1 0,0
Xsg13cmos5l_fill_2_531 VPWR VGND sg13cmos5l_fill_2
* cell instance sg13cmos5l_fill_2_532 r0 *1 0,0
Xsg13cmos5l_fill_2_532 VPWR VGND sg13cmos5l_fill_2
* cell instance sg13cmos5l_fill_2_533 r0 *1 0,0
Xsg13cmos5l_fill_2_533 VPWR VGND sg13cmos5l_fill_2
* cell instance sg13cmos5l_fill_2_534 r0 *1 0,0
Xsg13cmos5l_fill_2_534 VPWR VGND sg13cmos5l_fill_2
* cell instance sg13cmos5l_fill_2_535 r0 *1 0,0
Xsg13cmos5l_fill_2_535 VPWR VGND sg13cmos5l_fill_2
* cell instance sg13cmos5l_fill_2_536 r0 *1 0,0
Xsg13cmos5l_fill_2_536 VPWR VGND sg13cmos5l_fill_2
* cell instance sg13cmos5l_fill_2_537 r0 *1 0,0
Xsg13cmos5l_fill_2_537 VPWR VGND sg13cmos5l_fill_2
* cell instance sg13cmos5l_fill_2_538 r0 *1 0,0
Xsg13cmos5l_fill_2_538 VPWR VGND sg13cmos5l_fill_2
* cell instance sg13cmos5l_fill_2_539 r0 *1 0,0
Xsg13cmos5l_fill_2_539 VPWR VGND sg13cmos5l_fill_2
* cell instance sg13cmos5l_fill_2_540 r0 *1 0,0
Xsg13cmos5l_fill_2_540 VPWR VGND sg13cmos5l_fill_2
* cell instance sg13cmos5l_fill_2_541 r0 *1 0,0
Xsg13cmos5l_fill_2_541 VPWR VGND sg13cmos5l_fill_2
* cell instance sg13cmos5l_fill_2_542 r0 *1 0,0
Xsg13cmos5l_fill_2_542 VPWR VGND sg13cmos5l_fill_2
* cell instance sg13cmos5l_fill_2_543 r0 *1 0,0
Xsg13cmos5l_fill_2_543 VPWR VGND sg13cmos5l_fill_2
* cell instance sg13cmos5l_fill_2_544 r0 *1 0,0
Xsg13cmos5l_fill_2_544 VPWR VGND sg13cmos5l_fill_2
* cell instance sg13cmos5l_fill_2_545 r0 *1 0,0
Xsg13cmos5l_fill_2_545 VPWR VGND sg13cmos5l_fill_2
* cell instance sg13cmos5l_fill_2_546 r0 *1 0,0
Xsg13cmos5l_fill_2_546 VPWR VGND sg13cmos5l_fill_2
* cell instance sg13cmos5l_fill_2_547 r0 *1 0,0
Xsg13cmos5l_fill_2_547 VPWR VGND sg13cmos5l_fill_2
* cell instance sg13cmos5l_fill_2_548 r0 *1 0,0
Xsg13cmos5l_fill_2_548 VPWR VGND sg13cmos5l_fill_2
* cell instance sg13cmos5l_fill_2_549 r0 *1 0,0
Xsg13cmos5l_fill_2_549 VPWR VGND sg13cmos5l_fill_2
* cell instance sg13cmos5l_fill_2_550 r0 *1 0,0
Xsg13cmos5l_fill_2_550 VPWR VGND sg13cmos5l_fill_2
* cell instance sg13cmos5l_fill_2_551 r0 *1 0,0
Xsg13cmos5l_fill_2_551 VPWR VGND sg13cmos5l_fill_2
* cell instance sg13cmos5l_fill_2_552 r0 *1 0,0
Xsg13cmos5l_fill_2_552 VPWR VGND sg13cmos5l_fill_2
* cell instance sg13cmos5l_fill_2_553 r0 *1 0,0
Xsg13cmos5l_fill_2_553 VPWR VGND sg13cmos5l_fill_2
* cell instance sg13cmos5l_fill_2_554 r0 *1 0,0
Xsg13cmos5l_fill_2_554 VPWR VGND sg13cmos5l_fill_2
* cell instance sg13cmos5l_fill_2_555 r0 *1 0,0
Xsg13cmos5l_fill_2_555 VPWR VGND sg13cmos5l_fill_2
* cell instance sg13cmos5l_fill_2_556 r0 *1 0,0
Xsg13cmos5l_fill_2_556 VPWR VGND sg13cmos5l_fill_2
* cell instance sg13cmos5l_fill_2_557 r0 *1 0,0
Xsg13cmos5l_fill_2_557 VPWR VGND sg13cmos5l_fill_2
* cell instance sg13cmos5l_fill_2_558 r0 *1 0,0
Xsg13cmos5l_fill_2_558 VPWR VGND sg13cmos5l_fill_2
* cell instance sg13cmos5l_fill_2_559 r0 *1 0,0
Xsg13cmos5l_fill_2_559 VPWR VGND sg13cmos5l_fill_2
* cell instance sg13cmos5l_fill_2_560 r0 *1 0,0
Xsg13cmos5l_fill_2_560 VPWR VGND sg13cmos5l_fill_2
* cell instance sg13cmos5l_fill_2_561 r0 *1 0,0
Xsg13cmos5l_fill_2_561 VPWR VGND sg13cmos5l_fill_2
* cell instance sg13cmos5l_fill_2_562 r0 *1 0,0
Xsg13cmos5l_fill_2_562 VPWR VGND sg13cmos5l_fill_2
* cell instance sg13cmos5l_fill_2_563 r0 *1 0,0
Xsg13cmos5l_fill_2_563 VPWR VGND sg13cmos5l_fill_2
* cell instance sg13cmos5l_fill_2_564 r0 *1 0,0
Xsg13cmos5l_fill_2_564 VPWR VGND sg13cmos5l_fill_2
* cell instance sg13cmos5l_fill_2_565 r0 *1 0,0
Xsg13cmos5l_fill_2_565 VPWR VGND sg13cmos5l_fill_2
* cell instance sg13cmos5l_fill_2_566 r0 *1 0,0
Xsg13cmos5l_fill_2_566 VPWR VGND sg13cmos5l_fill_2
* cell instance sg13cmos5l_fill_2_567 r0 *1 0,0
Xsg13cmos5l_fill_2_567 VPWR VGND sg13cmos5l_fill_2
* cell instance sg13cmos5l_fill_2_568 r0 *1 0,0
Xsg13cmos5l_fill_2_568 VPWR VGND sg13cmos5l_fill_2
* cell instance sg13cmos5l_fill_2_569 r0 *1 0,0
Xsg13cmos5l_fill_2_569 VPWR VGND sg13cmos5l_fill_2
* cell instance sg13cmos5l_fill_2_570 r0 *1 0,0
Xsg13cmos5l_fill_2_570 VPWR VGND sg13cmos5l_fill_2
* cell instance sg13cmos5l_fill_2_571 r0 *1 0,0
Xsg13cmos5l_fill_2_571 VPWR VGND sg13cmos5l_fill_2
* cell instance sg13cmos5l_fill_2_572 r0 *1 0,0
Xsg13cmos5l_fill_2_572 VPWR VGND sg13cmos5l_fill_2
* cell instance sg13cmos5l_fill_2_573 r0 *1 0,0
Xsg13cmos5l_fill_2_573 VPWR VGND sg13cmos5l_fill_2
* cell instance sg13cmos5l_fill_2_574 r0 *1 0,0
Xsg13cmos5l_fill_2_574 VPWR VGND sg13cmos5l_fill_2
* cell instance sg13cmos5l_fill_2_575 r0 *1 0,0
Xsg13cmos5l_fill_2_575 VPWR VGND sg13cmos5l_fill_2
* cell instance sg13cmos5l_fill_2_576 r0 *1 0,0
Xsg13cmos5l_fill_2_576 VPWR VGND sg13cmos5l_fill_2
* cell instance sg13cmos5l_fill_2_577 r0 *1 0,0
Xsg13cmos5l_fill_2_577 VPWR VGND sg13cmos5l_fill_2
* cell instance sg13cmos5l_fill_2_578 r0 *1 0,0
Xsg13cmos5l_fill_2_578 VPWR VGND sg13cmos5l_fill_2
* cell instance sg13cmos5l_fill_2_579 r0 *1 0,0
Xsg13cmos5l_fill_2_579 VPWR VGND sg13cmos5l_fill_2
* cell instance sg13cmos5l_fill_2_580 r0 *1 0,0
Xsg13cmos5l_fill_2_580 VPWR VGND sg13cmos5l_fill_2
* cell instance sg13cmos5l_fill_2_581 r0 *1 0,0
Xsg13cmos5l_fill_2_581 VPWR VGND sg13cmos5l_fill_2
* cell instance sg13cmos5l_fill_2_582 r0 *1 0,0
Xsg13cmos5l_fill_2_582 VPWR VGND sg13cmos5l_fill_2
* cell instance sg13cmos5l_fill_2_583 r0 *1 0,0
Xsg13cmos5l_fill_2_583 VPWR VGND sg13cmos5l_fill_2
* cell instance sg13cmos5l_fill_2_584 r0 *1 0,0
Xsg13cmos5l_fill_2_584 VPWR VGND sg13cmos5l_fill_2
* cell instance sg13cmos5l_fill_2_585 r0 *1 0,0
Xsg13cmos5l_fill_2_585 VPWR VGND sg13cmos5l_fill_2
* cell instance sg13cmos5l_fill_2_586 r0 *1 0,0
Xsg13cmos5l_fill_2_586 VPWR VGND sg13cmos5l_fill_2
* cell instance sg13cmos5l_fill_2_587 r0 *1 0,0
Xsg13cmos5l_fill_2_587 VPWR VGND sg13cmos5l_fill_2
* cell instance sg13cmos5l_fill_2_588 r0 *1 0,0
Xsg13cmos5l_fill_2_588 VPWR VGND sg13cmos5l_fill_2
* cell instance sg13cmos5l_fill_2_589 r0 *1 0,0
Xsg13cmos5l_fill_2_589 VPWR VGND sg13cmos5l_fill_2
* cell instance sg13cmos5l_fill_2_590 r0 *1 0,0
Xsg13cmos5l_fill_2_590 VPWR VGND sg13cmos5l_fill_2
* cell instance sg13cmos5l_fill_2_591 r0 *1 0,0
Xsg13cmos5l_fill_2_591 VPWR VGND sg13cmos5l_fill_2
* cell instance sg13cmos5l_fill_2_592 r0 *1 0,0
Xsg13cmos5l_fill_2_592 VPWR VGND sg13cmos5l_fill_2
* cell instance sg13cmos5l_fill_2_593 r0 *1 0,0
Xsg13cmos5l_fill_2_593 VPWR VGND sg13cmos5l_fill_2
* cell instance sg13cmos5l_fill_2_594 r0 *1 0,0
Xsg13cmos5l_fill_2_594 VPWR VGND sg13cmos5l_fill_2
* cell instance sg13cmos5l_fill_2_595 r0 *1 0,0
Xsg13cmos5l_fill_2_595 VPWR VGND sg13cmos5l_fill_2
* cell instance sg13cmos5l_fill_2_596 r0 *1 0,0
Xsg13cmos5l_fill_2_596 VPWR VGND sg13cmos5l_fill_2
* cell instance sg13cmos5l_fill_2_597 r0 *1 0,0
Xsg13cmos5l_fill_2_597 VPWR VGND sg13cmos5l_fill_2
* cell instance sg13cmos5l_fill_2_598 r0 *1 0,0
Xsg13cmos5l_fill_2_598 VPWR VGND sg13cmos5l_fill_2
* cell instance sg13cmos5l_fill_2_599 r0 *1 0,0
Xsg13cmos5l_fill_2_599 VPWR VGND sg13cmos5l_fill_2
* cell instance sg13cmos5l_fill_2_600 r0 *1 0,0
Xsg13cmos5l_fill_2_600 VPWR VGND sg13cmos5l_fill_2
* cell instance sg13cmos5l_fill_2_601 r0 *1 0,0
Xsg13cmos5l_fill_2_601 VPWR VGND sg13cmos5l_fill_2
* cell instance sg13cmos5l_fill_2_602 r0 *1 0,0
Xsg13cmos5l_fill_2_602 VPWR VGND sg13cmos5l_fill_2
* cell instance sg13cmos5l_fill_2_603 r0 *1 0,0
Xsg13cmos5l_fill_2_603 VPWR VGND sg13cmos5l_fill_2
* cell instance sg13cmos5l_fill_2_604 r0 *1 0,0
Xsg13cmos5l_fill_2_604 VPWR VGND sg13cmos5l_fill_2
* cell instance sg13cmos5l_fill_2_605 r0 *1 0,0
Xsg13cmos5l_fill_2_605 VPWR VGND sg13cmos5l_fill_2
* cell instance sg13cmos5l_fill_2_606 r0 *1 0,0
Xsg13cmos5l_fill_2_606 VPWR VGND sg13cmos5l_fill_2
* cell instance sg13cmos5l_fill_2_607 r0 *1 0,0
Xsg13cmos5l_fill_2_607 VPWR VGND sg13cmos5l_fill_2
* cell instance sg13cmos5l_fill_2_608 r0 *1 0,0
Xsg13cmos5l_fill_2_608 VPWR VGND sg13cmos5l_fill_2
* cell instance sg13cmos5l_fill_2_609 r0 *1 0,0
Xsg13cmos5l_fill_2_609 VPWR VGND sg13cmos5l_fill_2
* cell instance sg13cmos5l_fill_2_610 r0 *1 0,0
Xsg13cmos5l_fill_2_610 VPWR VGND sg13cmos5l_fill_2
* cell instance sg13cmos5l_fill_2_611 r0 *1 0,0
Xsg13cmos5l_fill_2_611 VPWR VGND sg13cmos5l_fill_2
* cell instance sg13cmos5l_fill_2_612 r0 *1 0,0
Xsg13cmos5l_fill_2_612 VPWR VGND sg13cmos5l_fill_2
* cell instance sg13cmos5l_fill_2_613 r0 *1 0,0
Xsg13cmos5l_fill_2_613 VPWR VGND sg13cmos5l_fill_2
* cell instance sg13cmos5l_fill_2_614 r0 *1 0,0
Xsg13cmos5l_fill_2_614 VPWR VGND sg13cmos5l_fill_2
* cell instance sg13cmos5l_fill_2_615 r0 *1 0,0
Xsg13cmos5l_fill_2_615 VPWR VGND sg13cmos5l_fill_2
* cell instance sg13cmos5l_fill_2_616 r0 *1 0,0
Xsg13cmos5l_fill_2_616 VPWR VGND sg13cmos5l_fill_2
* cell instance sg13cmos5l_fill_2_617 r0 *1 0,0
Xsg13cmos5l_fill_2_617 VPWR VGND sg13cmos5l_fill_2
* cell instance sg13cmos5l_fill_2_618 r0 *1 0,0
Xsg13cmos5l_fill_2_618 VPWR VGND sg13cmos5l_fill_2
* cell instance sg13cmos5l_fill_2_619 r0 *1 0,0
Xsg13cmos5l_fill_2_619 VPWR VGND sg13cmos5l_fill_2
* cell instance sg13cmos5l_fill_2_620 r0 *1 0,0
Xsg13cmos5l_fill_2_620 VPWR VGND sg13cmos5l_fill_2
* cell instance sg13cmos5l_fill_2_621 r0 *1 0,0
Xsg13cmos5l_fill_2_621 VPWR VGND sg13cmos5l_fill_2
* cell instance sg13cmos5l_fill_2_622 r0 *1 0,0
Xsg13cmos5l_fill_2_622 VPWR VGND sg13cmos5l_fill_2
* cell instance sg13cmos5l_fill_2_623 r0 *1 0,0
Xsg13cmos5l_fill_2_623 VPWR VGND sg13cmos5l_fill_2
* cell instance sg13cmos5l_fill_2_624 r0 *1 0,0
Xsg13cmos5l_fill_2_624 VPWR VGND sg13cmos5l_fill_2
* cell instance sg13cmos5l_fill_2_625 r0 *1 0,0
Xsg13cmos5l_fill_2_625 VPWR VGND sg13cmos5l_fill_2
* cell instance sg13cmos5l_fill_2_626 r0 *1 0,0
Xsg13cmos5l_fill_2_626 VPWR VGND sg13cmos5l_fill_2
* cell instance sg13cmos5l_fill_2_627 r0 *1 0,0
Xsg13cmos5l_fill_2_627 VPWR VGND sg13cmos5l_fill_2
* cell instance sg13cmos5l_fill_2_628 r0 *1 0,0
Xsg13cmos5l_fill_2_628 VPWR VGND sg13cmos5l_fill_2
* cell instance sg13cmos5l_fill_2_629 r0 *1 0,0
Xsg13cmos5l_fill_2_629 VPWR VGND sg13cmos5l_fill_2
* cell instance sg13cmos5l_fill_2_630 r0 *1 0,0
Xsg13cmos5l_fill_2_630 VPWR VGND sg13cmos5l_fill_2
* cell instance sg13cmos5l_fill_2_631 r0 *1 0,0
Xsg13cmos5l_fill_2_631 VPWR VGND sg13cmos5l_fill_2
* cell instance sg13cmos5l_fill_2_632 r0 *1 0,0
Xsg13cmos5l_fill_2_632 VPWR VGND sg13cmos5l_fill_2
* cell instance sg13cmos5l_fill_2_633 r0 *1 0,0
Xsg13cmos5l_fill_2_633 VPWR VGND sg13cmos5l_fill_2
* cell instance sg13cmos5l_fill_2_634 r0 *1 0,0
Xsg13cmos5l_fill_2_634 VPWR VGND sg13cmos5l_fill_2
* cell instance sg13cmos5l_fill_2_635 r0 *1 0,0
Xsg13cmos5l_fill_2_635 VPWR VGND sg13cmos5l_fill_2
* cell instance sg13cmos5l_fill_2_636 r0 *1 0,0
Xsg13cmos5l_fill_2_636 VPWR VGND sg13cmos5l_fill_2
* cell instance sg13cmos5l_fill_2_637 r0 *1 0,0
Xsg13cmos5l_fill_2_637 VPWR VGND sg13cmos5l_fill_2
* cell instance sg13cmos5l_fill_2_638 r0 *1 0,0
Xsg13cmos5l_fill_2_638 VPWR VGND sg13cmos5l_fill_2
* cell instance sg13cmos5l_fill_2_639 r0 *1 0,0
Xsg13cmos5l_fill_2_639 VPWR VGND sg13cmos5l_fill_2
* cell instance sg13cmos5l_fill_2_640 r0 *1 0,0
Xsg13cmos5l_fill_2_640 VPWR VGND sg13cmos5l_fill_2
* cell instance sg13cmos5l_fill_2_641 r0 *1 0,0
Xsg13cmos5l_fill_2_641 VPWR VGND sg13cmos5l_fill_2
* cell instance sg13cmos5l_fill_2_642 r0 *1 0,0
Xsg13cmos5l_fill_2_642 VPWR VGND sg13cmos5l_fill_2
* cell instance sg13cmos5l_fill_2_643 r0 *1 0,0
Xsg13cmos5l_fill_2_643 VPWR VGND sg13cmos5l_fill_2
* cell instance sg13cmos5l_fill_2_644 r0 *1 0,0
Xsg13cmos5l_fill_2_644 VPWR VGND sg13cmos5l_fill_2
* cell instance sg13cmos5l_fill_2_645 r0 *1 0,0
Xsg13cmos5l_fill_2_645 VPWR VGND sg13cmos5l_fill_2
* cell instance sg13cmos5l_fill_2_646 r0 *1 0,0
Xsg13cmos5l_fill_2_646 VPWR VGND sg13cmos5l_fill_2
* cell instance sg13cmos5l_fill_2_647 r0 *1 0,0
Xsg13cmos5l_fill_2_647 VPWR VGND sg13cmos5l_fill_2
* cell instance sg13cmos5l_fill_2_648 r0 *1 0,0
Xsg13cmos5l_fill_2_648 VPWR VGND sg13cmos5l_fill_2
* cell instance sg13cmos5l_fill_2_649 r0 *1 0,0
Xsg13cmos5l_fill_2_649 VPWR VGND sg13cmos5l_fill_2
* cell instance sg13cmos5l_fill_2_650 r0 *1 0,0
Xsg13cmos5l_fill_2_650 VPWR VGND sg13cmos5l_fill_2
* cell instance sg13cmos5l_fill_2_651 r0 *1 0,0
Xsg13cmos5l_fill_2_651 VPWR VGND sg13cmos5l_fill_2
* cell instance sg13cmos5l_fill_2_652 r0 *1 0,0
Xsg13cmos5l_fill_2_652 VPWR VGND sg13cmos5l_fill_2
* cell instance sg13cmos5l_fill_2_653 r0 *1 0,0
Xsg13cmos5l_fill_2_653 VPWR VGND sg13cmos5l_fill_2
* cell instance sg13cmos5l_fill_2_654 r0 *1 0,0
Xsg13cmos5l_fill_2_654 VPWR VGND sg13cmos5l_fill_2
* cell instance sg13cmos5l_fill_2_655 r0 *1 0,0
Xsg13cmos5l_fill_2_655 VPWR VGND sg13cmos5l_fill_2
* cell instance sg13cmos5l_fill_2_656 r0 *1 0,0
Xsg13cmos5l_fill_2_656 VPWR VGND sg13cmos5l_fill_2
* cell instance sg13cmos5l_fill_2_657 r0 *1 0,0
Xsg13cmos5l_fill_2_657 VPWR VGND sg13cmos5l_fill_2
* cell instance sg13cmos5l_fill_2_658 r0 *1 0,0
Xsg13cmos5l_fill_2_658 VPWR VGND sg13cmos5l_fill_2
* cell instance sg13cmos5l_fill_2_659 r0 *1 0,0
Xsg13cmos5l_fill_2_659 VPWR VGND sg13cmos5l_fill_2
* cell instance sg13cmos5l_fill_2_660 r0 *1 0,0
Xsg13cmos5l_fill_2_660 VPWR VGND sg13cmos5l_fill_2
* cell instance sg13cmos5l_fill_2_661 r0 *1 0,0
Xsg13cmos5l_fill_2_661 VPWR VGND sg13cmos5l_fill_2
* cell instance sg13cmos5l_fill_2_662 r0 *1 0,0
Xsg13cmos5l_fill_2_662 VPWR VGND sg13cmos5l_fill_2
* cell instance sg13cmos5l_fill_2_663 r0 *1 0,0
Xsg13cmos5l_fill_2_663 VPWR VGND sg13cmos5l_fill_2
* cell instance sg13cmos5l_fill_2_664 r0 *1 0,0
Xsg13cmos5l_fill_2_664 VPWR VGND sg13cmos5l_fill_2
* cell instance sg13cmos5l_fill_2_665 r0 *1 0,0
Xsg13cmos5l_fill_2_665 VPWR VGND sg13cmos5l_fill_2
* cell instance sg13cmos5l_fill_2_666 r0 *1 0,0
Xsg13cmos5l_fill_2_666 VPWR VGND sg13cmos5l_fill_2
* cell instance sg13cmos5l_fill_2_667 r0 *1 0,0
Xsg13cmos5l_fill_2_667 VPWR VGND sg13cmos5l_fill_2
* cell instance sg13cmos5l_fill_2_668 r0 *1 0,0
Xsg13cmos5l_fill_2_668 VPWR VGND sg13cmos5l_fill_2
* cell instance sg13cmos5l_fill_2_669 r0 *1 0,0
Xsg13cmos5l_fill_2_669 VPWR VGND sg13cmos5l_fill_2
* cell instance sg13cmos5l_fill_2_670 r0 *1 0,0
Xsg13cmos5l_fill_2_670 VPWR VGND sg13cmos5l_fill_2
* cell instance sg13cmos5l_fill_2_671 r0 *1 0,0
Xsg13cmos5l_fill_2_671 VPWR VGND sg13cmos5l_fill_2
* cell instance sg13cmos5l_fill_2_672 r0 *1 0,0
Xsg13cmos5l_fill_2_672 VPWR VGND sg13cmos5l_fill_2
* cell instance sg13cmos5l_fill_2_673 r0 *1 0,0
Xsg13cmos5l_fill_2_673 VPWR VGND sg13cmos5l_fill_2
* cell instance sg13cmos5l_fill_2_674 r0 *1 0,0
Xsg13cmos5l_fill_2_674 VPWR VGND sg13cmos5l_fill_2
* cell instance sg13cmos5l_fill_2_675 r0 *1 0,0
Xsg13cmos5l_fill_2_675 VPWR VGND sg13cmos5l_fill_2
* cell instance sg13cmos5l_fill_2_676 r0 *1 0,0
Xsg13cmos5l_fill_2_676 VPWR VGND sg13cmos5l_fill_2
* cell instance sg13cmos5l_fill_2_677 r0 *1 0,0
Xsg13cmos5l_fill_2_677 VPWR VGND sg13cmos5l_fill_2
* cell instance sg13cmos5l_fill_2_678 r0 *1 0,0
Xsg13cmos5l_fill_2_678 VPWR VGND sg13cmos5l_fill_2
* cell instance sg13cmos5l_fill_2_679 r0 *1 0,0
Xsg13cmos5l_fill_2_679 VPWR VGND sg13cmos5l_fill_2
* cell instance sg13cmos5l_fill_2_680 r0 *1 0,0
Xsg13cmos5l_fill_2_680 VPWR VGND sg13cmos5l_fill_2
* cell instance sg13cmos5l_fill_2_681 r0 *1 0,0
Xsg13cmos5l_fill_2_681 VPWR VGND sg13cmos5l_fill_2
* cell instance sg13cmos5l_fill_2_682 r0 *1 0,0
Xsg13cmos5l_fill_2_682 VPWR VGND sg13cmos5l_fill_2
* cell instance sg13cmos5l_fill_2_683 r0 *1 0,0
Xsg13cmos5l_fill_2_683 VPWR VGND sg13cmos5l_fill_2
* cell instance sg13cmos5l_fill_2_684 r0 *1 0,0
Xsg13cmos5l_fill_2_684 VPWR VGND sg13cmos5l_fill_2
* cell instance sg13cmos5l_fill_2_685 r0 *1 0,0
Xsg13cmos5l_fill_2_685 VPWR VGND sg13cmos5l_fill_2
* cell instance sg13cmos5l_fill_2_686 r0 *1 0,0
Xsg13cmos5l_fill_2_686 VPWR VGND sg13cmos5l_fill_2
* cell instance sg13cmos5l_fill_2_687 r0 *1 0,0
Xsg13cmos5l_fill_2_687 VPWR VGND sg13cmos5l_fill_2
* cell instance sg13cmos5l_fill_2_688 r0 *1 0,0
Xsg13cmos5l_fill_2_688 VPWR VGND sg13cmos5l_fill_2
* cell instance sg13cmos5l_fill_2_689 r0 *1 0,0
Xsg13cmos5l_fill_2_689 VPWR VGND sg13cmos5l_fill_2
* cell instance sg13cmos5l_fill_2_690 r0 *1 0,0
Xsg13cmos5l_fill_2_690 VPWR VGND sg13cmos5l_fill_2
* cell instance sg13cmos5l_fill_2_691 r0 *1 0,0
Xsg13cmos5l_fill_2_691 VPWR VGND sg13cmos5l_fill_2
* cell instance sg13cmos5l_fill_2_692 r0 *1 0,0
Xsg13cmos5l_fill_2_692 VPWR VGND sg13cmos5l_fill_2
* cell instance sg13cmos5l_fill_2_693 r0 *1 0,0
Xsg13cmos5l_fill_2_693 VPWR VGND sg13cmos5l_fill_2
* cell instance sg13cmos5l_fill_2_694 r0 *1 0,0
Xsg13cmos5l_fill_2_694 VPWR VGND sg13cmos5l_fill_2
* cell instance sg13cmos5l_fill_2_695 r0 *1 0,0
Xsg13cmos5l_fill_2_695 VPWR VGND sg13cmos5l_fill_2
* cell instance sg13cmos5l_fill_2_696 r0 *1 0,0
Xsg13cmos5l_fill_2_696 VPWR VGND sg13cmos5l_fill_2
* cell instance sg13cmos5l_fill_2_697 r0 *1 0,0
Xsg13cmos5l_fill_2_697 VPWR VGND sg13cmos5l_fill_2
* cell instance sg13cmos5l_fill_2_698 r0 *1 0,0
Xsg13cmos5l_fill_2_698 VPWR VGND sg13cmos5l_fill_2
* cell instance sg13cmos5l_fill_2_699 r0 *1 0,0
Xsg13cmos5l_fill_2_699 VPWR VGND sg13cmos5l_fill_2
* cell instance sg13cmos5l_fill_2_700 r0 *1 0,0
Xsg13cmos5l_fill_2_700 VPWR VGND sg13cmos5l_fill_2
* cell instance sg13cmos5l_fill_2_701 r0 *1 0,0
Xsg13cmos5l_fill_2_701 VPWR VGND sg13cmos5l_fill_2
* cell instance sg13cmos5l_fill_2_702 r0 *1 0,0
Xsg13cmos5l_fill_2_702 VPWR VGND sg13cmos5l_fill_2
* cell instance sg13cmos5l_fill_2_703 r0 *1 0,0
Xsg13cmos5l_fill_2_703 VPWR VGND sg13cmos5l_fill_2
* cell instance sg13cmos5l_fill_2_704 r0 *1 0,0
Xsg13cmos5l_fill_2_704 VPWR VGND sg13cmos5l_fill_2
* cell instance sg13cmos5l_fill_2_705 r0 *1 0,0
Xsg13cmos5l_fill_2_705 VPWR VGND sg13cmos5l_fill_2
* cell instance sg13cmos5l_fill_2_706 r0 *1 0,0
Xsg13cmos5l_fill_2_706 VPWR VGND sg13cmos5l_fill_2
* cell instance sg13cmos5l_fill_2_707 r0 *1 0,0
Xsg13cmos5l_fill_2_707 VPWR VGND sg13cmos5l_fill_2
* cell instance sg13cmos5l_fill_2_708 r0 *1 0,0
Xsg13cmos5l_fill_2_708 VPWR VGND sg13cmos5l_fill_2
* cell instance sg13cmos5l_fill_2_709 r0 *1 0,0
Xsg13cmos5l_fill_2_709 VPWR VGND sg13cmos5l_fill_2
* cell instance sg13cmos5l_fill_2_710 r0 *1 0,0
Xsg13cmos5l_fill_2_710 VPWR VGND sg13cmos5l_fill_2
* cell instance sg13cmos5l_fill_2_711 r0 *1 0,0
Xsg13cmos5l_fill_2_711 VPWR VGND sg13cmos5l_fill_2
* cell instance sg13cmos5l_fill_2_712 r0 *1 0,0
Xsg13cmos5l_fill_2_712 VPWR VGND sg13cmos5l_fill_2
* cell instance sg13cmos5l_fill_2_713 r0 *1 0,0
Xsg13cmos5l_fill_2_713 VPWR VGND sg13cmos5l_fill_2
* cell instance sg13cmos5l_fill_2_714 r0 *1 0,0
Xsg13cmos5l_fill_2_714 VPWR VGND sg13cmos5l_fill_2
* cell instance sg13cmos5l_fill_2_715 r0 *1 0,0
Xsg13cmos5l_fill_2_715 VPWR VGND sg13cmos5l_fill_2
* cell instance sg13cmos5l_fill_2_716 r0 *1 0,0
Xsg13cmos5l_fill_2_716 VPWR VGND sg13cmos5l_fill_2
* cell instance sg13cmos5l_fill_2_717 r0 *1 0,0
Xsg13cmos5l_fill_2_717 VPWR VGND sg13cmos5l_fill_2
* cell instance sg13cmos5l_fill_2_718 r0 *1 0,0
Xsg13cmos5l_fill_2_718 VPWR VGND sg13cmos5l_fill_2
* cell instance sg13cmos5l_fill_2_719 r0 *1 0,0
Xsg13cmos5l_fill_2_719 VPWR VGND sg13cmos5l_fill_2
* cell instance sg13cmos5l_fill_2_720 r0 *1 0,0
Xsg13cmos5l_fill_2_720 VPWR VGND sg13cmos5l_fill_2
* cell instance sg13cmos5l_fill_2_721 r0 *1 0,0
Xsg13cmos5l_fill_2_721 VPWR VGND sg13cmos5l_fill_2
* cell instance sg13cmos5l_fill_2_722 r0 *1 0,0
Xsg13cmos5l_fill_2_722 VPWR VGND sg13cmos5l_fill_2
* cell instance sg13cmos5l_fill_2_723 r0 *1 0,0
Xsg13cmos5l_fill_2_723 VPWR VGND sg13cmos5l_fill_2
* cell instance sg13cmos5l_fill_2_724 r0 *1 0,0
Xsg13cmos5l_fill_2_724 VPWR VGND sg13cmos5l_fill_2
* cell instance sg13cmos5l_fill_2_725 r0 *1 0,0
Xsg13cmos5l_fill_2_725 VPWR VGND sg13cmos5l_fill_2
* cell instance sg13cmos5l_fill_2_726 r0 *1 0,0
Xsg13cmos5l_fill_2_726 VPWR VGND sg13cmos5l_fill_2
* cell instance sg13cmos5l_fill_2_727 r0 *1 0,0
Xsg13cmos5l_fill_2_727 VPWR VGND sg13cmos5l_fill_2
* cell instance sg13cmos5l_fill_2_728 r0 *1 0,0
Xsg13cmos5l_fill_2_728 VPWR VGND sg13cmos5l_fill_2
* cell instance sg13cmos5l_fill_2_729 r0 *1 0,0
Xsg13cmos5l_fill_2_729 VPWR VGND sg13cmos5l_fill_2
* cell instance sg13cmos5l_fill_2_730 r0 *1 0,0
Xsg13cmos5l_fill_2_730 VPWR VGND sg13cmos5l_fill_2
* cell instance sg13cmos5l_fill_2_731 r0 *1 0,0
Xsg13cmos5l_fill_2_731 VPWR VGND sg13cmos5l_fill_2
* cell instance sg13cmos5l_fill_2_732 r0 *1 0,0
Xsg13cmos5l_fill_2_732 VPWR VGND sg13cmos5l_fill_2
* cell instance sg13cmos5l_fill_2_733 r0 *1 0,0
Xsg13cmos5l_fill_2_733 VPWR VGND sg13cmos5l_fill_2
* cell instance sg13cmos5l_fill_2_734 r0 *1 0,0
Xsg13cmos5l_fill_2_734 VPWR VGND sg13cmos5l_fill_2
* cell instance sg13cmos5l_fill_2_735 r0 *1 0,0
Xsg13cmos5l_fill_2_735 VPWR VGND sg13cmos5l_fill_2
* cell instance sg13cmos5l_fill_2_736 r0 *1 0,0
Xsg13cmos5l_fill_2_736 VPWR VGND sg13cmos5l_fill_2
* cell instance sg13cmos5l_fill_2_737 r0 *1 0,0
Xsg13cmos5l_fill_2_737 VPWR VGND sg13cmos5l_fill_2
* cell instance sg13cmos5l_fill_2_738 r0 *1 0,0
Xsg13cmos5l_fill_2_738 VPWR VGND sg13cmos5l_fill_2
* cell instance sg13cmos5l_fill_2_739 r0 *1 0,0
Xsg13cmos5l_fill_2_739 VPWR VGND sg13cmos5l_fill_2
* cell instance sg13cmos5l_fill_2_740 r0 *1 0,0
Xsg13cmos5l_fill_2_740 VPWR VGND sg13cmos5l_fill_2
* cell instance sg13cmos5l_fill_2_741 r0 *1 0,0
Xsg13cmos5l_fill_2_741 VPWR VGND sg13cmos5l_fill_2
* cell instance sg13cmos5l_fill_2_742 r0 *1 0,0
Xsg13cmos5l_fill_2_742 VPWR VGND sg13cmos5l_fill_2
* cell instance sg13cmos5l_fill_2_743 r0 *1 0,0
Xsg13cmos5l_fill_2_743 VPWR VGND sg13cmos5l_fill_2
* cell instance sg13cmos5l_fill_2_744 r0 *1 0,0
Xsg13cmos5l_fill_2_744 VPWR VGND sg13cmos5l_fill_2
* cell instance sg13cmos5l_fill_2_745 r0 *1 0,0
Xsg13cmos5l_fill_2_745 VPWR VGND sg13cmos5l_fill_2
* cell instance sg13cmos5l_fill_2_746 r0 *1 0,0
Xsg13cmos5l_fill_2_746 VPWR VGND sg13cmos5l_fill_2
* cell instance sg13cmos5l_fill_2_747 r0 *1 0,0
Xsg13cmos5l_fill_2_747 VPWR VGND sg13cmos5l_fill_2
* cell instance sg13cmos5l_fill_2_748 r0 *1 0,0
Xsg13cmos5l_fill_2_748 VPWR VGND sg13cmos5l_fill_2
* cell instance sg13cmos5l_fill_2_749 r0 *1 0,0
Xsg13cmos5l_fill_2_749 VPWR VGND sg13cmos5l_fill_2
* cell instance sg13cmos5l_fill_2_750 r0 *1 0,0
Xsg13cmos5l_fill_2_750 VPWR VGND sg13cmos5l_fill_2
* cell instance sg13cmos5l_fill_2_751 r0 *1 0,0
Xsg13cmos5l_fill_2_751 VPWR VGND sg13cmos5l_fill_2
* cell instance sg13cmos5l_fill_2_752 r0 *1 0,0
Xsg13cmos5l_fill_2_752 VPWR VGND sg13cmos5l_fill_2
* cell instance sg13cmos5l_fill_2_753 r0 *1 0,0
Xsg13cmos5l_fill_2_753 VPWR VGND sg13cmos5l_fill_2
* cell instance sg13cmos5l_fill_2_754 r0 *1 0,0
Xsg13cmos5l_fill_2_754 VPWR VGND sg13cmos5l_fill_2
* cell instance sg13cmos5l_fill_2_755 r0 *1 0,0
Xsg13cmos5l_fill_2_755 VPWR VGND sg13cmos5l_fill_2
* cell instance sg13cmos5l_fill_2_756 r0 *1 0,0
Xsg13cmos5l_fill_2_756 VPWR VGND sg13cmos5l_fill_2
* cell instance sg13cmos5l_fill_2_757 r0 *1 0,0
Xsg13cmos5l_fill_2_757 VPWR VGND sg13cmos5l_fill_2
* cell instance sg13cmos5l_fill_2_758 r0 *1 0,0
Xsg13cmos5l_fill_2_758 VPWR VGND sg13cmos5l_fill_2
* cell instance sg13cmos5l_fill_2_759 r0 *1 0,0
Xsg13cmos5l_fill_2_759 VPWR VGND sg13cmos5l_fill_2
* cell instance sg13cmos5l_fill_2_760 r0 *1 0,0
Xsg13cmos5l_fill_2_760 VPWR VGND sg13cmos5l_fill_2
* cell instance sg13cmos5l_fill_2_761 r0 *1 0,0
Xsg13cmos5l_fill_2_761 VPWR VGND sg13cmos5l_fill_2
* cell instance sg13cmos5l_fill_2_762 r0 *1 0,0
Xsg13cmos5l_fill_2_762 VPWR VGND sg13cmos5l_fill_2
* cell instance sg13cmos5l_fill_2_763 r0 *1 0,0
Xsg13cmos5l_fill_2_763 VPWR VGND sg13cmos5l_fill_2
* cell instance sg13cmos5l_fill_2_764 r0 *1 0,0
Xsg13cmos5l_fill_2_764 VPWR VGND sg13cmos5l_fill_2
* cell instance sg13cmos5l_fill_2_765 r0 *1 0,0
Xsg13cmos5l_fill_2_765 VPWR VGND sg13cmos5l_fill_2
* cell instance sg13cmos5l_fill_2_766 r0 *1 0,0
Xsg13cmos5l_fill_2_766 VPWR VGND sg13cmos5l_fill_2
* cell instance sg13cmos5l_fill_2_767 r0 *1 0,0
Xsg13cmos5l_fill_2_767 VPWR VGND sg13cmos5l_fill_2
* cell instance sg13cmos5l_fill_2_768 r0 *1 0,0
Xsg13cmos5l_fill_2_768 VPWR VGND sg13cmos5l_fill_2
* cell instance sg13cmos5l_fill_2_769 r0 *1 0,0
Xsg13cmos5l_fill_2_769 VPWR VGND sg13cmos5l_fill_2
* cell instance sg13cmos5l_fill_2_770 r0 *1 0,0
Xsg13cmos5l_fill_2_770 VPWR VGND sg13cmos5l_fill_2
* cell instance sg13cmos5l_fill_2_771 r0 *1 0,0
Xsg13cmos5l_fill_2_771 VPWR VGND sg13cmos5l_fill_2
* cell instance sg13cmos5l_fill_2_772 r0 *1 0,0
Xsg13cmos5l_fill_2_772 VPWR VGND sg13cmos5l_fill_2
* cell instance sg13cmos5l_fill_2_773 r0 *1 0,0
Xsg13cmos5l_fill_2_773 VPWR VGND sg13cmos5l_fill_2
* cell instance sg13cmos5l_fill_2_774 r0 *1 0,0
Xsg13cmos5l_fill_2_774 VPWR VGND sg13cmos5l_fill_2
* cell instance sg13cmos5l_fill_2_775 r0 *1 0,0
Xsg13cmos5l_fill_2_775 VPWR VGND sg13cmos5l_fill_2
* cell instance sg13cmos5l_fill_2_776 r0 *1 0,0
Xsg13cmos5l_fill_2_776 VPWR VGND sg13cmos5l_fill_2
* cell instance sg13cmos5l_fill_2_777 r0 *1 0,0
Xsg13cmos5l_fill_2_777 VPWR VGND sg13cmos5l_fill_2
* cell instance sg13cmos5l_fill_2_778 r0 *1 0,0
Xsg13cmos5l_fill_2_778 VPWR VGND sg13cmos5l_fill_2
* cell instance sg13cmos5l_fill_2_779 r0 *1 0,0
Xsg13cmos5l_fill_2_779 VPWR VGND sg13cmos5l_fill_2
* cell instance sg13cmos5l_fill_2_780 r0 *1 0,0
Xsg13cmos5l_fill_2_780 VPWR VGND sg13cmos5l_fill_2
* cell instance sg13cmos5l_fill_2_781 r0 *1 0,0
Xsg13cmos5l_fill_2_781 VPWR VGND sg13cmos5l_fill_2
* cell instance sg13cmos5l_fill_2_782 r0 *1 0,0
Xsg13cmos5l_fill_2_782 VPWR VGND sg13cmos5l_fill_2
* cell instance sg13cmos5l_fill_2_783 r0 *1 0,0
Xsg13cmos5l_fill_2_783 VPWR VGND sg13cmos5l_fill_2
* cell instance sg13cmos5l_fill_2_784 r0 *1 0,0
Xsg13cmos5l_fill_2_784 VPWR VGND sg13cmos5l_fill_2
* cell instance sg13cmos5l_fill_2_785 r0 *1 0,0
Xsg13cmos5l_fill_2_785 VPWR VGND sg13cmos5l_fill_2
* cell instance sg13cmos5l_fill_2_786 r0 *1 0,0
Xsg13cmos5l_fill_2_786 VPWR VGND sg13cmos5l_fill_2
* cell instance sg13cmos5l_fill_2_787 r0 *1 0,0
Xsg13cmos5l_fill_2_787 VPWR VGND sg13cmos5l_fill_2
* cell instance sg13cmos5l_fill_2_788 r0 *1 0,0
Xsg13cmos5l_fill_2_788 VPWR VGND sg13cmos5l_fill_2
* cell instance sg13cmos5l_fill_2_789 r0 *1 0,0
Xsg13cmos5l_fill_2_789 VPWR VGND sg13cmos5l_fill_2
* cell instance sg13cmos5l_fill_2_790 r0 *1 0,0
Xsg13cmos5l_fill_2_790 VPWR VGND sg13cmos5l_fill_2
* cell instance sg13cmos5l_fill_2_791 r0 *1 0,0
Xsg13cmos5l_fill_2_791 VPWR VGND sg13cmos5l_fill_2
* cell instance sg13cmos5l_fill_2_792 r0 *1 0,0
Xsg13cmos5l_fill_2_792 VPWR VGND sg13cmos5l_fill_2
* cell instance sg13cmos5l_fill_2_793 r0 *1 0,0
Xsg13cmos5l_fill_2_793 VPWR VGND sg13cmos5l_fill_2
* cell instance sg13cmos5l_inv_1_0 r0 *1 0,0
Xsg13cmos5l_inv_1_0 \$3899 VPWR VGND \$3896 sg13cmos5l_inv_1
* cell instance sg13cmos5l_inv_1_1 r0 *1 0,0
Xsg13cmos5l_inv_1_1 \$1935 VPWR VGND \$1920 sg13cmos5l_inv_1
* cell instance sg13cmos5l_inv_1_2 r0 *1 0,0
Xsg13cmos5l_inv_1_2 \$2119 VPWR VGND \$2302 sg13cmos5l_inv_1
* cell instance sg13cmos5l_inv_1_3 r0 *1 0,0
Xsg13cmos5l_inv_1_3 \$3322 VPWR VGND \$3320 sg13cmos5l_inv_1
* cell instance sg13cmos5l_inv_1_4 r0 *1 0,0
Xsg13cmos5l_inv_1_4 \$611 VPWR VGND \$606 sg13cmos5l_inv_1
* cell instance sg13cmos5l_inv_1_5 r0 *1 0,0
Xsg13cmos5l_inv_1_5 \$1600 VPWR VGND \$1592 sg13cmos5l_inv_1
* cell instance sg13cmos5l_inv_1_6 r0 *1 0,0
Xsg13cmos5l_inv_1_6 \$1302 VPWR VGND \$1032 sg13cmos5l_inv_1
* cell instance sg13cmos5l_inv_1_7 r0 *1 0,0
Xsg13cmos5l_inv_1_7 \$2679 VPWR VGND \$2678 sg13cmos5l_inv_1
* cell instance sg13cmos5l_inv_1_8 r0 *1 0,0
Xsg13cmos5l_inv_1_8 \$9824 VPWR VGND \$9636 sg13cmos5l_inv_1
* cell instance sg13cmos5l_inv_1_9 r0 *1 0,0
Xsg13cmos5l_inv_1_9 \$8228 VPWR VGND \$8135 sg13cmos5l_inv_1
* cell instance sg13cmos5l_inv_1_10 r0 *1 0,0
Xsg13cmos5l_inv_1_10 \$1606 VPWR VGND \$1445 sg13cmos5l_inv_1
* cell instance sg13cmos5l_inv_1_11 r0 *1 0,0
Xsg13cmos5l_inv_1_11 \$906 VPWR VGND \$756 sg13cmos5l_inv_1
* cell instance sg13cmos5l_inv_1_12 r0 *1 0,0
Xsg13cmos5l_inv_1_12 \$17989 VPWR VGND \$19317 sg13cmos5l_inv_1
* cell instance sg13cmos5l_inv_1_13 r0 *1 0,0
Xsg13cmos5l_inv_1_13 \$7841 VPWR VGND \$7843 sg13cmos5l_inv_1
* cell instance sg13cmos5l_inv_1_14 r0 *1 0,0
Xsg13cmos5l_inv_1_14 \$4079 VPWR VGND \$2925 sg13cmos5l_inv_1
* cell instance sg13cmos5l_inv_1_15 r0 *1 0,0
Xsg13cmos5l_inv_1_15 \$3132 VPWR VGND \$3513 sg13cmos5l_inv_1
* cell instance sg13cmos5l_inv_1_16 r0 *1 0,0
Xsg13cmos5l_inv_1_16 \$915 VPWR VGND \$763 sg13cmos5l_inv_1
* cell instance sg13cmos5l_inv_1_17 r0 *1 0,0
Xsg13cmos5l_inv_1_17 \$1952 VPWR VGND \$1769 sg13cmos5l_inv_1
* cell instance sg13cmos5l_inv_1_18 r0 *1 0,0
Xsg13cmos5l_inv_1_18 \$2699 VPWR VGND \$2487 sg13cmos5l_inv_1
* cell instance sg13cmos5l_inv_1_19 r0 *1 0,0
Xsg13cmos5l_inv_1_19 \$10223 VPWR VGND \$10747 sg13cmos5l_inv_1
* cell instance sg13cmos5l_inv_1_20 r0 *1 0,0
Xsg13cmos5l_inv_1_20 \$377 VPWR VGND \$1036 sg13cmos5l_inv_1
* cell instance sg13cmos5l_inv_1_21 r0 *1 0,0
Xsg13cmos5l_inv_1_21 \$10224 VPWR VGND \$10752 sg13cmos5l_inv_1
* cell instance sg13cmos5l_inv_1_22 r0 *1 0,0
Xsg13cmos5l_inv_1_22 \$1793 VPWR VGND \$2494 sg13cmos5l_inv_1
* cell instance sg13cmos5l_inv_1_23 r0 *1 0,0
Xsg13cmos5l_inv_1_23 \$2312 VPWR VGND \$1963 sg13cmos5l_inv_1
* cell instance sg13cmos5l_inv_1_24 r0 *1 0,0
Xsg13cmos5l_inv_1_24 \$924 VPWR VGND \$778 sg13cmos5l_inv_1
* cell instance sg13cmos5l_inv_1_25 r0 *1 0,0
Xsg13cmos5l_inv_1_25 \$1478 VPWR VGND \$1616 sg13cmos5l_inv_1
* cell instance sg13cmos5l_inv_1_26 r0 *1 0,0
Xsg13cmos5l_inv_1_26 \$935 VPWR VGND \$1212 sg13cmos5l_inv_1
* cell instance sg13cmos5l_inv_1_27 r0 *1 0,0
Xsg13cmos5l_inv_1_27 \$501 VPWR VGND \$505 sg13cmos5l_inv_1
* cell instance sg13cmos5l_inv_1_28 r0 *1 0,0
Xsg13cmos5l_inv_1_28 \$1494 VPWR VGND \$1628 sg13cmos5l_inv_1
* cell instance sg13cmos5l_inv_1_29 r0 *1 0,0
Xsg13cmos5l_inv_1_29 \$811 VPWR VGND \$799 sg13cmos5l_inv_1
* cell instance sg13cmos5l_inv_1_30 r0 *1 0,0
Xsg13cmos5l_inv_1_30 \$411 VPWR VGND \$1070 sg13cmos5l_inv_1
* cell instance sg13cmos5l_inv_1_31 r0 *1 0,0
Xsg13cmos5l_inv_1_31 \$6073 VPWR VGND \$6074 sg13cmos5l_inv_1
* cell instance sg13cmos5l_inv_1_32 r0 *1 0,0
Xsg13cmos5l_inv_1_32 \$2722 VPWR VGND \$2709 sg13cmos5l_inv_1
* cell instance sg13cmos5l_inv_1_33 r0 *1 0,0
Xsg13cmos5l_inv_1_33 \$654 VPWR VGND \$825 sg13cmos5l_inv_1
* cell instance sg13cmos5l_inv_1_34 r0 *1 0,0
Xsg13cmos5l_inv_1_34 \$5522 VPWR VGND \$5449 sg13cmos5l_inv_1
* cell instance sg13cmos5l_inv_1_35 r0 *1 0,0
Xsg13cmos5l_inv_1_35 \$1341 VPWR VGND \$1337 sg13cmos5l_inv_1
* cell instance sg13cmos5l_inv_1_36 r0 *1 0,0
Xsg13cmos5l_inv_1_36 \$513 VPWR VGND \$953 sg13cmos5l_inv_1
* cell instance sg13cmos5l_inv_1_37 r0 *1 0,0
Xsg13cmos5l_inv_1_37 \$2148 VPWR VGND \$1980 sg13cmos5l_inv_1
* cell instance sg13cmos5l_inv_1_38 r0 *1 0,0
Xsg13cmos5l_inv_1_38 \$1080 VPWR VGND \$1081 sg13cmos5l_inv_1
* cell instance sg13cmos5l_inv_1_39 r0 *1 0,0
Xsg13cmos5l_inv_1_39 \$1807 VPWR VGND \$2967 sg13cmos5l_inv_1
* cell instance sg13cmos5l_inv_1_40 r0 *1 0,0
Xsg13cmos5l_inv_1_40 \$1079 VPWR VGND \$1084 sg13cmos5l_inv_1
* cell instance sg13cmos5l_inv_1_41 r0 *1 0,0
Xsg13cmos5l_inv_1_41 \$5527 VPWR VGND \$5676 sg13cmos5l_inv_1
* cell instance sg13cmos5l_inv_1_42 r0 *1 0,0
Xsg13cmos5l_inv_1_42 \$5684 VPWR VGND \$5893 sg13cmos5l_inv_1
* cell instance sg13cmos5l_inv_1_43 r0 *1 0,0
Xsg13cmos5l_inv_1_43 \$1514 VPWR VGND \$1515 sg13cmos5l_inv_1
* cell instance sg13cmos5l_inv_1_44 r0 *1 0,0
Xsg13cmos5l_inv_1_44 \$2458 VPWR VGND \$1794 sg13cmos5l_inv_1
* cell instance sg13cmos5l_inv_1_45 r0 *1 0,0
Xsg13cmos5l_inv_1_45 \$19617 VPWR VGND \$6448 sg13cmos5l_inv_1
* cell instance sg13cmos5l_inv_1_46 r0 *1 0,0
Xsg13cmos5l_inv_1_46 \$5611 VPWR VGND \$5680 sg13cmos5l_inv_1
* cell instance sg13cmos5l_inv_1_47 r0 *1 0,0
Xsg13cmos5l_inv_1_47 \$956 VPWR VGND \$1293 sg13cmos5l_inv_1
* cell instance sg13cmos5l_inv_1_48 r0 *1 0,0
Xsg13cmos5l_inv_1_48 \$541 VPWR VGND \$642 sg13cmos5l_inv_1
* cell instance sg13cmos5l_inv_1_49 r0 *1 0,0
Xsg13cmos5l_inv_1_49 \$1833 VPWR VGND \$2744 sg13cmos5l_inv_1
* cell instance sg13cmos5l_inv_1_50 r0 *1 0,0
Xsg13cmos5l_inv_1_50 \$1651 VPWR VGND \$1801 sg13cmos5l_inv_1
* cell instance sg13cmos5l_inv_1_51 r0 *1 0,0
Xsg13cmos5l_inv_1_51 \$2363 VPWR VGND \$2364 sg13cmos5l_inv_1
* cell instance sg13cmos5l_inv_1_52 r0 *1 0,0
Xsg13cmos5l_inv_1_52 \$2992 VPWR VGND \$2754 sg13cmos5l_inv_1
* cell instance sg13cmos5l_inv_1_53 r0 *1 0,0
Xsg13cmos5l_inv_1_53 \$5287 VPWR VGND \$5531 sg13cmos5l_inv_1
* cell instance sg13cmos5l_inv_1_54 r0 *1 0,0
Xsg13cmos5l_inv_1_54 \$2976 VPWR VGND \$3405 sg13cmos5l_inv_1
* cell instance sg13cmos5l_inv_1_55 r0 *1 0,0
Xsg13cmos5l_inv_1_55 \$3192 VPWR VGND \$3105 sg13cmos5l_inv_1
* cell instance sg13cmos5l_inv_1_56 r0 *1 0,0
Xsg13cmos5l_inv_1_56 \$3398 VPWR VGND \$2996 sg13cmos5l_inv_1
* cell instance sg13cmos5l_inv_1_57 r0 *1 0,0
Xsg13cmos5l_inv_1_57 \$418 VPWR VGND \$1547 sg13cmos5l_inv_1
* cell instance sg13cmos5l_inv_1_58 r0 *1 0,0
Xsg13cmos5l_inv_1_58 \$2561 VPWR VGND \$2763 sg13cmos5l_inv_1
* cell instance sg13cmos5l_inv_1_59 r0 *1 0,0
Xsg13cmos5l_inv_1_59 \$129 VPWR VGND \$1386 sg13cmos5l_inv_1
* cell instance sg13cmos5l_inv_1_60 r0 *1 0,0
Xsg13cmos5l_inv_1_60 \$41 VPWR VGND \$1576 sg13cmos5l_inv_1
* cell instance sg13cmos5l_inv_1_61 r0 *1 0,0
Xsg13cmos5l_inv_1_61 \$93 VPWR VGND \$64 sg13cmos5l_inv_1
* cell instance sg13cmos5l_inv_1_62 r0 *1 0,0
Xsg13cmos5l_inv_1_62 \$66 VPWR VGND \$723 sg13cmos5l_inv_1
* cell instance sg13cmos5l_inv_1_63 r0 *1 0,0
Xsg13cmos5l_inv_1_63 \$3020 VPWR VGND \$3201 sg13cmos5l_inv_1
* cell instance sg13cmos5l_inv_1_64 r0 *1 0,0
Xsg13cmos5l_inv_1_64 \$1694 VPWR VGND \$3591 sg13cmos5l_inv_1
* cell instance sg13cmos5l_inv_1_65 r0 *1 0,0
Xsg13cmos5l_inv_1_65 \$2391 VPWR VGND \$2770 sg13cmos5l_inv_1
* cell instance sg13cmos5l_inv_1_66 r0 *1 0,0
Xsg13cmos5l_inv_1_66 \$2049 VPWR VGND \$2221 sg13cmos5l_inv_1
* cell instance sg13cmos5l_inv_1_67 r0 *1 0,0
Xsg13cmos5l_inv_1_67 \$871 VPWR VGND \$1000 sg13cmos5l_inv_1
* cell instance sg13cmos5l_inv_1_68 r0 *1 0,0
Xsg13cmos5l_inv_1_68 \$2579 VPWR VGND \$2577 sg13cmos5l_inv_1
* cell instance sg13cmos5l_inv_1_69 r0 *1 0,0
Xsg13cmos5l_inv_1_69 \$2773 VPWR VGND \$2580 sg13cmos5l_inv_1
* cell instance sg13cmos5l_inv_1_70 r0 *1 0,0
Xsg13cmos5l_inv_1_70 \$76 VPWR VGND \$15 sg13cmos5l_inv_1
* cell instance sg13cmos5l_inv_1_71 r0 *1 0,0
Xsg13cmos5l_inv_1_71 \$3595 VPWR VGND \$3416 sg13cmos5l_inv_1
* cell instance sg13cmos5l_inv_1_72 r0 *1 0,0
Xsg13cmos5l_inv_1_72 \$27 VPWR VGND \$30 sg13cmos5l_inv_1
* cell instance sg13cmos5l_inv_1_73 r0 *1 0,0
Xsg13cmos5l_inv_1_73 \$2801 VPWR VGND \$3492 sg13cmos5l_inv_1
* cell instance sg13cmos5l_inv_1_74 r0 *1 0,0
Xsg13cmos5l_inv_1_74 \$3044 VPWR VGND \$3045 sg13cmos5l_inv_1
* cell instance sg13cmos5l_inv_1_75 r0 *1 0,0
Xsg13cmos5l_inv_1_75 \$2616 VPWR VGND \$3234 sg13cmos5l_inv_1
* cell instance sg13cmos5l_inv_1_76 r0 *1 0,0
Xsg13cmos5l_inv_1_76 \$2818 VPWR VGND \$2897 sg13cmos5l_inv_1
* cell instance sg13cmos5l_inv_1_77 r0 *1 0,0
Xsg13cmos5l_inv_1_77 \$2426 VPWR VGND \$3108 sg13cmos5l_inv_1
* cell instance sg13cmos5l_inv_1_78 r0 *1 0,0
Xsg13cmos5l_inv_1_78 \$4192 VPWR VGND \$4360 sg13cmos5l_inv_1
* cell instance sg13cmos5l_inv_1_79 r0 *1 0,0
Xsg13cmos5l_inv_1_79 \$4194 VPWR VGND \$4203 sg13cmos5l_inv_1
* cell instance sg13cmos5l_inv_1_80 r0 *1 0,0
Xsg13cmos5l_inv_1_80 \$4195 VPWR VGND \$4204 sg13cmos5l_inv_1
* cell instance sg13cmos5l_inv_1_81 r0 *1 0,0
Xsg13cmos5l_inv_1_81 \$4197 VPWR VGND \$3998 sg13cmos5l_inv_1
* cell instance sg13cmos5l_inv_1_82 r0 *1 0,0
Xsg13cmos5l_inv_1_82 \$6706 VPWR VGND \$6386 sg13cmos5l_inv_1
* cell instance sg13cmos5l_inv_1_83 r0 *1 0,0
Xsg13cmos5l_inv_1_83 \$2641 VPWR VGND \$3063 sg13cmos5l_inv_1
* cell instance sg13cmos5l_inv_1_84 r0 *1 0,0
Xsg13cmos5l_inv_1_84 \$5046 VPWR VGND \$5390 sg13cmos5l_inv_1
* cell instance sg13cmos5l_inv_1_85 r0 *1 0,0
Xsg13cmos5l_inv_1_85 \$2275 VPWR VGND \$3064 sg13cmos5l_inv_1
* cell instance sg13cmos5l_inv_1_86 r0 *1 0,0
Xsg13cmos5l_inv_1_86 \$3250 VPWR VGND \$3065 sg13cmos5l_inv_1
* cell instance sg13cmos5l_inv_1_87 r0 *1 0,0
Xsg13cmos5l_inv_1_87 \$2837 VPWR VGND \$2838 sg13cmos5l_inv_1
* cell instance sg13cmos5l_inv_1_88 r0 *1 0,0
Xsg13cmos5l_inv_1_88 \$2270 VPWR VGND \$3261 sg13cmos5l_inv_1
* cell instance sg13cmos5l_inv_1_89 r0 *1 0,0
Xsg13cmos5l_inv_1_89 \$5048 VPWR VGND \$5587 sg13cmos5l_inv_1
* cell instance sg13cmos5l_inv_1_90 r0 *1 0,0
Xsg13cmos5l_inv_1_90 \$5758 VPWR VGND \$5991 sg13cmos5l_inv_1
* cell instance sg13cmos5l_inv_1_91 r0 *1 0,0
Xsg13cmos5l_inv_1_91 \$6938 VPWR VGND \$7181 sg13cmos5l_inv_1
* cell instance sg13cmos5l_inv_1_92 r0 *1 0,0
Xsg13cmos5l_inv_1_92 \$7454 VPWR VGND \$7452 sg13cmos5l_inv_1
* cell instance sg13cmos5l_inv_1_93 r0 *1 0,0
Xsg13cmos5l_inv_1_93 \$4056 VPWR VGND \$4375 sg13cmos5l_inv_1
* cell instance sg13cmos5l_inv_1_94 r0 *1 0,0
Xsg13cmos5l_inv_1_94 \$7453 VPWR VGND \$7450 sg13cmos5l_inv_1
* cell instance sg13cmos5l_inv_1_95 r0 *1 0,0
Xsg13cmos5l_inv_1_95 \$5028 VPWR VGND \$5092 sg13cmos5l_inv_1
* cell instance sg13cmos5l_inv_1_96 r0 *1 0,0
Xsg13cmos5l_inv_1_96 \$4738 VPWR VGND \$4895 sg13cmos5l_inv_1
* cell instance sg13cmos5l_inv_1_97 r0 *1 0,0
Xsg13cmos5l_inv_1_97 \$5782 VPWR VGND \$6188 sg13cmos5l_inv_1
* cell instance sg13cmos5l_inv_1_98 r0 *1 0,0
Xsg13cmos5l_inv_1_98 \$5057 VPWR VGND \$4897 sg13cmos5l_inv_1
* cell instance sg13cmos5l_inv_1_99 r0 *1 0,0
Xsg13cmos5l_inv_1_99 \$3894 VPWR VGND \$4381 sg13cmos5l_inv_1
* cell instance sg13cmos5l_inv_1_100 r0 *1 0,0
Xsg13cmos5l_inv_1_100 \$3021 VPWR VGND \$5399 sg13cmos5l_inv_1
* cell instance sg13cmos5l_inv_1_101 r0 *1 0,0
Xsg13cmos5l_inv_1_101 \$4735 VPWR VGND \$4898 sg13cmos5l_inv_1
* cell instance sg13cmos5l_inv_1_102 r0 *1 0,0
Xsg13cmos5l_inv_1_102 \$5061 VPWR VGND \$4900 sg13cmos5l_inv_1
* cell instance sg13cmos5l_inv_2_0 r0 *1 0,0
Xsg13cmos5l_inv_2_0 \$6845 VPWR VGND \$8032 sg13cmos5l_inv_2
* cell instance sg13cmos5l_inv_4_0 r0 *1 0,0
Xsg13cmos5l_inv_4_0 \$5654 VPWR VGND \$6460 sg13cmos5l_inv_4
* cell instance sg13cmos5l_inv_4_1 r0 *1 0,0
Xsg13cmos5l_inv_4_1 \$1871 VPWR VGND \$2392 sg13cmos5l_inv_4
* cell instance sg13cmos5l_inv_4_2 r0 *1 0,0
Xsg13cmos5l_inv_4_2 \$1726 VPWR VGND \$2614 sg13cmos5l_inv_4
* cell instance sg13cmos5l_inv_8_0 r0 *1 0,0
Xsg13cmos5l_inv_8_0 \$747 VPWR VGND \$1181 sg13cmos5l_inv_8
* cell instance sg13cmos5l_inv_8_1 r0 *1 0,0
Xsg13cmos5l_inv_8_1 \$16038 VPWR VGND \$19329 sg13cmos5l_inv_8
* cell instance sg13cmos5l_inv_8_2 r0 *1 0,0
Xsg13cmos5l_inv_8_2 \$5361 VPWR VGND \$6369 sg13cmos5l_inv_8
* cell instance sg13cmos5l_mux2_1_0 r0 *1 0,0
Xsg13cmos5l_mux2_1_0 \$10917 \$6533 \$12206 VPWR VGND \$10765 sg13cmos5l_mux2_1
* cell instance sg13cmos5l_mux2_1_1 r0 *1 0,0
Xsg13cmos5l_mux2_1_1 \$12922 \$10917 \$12206 VPWR VGND \$12734 sg13cmos5l_mux2_1
* cell instance sg13cmos5l_mux2_1_2 r0 *1 0,0
Xsg13cmos5l_mux2_1_2 \$10460 \$9823 \$11400 VPWR VGND \$6466 sg13cmos5l_mux2_1
* cell instance sg13cmos5l_mux2_1_3 r0 *1 0,0
Xsg13cmos5l_mux2_1_3 \$6026 \$6226 \$6024 VPWR VGND \$6019 sg13cmos5l_mux2_1
* cell instance sg13cmos5l_mux2_1_4 r0 *1 0,0
Xsg13cmos5l_mux2_1_4 \$12310 \$12309 \$11400 VPWR VGND \$6441 sg13cmos5l_mux2_1
* cell instance sg13cmos5l_mux2_1_5 r0 *1 0,0
Xsg13cmos5l_mux2_1_5 \$13377 \$12922 \$12206 VPWR VGND \$13959 sg13cmos5l_mux2_1
* cell instance sg13cmos5l_mux2_1_6 r0 *1 0,0
Xsg13cmos5l_mux2_1_6 \$12311 \$10921 \$12206 VPWR VGND \$13281 sg13cmos5l_mux2_1
* cell instance sg13cmos5l_mux2_1_7 r0 *1 0,0
Xsg13cmos5l_mux2_1_7 \$5852 \$5853 \$6021 VPWR VGND \$5791 sg13cmos5l_mux2_1
* cell instance sg13cmos5l_mux2_1_8 r0 *1 0,0
Xsg13cmos5l_mux2_1_8 \$11972 \$12311 \$12206 VPWR VGND \$12563 sg13cmos5l_mux2_1
* cell instance sg13cmos5l_mux2_1_9 r0 *1 0,0
Xsg13cmos5l_mux2_1_9 \$10919 \$10740 \$11400 VPWR VGND \$6726 sg13cmos5l_mux2_1
* cell instance sg13cmos5l_mux2_1_10 r0 *1 0,0
Xsg13cmos5l_mux2_1_10 \$12314 \$11972 \$12206 VPWR VGND \$12125
+ sg13cmos5l_mux2_1
* cell instance sg13cmos5l_mux2_1_11 r0 *1 0,0
Xsg13cmos5l_mux2_1_11 \$10921 \$13963 \$12206 VPWR VGND \$12924
+ sg13cmos5l_mux2_1
* cell instance sg13cmos5l_mux2_1_12 r0 *1 0,0
Xsg13cmos5l_mux2_1_12 \$13963 \$13377 \$12206 VPWR VGND \$13295
+ sg13cmos5l_mux2_1
* cell instance sg13cmos5l_mux2_1_13 r0 *1 0,0
Xsg13cmos5l_mux2_1_13 \$6911 \$6267 \$5884 VPWR VGND \$6953 sg13cmos5l_mux2_1
* cell instance sg13cmos5l_mux2_1_14 r0 *1 0,0
Xsg13cmos5l_mux2_1_14 \$6446 \$3780 \$5884 VPWR VGND \$6759 sg13cmos5l_mux2_1
* cell instance sg13cmos5l_mux2_1_15 r0 *1 0,0
Xsg13cmos5l_mux2_1_15 \$12927 \$12314 \$8563 VPWR VGND \$12757 sg13cmos5l_mux2_1
* cell instance sg13cmos5l_mux2_1_16 r0 *1 0,0
Xsg13cmos5l_mux2_1_16 \$12317 \$12927 \$8563 VPWR VGND \$13309 sg13cmos5l_mux2_1
* cell instance sg13cmos5l_mux2_1_17 r0 *1 0,0
Xsg13cmos5l_mux2_1_17 \$6053 \$4252 \$5884 VPWR VGND \$6263 sg13cmos5l_mux2_1
* cell instance sg13cmos5l_mux2_1_18 r0 *1 0,0
Xsg13cmos5l_mux2_1_18 \$6853 \$3525 \$5884 VPWR VGND \$6829 sg13cmos5l_mux2_1
* cell instance sg13cmos5l_mux2_1_19 r0 *1 0,0
Xsg13cmos5l_mux2_1_19 \$5283 \$4149 \$5884 VPWR VGND \$5277 sg13cmos5l_mux2_1
* cell instance sg13cmos5l_mux2_1_20 r0 *1 0,0
Xsg13cmos5l_mux2_1_20 \$6060 \$4251 \$5884 VPWR VGND \$6059 sg13cmos5l_mux2_1
* cell instance sg13cmos5l_mux2_1_21 r0 *1 0,0
Xsg13cmos5l_mux2_1_21 \$5515 \$4857 \$5884 VPWR VGND \$5505 sg13cmos5l_mux2_1
* cell instance sg13cmos5l_mux2_1_22 r0 *1 0,0
Xsg13cmos5l_mux2_1_22 \$5881 \$4507 \$5884 VPWR VGND \$5882 sg13cmos5l_mux2_1
* cell instance sg13cmos5l_mux2_1_23 r0 *1 0,0
Xsg13cmos5l_mux2_1_23 \$5289 \$5160 \$5287 VPWR VGND \$5290 sg13cmos5l_mux2_1
* cell instance sg13cmos5l_mux2_1_24 r0 *1 0,0
Xsg13cmos5l_mux2_1_24 \$4507 \$453 \$4623 VPWR VGND \$4509 sg13cmos5l_mux2_1
* cell instance sg13cmos5l_mux2_1_25 r0 *1 0,0
Xsg13cmos5l_mux2_1_25 \$4251 \$983 \$4623 VPWR VGND \$2541 sg13cmos5l_mux2_1
* cell instance sg13cmos5l_mux2_1_26 r0 *1 0,0
Xsg13cmos5l_mux2_1_26 \$4252 \$585 \$4623 VPWR VGND \$3299 sg13cmos5l_mux2_1
* cell instance sg13cmos5l_mux2_1_27 r0 *1 0,0
Xsg13cmos5l_mux2_1_27 \$4857 \$802 \$4623 VPWR VGND \$4504 sg13cmos5l_mux2_1
* cell instance sg13cmos5l_mux2_1_28 r0 *1 0,0
Xsg13cmos5l_mux2_1_28 \$6267 \$4143 \$3772 VPWR VGND \$2378 sg13cmos5l_mux2_1
* cell instance sg13cmos5l_mux2_1_29 r0 *1 0,0
Xsg13cmos5l_mux2_1_29 \$3525 \$1385 \$3772 VPWR VGND \$3777 sg13cmos5l_mux2_1
* cell instance sg13cmos5l_mux2_1_30 r0 *1 0,0
Xsg13cmos5l_mux2_1_30 \$3780 \$1123 \$3772 VPWR VGND \$2194 sg13cmos5l_mux2_1
* cell instance sg13cmos5l_mux2_1_31 r0 *1 0,0
Xsg13cmos5l_mux2_1_31 \$4149 \$1742 \$3772 VPWR VGND \$2198 sg13cmos5l_mux2_1
* cell instance sg13cmos5l_mux2_1_32 r0 *1 0,0
Xsg13cmos5l_mux2_1_32 \$5304 \$1011 \$5008 VPWR VGND \$5610 sg13cmos5l_mux2_1
* cell instance sg13cmos5l_mux2_1_33 r0 *1 0,0
Xsg13cmos5l_mux2_1_33 \$5610 \$5723 \$5337 VPWR VGND \$5704 sg13cmos5l_mux2_1
* cell instance sg13cmos5l_mux2_1_34 r0 *1 0,0
Xsg13cmos5l_mux2_1_34 \$4341 \$1898 \$4170 VPWR VGND \$4927 sg13cmos5l_mux2_1
* cell instance sg13cmos5l_mux2_1_35 r0 *1 0,0
Xsg13cmos5l_mux2_1_35 \$4346 \$4345 \$4561 VPWR VGND \$4173 sg13cmos5l_mux2_1
* cell instance sg13cmos5l_mux2_1_36 r0 *1 0,0
Xsg13cmos5l_mux2_1_36 \$3974 \$2060 \$3975 VPWR VGND \$3432 sg13cmos5l_mux2_1
* cell instance sg13cmos5l_mux2_1_37 r0 *1 0,0
Xsg13cmos5l_mux2_1_37 \$4705 \$4565 \$3975 VPWR VGND \$4346 sg13cmos5l_mux2_1
* cell instance sg13cmos5l_mux2_1_38 r0 *1 0,0
Xsg13cmos5l_mux2_1_38 \$3982 \$4181 \$3975 VPWR VGND \$4344 sg13cmos5l_mux2_1
* cell instance sg13cmos5l_mux2_1_39 r0 *1 0,0
Xsg13cmos5l_mux2_1_39 \$3608 \$2071 \$3975 VPWR VGND \$3236 sg13cmos5l_mux2_1
* cell instance sg13cmos5l_mux2_1_40 r0 *1 0,0
Xsg13cmos5l_mux2_1_40 \$2260 \$2894 \$2803 VPWR VGND \$2805 sg13cmos5l_mux2_1
* cell instance sg13cmos5l_mux2_1_41 r0 *1 0,0
Xsg13cmos5l_mux2_1_41 \$2260 \$2259 \$2256 VPWR VGND \$2261 sg13cmos5l_mux2_1
* cell instance sg13cmos5l_mux2_1_42 r0 *1 0,0
Xsg13cmos5l_mux2_1_42 \$4353 \$2082 \$3825 VPWR VGND \$4418 sg13cmos5l_mux2_1
* cell instance sg13cmos5l_mux2_1_43 r0 *1 0,0
Xsg13cmos5l_mux2_1_43 \$4706 \$4709 \$3825 VPWR VGND \$4883 sg13cmos5l_mux2_1
* cell instance sg13cmos5l_mux2_1_44 r0 *1 0,0
Xsg13cmos5l_mux2_1_44 \$3824 \$3983 \$3825 VPWR VGND \$3241 sg13cmos5l_mux2_1
* cell instance sg13cmos5l_mux2_1_45 r0 *1 0,0
Xsg13cmos5l_mux2_1_45 \$2260 \$2622 \$2620 VPWR VGND \$2415 sg13cmos5l_mux2_1
* cell instance sg13cmos5l_mux2_1_46 r0 *1 0,0
Xsg13cmos5l_mux2_1_46 \$2260 \$2911 \$2817 VPWR VGND \$2898 sg13cmos5l_mux2_1
* cell instance sg13cmos5l_mux2_1_47 r0 *1 0,0
Xsg13cmos5l_mux2_1_47 \$2629 \$2433 \$2620 VPWR VGND \$2630 sg13cmos5l_mux2_1
* cell instance sg13cmos5l_mux2_1_48 r0 *1 0,0
Xsg13cmos5l_mux2_1_48 \$2629 \$3682 \$2803 VPWR VGND \$3623 sg13cmos5l_mux2_1
* cell instance sg13cmos5l_mux2_1_49 r0 *1 0,0
Xsg13cmos5l_mux2_1_49 \$2629 \$3059 \$2817 VPWR VGND \$2901 sg13cmos5l_mux2_1
* cell instance sg13cmos5l_mux2_1_50 r0 *1 0,0
Xsg13cmos5l_mux2_1_50 \$2629 \$2429 \$2256 VPWR VGND \$2263 sg13cmos5l_mux2_1
* cell instance sg13cmos5l_mux2_1_51 r0 *1 0,0
Xsg13cmos5l_mux2_1_51 \$6545 \$10600 \$8563 VPWR VGND \$10756 sg13cmos5l_mux2_1
* cell instance sg13cmos5l_mux2_1_52 r0 *1 0,0
Xsg13cmos5l_mux2_1_52 \$10305 \$10293 \$6855 VPWR VGND \$6919 sg13cmos5l_mux2_1
* cell instance sg13cmos5l_mux2_1_53 r0 *1 0,0
Xsg13cmos5l_mux2_1_53 \$9310 \$9311 \$8563 VPWR VGND \$9178 sg13cmos5l_mux2_1
* cell instance sg13cmos5l_mux2_1_54 r0 *1 0,0
Xsg13cmos5l_mux2_1_54 \$8324 \$9311 \$6855 VPWR VGND \$6839 sg13cmos5l_mux2_1
* cell instance sg13cmos5l_mux2_1_55 r0 *1 0,0
Xsg13cmos5l_mux2_1_55 \$2644 \$2290 \$2256 VPWR VGND \$2437 sg13cmos5l_mux2_1
* cell instance sg13cmos5l_mux2_1_56 r0 *1 0,0
Xsg13cmos5l_mux2_1_56 \$9580 \$9581 \$6855 VPWR VGND \$6832 sg13cmos5l_mux2_1
* cell instance sg13cmos5l_mux2_1_57 r0 *1 0,0
Xsg13cmos5l_mux2_1_57 \$2644 \$2847 \$2817 VPWR VGND \$3068 sg13cmos5l_mux2_1
* cell instance sg13cmos5l_mux2_1_58 r0 *1 0,0
Xsg13cmos5l_mux2_1_58 \$2644 \$3686 \$2803 VPWR VGND \$3843 sg13cmos5l_mux2_1
* cell instance sg13cmos5l_mux2_1_59 r0 *1 0,0
Xsg13cmos5l_mux2_1_59 \$2644 \$2904 \$2620 VPWR VGND \$2841 sg13cmos5l_mux2_1
* cell instance sg13cmos5l_mux2_1_60 r0 *1 0,0
Xsg13cmos5l_mux2_1_60 \$10600 \$9310 \$8563 VPWR VGND \$9584 sg13cmos5l_mux2_1
* cell instance sg13cmos5l_mux2_1_61 r0 *1 0,0
Xsg13cmos5l_mux2_1_61 \$8003 \$8327 \$5973 VPWR VGND \$6870 sg13cmos5l_mux2_1
* cell instance sg13cmos5l_mux2_1_62 r0 *1 0,0
Xsg13cmos5l_mux2_1_62 \$8329 \$8564 \$8563 VPWR VGND \$8526 sg13cmos5l_mux2_1
* cell instance sg13cmos5l_mux2_1_63 r0 *1 0,0
Xsg13cmos5l_mux2_1_63 \$9311 \$8296 \$8563 VPWR VGND \$8805 sg13cmos5l_mux2_1
* cell instance sg13cmos5l_mux2_1_64 r0 *1 0,0
Xsg13cmos5l_mux2_1_64 \$9093 \$8329 \$5973 VPWR VGND \$9327 sg13cmos5l_mux2_1
* cell instance sg13cmos5l_mux2_1_65 r0 *1 0,0
Xsg13cmos5l_mux2_1_65 \$3071 \$3082 \$2620 VPWR VGND \$2905 sg13cmos5l_mux2_1
* cell instance sg13cmos5l_mux2_1_66 r0 *1 0,0
Xsg13cmos5l_mux2_1_66 \$3822 \$3859 \$3423 VPWR VGND \$3860 sg13cmos5l_mux2_1
* cell instance sg13cmos5l_mux2_1_67 r0 *1 0,0
Xsg13cmos5l_mux2_1_67 \$4583 \$4590 \$2256 VPWR VGND \$4591 sg13cmos5l_mux2_1
* cell instance sg13cmos5l_mux2_1_68 r0 *1 0,0
Xsg13cmos5l_mux2_1_68 \$3071 \$2657 \$2256 VPWR VGND \$2659 sg13cmos5l_mux2_1
* cell instance sg13cmos5l_mux2_1_69 r0 *1 0,0
Xsg13cmos5l_mux2_1_69 \$3071 \$3088 \$2817 VPWR VGND \$3089 sg13cmos5l_mux2_1
* cell instance sg13cmos5l_mux2_1_70 r0 *1 0,0
Xsg13cmos5l_mux2_1_70 \$3071 \$3315 \$2803 VPWR VGND \$3277 sg13cmos5l_mux2_1
* cell instance sg13cmos5l_mux2_1_71 r0 *1 0,0
Xsg13cmos5l_mux2_1_71 \$3822 \$3486 \$2256 VPWR VGND \$3645 sg13cmos5l_mux2_1
* cell instance sg13cmos5l_mux2_1_72 r0 *1 0,0
Xsg13cmos5l_mux2_1_72 \$4740 \$5225 \$3423 VPWR VGND \$5226 sg13cmos5l_mux2_1
* cell instance sg13cmos5l_mux2_1_73 r0 *1 0,0
Xsg13cmos5l_mux2_1_73 \$4740 \$4906 \$2611 VPWR VGND \$4907 sg13cmos5l_mux2_1
* cell instance sg13cmos5l_mux2_1_74 r0 *1 0,0
Xsg13cmos5l_mux2_1_74 \$3822 \$4058 \$2620 VPWR VGND \$4024 sg13cmos5l_mux2_1
* cell instance sg13cmos5l_mux2_1_75 r0 *1 0,0
Xsg13cmos5l_mux2_1_75 \$4740 \$4742 \$2670 VPWR VGND \$4743 sg13cmos5l_mux2_1
* cell instance sg13cmos5l_mux2_1_76 r0 *1 0,0
Xsg13cmos5l_mux2_1_76 \$4583 \$4233 \$2817 VPWR VGND \$4234 sg13cmos5l_mux2_1
* cell instance sg13cmos5l_mux2_1_77 r0 *1 0,0
Xsg13cmos5l_mux2_1_77 \$3822 \$3649 \$2817 VPWR VGND \$3873 sg13cmos5l_mux2_1
* cell instance sg13cmos5l_mux2_1_78 r0 *1 0,0
Xsg13cmos5l_mux2_1_78 \$4740 \$5064 \$2816 VPWR VGND \$5065 sg13cmos5l_mux2_1
* cell instance sg13cmos5l_mux2_1_79 r0 *1 0,0
Xsg13cmos5l_mux2_1_79 \$4583 \$4424 \$2620 VPWR VGND \$4395 sg13cmos5l_mux2_1
* cell instance sg13cmos5l_mux4_1_0 r0 *1 0,0
Xsg13cmos5l_mux4_1_0 \$1441 \$1760 \$2309 \$2485 \$1323 \$1201 VPWR VGND \$1945
+ sg13cmos5l_mux4_1
* cell instance sg13cmos5l_mux4_1_1 r0 *1 0,0
Xsg13cmos5l_mux4_1_1 \$3336 \$3134 \$3323 \$3505 \$1323 \$1201 VPWR VGND \$3316
+ sg13cmos5l_mux4_1
* cell instance sg13cmos5l_mux4_1_2 r0 *1 0,0
Xsg13cmos5l_mux4_1_2 \$763 \$1036 \$756 \$1032 \$1323 \$1201 VPWR VGND \$1202
+ sg13cmos5l_mux4_1
* cell instance sg13cmos5l_mux4_1_3 r0 *1 0,0
Xsg13cmos5l_mux4_1_3 \$1954 \$2291 \$751 \$1574 \$1323 \$1201 VPWR VGND \$2095
+ sg13cmos5l_mux4_1
* cell instance sg13cmos5l_mux4_1_4 r0 *1 0,0
Xsg13cmos5l_mux4_1_4 \$1485 \$1476 \$1203 \$931 \$1929 \$1076 VPWR VGND \$1490
+ sg13cmos5l_mux4_1
* cell instance sg13cmos5l_mux4_1_5 r0 *1 0,0
Xsg13cmos5l_mux4_1_5 \$826 \$535 \$881 \$517 \$1929 \$1076 VPWR VGND \$1063
+ sg13cmos5l_mux4_1
* cell instance sg13cmos5l_mux4_1_6 r0 *1 0,0
Xsg13cmos5l_mux4_1_6 \$1084 \$1801 \$1515 \$1794 \$1323 \$1076 VPWR VGND \$1625
+ sg13cmos5l_mux4_1
* cell instance sg13cmos5l_mux4_1_7 r0 *1 0,0
Xsg13cmos5l_mux4_1_7 \$1988 \$1990 \$2113 \$1342 \$1929 \$1076 VPWR VGND \$1985
+ sg13cmos5l_mux4_1
* cell instance sg13cmos5l_mux4_1_8 r0 *1 0,0
Xsg13cmos5l_mux4_1_8 \$4125 \$2786 \$3023 \$4046 \$3397 \$3956 VPWR VGND \$3952
+ sg13cmos5l_mux4_1
* cell instance sg13cmos5l_mux4_1_9 r0 *1 0,0
Xsg13cmos5l_mux4_1_9 \$3045 \$2897 \$3234 \$3108 \$3236 \$3241 VPWR VGND \$56
+ sg13cmos5l_mux4_1
* cell instance sg13cmos5l_mux4_1_10 r0 *1 0,0
Xsg13cmos5l_mux4_1_10 \$3044 \$2818 \$2616 \$2426 \$3432 \$4927 VPWR VGND
+ \$3438 sg13cmos5l_mux4_1
* cell instance sg13cmos5l_mux4_1_11 r0 *1 0,0
Xsg13cmos5l_mux4_1_11 \$3044 \$2818 \$2616 \$2426 \$3236 \$3241 VPWR VGND
+ \$3312 sg13cmos5l_mux4_1
* cell instance sg13cmos5l_mux4_1_12 r0 *1 0,0
Xsg13cmos5l_mux4_1_12 \$4192 \$4194 \$4195 \$4197 \$4927 \$4359 VPWR VGND
+ \$5373 sg13cmos5l_mux4_1
* cell instance sg13cmos5l_mux4_1_13 r0 *1 0,0
Xsg13cmos5l_mux4_1_13 \$4192 \$4194 \$4195 \$4197 \$3241 \$3223 VPWR VGND
+ \$4125 sg13cmos5l_mux4_1
* cell instance sg13cmos5l_mux4_1_14 r0 *1 0,0
Xsg13cmos5l_mux4_1_14 \$2641 \$2837 \$2275 \$3250 \$3031 \$3313 VPWR VGND
+ \$2786 sg13cmos5l_mux4_1
* cell instance sg13cmos5l_mux4_1_15 r0 *1 0,0
Xsg13cmos5l_mux4_1_15 \$2641 \$2837 \$2275 \$3250 \$4536 \$4359 VPWR VGND
+ \$5211 sg13cmos5l_mux4_1
* cell instance sg13cmos5l_mux4_1_16 r0 *1 0,0
Xsg13cmos5l_mux4_1_16 \$4360 \$4203 \$4204 \$3998 \$3241 \$3313 VPWR VGND
+ \$4200 sg13cmos5l_mux4_1
* cell instance sg13cmos5l_mux4_1_17 r0 *1 0,0
Xsg13cmos5l_mux4_1_17 \$3063 \$2838 \$3064 \$3065 \$3254 \$3313 VPWR VGND
+ \$3260 sg13cmos5l_mux4_1
* cell instance sg13cmos5l_mux4_1_18 r0 *1 0,0
Xsg13cmos5l_mux4_1_18 \$2842 \$2843 \$2276 \$3265 \$3254 \$3268 VPWR VGND
+ \$5220 sg13cmos5l_mux4_1
* cell instance sg13cmos5l_mux4_1_19 r0 *1 0,0
Xsg13cmos5l_mux4_1_19 \$2842 \$2843 \$2276 \$3265 \$4536 \$4359 VPWR VGND
+ \$5046 sg13cmos5l_mux4_1
* cell instance sg13cmos5l_mux4_1_20 r0 *1 0,0
Xsg13cmos5l_mux4_1_20 \$2908 \$3314 \$2658 \$3272 \$3254 \$3268 VPWR VGND
+ \$2466 sg13cmos5l_mux4_1
* cell instance sg13cmos5l_mux4_1_21 r0 *1 0,0
Xsg13cmos5l_mux4_1_21 \$2908 \$3314 \$2658 \$3272 \$4536 \$4359 VPWR VGND
+ \$5055 sg13cmos5l_mux4_1
* cell instance sg13cmos5l_mux4_1_22 r0 *1 0,0
Xsg13cmos5l_mux4_1_22 \$4895 \$4897 \$4898 \$4900 \$3031 \$3313 VPWR VGND
+ \$5594 sg13cmos5l_mux4_1
* cell instance sg13cmos5l_mux4_1_23 r0 *1 0,0
Xsg13cmos5l_mux4_1_23 \$4017 \$3894 \$4015 \$3688 \$3268 \$3241 VPWR VGND \$3
+ sg13cmos5l_mux4_1
* cell instance sg13cmos5l_nand2_1_0 r0 *1 0,0
Xsg13cmos5l_nand2_1_0 \$6875 \$6021 VPWR VGND \$6878 sg13cmos5l_nand2_1
* cell instance sg13cmos5l_nand2_1_1 r0 *1 0,0
Xsg13cmos5l_nand2_1_1 \$8819 \$8133 VPWR VGND \$8818 sg13cmos5l_nand2_1
* cell instance sg13cmos5l_nand2_1_2 r0 *1 0,0
Xsg13cmos5l_nand2_1_2 \$6024 \$6735 VPWR VGND \$6736 sg13cmos5l_nand2_1
* cell instance sg13cmos5l_nand2_1_3 r0 *1 0,0
Xsg13cmos5l_nand2_1_3 \$6737 \$6879 VPWR VGND \$6880 sg13cmos5l_nand2_1
* cell instance sg13cmos5l_nand2_1_4 r0 *1 0,0
Xsg13cmos5l_nand2_1_4 \$8549 \$8133 VPWR VGND \$8453 sg13cmos5l_nand2_1
* cell instance sg13cmos5l_nand2_1_5 r0 *1 0,0
Xsg13cmos5l_nand2_1_5 \$9503 \$8133 VPWR VGND \$9421 sg13cmos5l_nand2_1
* cell instance sg13cmos5l_nand2_1_6 r0 *1 0,0
Xsg13cmos5l_nand2_1_6 \$6882 \$6021 VPWR VGND \$6881 sg13cmos5l_nand2_1
* cell instance sg13cmos5l_nand2_1_7 r0 *1 0,0
Xsg13cmos5l_nand2_1_7 \$8134 \$8133 VPWR VGND \$8031 sg13cmos5l_nand2_1
* cell instance sg13cmos5l_nand2_1_8 r0 *1 0,0
Xsg13cmos5l_nand2_1_8 \$3904 \$2680 VPWR VGND \$3903 sg13cmos5l_nand2_1
* cell instance sg13cmos5l_nand2_1_9 r0 *1 0,0
Xsg13cmos5l_nand2_1_9 \$19486 \$17275 VPWR VGND \$19485 sg13cmos5l_nand2_1
* cell instance sg13cmos5l_nand2_1_10 r0 *1 0,0
Xsg13cmos5l_nand2_1_10 \$2869 \$2680 VPWR VGND \$2681 sg13cmos5l_nand2_1
* cell instance sg13cmos5l_nand2_1_11 r0 *1 0,0
Xsg13cmos5l_nand2_1_11 \$5467 \$6021 VPWR VGND \$5466 sg13cmos5l_nand2_1
* cell instance sg13cmos5l_nand2_1_12 r0 *1 0,0
Xsg13cmos5l_nand2_1_12 \$19413 \$16437 VPWR VGND \$19412 sg13cmos5l_nand2_1
* cell instance sg13cmos5l_nand2_1_13 r0 *1 0,0
Xsg13cmos5l_nand2_1_13 \$3330 \$2680 VPWR VGND \$3128 sg13cmos5l_nand2_1
* cell instance sg13cmos5l_nand2_1_14 r0 *1 0,0
Xsg13cmos5l_nand2_1_14 \$238 \$458 VPWR VGND \$459 sg13cmos5l_nand2_1
* cell instance sg13cmos5l_nand2_1_15 r0 *1 0,0
Xsg13cmos5l_nand2_1_15 \$4125 \$5842 VPWR VGND \$6229 sg13cmos5l_nand2_1
* cell instance sg13cmos5l_nand2_1_16 r0 *1 0,0
Xsg13cmos5l_nand2_1_16 \$9085 \$8133 VPWR VGND \$8849 sg13cmos5l_nand2_1
* cell instance sg13cmos5l_nand2_1_17 r0 *1 0,0
Xsg13cmos5l_nand2_1_17 \$1191 \$3899 VPWR VGND \$3511 sg13cmos5l_nand2_1
* cell instance sg13cmos5l_nand2_1_18 r0 *1 0,0
Xsg13cmos5l_nand2_1_18 \$4670 \$6032 VPWR VGND \$5841 sg13cmos5l_nand2_1
* cell instance sg13cmos5l_nand2_1_19 r0 *1 0,0
Xsg13cmos5l_nand2_1_19 \$9825 \$8133 VPWR VGND \$9529 sg13cmos5l_nand2_1
* cell instance sg13cmos5l_nand2_1_20 r0 *1 0,0
Xsg13cmos5l_nand2_1_20 \$11400 \$12311 VPWR VGND \$12043 sg13cmos5l_nand2_1
* cell instance sg13cmos5l_nand2_1_21 r0 *1 0,0
Xsg13cmos5l_nand2_1_21 \$244 \$458 VPWR VGND \$1187 sg13cmos5l_nand2_1
* cell instance sg13cmos5l_nand2_1_22 r0 *1 0,0
Xsg13cmos5l_nand2_1_22 \$6032 \$6233 VPWR VGND \$6034 sg13cmos5l_nand2_1
* cell instance sg13cmos5l_nand2_1_23 r0 *1 0,0
Xsg13cmos5l_nand2_1_23 \$17277 \$17275 VPWR VGND \$17276 sg13cmos5l_nand2_1
* cell instance sg13cmos5l_nand2_1_24 r0 *1 0,0
Xsg13cmos5l_nand2_1_24 \$11400 \$11972 VPWR VGND \$11822 sg13cmos5l_nand2_1
* cell instance sg13cmos5l_nand2_1_25 r0 *1 0,0
Xsg13cmos5l_nand2_1_25 \$3334 \$2680 VPWR VGND \$3332 sg13cmos5l_nand2_1
* cell instance sg13cmos5l_nand2_1_26 r0 *1 0,0
Xsg13cmos5l_nand2_1_26 \$372 \$458 VPWR VGND \$371 sg13cmos5l_nand2_1
* cell instance sg13cmos5l_nand2_1_27 r0 *1 0,0
Xsg13cmos5l_nand2_1_27 \$4257 \$2680 VPWR VGND \$4262 sg13cmos5l_nand2_1
* cell instance sg13cmos5l_nand2_1_28 r0 *1 0,0
Xsg13cmos5l_nand2_1_28 \$19493 \$17275 VPWR VGND \$19492 sg13cmos5l_nand2_1
* cell instance sg13cmos5l_nand2_1_29 r0 *1 0,0
Xsg13cmos5l_nand2_1_29 \$11296 \$10921 VPWR VGND \$10743 sg13cmos5l_nand2_1
* cell instance sg13cmos5l_nand2_1_30 r0 *1 0,0
Xsg13cmos5l_nand2_1_30 \$18972 \$17275 VPWR VGND \$19044 sg13cmos5l_nand2_1
* cell instance sg13cmos5l_nand2_1_31 r0 *1 0,0
Xsg13cmos5l_nand2_1_31 \$78 \$458 VPWR VGND \$1463 sg13cmos5l_nand2_1
* cell instance sg13cmos5l_nand2_1_32 r0 *1 0,0
Xsg13cmos5l_nand2_1_32 \$4269 \$2680 VPWR VGND \$4084 sg13cmos5l_nand2_1
* cell instance sg13cmos5l_nand2_1_33 r0 *1 0,0
Xsg13cmos5l_nand2_1_33 \$7896 \$7895 VPWR VGND \$7894 sg13cmos5l_nand2_1
* cell instance sg13cmos5l_nand2_1_34 r0 *1 0,0
Xsg13cmos5l_nand2_1_34 \$2932 \$1984 VPWR VGND \$3907 sg13cmos5l_nand2_1
* cell instance sg13cmos5l_nand2_1_35 r0 *1 0,0
Xsg13cmos5l_nand2_1_35 \$19472 \$16437 VPWR VGND \$19498 sg13cmos5l_nand2_1
* cell instance sg13cmos5l_nand2_1_36 r0 *1 0,0
Xsg13cmos5l_nand2_1_36 \$382 \$458 VPWR VGND \$476 sg13cmos5l_nand2_1
* cell instance sg13cmos5l_nand2_1_37 r0 *1 0,0
Xsg13cmos5l_nand2_1_37 \$1209 \$1984 VPWR VGND \$2700 sg13cmos5l_nand2_1
* cell instance sg13cmos5l_nand2_1_38 r0 *1 0,0
Xsg13cmos5l_nand2_1_38 \$3527 \$4957 VPWR VGND \$5480 sg13cmos5l_nand2_1
* cell instance sg13cmos5l_nand2_1_39 r0 *1 0,0
Xsg13cmos5l_nand2_1_39 \$9426 \$7895 VPWR VGND \$9602 sg13cmos5l_nand2_1
* cell instance sg13cmos5l_nand2_1_40 r0 *1 0,0
Xsg13cmos5l_nand2_1_40 \$11296 \$13963 VPWR VGND \$13814 sg13cmos5l_nand2_1
* cell instance sg13cmos5l_nand2_1_41 r0 *1 0,0
Xsg13cmos5l_nand2_1_41 \$2319 \$493 VPWR VGND \$2317 sg13cmos5l_nand2_1
* cell instance sg13cmos5l_nand2_1_42 r0 *1 0,0
Xsg13cmos5l_nand2_1_42 \$11974 \$12314 VPWR VGND \$11827 sg13cmos5l_nand2_1
* cell instance sg13cmos5l_nand2_1_43 r0 *1 0,0
Xsg13cmos5l_nand2_1_43 \$17992 \$16437 VPWR VGND \$17802 sg13cmos5l_nand2_1
* cell instance sg13cmos5l_nand2_1_44 r0 *1 0,0
Xsg13cmos5l_nand2_1_44 \$11974 \$13377 VPWR VGND \$12751 sg13cmos5l_nand2_1
* cell instance sg13cmos5l_nand2_1_45 r0 *1 0,0
Xsg13cmos5l_nand2_1_45 \$263 \$458 VPWR VGND \$1048 sg13cmos5l_nand2_1
* cell instance sg13cmos5l_nand2_1_46 r0 *1 0,0
Xsg13cmos5l_nand2_1_46 \$19322 \$16435 VPWR VGND \$19323 sg13cmos5l_nand2_1
* cell instance sg13cmos5l_nand2_1_47 r0 *1 0,0
Xsg13cmos5l_nand2_1_47 \$9547 \$7895 VPWR VGND \$9548 sg13cmos5l_nand2_1
* cell instance sg13cmos5l_nand2_1_48 r0 *1 0,0
Xsg13cmos5l_nand2_1_48 \$9088 \$7895 VPWR VGND \$9079 sg13cmos5l_nand2_1
* cell instance sg13cmos5l_nand2_1_49 r0 *1 0,0
Xsg13cmos5l_nand2_1_49 \$9089 \$7895 VPWR VGND \$8555 sg13cmos5l_nand2_1
* cell instance sg13cmos5l_nand2_1_50 r0 *1 0,0
Xsg13cmos5l_nand2_1_50 \$1770 \$2320 VPWR VGND \$1644 sg13cmos5l_nand2_1
* cell instance sg13cmos5l_nand2_1_51 r0 *1 0,0
Xsg13cmos5l_nand2_1_51 \$8054 \$7895 VPWR VGND \$8122 sg13cmos5l_nand2_1
* cell instance sg13cmos5l_nand2_1_52 r0 *1 0,0
Xsg13cmos5l_nand2_1_52 \$18975 \$18974 VPWR VGND \$18749 sg13cmos5l_nand2_1
* cell instance sg13cmos5l_nand2_1_53 r0 *1 0,0
Xsg13cmos5l_nand2_1_53 \$2312 \$1793 VPWR VGND \$1326 sg13cmos5l_nand2_1
* cell instance sg13cmos5l_nand2_1_54 r0 *1 0,0
Xsg13cmos5l_nand2_1_54 \$4950 \$2680 VPWR VGND \$1969 sg13cmos5l_nand2_1
* cell instance sg13cmos5l_nand2_1_55 r0 *1 0,0
Xsg13cmos5l_nand2_1_55 \$19511 \$18974 VPWR VGND \$19510 sg13cmos5l_nand2_1
* cell instance sg13cmos5l_nand2_1_56 r0 *1 0,0
Xsg13cmos5l_nand2_1_56 \$2934 \$2708 VPWR VGND \$2933 sg13cmos5l_nand2_1
* cell instance sg13cmos5l_nand2_1_57 r0 *1 0,0
Xsg13cmos5l_nand2_1_57 \$11974 \$12927 VPWR VGND \$12219 sg13cmos5l_nand2_1
* cell instance sg13cmos5l_nand2_1_58 r0 *1 0,0
Xsg13cmos5l_nand2_1_58 \$1963 \$1793 VPWR VGND \$1965 sg13cmos5l_nand2_1
* cell instance sg13cmos5l_nand2_1_59 r0 *1 0,0
Xsg13cmos5l_nand2_1_59 \$4281 \$2680 VPWR VGND \$1619 sg13cmos5l_nand2_1
* cell instance sg13cmos5l_nand2_1_60 r0 *1 0,0
Xsg13cmos5l_nand2_1_60 \$18441 \$16435 VPWR VGND \$18236 sg13cmos5l_nand2_1
* cell instance sg13cmos5l_nand2_1_61 r0 *1 0,0
Xsg13cmos5l_nand2_1_61 \$2494 \$2322 VPWR VGND \$2491 sg13cmos5l_nand2_1
* cell instance sg13cmos5l_nand2_1_62 r0 *1 0,0
Xsg13cmos5l_nand2_1_62 \$12317 \$11974 VPWR VGND \$12047 sg13cmos5l_nand2_1
* cell instance sg13cmos5l_nand2_1_63 r0 *1 0,0
Xsg13cmos5l_nand2_1_63 \$17295 \$16435 VPWR VGND \$16436 sg13cmos5l_nand2_1
* cell instance sg13cmos5l_nand2_1_64 r0 *1 0,0
Xsg13cmos5l_nand2_1_64 \$16287 \$16437 VPWR VGND \$16438 sg13cmos5l_nand2_1
* cell instance sg13cmos5l_nand2_1_65 r0 *1 0,0
Xsg13cmos5l_nand2_1_65 \$1206 \$1318 VPWR VGND \$1412 sg13cmos5l_nand2_1
* cell instance sg13cmos5l_nand2_1_66 r0 *1 0,0
Xsg13cmos5l_nand2_1_66 \$3352 \$3523 VPWR VGND \$3524 sg13cmos5l_nand2_1
* cell instance sg13cmos5l_nand2_1_67 r0 *1 0,0
Xsg13cmos5l_nand2_1_67 \$489 \$458 VPWR VGND \$494 sg13cmos5l_nand2_1
* cell instance sg13cmos5l_nand2_1_68 r0 *1 0,0
Xsg13cmos5l_nand2_1_68 \$1929 \$1201 VPWR VGND \$2497 sg13cmos5l_nand2_1
* cell instance sg13cmos5l_nand2_1_69 r0 *1 0,0
Xsg13cmos5l_nand2_1_69 \$17297 \$16435 VPWR VGND \$17294 sg13cmos5l_nand2_1
* cell instance sg13cmos5l_nand2_1_70 r0 *1 0,0
Xsg13cmos5l_nand2_1_70 \$4481 \$4296 VPWR VGND \$3733 sg13cmos5l_nand2_1
* cell instance sg13cmos5l_nand2_1_71 r0 *1 0,0
Xsg13cmos5l_nand2_1_71 \$1963 \$2497 VPWR VGND \$2138 sg13cmos5l_nand2_1
* cell instance sg13cmos5l_nand2_1_72 r0 *1 0,0
Xsg13cmos5l_nand2_1_72 \$1770 \$2497 VPWR VGND \$1185 sg13cmos5l_nand2_1
* cell instance sg13cmos5l_nand2_1_73 r0 *1 0,0
Xsg13cmos5l_nand2_1_73 \$3487 \$4286 VPWR VGND \$4291 sg13cmos5l_nand2_1
* cell instance sg13cmos5l_nand2_1_74 r0 *1 0,0
Xsg13cmos5l_nand2_1_74 \$19561 \$18974 VPWR VGND \$19517 sg13cmos5l_nand2_1
* cell instance sg13cmos5l_nand2_1_75 r0 *1 0,0
Xsg13cmos5l_nand2_1_75 \$390 \$458 VPWR VGND \$495 sg13cmos5l_nand2_1
* cell instance sg13cmos5l_nand2_1_76 r0 *1 0,0
Xsg13cmos5l_nand2_1_76 \$1793 \$2138 VPWR VGND \$2139 sg13cmos5l_nand2_1
* cell instance sg13cmos5l_nand2_1_77 r0 *1 0,0
Xsg13cmos5l_nand2_1_77 \$4487 \$4662 VPWR VGND \$4663 sg13cmos5l_nand2_1
* cell instance sg13cmos5l_nand2_1_78 r0 *1 0,0
Xsg13cmos5l_nand2_1_78 \$4672 \$4839 VPWR VGND \$4962 sg13cmos5l_nand2_1
* cell instance sg13cmos5l_nand2_1_79 r0 *1 0,0
Xsg13cmos5l_nand2_1_79 \$6056 \$7324 VPWR VGND \$6055 sg13cmos5l_nand2_1
* cell instance sg13cmos5l_nand2_1_80 r0 *1 0,0
Xsg13cmos5l_nand2_1_80 \$937 \$2327 VPWR VGND \$2328 sg13cmos5l_nand2_1
* cell instance sg13cmos5l_nand2_1_81 r0 *1 0,0
Xsg13cmos5l_nand2_1_81 \$92 \$401 VPWR VGND \$939 sg13cmos5l_nand2_1
* cell instance sg13cmos5l_nand2_1_82 r0 *1 0,0
Xsg13cmos5l_nand2_1_82 \$4098 \$493 VPWR VGND \$2126 sg13cmos5l_nand2_1
* cell instance sg13cmos5l_nand2_1_83 r0 *1 0,0
Xsg13cmos5l_nand2_1_83 \$402 \$401 VPWR VGND \$351 sg13cmos5l_nand2_1
* cell instance sg13cmos5l_nand2_1_84 r0 *1 0,0
Xsg13cmos5l_nand2_1_84 \$4671 \$4670 VPWR VGND \$3360 sg13cmos5l_nand2_1
* cell instance sg13cmos5l_nand2_1_85 r0 *1 0,0
Xsg13cmos5l_nand2_1_85 \$19579 \$19480 VPWR VGND \$19578 sg13cmos5l_nand2_1
* cell instance sg13cmos5l_nand2_1_86 r0 *1 0,0
Xsg13cmos5l_nand2_1_86 \$1982 \$1224 VPWR VGND \$1981 sg13cmos5l_nand2_1
* cell instance sg13cmos5l_nand2_1_87 r0 *1 0,0
Xsg13cmos5l_nand2_1_87 \$4672 \$4757 VPWR VGND \$4036 sg13cmos5l_nand2_1
* cell instance sg13cmos5l_nand2_1_88 r0 *1 0,0
Xsg13cmos5l_nand2_1_88 \$1225 \$1316 VPWR VGND \$1334 sg13cmos5l_nand2_1
* cell instance sg13cmos5l_nand2_1_89 r0 *1 0,0
Xsg13cmos5l_nand2_1_89 \$3361 \$409 VPWR VGND \$3344 sg13cmos5l_nand2_1
* cell instance sg13cmos5l_nand2_1_90 r0 *1 0,0
Xsg13cmos5l_nand2_1_90 \$4036 \$2936 VPWR VGND \$4673 sg13cmos5l_nand2_1
* cell instance sg13cmos5l_nand2_1_91 r0 *1 0,0
Xsg13cmos5l_nand2_1_91 \$5082 \$5157 VPWR VGND \$5156 sg13cmos5l_nand2_1
* cell instance sg13cmos5l_nand2_1_92 r0 *1 0,0
Xsg13cmos5l_nand2_1_92 \$481 \$1984 VPWR VGND \$1797 sg13cmos5l_nand2_1
* cell instance sg13cmos5l_nand2_1_93 r0 *1 0,0
Xsg13cmos5l_nand2_1_93 \$1335 \$520 VPWR VGND \$1414 sg13cmos5l_nand2_1
* cell instance sg13cmos5l_nand2_1_94 r0 *1 0,0
Xsg13cmos5l_nand2_1_94 \$1643 \$401 VPWR VGND \$1641 sg13cmos5l_nand2_1
* cell instance sg13cmos5l_nand2_1_95 r0 *1 0,0
Xsg13cmos5l_nand2_1_95 \$2875 \$1984 VPWR VGND \$1645 sg13cmos5l_nand2_1
* cell instance sg13cmos5l_nand2_1_96 r0 *1 0,0
Xsg13cmos5l_nand2_1_96 \$652 \$401 VPWR VGND \$408 sg13cmos5l_nand2_1
* cell instance sg13cmos5l_nand2_1_97 r0 *1 0,0
Xsg13cmos5l_nand2_1_97 \$3374 \$409 VPWR VGND \$3377 sg13cmos5l_nand2_1
* cell instance sg13cmos5l_nand2_1_98 r0 *1 0,0
Xsg13cmos5l_nand2_1_98 \$2148 \$1808 VPWR VGND \$2455 sg13cmos5l_nand2_1
* cell instance sg13cmos5l_nand2_1_99 r0 *1 0,0
Xsg13cmos5l_nand2_1_99 \$2141 \$1990 VPWR VGND \$2348 sg13cmos5l_nand2_1
* cell instance sg13cmos5l_nand2_1_100 r0 *1 0,0
Xsg13cmos5l_nand2_1_100 \$2141 \$2113 VPWR VGND \$3155 sg13cmos5l_nand2_1
* cell instance sg13cmos5l_nand2_1_101 r0 *1 0,0
Xsg13cmos5l_nand2_1_101 \$1078 \$401 VPWR VGND \$1077 sg13cmos5l_nand2_1
* cell instance sg13cmos5l_nand2_1_102 r0 *1 0,0
Xsg13cmos5l_nand2_1_102 \$191 \$409 VPWR VGND \$410 sg13cmos5l_nand2_1
* cell instance sg13cmos5l_nand2_1_103 r0 *1 0,0
Xsg13cmos5l_nand2_1_103 \$1963 \$1986 VPWR VGND \$2351 sg13cmos5l_nand2_1
* cell instance sg13cmos5l_nand2_1_104 r0 *1 0,0
Xsg13cmos5l_nand2_1_104 \$58 \$4979 VPWR VGND \$5672 sg13cmos5l_nand2_1
* cell instance sg13cmos5l_nand2_1_105 r0 *1 0,0
Xsg13cmos5l_nand2_1_105 \$3929 \$409 VPWR VGND \$3157 sg13cmos5l_nand2_1
* cell instance sg13cmos5l_nand2_1_106 r0 *1 0,0
Xsg13cmos5l_nand2_1_106 \$5527 \$5522 VPWR VGND \$5526 sg13cmos5l_nand2_1
* cell instance sg13cmos5l_nand2_1_107 r0 *1 0,0
Xsg13cmos5l_nand2_1_107 \$3 \$4979 VPWR VGND \$5674 sg13cmos5l_nand2_1
* cell instance sg13cmos5l_nand2_1_108 r0 *1 0,0
Xsg13cmos5l_nand2_1_108 \$5287 \$5675 VPWR VGND \$5668 sg13cmos5l_nand2_1
* cell instance sg13cmos5l_nand2_1_109 r0 *1 0,0
Xsg13cmos5l_nand2_1_109 \$3538 \$409 VPWR VGND \$2737 sg13cmos5l_nand2_1
* cell instance sg13cmos5l_nand2_1_110 r0 *1 0,0
Xsg13cmos5l_nand2_1_110 \$3937 \$409 VPWR VGND \$1814 sg13cmos5l_nand2_1
* cell instance sg13cmos5l_nand2_1_111 r0 *1 0,0
Xsg13cmos5l_nand2_1_111 \$1243 \$401 VPWR VGND \$1242 sg13cmos5l_nand2_1
* cell instance sg13cmos5l_nand2_1_112 r0 *1 0,0
Xsg13cmos5l_nand2_1_112 \$4856 \$4773 VPWR VGND \$4855 sg13cmos5l_nand2_1
* cell instance sg13cmos5l_nand2_1_113 r0 *1 0,0
Xsg13cmos5l_nand2_1_113 \$4856 \$2020 VPWR VGND \$4978 sg13cmos5l_nand2_1
* cell instance sg13cmos5l_nand2_1_114 r0 *1 0,0
Xsg13cmos5l_nand2_1_114 \$2168 \$409 VPWR VGND \$2167 sg13cmos5l_nand2_1
* cell instance sg13cmos5l_nand2_1_115 r0 *1 0,0
Xsg13cmos5l_nand2_1_115 \$5010 \$4927 VPWR VGND \$6085 sg13cmos5l_nand2_1
* cell instance sg13cmos5l_nand2_1_116 r0 *1 0,0
Xsg13cmos5l_nand2_1_116 \$5083 \$5307 VPWR VGND \$5310 sg13cmos5l_nand2_1
* cell instance sg13cmos5l_nand2_1_117 r0 *1 0,0
Xsg13cmos5l_nand2_1_117 \$6054 \$6301 VPWR VGND \$6203 sg13cmos5l_nand2_1
* cell instance sg13cmos5l_nand2_1_118 r0 *1 0,0
Xsg13cmos5l_nand2_1_118 \$3570 \$3960 VPWR VGND \$3949 sg13cmos5l_nand2_1
* cell instance sg13cmos5l_nand2_1_119 r0 *1 0,0
Xsg13cmos5l_nand2_1_119 \$3785 \$4862 VPWR VGND \$5004 sg13cmos5l_nand2_1
* cell instance sg13cmos5l_nand2_1_120 r0 *1 0,0
Xsg13cmos5l_nand2_1_120 \$5529 \$5531 VPWR VGND \$5688 sg13cmos5l_nand2_1
* cell instance sg13cmos5l_nand2_1_121 r0 *1 0,0
Xsg13cmos5l_nand2_1_121 \$5010 \$4536 VPWR VGND \$4760 sg13cmos5l_nand2_1
* cell instance sg13cmos5l_nand2_1_122 r0 *1 0,0
Xsg13cmos5l_nand2_1_122 \$4760 \$4925 VPWR VGND \$5006 sg13cmos5l_nand2_1
* cell instance sg13cmos5l_nand2_1_123 r0 *1 0,0
Xsg13cmos5l_nand2_1_123 \$2547 \$2998 VPWR VGND \$1843 sg13cmos5l_nand2_1
* cell instance sg13cmos5l_nand2_1_124 r0 *1 0,0
Xsg13cmos5l_nand2_1_124 \$5050 \$4853 VPWR VGND \$5316 sg13cmos5l_nand2_1
* cell instance sg13cmos5l_nand2_1_125 r0 *1 0,0
Xsg13cmos5l_nand2_1_125 \$2027 \$1839 VPWR VGND \$1924 sg13cmos5l_nand2_1
* cell instance sg13cmos5l_nand2_1_126 r0 *1 0,0
Xsg13cmos5l_nand2_1_126 \$2189 \$1854 VPWR VGND \$2190 sg13cmos5l_nand2_1
* cell instance sg13cmos5l_nand2_1_127 r0 *1 0,0
Xsg13cmos5l_nand2_1_127 \$1846 \$1843 VPWR VGND \$1847 sg13cmos5l_nand2_1
* cell instance sg13cmos5l_nand2_1_128 r0 *1 0,0
Xsg13cmos5l_nand2_1_128 \$1550 \$5187 VPWR VGND \$5330 sg13cmos5l_nand2_1
* cell instance sg13cmos5l_nand2_1_129 r0 *1 0,0
Xsg13cmos5l_nand2_1_129 \$4861 \$4925 VPWR VGND \$4864 sg13cmos5l_nand2_1
* cell instance sg13cmos5l_nand2_1_130 r0 *1 0,0
Xsg13cmos5l_nand2_1_130 \$1823 \$2380 VPWR VGND \$2381 sg13cmos5l_nand2_1
* cell instance sg13cmos5l_nand2_1_131 r0 *1 0,0
Xsg13cmos5l_nand2_1_131 \$1689 \$5187 VPWR VGND \$5191 sg13cmos5l_nand2_1
* cell instance sg13cmos5l_nand2_1_132 r0 *1 0,0
Xsg13cmos5l_nand2_1_132 \$105 \$65 VPWR VGND \$433 sg13cmos5l_nand2_1
* cell instance sg13cmos5l_nand2_1_133 r0 *1 0,0
Xsg13cmos5l_nand2_1_133 \$2765 \$2384 VPWR VGND \$2764 sg13cmos5l_nand2_1
* cell instance sg13cmos5l_nand2_1_134 r0 *1 0,0
Xsg13cmos5l_nand2_1_134 \$1125 \$558 VPWR VGND \$988 sg13cmos5l_nand2_1
* cell instance sg13cmos5l_nand2_1_135 r0 *1 0,0
Xsg13cmos5l_nand2_1_135 \$1863 \$5187 VPWR VGND \$5332 sg13cmos5l_nand2_1
* cell instance sg13cmos5l_nand2_1_136 r0 *1 0,0
Xsg13cmos5l_nand2_1_136 \$2669 \$3786 VPWR VGND \$3965 sg13cmos5l_nand2_1
* cell instance sg13cmos5l_nand2_1_137 r0 *1 0,0
Xsg13cmos5l_nand2_1_137 \$3409 \$3318 VPWR VGND \$4335 sg13cmos5l_nand2_1
* cell instance sg13cmos5l_nand2_1_138 r0 *1 0,0
Xsg13cmos5l_nand2_1_138 \$41 \$93 VPWR VGND \$1270 sg13cmos5l_nand2_1
* cell instance sg13cmos5l_nand2_1_139 r0 *1 0,0
Xsg13cmos5l_nand2_1_139 \$1692 \$5187 VPWR VGND \$5192 sg13cmos5l_nand2_1
* cell instance sg13cmos5l_nand2_1_140 r0 *1 0,0
Xsg13cmos5l_nand2_1_140 \$2669 \$3017 VPWR VGND \$3016 sg13cmos5l_nand2_1
* cell instance sg13cmos5l_nand2_1_141 r0 *1 0,0
Xsg13cmos5l_nand2_1_141 \$2210 \$3201 VPWR VGND \$3202 sg13cmos5l_nand2_1
* cell instance sg13cmos5l_nand2_1_142 r0 *1 0,0
Xsg13cmos5l_nand2_1_142 \$1905 \$5187 VPWR VGND \$5193 sg13cmos5l_nand2_1
* cell instance sg13cmos5l_nand2_1_143 r0 *1 0,0
Xsg13cmos5l_nand2_1_143 \$2382 \$1876 VPWR VGND \$2046 sg13cmos5l_nand2_1
* cell instance sg13cmos5l_nand2_1_144 r0 *1 0,0
Xsg13cmos5l_nand2_1_144 \$4686 \$4986 VPWR VGND \$4862 sg13cmos5l_nand2_1
* cell instance sg13cmos5l_nand2_1_145 r0 *1 0,0
Xsg13cmos5l_nand2_1_145 \$5570 \$5334 VPWR VGND \$5713 sg13cmos5l_nand2_1
* cell instance sg13cmos5l_nand2_1_146 r0 *1 0,0
Xsg13cmos5l_nand2_1_146 \$1694 \$2384 VPWR VGND \$7 sg13cmos5l_nand2_1
* cell instance sg13cmos5l_nand2_1_147 r0 *1 0,0
Xsg13cmos5l_nand2_1_147 \$15 \$5187 VPWR VGND \$5194 sg13cmos5l_nand2_1
* cell instance sg13cmos5l_nand2_1_148 r0 *1 0,0
Xsg13cmos5l_nand2_1_148 \$105 \$15 VPWR VGND \$1266 sg13cmos5l_nand2_1
* cell instance sg13cmos5l_nand2_1_149 r0 *1 0,0
Xsg13cmos5l_nand2_1_149 \$1266 \$419 VPWR VGND \$1130 sg13cmos5l_nand2_1
* cell instance sg13cmos5l_nand2_1_150 r0 *1 0,0
Xsg13cmos5l_nand2_1_150 \$3592 \$3676 VPWR VGND \$2211 sg13cmos5l_nand2_1
* cell instance sg13cmos5l_nand2_1_151 r0 *1 0,0
Xsg13cmos5l_nand2_1_151 \$5571 \$5337 VPWR VGND \$5562 sg13cmos5l_nand2_1
* cell instance sg13cmos5l_nand2_1_152 r0 *1 0,0
Xsg13cmos5l_nand2_1_152 \$2210 \$2388 VPWR VGND \$2573 sg13cmos5l_nand2_1
* cell instance sg13cmos5l_nand2_1_153 r0 *1 0,0
Xsg13cmos5l_nand2_1_153 \$5565 \$5334 VPWR VGND \$5717 sg13cmos5l_nand2_1
* cell instance sg13cmos5l_nand2_1_154 r0 *1 0,0
Xsg13cmos5l_nand2_1_154 \$1362 \$2231 VPWR VGND \$3593 sg13cmos5l_nand2_1
* cell instance sg13cmos5l_nand2_1_155 r0 *1 0,0
Xsg13cmos5l_nand2_1_155 \$21 \$20 VPWR VGND \$17 sg13cmos5l_nand2_1
* cell instance sg13cmos5l_nand2_1_156 r0 *1 0,0
Xsg13cmos5l_nand2_1_156 \$455 \$430 VPWR VGND \$564 sg13cmos5l_nand2_1
* cell instance sg13cmos5l_nand2_1_157 r0 *1 0,0
Xsg13cmos5l_nand2_1_157 \$5961 \$5564 VPWR VGND \$6347 sg13cmos5l_nand2_1
* cell instance sg13cmos5l_nand2_1_158 r0 *1 0,0
Xsg13cmos5l_nand2_1_158 \$5576 \$5564 VPWR VGND \$5718 sg13cmos5l_nand2_1
* cell instance sg13cmos5l_nand2_1_159 r0 *1 0,0
Xsg13cmos5l_nand2_1_159 \$23 \$1280 VPWR VGND \$1263 sg13cmos5l_nand2_1
* cell instance sg13cmos5l_nand2_1_160 r0 *1 0,0
Xsg13cmos5l_nand2_1_160 \$1694 \$2218 VPWR VGND \$3211 sg13cmos5l_nand2_1
* cell instance sg13cmos5l_nand2_1_161 r0 *1 0,0
Xsg13cmos5l_nand2_1_161 \$3595 \$3414 VPWR VGND \$2766 sg13cmos5l_nand2_1
* cell instance sg13cmos5l_nand2_1_162 r0 *1 0,0
Xsg13cmos5l_nand2_1_162 \$120 \$27 VPWR VGND \$96 sg13cmos5l_nand2_1
* cell instance sg13cmos5l_nand2_1_163 r0 *1 0,0
Xsg13cmos5l_nand2_1_163 \$113 \$436 VPWR VGND \$119 sg13cmos5l_nand2_1
* cell instance sg13cmos5l_nand2_1_164 r0 *1 0,0
Xsg13cmos5l_nand2_1_164 \$4681 \$5365 VPWR VGND \$5366 sg13cmos5l_nand2_1
* cell instance sg13cmos5l_nand2_1_165 r0 *1 0,0
Xsg13cmos5l_nand2_1_165 \$121 \$866 VPWR VGND \$721 sg13cmos5l_nand2_1
* cell instance sg13cmos5l_nand2_1_166 r0 *1 0,0
Xsg13cmos5l_nand2_1_166 \$1003 \$121 VPWR VGND \$563 sg13cmos5l_nand2_1
* cell instance sg13cmos5l_nand2_1_167 r0 *1 0,0
Xsg13cmos5l_nand2_1_167 \$4344 \$4343 VPWR VGND \$4172 sg13cmos5l_nand2_1
* cell instance sg13cmos5l_nand2_1_168 r0 *1 0,0
Xsg13cmos5l_nand2_1_168 \$5970 \$5564 VPWR VGND \$6011 sg13cmos5l_nand2_1
* cell instance sg13cmos5l_nand2_1_169 r0 *1 0,0
Xsg13cmos5l_nand2_1_169 \$34 \$50 VPWR VGND \$33 sg13cmos5l_nand2_1
* cell instance sg13cmos5l_nand2_1_170 r0 *1 0,0
Xsg13cmos5l_nand2_1_170 \$121 \$103 VPWR VGND \$216 sg13cmos5l_nand2_1
* cell instance sg13cmos5l_nand2_1_171 r0 *1 0,0
Xsg13cmos5l_nand2_1_171 \$72 \$103 VPWR VGND \$342 sg13cmos5l_nand2_1
* cell instance sg13cmos5l_nand2_1_172 r0 *1 0,0
Xsg13cmos5l_nand2_1_172 \$1576 \$345 VPWR VGND \$439 sg13cmos5l_nand2_1
* cell instance sg13cmos5l_nand2_1_173 r0 *1 0,0
Xsg13cmos5l_nand2_1_173 \$23 \$121 VPWR VGND \$1144 sg13cmos5l_nand2_1
* cell instance sg13cmos5l_nand2_1_174 r0 *1 0,0
Xsg13cmos5l_nand2_1_174 \$4417 \$4343 VPWR VGND \$5025 sg13cmos5l_nand2_1
* cell instance sg13cmos5l_nand2_1_175 r0 *1 0,0
Xsg13cmos5l_nand2_1_175 \$53 \$72 VPWR VGND \$121 sg13cmos5l_nand2_1
* cell instance sg13cmos5l_nand2_1_176 r0 *1 0,0
Xsg13cmos5l_nand2_1_176 \$4880 \$4345 VPWR VGND \$5203 sg13cmos5l_nand2_1
* cell instance sg13cmos5l_nand2_1_177 r0 *1 0,0
Xsg13cmos5l_nand2_1_177 \$129 \$65 VPWR VGND \$1006 sg13cmos5l_nand2_1
* cell instance sg13cmos5l_nand2_1_178 r0 *1 0,0
Xsg13cmos5l_nand2_1_178 \$1006 \$866 VPWR VGND \$1566 sg13cmos5l_nand2_1
* cell instance sg13cmos5l_nand2_1_179 r0 *1 0,0
Xsg13cmos5l_nand2_1_179 \$2787 \$2384 VPWR VGND \$3028 sg13cmos5l_nand2_1
* cell instance sg13cmos5l_nand2_1_180 r0 *1 0,0
Xsg13cmos5l_nand2_1_180 \$2592 \$2384 VPWR VGND \$2593 sg13cmos5l_nand2_1
* cell instance sg13cmos5l_nand2_1_181 r0 *1 0,0
Xsg13cmos5l_nand2_1_181 \$4346 \$4345 VPWR VGND \$4171 sg13cmos5l_nand2_1
* cell instance sg13cmos5l_nand2_1_182 r0 *1 0,0
Xsg13cmos5l_nand2_1_182 \$223 \$575 VPWR VGND \$576 sg13cmos5l_nand2_1
* cell instance sg13cmos5l_nand2_1_183 r0 *1 0,0
Xsg13cmos5l_nand2_1_183 \$4880 \$4704 VPWR VGND \$4881 sg13cmos5l_nand2_1
* cell instance sg13cmos5l_nand2_1_184 r0 *1 0,0
Xsg13cmos5l_nand2_1_184 \$4344 \$5368 VPWR VGND \$5391 sg13cmos5l_nand2_1
* cell instance sg13cmos5l_nand2_1_185 r0 *1 0,0
Xsg13cmos5l_nand2_1_185 \$105 \$72 VPWR VGND \$48 sg13cmos5l_nand2_1
* cell instance sg13cmos5l_nand2_1_186 r0 *1 0,0
Xsg13cmos5l_nand2_1_186 \$4344 \$5026 VPWR VGND \$5027 sg13cmos5l_nand2_1
* cell instance sg13cmos5l_nand2_1_187 r0 *1 0,0
Xsg13cmos5l_nand2_1_187 \$115 \$67 VPWR VGND \$127 sg13cmos5l_nand2_1
* cell instance sg13cmos5l_nand2_1_188 r0 *1 0,0
Xsg13cmos5l_nand2_1_188 \$3833 \$3982 VPWR VGND \$4189 sg13cmos5l_nand2_1
* cell instance sg13cmos5l_nand2_1_189 r0 *1 0,0
Xsg13cmos5l_nand2_1_189 \$343 \$34 VPWR VGND \$57 sg13cmos5l_nand2_1
* cell instance sg13cmos5l_nand2_1_190 r0 *1 0,0
Xsg13cmos5l_nand2_1_190 \$4125 \$5373 VPWR VGND \$5759 sg13cmos5l_nand2_1
* cell instance sg13cmos5l_nand2_1_191 r0 *1 0,0
Xsg13cmos5l_nand2_1_191 \$5204 \$5438 VPWR VGND \$5441 sg13cmos5l_nand2_1
* cell instance sg13cmos5l_nand2_1_192 r0 *1 0,0
Xsg13cmos5l_nand2_1_192 \$1362 \$5373 VPWR VGND \$5760 sg13cmos5l_nand2_1
* cell instance sg13cmos5l_nand2_1_193 r0 *1 0,0
Xsg13cmos5l_nand2_1_193 \$3829 \$2803 VPWR VGND \$3828 sg13cmos5l_nand2_1
* cell instance sg13cmos5l_nand2_1_194 r0 *1 0,0
Xsg13cmos5l_nand2_1_194 \$3833 \$3824 VPWR VGND \$4568 sg13cmos5l_nand2_1
* cell instance sg13cmos5l_nand2_1_195 r0 *1 0,0
Xsg13cmos5l_nand2_1_195 \$2786 \$4884 VPWR VGND \$4887 sg13cmos5l_nand2_1
* cell instance sg13cmos5l_nand2_1_196 r0 *1 0,0
Xsg13cmos5l_nand2_1_196 \$4572 \$2817 VPWR VGND \$4571 sg13cmos5l_nand2_1
* cell instance sg13cmos5l_nand2_1_197 r0 *1 0,0
Xsg13cmos5l_nand2_1_197 \$2786 \$5211 VPWR VGND \$5212 sg13cmos5l_nand2_1
* cell instance sg13cmos5l_nand2_1_198 r0 *1 0,0
Xsg13cmos5l_nand2_1_198 \$3833 \$3608 VPWR VGND \$3834 sg13cmos5l_nand2_1
* cell instance sg13cmos5l_nand2_1_199 r0 *1 0,0
Xsg13cmos5l_nand2_1_199 \$4000 \$2256 VPWR VGND \$3999 sg13cmos5l_nand2_1
* cell instance sg13cmos5l_nand2_1_200 r0 *1 0,0
Xsg13cmos5l_nand2_1_200 \$4574 \$2620 VPWR VGND \$4362 sg13cmos5l_nand2_1
* cell instance sg13cmos5l_nand2_1_201 r0 *1 0,0
Xsg13cmos5l_nand2_1_201 \$6856 \$6855 VPWR VGND \$6645 sg13cmos5l_nand2_1
* cell instance sg13cmos5l_nand2_1_202 r0 *1 0,0
Xsg13cmos5l_nand2_1_202 \$5771 \$5584 VPWR VGND \$5044 sg13cmos5l_nand2_1
* cell instance sg13cmos5l_nand2_1_203 r0 *1 0,0
Xsg13cmos5l_nand2_1_203 \$4725 \$4705 VPWR VGND \$4724 sg13cmos5l_nand2_1
* cell instance sg13cmos5l_nand2_1_204 r0 *1 0,0
Xsg13cmos5l_nand2_1_204 \$6212 \$6387 VPWR VGND \$6388 sg13cmos5l_nand2_1
* cell instance sg13cmos5l_nand2_1_205 r0 *1 0,0
Xsg13cmos5l_nand2_1_205 \$4725 \$4353 VPWR VGND \$4727 sg13cmos5l_nand2_1
* cell instance sg13cmos5l_nand2_1_206 r0 *1 0,0
Xsg13cmos5l_nand2_1_206 \$3023 \$5046 VPWR VGND \$5048 sg13cmos5l_nand2_1
* cell instance sg13cmos5l_nand2_1_207 r0 *1 0,0
Xsg13cmos5l_nand2_1_207 \$6855 \$5684 VPWR VGND \$7225 sg13cmos5l_nand2_1
* cell instance sg13cmos5l_nand2_1_208 r0 *1 0,0
Xsg13cmos5l_nand2_1_208 \$6185 \$6184 VPWR VGND \$5993 sg13cmos5l_nand2_1
* cell instance sg13cmos5l_nand2_1_209 r0 *1 0,0
Xsg13cmos5l_nand2_1_209 \$6938 \$6937 VPWR VGND \$6858 sg13cmos5l_nand2_1
* cell instance sg13cmos5l_nand2_1_210 r0 *1 0,0
Xsg13cmos5l_nand2_1_210 \$5050 \$4586 VPWR VGND \$5589 sg13cmos5l_nand2_1
* cell instance sg13cmos5l_nand2_1_211 r0 *1 0,0
Xsg13cmos5l_nand2_1_211 \$3268 \$3254 VPWR VGND \$3484 sg13cmos5l_nand2_1
* cell instance sg13cmos5l_nand2_1_212 r0 *1 0,0
Xsg13cmos5l_nand2_1_212 \$3856 \$4013 VPWR VGND \$4014 sg13cmos5l_nand2_1
* cell instance sg13cmos5l_nand2_1_213 r0 *1 0,0
Xsg13cmos5l_nand2_1_213 \$5053 \$5052 VPWR VGND \$5056 sg13cmos5l_nand2_1
* cell instance sg13cmos5l_nand2_1_214 r0 *1 0,0
Xsg13cmos5l_nand2_1_214 \$5580 \$5996 VPWR VGND \$5784 sg13cmos5l_nand2_1
* cell instance sg13cmos5l_nand2_1_215 r0 *1 0,0
Xsg13cmos5l_nand2_1_215 \$4017 \$4773 VPWR VGND \$4253 sg13cmos5l_nand2_1
* cell instance sg13cmos5l_nand2_1_216 r0 *1 0,0
Xsg13cmos5l_nand2_1_216 \$5996 \$6188 VPWR VGND \$6187 sg13cmos5l_nand2_1
* cell instance sg13cmos5l_nand2_1_217 r0 *1 0,0
Xsg13cmos5l_nand2_1_217 \$2466 \$5055 VPWR VGND \$5996 sg13cmos5l_nand2_1
* cell instance sg13cmos5l_nand2_1_218 r0 *1 0,0
Xsg13cmos5l_nand2_1_218 \$5089 \$4383 VPWR VGND \$5222 sg13cmos5l_nand2_1
* cell instance sg13cmos5l_nand2_1_219 r0 *1 0,0
Xsg13cmos5l_nand2_1_219 \$5089 \$5060 VPWR VGND \$5404 sg13cmos5l_nand2_1
* cell instance sg13cmos5l_nand2_1_220 r0 *1 0,0
Xsg13cmos5l_nand2_1_220 \$5399 \$5060 VPWR VGND \$5600 sg13cmos5l_nand2_1
* cell instance sg13cmos5l_nand2_1_221 r0 *1 0,0
Xsg13cmos5l_nand2_1_221 \$3 \$4383 VPWR VGND \$6000 sg13cmos5l_nand2_1
* cell instance sg13cmos5l_nand2b_1_0 r0 *1 0,0
Xsg13cmos5l_nand2b_1_0 \$6417 \$6886 VPWR VGND \$6846 sg13cmos5l_nand2b_1
* cell instance sg13cmos5l_nand2b_1_1 r0 *1 0,0
Xsg13cmos5l_nand2b_1_1 \$7457 \$7489 VPWR VGND \$6886 sg13cmos5l_nand2b_1
* cell instance sg13cmos5l_nand2b_1_2 r0 *1 0,0
Xsg13cmos5l_nand2b_1_2 \$3323 \$2932 VPWR VGND \$3347 sg13cmos5l_nand2b_1
* cell instance sg13cmos5l_nand2b_1_3 r0 *1 0,0
Xsg13cmos5l_nand2b_1_3 \$3352 \$3523 VPWR VGND \$3145 sg13cmos5l_nand2b_1
* cell instance sg13cmos5l_nand2b_1_4 r0 *1 0,0
Xsg13cmos5l_nand2b_1_4 \$3353 \$3527 VPWR VGND \$3523 sg13cmos5l_nand2b_1
* cell instance sg13cmos5l_nand2b_1_5 r0 *1 0,0
Xsg13cmos5l_nand2b_1_5 \$1324 \$1326 VPWR VGND \$1413 sg13cmos5l_nand2b_1
* cell instance sg13cmos5l_nand2b_1_6 r0 *1 0,0
Xsg13cmos5l_nand2b_1_6 \$3352 \$3353 VPWR VGND \$2701 sg13cmos5l_nand2b_1
* cell instance sg13cmos5l_nand2b_1_7 r0 *1 0,0
Xsg13cmos5l_nand2b_1_7 \$3353 \$4092 VPWR VGND \$2324 sg13cmos5l_nand2b_1
* cell instance sg13cmos5l_nand2b_1_8 r0 *1 0,0
Xsg13cmos5l_nand2b_1_8 \$1410 \$3352 VPWR VGND \$3356 sg13cmos5l_nand2b_1
* cell instance sg13cmos5l_nand2b_1_9 r0 *1 0,0
Xsg13cmos5l_nand2b_1_9 \$1324 \$2139 VPWR VGND \$1066 sg13cmos5l_nand2b_1
* cell instance sg13cmos5l_nand2b_1_10 r0 *1 0,0
Xsg13cmos5l_nand2b_1_10 \$1511 \$2313 VPWR VGND \$2330 sg13cmos5l_nand2b_1
* cell instance sg13cmos5l_nand2b_1_11 r0 *1 0,0
Xsg13cmos5l_nand2b_1_11 \$2135 \$3729 VPWR VGND \$2710 sg13cmos5l_nand2b_1
* cell instance sg13cmos5l_nand2b_1_12 r0 *1 0,0
Xsg13cmos5l_nand2b_1_12 \$4100 \$5875 VPWR VGND \$5797 sg13cmos5l_nand2b_1
* cell instance sg13cmos5l_nand2b_1_13 r0 *1 0,0
Xsg13cmos5l_nand2b_1_13 \$1511 \$1193 VPWR VGND \$1735 sg13cmos5l_nand2b_1
* cell instance sg13cmos5l_nand2b_1_14 r0 *1 0,0
Xsg13cmos5l_nand2b_1_14 \$4685 \$4841 VPWR VGND \$4853 sg13cmos5l_nand2b_1
* cell instance sg13cmos5l_nand2b_1_15 r0 *1 0,0
Xsg13cmos5l_nand2b_1_15 \$4517 \$4523 VPWR VGND \$4524 sg13cmos5l_nand2b_1
* cell instance sg13cmos5l_nand2b_1_16 r0 *1 0,0
Xsg13cmos5l_nand2b_1_16 \$5684 \$5682 VPWR VGND \$4523 sg13cmos5l_nand2b_1
* cell instance sg13cmos5l_nand2b_1_17 r0 *1 0,0
Xsg13cmos5l_nand2b_1_17 \$1845 \$2195 VPWR VGND \$2542 sg13cmos5l_nand2b_1
* cell instance sg13cmos5l_nand2b_1_18 r0 *1 0,0
Xsg13cmos5l_nand2b_1_18 \$2985 \$3407 VPWR VGND \$3408 sg13cmos5l_nand2b_1
* cell instance sg13cmos5l_nand2b_1_19 r0 *1 0,0
Xsg13cmos5l_nand2b_1_19 \$864 \$5187 VPWR VGND \$5424 sg13cmos5l_nand2b_1
* cell instance sg13cmos5l_nand2b_1_20 r0 *1 0,0
Xsg13cmos5l_nand2b_1_20 \$856 \$558 VPWR VGND \$1124 sg13cmos5l_nand2b_1
* cell instance sg13cmos5l_nand2b_1_21 r0 *1 0,0
Xsg13cmos5l_nand2b_1_21 \$2381 \$1125 VPWR VGND \$1863 sg13cmos5l_nand2b_1
* cell instance sg13cmos5l_nand2b_1_22 r0 *1 0,0
Xsg13cmos5l_nand2b_1_22 \$1125 \$558 VPWR VGND \$1027 sg13cmos5l_nand2b_1
* cell instance sg13cmos5l_nand2b_1_23 r0 *1 0,0
Xsg13cmos5l_nand2b_1_23 \$6123 \$6211 VPWR VGND \$5927 sg13cmos5l_nand2b_1
* cell instance sg13cmos5l_nand2b_1_24 r0 *1 0,0
Xsg13cmos5l_nand2b_1_24 \$2997 \$3302 VPWR VGND \$2391 sg13cmos5l_nand2b_1
* cell instance sg13cmos5l_nand2b_1_25 r0 *1 0,0
Xsg13cmos5l_nand2b_1_25 \$5 \$15 VPWR VGND \$1002 sg13cmos5l_nand2b_1
* cell instance sg13cmos5l_nand2b_1_26 r0 *1 0,0
Xsg13cmos5l_nand2b_1_26 \$12 \$36 VPWR VGND \$19 sg13cmos5l_nand2b_1
* cell instance sg13cmos5l_nand2b_1_27 r0 *1 0,0
Xsg13cmos5l_nand2b_1_27 \$5025 \$5204 VPWR VGND \$4986 sg13cmos5l_nand2b_1
* cell instance sg13cmos5l_nand2b_1_28 r0 *1 0,0
Xsg13cmos5l_nand2b_1_28 \$730 \$866 VPWR VGND \$1570 sg13cmos5l_nand2b_1
* cell instance sg13cmos5l_nand2b_1_29 r0 *1 0,0
Xsg13cmos5l_nand2b_1_29 \$34 \$53 VPWR VGND \$578 sg13cmos5l_nand2b_1
* cell instance sg13cmos5l_nand2b_1_30 r0 *1 0,0
Xsg13cmos5l_nand2b_1_30 \$72 \$53 VPWR VGND \$115 sg13cmos5l_nand2b_1
* cell instance sg13cmos5l_nand2b_1_31 r0 *1 0,0
Xsg13cmos5l_nand2b_1_31 \$53 \$76 VPWR VGND \$67 sg13cmos5l_nand2b_1
* cell instance sg13cmos5l_nand2b_1_32 r0 *1 0,0
Xsg13cmos5l_nand2b_1_32 \$5203 \$5438 VPWR VGND \$5439 sg13cmos5l_nand2b_1
* cell instance sg13cmos5l_nand2b_1_33 r0 *1 0,0
Xsg13cmos5l_nand2b_1_33 \$3493 \$3491 VPWR VGND \$3617 sg13cmos5l_nand2b_1
* cell instance sg13cmos5l_nand2b_1_34 r0 *1 0,0
Xsg13cmos5l_nand2b_1_34 \$3620 \$3491 VPWR VGND \$3615 sg13cmos5l_nand2b_1
* cell instance sg13cmos5l_nand2b_1_35 r0 *1 0,0
Xsg13cmos5l_nand2b_1_35 \$5047 \$5048 VPWR VGND \$6016 sg13cmos5l_nand2b_1
* cell instance sg13cmos5l_nand2b_1_36 r0 *1 0,0
Xsg13cmos5l_nand2b_1_36 \$5439 \$5394 VPWR VGND \$5592 sg13cmos5l_nand2b_1
* cell instance sg13cmos5l_nand2b_1_37 r0 *1 0,0
Xsg13cmos5l_nand2b_1_37 \$6857 \$6939 VPWR VGND \$6941 sg13cmos5l_nand2b_1
* cell instance sg13cmos5l_nand2b_1_38 r0 *1 0,0
Xsg13cmos5l_nand2b_1_38 \$5787 \$6000 VPWR VGND \$6189 sg13cmos5l_nand2b_1
* cell instance sg13cmos5l_nand3_1_0 r0 *1 0,0
Xsg13cmos5l_nand3_1_0 \$1180 \$1185 \$1184 VPWR VGND \$1035 sg13cmos5l_nand3_1
* cell instance sg13cmos5l_nand3_1_1 r0 *1 0,0
Xsg13cmos5l_nand3_1_1 \$1760 \$1765 \$1184 VPWR VGND \$1764 sg13cmos5l_nand3_1
* cell instance sg13cmos5l_nand3_1_2 r0 *1 0,0
Xsg13cmos5l_nand3_1_2 \$2129 \$2138 \$1768 VPWR VGND \$2128 sg13cmos5l_nand3_1
* cell instance sg13cmos5l_nand3_1_3 r0 *1 0,0
Xsg13cmos5l_nand3_1_3 \$1574 \$2489 \$2311 VPWR VGND \$2488 sg13cmos5l_nand3_1
* cell instance sg13cmos5l_nand3_1_4 r0 *1 0,0
Xsg13cmos5l_nand3_1_4 \$3134 \$2321 \$2311 VPWR VGND \$3136 sg13cmos5l_nand3_1
* cell instance sg13cmos5l_nand3_1_5 r0 *1 0,0
Xsg13cmos5l_nand3_1_5 \$3323 \$1410 \$2311 VPWR VGND \$3515 sg13cmos5l_nand3_1
* cell instance sg13cmos5l_nand3_1_6 r0 *1 0,0
Xsg13cmos5l_nand3_1_6 \$2699 \$2491 \$1184 VPWR VGND \$2315 sg13cmos5l_nand3_1
* cell instance sg13cmos5l_nand3_1_7 r0 *1 0,0
Xsg13cmos5l_nand3_1_7 \$1949 \$3139 \$2311 VPWR VGND \$3138 sg13cmos5l_nand3_1
* cell instance sg13cmos5l_nand3_1_8 r0 *1 0,0
Xsg13cmos5l_nand3_1_8 \$473 \$1644 \$1184 VPWR VGND \$780 sg13cmos5l_nand3_1
* cell instance sg13cmos5l_nand3_1_9 r0 *1 0,0
Xsg13cmos5l_nand3_1_9 \$6049 \$6256 \$5864 VPWR VGND \$6048 sg13cmos5l_nand3_1
* cell instance sg13cmos5l_nand3_1_10 r0 *1 0,0
Xsg13cmos5l_nand3_1_10 \$876 \$931 \$1319 VPWR VGND \$1320 sg13cmos5l_nand3_1
* cell instance sg13cmos5l_nand3_1_11 r0 *1 0,0
Xsg13cmos5l_nand3_1_11 \$1494 \$913 \$1413 VPWR VGND \$800 sg13cmos5l_nand3_1
* cell instance sg13cmos5l_nand3_1_12 r0 *1 0,0
Xsg13cmos5l_nand3_1_12 \$2135 \$3139 \$3356 VPWR VGND \$3357 sg13cmos5l_nand3_1
* cell instance sg13cmos5l_nand3_1_13 r0 *1 0,0
Xsg13cmos5l_nand3_1_13 \$5152 \$4672 \$5148 VPWR VGND \$5153 sg13cmos5l_nand3_1
* cell instance sg13cmos5l_nand3_1_14 r0 *1 0,0
Xsg13cmos5l_nand3_1_14 \$3921 \$4096 \$3358 VPWR VGND \$4097 sg13cmos5l_nand3_1
* cell instance sg13cmos5l_nand3_1_15 r0 *1 0,0
Xsg13cmos5l_nand3_1_15 \$1068 \$1415 \$1492 VPWR VGND \$1493 sg13cmos5l_nand3_1
* cell instance sg13cmos5l_nand3_1_16 r0 *1 0,0
Xsg13cmos5l_nand3_1_16 \$1069 \$1068 \$1066 VPWR VGND \$1067 sg13cmos5l_nand3_1
* cell instance sg13cmos5l_nand3_1_17 r0 *1 0,0
Xsg13cmos5l_nand3_1_17 \$4517 \$4841 \$4839 VPWR VGND \$4846 sg13cmos5l_nand3_1
* cell instance sg13cmos5l_nand3_1_18 r0 *1 0,0
Xsg13cmos5l_nand3_1_18 \$4623 \$4841 \$4839 VPWR VGND \$4847 sg13cmos5l_nand3_1
* cell instance sg13cmos5l_nand3_1_19 r0 *1 0,0
Xsg13cmos5l_nand3_1_19 \$1963 \$2875 \$1986 VPWR VGND \$2666 sg13cmos5l_nand3_1
* cell instance sg13cmos5l_nand3_1_20 r0 *1 0,0
Xsg13cmos5l_nand3_1_20 \$811 \$1068 \$2330 VPWR VGND \$950 sg13cmos5l_nand3_1
* cell instance sg13cmos5l_nand3_1_21 r0 *1 0,0
Xsg13cmos5l_nand3_1_21 \$1348 \$1347 \$401 VPWR VGND \$1346 sg13cmos5l_nand3_1
* cell instance sg13cmos5l_nand3_1_22 r0 *1 0,0
Xsg13cmos5l_nand3_1_22 \$2148 \$956 \$2351 VPWR VGND \$2352 sg13cmos5l_nand3_1
* cell instance sg13cmos5l_nand3_1_23 r0 *1 0,0
Xsg13cmos5l_nand3_1_23 \$413 \$1346 \$1349 VPWR VGND \$1240 sg13cmos5l_nand3_1
* cell instance sg13cmos5l_nand3_1_24 r0 *1 0,0
Xsg13cmos5l_nand3_1_24 \$1520 \$956 \$1735 VPWR VGND \$1649 sg13cmos5l_nand3_1
* cell instance sg13cmos5l_nand3_1_25 r0 *1 0,0
Xsg13cmos5l_nand3_1_25 \$666 \$4523 \$4520 VPWR VGND \$4521 sg13cmos5l_nand3_1
* cell instance sg13cmos5l_nand3_1_26 r0 *1 0,0
Xsg13cmos5l_nand3_1_26 \$5418 \$4955 \$5163 VPWR VGND \$5307 sg13cmos5l_nand3_1
* cell instance sg13cmos5l_nand3_1_27 r0 *1 0,0
Xsg13cmos5l_nand3_1_27 \$1845 \$2992 \$2884 VPWR VGND \$2544 sg13cmos5l_nand3_1
* cell instance sg13cmos5l_nand3_1_28 r0 *1 0,0
Xsg13cmos5l_nand3_1_28 \$417 \$96 \$415 VPWR VGND \$416 sg13cmos5l_nand3_1
* cell instance sg13cmos5l_nand3_1_29 r0 *1 0,0
Xsg13cmos5l_nand3_1_29 \$105 \$66 \$95 VPWR VGND \$856 sg13cmos5l_nand3_1
* cell instance sg13cmos5l_nand3_1_30 r0 *1 0,0
Xsg13cmos5l_nand3_1_30 \$60 \$7 \$8 VPWR VGND \$702 sg13cmos5l_nand3_1
* cell instance sg13cmos5l_nand3_1_31 r0 *1 0,0
Xsg13cmos5l_nand3_1_31 \$4337 \$4318 \$2195 VPWR VGND \$4547 sg13cmos5l_nand3_1
* cell instance sg13cmos5l_nand3_1_32 r0 *1 0,0
Xsg13cmos5l_nand3_1_32 \$2049 \$1876 \$2214 VPWR VGND \$2106 sg13cmos5l_nand3_1
* cell instance sg13cmos5l_nand3_1_33 r0 *1 0,0
Xsg13cmos5l_nand3_1_33 \$5571 \$5570 \$5569 VPWR VGND \$5343 sg13cmos5l_nand3_1
* cell instance sg13cmos5l_nand3_1_34 r0 *1 0,0
Xsg13cmos5l_nand3_1_34 \$2669 \$3593 \$3210 VPWR VGND \$3596 sg13cmos5l_nand3_1
* cell instance sg13cmos5l_nand3_1_35 r0 *1 0,0
Xsg13cmos5l_nand3_1_35 \$5571 \$5570 \$5565 VPWR VGND \$5575 sg13cmos5l_nand3_1
* cell instance sg13cmos5l_nand3_1_36 r0 *1 0,0
Xsg13cmos5l_nand3_1_36 \$113 \$115 \$67 VPWR VGND \$114 sg13cmos5l_nand3_1
* cell instance sg13cmos5l_nand3_1_37 r0 *1 0,0
Xsg13cmos5l_nand3_1_37 \$69 \$10 \$23 VPWR VGND \$24 sg13cmos5l_nand3_1
* cell instance sg13cmos5l_nand3_1_38 r0 *1 0,0
Xsg13cmos5l_nand3_1_38 \$5723 \$5961 \$5732 VPWR VGND \$5960 sg13cmos5l_nand3_1
* cell instance sg13cmos5l_nand3_1_39 r0 *1 0,0
Xsg13cmos5l_nand3_1_39 \$15 \$23 \$25 VPWR VGND \$26 sg13cmos5l_nand3_1
* cell instance sg13cmos5l_nand3_1_40 r0 *1 0,0
Xsg13cmos5l_nand3_1_40 \$121 \$119 \$103 VPWR VGND \$120 sg13cmos5l_nand3_1
* cell instance sg13cmos5l_nand3_1_41 r0 *1 0,0
Xsg13cmos5l_nand3_1_41 \$1694 \$2588 \$2586 VPWR VGND \$2578 sg13cmos5l_nand3_1
* cell instance sg13cmos5l_nand3_1_42 r0 *1 0,0
Xsg13cmos5l_nand3_1_42 \$4417 \$4880 \$4704 VPWR VGND \$4703 sg13cmos5l_nand3_1
* cell instance sg13cmos5l_nand3_1_43 r0 *1 0,0
Xsg13cmos5l_nand3_1_43 \$1579 \$217 \$1406 VPWR VGND \$1407 sg13cmos5l_nand3_1
* cell instance sg13cmos5l_nand3_1_44 r0 *1 0,0
Xsg13cmos5l_nand3_1_44 \$1579 \$1713 \$1570 VPWR VGND \$1715 sg13cmos5l_nand3_1
* cell instance sg13cmos5l_nand3_1_45 r0 *1 0,0
Xsg13cmos5l_nand3_1_45 \$34 \$728 \$67 VPWR VGND \$731 sg13cmos5l_nand3_1
* cell instance sg13cmos5l_nand3_1_46 r0 *1 0,0
Xsg13cmos5l_nand3_1_46 \$573 \$129 \$67 VPWR VGND \$128 sg13cmos5l_nand3_1
* cell instance sg13cmos5l_nand3_1_47 r0 *1 0,0
Xsg13cmos5l_nand3_1_47 \$57 \$448 \$336 VPWR VGND \$447 sg13cmos5l_nand3_1
* cell instance sg13cmos5l_nand3_1_48 r0 *1 0,0
Xsg13cmos5l_nand3_1_48 \$3604 \$3613 \$3612 VPWR VGND \$2611 sg13cmos5l_nand3_1
* cell instance sg13cmos5l_nand3_1_49 r0 *1 0,0
Xsg13cmos5l_nand3_1_49 \$4185 \$4887 \$4885 VPWR VGND \$4886 sg13cmos5l_nand3_1
* cell instance sg13cmos5l_nand3_1_50 r0 *1 0,0
Xsg13cmos5l_nand3_1_50 \$5039 \$5038 \$5381 VPWR VGND \$4712 sg13cmos5l_nand3_1
* cell instance sg13cmos5l_nand3_1_51 r0 *1 0,0
Xsg13cmos5l_nand3_1_51 \$5212 \$5769 \$6016 VPWR VGND \$6173 sg13cmos5l_nand3_1
* cell instance sg13cmos5l_nand3_1_52 r0 *1 0,0
Xsg13cmos5l_nand3_1_52 \$6855 \$7999 \$5684 VPWR VGND \$7998 sg13cmos5l_nand3_1
* cell instance sg13cmos5l_nand3_1_53 r0 *1 0,0
Xsg13cmos5l_nand3_1_53 \$5993 \$5779 \$6383 VPWR VGND \$6390 sg13cmos5l_nand3_1
* cell instance sg13cmos5l_nand3_1_54 r0 *1 0,0
Xsg13cmos5l_nand3_1_54 \$6938 \$6937 \$6859 VPWR VGND \$6939 sg13cmos5l_nand3_1
* cell instance sg13cmos5l_nand3_1_55 r0 *1 0,0
Xsg13cmos5l_nand3_1_55 \$7455 \$7454 \$7453 VPWR VGND \$7130 sg13cmos5l_nand3_1
* cell instance sg13cmos5l_nand3_1_56 r0 *1 0,0
Xsg13cmos5l_nand3_1_56 \$5589 \$6185 \$6187 VPWR VGND \$6393 sg13cmos5l_nand3_1
* cell instance sg13cmos5l_nand3_1_57 r0 *1 0,0
Xsg13cmos5l_nand3_1_57 \$5035 \$5222 \$5401 VPWR VGND \$5403 sg13cmos5l_nand3_1
* cell instance sg13cmos5l_nand3_1_58 r0 *1 0,0
Xsg13cmos5l_nand3_1_58 \$5782 \$5787 \$5597 VPWR VGND \$5786 sg13cmos5l_nand3_1
* cell instance sg13cmos5l_nand3_1_59 r0 *1 0,0
Xsg13cmos5l_nand3_1_59 \$5996 \$6394 \$6189 VPWR VGND \$6404 sg13cmos5l_nand3_1
* cell instance sg13cmos5l_nand3b_1_0 r0 *1 0,0
Xsg13cmos5l_nand3b_1_0 \$2313 \$2311 \$2309 VPWR VGND \$2310 sg13cmos5l_nand3b_1
* cell instance sg13cmos5l_nand3b_1_1 r0 *1 0,0
Xsg13cmos5l_nand3b_1_1 \$1193 \$1184 \$904 VPWR VGND \$1194 sg13cmos5l_nand3b_1
* cell instance sg13cmos5l_nand3b_1_2 r0 *1 0,0
Xsg13cmos5l_nand3b_1_2 \$694 \$985 \$988 VPWR VGND \$555 sg13cmos5l_nand3b_1
* cell instance sg13cmos5l_nand3b_1_3 r0 *1 0,0
Xsg13cmos5l_nand3b_1_3 \$715 \$728 \$33 VPWR VGND \$569 sg13cmos5l_nand3b_1
* cell instance sg13cmos5l_nand3b_1_4 r0 *1 0,0
Xsg13cmos5l_nand3b_1_4 \$1894 \$1914 \$1705 VPWR VGND \$1913 sg13cmos5l_nand3b_1
* cell instance sg13cmos5l_nand3b_1_5 r0 *1 0,0
Xsg13cmos5l_nand3b_1_5 \$864 \$1018 \$1715 VPWR VGND \$1717 sg13cmos5l_nand3b_1
* cell instance sg13cmos5l_nand3b_1_6 r0 *1 0,0
Xsg13cmos5l_nand3b_1_6 \$3431 \$3615 \$3604 VPWR VGND \$2670 sg13cmos5l_nand3b_1
* cell instance sg13cmos5l_nand3b_1_7 r0 *1 0,0
Xsg13cmos5l_nand3b_1_7 \$3610 \$3617 \$3604 VPWR VGND \$2816 sg13cmos5l_nand3b_1
* cell instance sg13cmos5l_nand4_1_0 r0 *1 0,0
Xsg13cmos5l_nand4_1_0 \$6864 \$6848 \$6847 \$6846 VPWR VGND \$5842
+ sg13cmos5l_nand4_1
* cell instance sg13cmos5l_nand4_1_1 r0 *1 0,0
Xsg13cmos5l_nand4_1_1 \$3109 \$3664 \$1410 \$2311 VPWR VGND \$3510
+ sg13cmos5l_nand4_1
* cell instance sg13cmos5l_nand4_1_2 r0 *1 0,0
Xsg13cmos5l_nand4_1_2 \$6247 \$7501 \$5635 \$5280 VPWR VGND \$5641
+ sg13cmos5l_nand4_1
* cell instance sg13cmos5l_nand4_1_3 r0 *1 0,0
Xsg13cmos5l_nand4_1_3 \$3432 \$3912 \$6435 \$5639 VPWR VGND \$5863
+ sg13cmos5l_nand4_1
* cell instance sg13cmos5l_nand4_1_4 r0 *1 0,0
Xsg13cmos5l_nand4_1_4 \$5078 \$6244 \$6232 \$6257 VPWR VGND \$6258
+ sg13cmos5l_nand4_1
* cell instance sg13cmos5l_nand4_1_5 r0 *1 0,0
Xsg13cmos5l_nand4_1_5 \$5866 \$5859 \$5146 \$5868 VPWR VGND \$5869
+ sg13cmos5l_nand4_1
* cell instance sg13cmos5l_nand4_1_6 r0 *1 0,0
Xsg13cmos5l_nand4_1_6 \$3921 \$2666 \$4040 \$3917 VPWR VGND \$3920
+ sg13cmos5l_nand4_1
* cell instance sg13cmos5l_nand4_1_7 r0 *1 0,0
Xsg13cmos5l_nand4_1_7 \$3921 \$2710 \$3726 \$3667 VPWR VGND \$3737
+ sg13cmos5l_nand4_1
* cell instance sg13cmos5l_nand4_1_8 r0 *1 0,0
Xsg13cmos5l_nand4_1_8 \$2710 \$2505 \$2332 \$2503 VPWR VGND \$2504
+ sg13cmos5l_nand4_1
* cell instance sg13cmos5l_nand4_1_9 r0 *1 0,0
Xsg13cmos5l_nand4_1_9 \$4846 \$5153 \$5156 \$5155 VPWR VGND \$5077
+ sg13cmos5l_nand4_1
* cell instance sg13cmos5l_nand4_1_10 r0 *1 0,0
Xsg13cmos5l_nand4_1_10 \$4511 \$4678 \$4504 \$3299 VPWR VGND \$4677
+ sg13cmos5l_nand4_1
* cell instance sg13cmos5l_nand4_1_11 r0 *1 0,0
Xsg13cmos5l_nand4_1_11 \$4511 \$4678 \$4850 \$3299 VPWR VGND \$4851
+ sg13cmos5l_nand4_1
* cell instance sg13cmos5l_nand4_1_12 r0 *1 0,0
Xsg13cmos5l_nand4_1_12 \$4511 \$3550 \$4504 \$4510 VPWR VGND \$4316
+ sg13cmos5l_nand4_1
* cell instance sg13cmos5l_nand4_1_13 r0 *1 0,0
Xsg13cmos5l_nand4_1_13 \$4511 \$4678 \$4850 \$4510 VPWR VGND \$4685
+ sg13cmos5l_nand4_1
* cell instance sg13cmos5l_nand4_1_14 r0 *1 0,0
Xsg13cmos5l_nand4_1_14 \$3785 \$4681 \$4773 \$4673 VPWR VGND \$4487
+ sg13cmos5l_nand4_1
* cell instance sg13cmos5l_nand4_1_15 r0 *1 0,0
Xsg13cmos5l_nand4_1_15 \$5418 \$4955 \$5306 \$5163 VPWR VGND \$5305
+ sg13cmos5l_nand4_1
* cell instance sg13cmos5l_nand4_1_16 r0 *1 0,0
Xsg13cmos5l_nand4_1_16 \$4861 \$4856 \$4876 \$4672 VPWR VGND \$3959
+ sg13cmos5l_nand4_1
* cell instance sg13cmos5l_nand4_1_17 r0 *1 0,0
Xsg13cmos5l_nand4_1_17 \$1845 \$2754 \$2758 \$2884 VPWR VGND \$2757
+ sg13cmos5l_nand4_1
* cell instance sg13cmos5l_nand4_1_18 r0 *1 0,0
Xsg13cmos5l_nand4_1_18 \$2194 \$4331 \$2759 \$4332 VPWR VGND \$4315
+ sg13cmos5l_nand4_1
* cell instance sg13cmos5l_nand4_1_19 r0 *1 0,0
Xsg13cmos5l_nand4_1_19 \$2049 \$1876 \$2567 \$2214 VPWR VGND \$2215
+ sg13cmos5l_nand4_1
* cell instance sg13cmos5l_nand4_1_20 r0 *1 0,0
Xsg13cmos5l_nand4_1_20 \$4343 \$4547 \$4558 \$4703 VPWR VGND \$4545
+ sg13cmos5l_nand4_1
* cell instance sg13cmos5l_nand4_1_21 r0 *1 0,0
Xsg13cmos5l_nand4_1_21 \$4344 \$4343 \$4171 \$4173 VPWR VGND \$4558
+ sg13cmos5l_nand4_1
* cell instance sg13cmos5l_nand4_1_22 r0 *1 0,0
Xsg13cmos5l_nand4_1_22 \$5970 \$5723 \$5961 \$5576 VPWR VGND \$5971
+ sg13cmos5l_nand4_1
* cell instance sg13cmos5l_nand4_1_23 r0 *1 0,0
Xsg13cmos5l_nand4_1_23 \$600 \$433 \$33 \$342 VPWR VGND \$722 sg13cmos5l_nand4_1
* cell instance sg13cmos5l_nand4_1_24 r0 *1 0,0
Xsg13cmos5l_nand4_1_24 \$4417 \$4343 \$4880 \$4345 VPWR VGND \$4686
+ sg13cmos5l_nand4_1
* cell instance sg13cmos5l_nand4_1_25 r0 *1 0,0
Xsg13cmos5l_nand4_1_25 \$4417 \$4343 \$4346 \$4345 VPWR VGND \$3573
+ sg13cmos5l_nand4_1
* cell instance sg13cmos5l_nand4_1_26 r0 *1 0,0
Xsg13cmos5l_nand4_1_26 \$5894 \$5440 \$5982 \$5981 VPWR VGND \$5023
+ sg13cmos5l_nand4_1
* cell instance sg13cmos5l_nand4_1_27 r0 *1 0,0
Xsg13cmos5l_nand4_1_27 \$1268 \$446 \$57 \$448 VPWR VGND \$449
+ sg13cmos5l_nand4_1
* cell instance sg13cmos5l_nand4_1_28 r0 *1 0,0
Xsg13cmos5l_nand4_1_28 \$5044 \$5091 \$5043 \$5090 VPWR VGND \$4889
+ sg13cmos5l_nand4_1
* cell instance sg13cmos5l_nand4_1_29 r0 *1 0,0
Xsg13cmos5l_nand4_1_29 \$5767 \$5589 \$5778 \$5586 VPWR VGND \$5777
+ sg13cmos5l_nand4_1
* cell instance sg13cmos5l_nand4_1_30 r0 *1 0,0
Xsg13cmos5l_nand4_1_30 \$6855 \$5898 \$5684 \$7455 VPWR VGND \$7688
+ sg13cmos5l_nand4_1
* cell instance sg13cmos5l_nor2_1_0 r0 *1 0,0
Xsg13cmos5l_nor2_1_0 \$2114 \$2116 VPWR VGND \$2115 sg13cmos5l_nor2_1
* cell instance sg13cmos5l_nor2_1_1 r0 *1 0,0
Xsg13cmos5l_nor2_1_1 \$6017 \$6018 VPWR VGND \$5612 sg13cmos5l_nor2_1
* cell instance sg13cmos5l_nor2_1_2 r0 *1 0,0
Xsg13cmos5l_nor2_1_2 \$1285 \$1033 VPWR VGND \$1030 sg13cmos5l_nor2_1
* cell instance sg13cmos5l_nor2_1_3 r0 *1 0,0
Xsg13cmos5l_nor2_1_3 \$10460 \$6789 VPWR VGND \$9737 sg13cmos5l_nor2_1
* cell instance sg13cmos5l_nor2_1_4 r0 *1 0,0
Xsg13cmos5l_nor2_1_4 \$607 \$608 VPWR VGND \$602 sg13cmos5l_nor2_1
* cell instance sg13cmos5l_nor2_1_5 r0 *1 0,0
Xsg13cmos5l_nor2_1_5 \$2307 \$4936 VPWR VGND \$5245 sg13cmos5l_nor2_1
* cell instance sg13cmos5l_nor2_1_6 r0 *1 0,0
Xsg13cmos5l_nor2_1_6 \$12310 \$6789 VPWR VGND \$11970 sg13cmos5l_nor2_1
* cell instance sg13cmos5l_nor2_1_7 r0 *1 0,0
Xsg13cmos5l_nor2_1_7 \$7533 \$7240 VPWR VGND \$7532 sg13cmos5l_nor2_1
* cell instance sg13cmos5l_nor2_1_8 r0 *1 0,0
Xsg13cmos5l_nor2_1_8 \$3900 \$3901 VPWR VGND \$3897 sg13cmos5l_nor2_1
* cell instance sg13cmos5l_nor2_1_9 r0 *1 0,0
Xsg13cmos5l_nor2_1_9 \$6018 \$6024 VPWR VGND \$6021 sg13cmos5l_nor2_1
* cell instance sg13cmos5l_nor2_1_10 r0 *1 0,0
Xsg13cmos5l_nor2_1_10 \$1766 \$4936 VPWR VGND \$4929 sg13cmos5l_nor2_1
* cell instance sg13cmos5l_nor2_1_11 r0 *1 0,0
Xsg13cmos5l_nor2_1_11 \$1442 \$1439 VPWR VGND \$1431 sg13cmos5l_nor2_1
* cell instance sg13cmos5l_nor2_1_12 r0 *1 0,0
Xsg13cmos5l_nor2_1_12 \$2304 \$2303 VPWR VGND \$2299 sg13cmos5l_nor2_1
* cell instance sg13cmos5l_nor2_1_13 r0 *1 0,0
Xsg13cmos5l_nor2_1_13 \$2917 \$2916 VPWR VGND \$2912 sg13cmos5l_nor2_1
* cell instance sg13cmos5l_nor2_1_14 r0 *1 0,0
Xsg13cmos5l_nor2_1_14 \$3327 \$3509 VPWR VGND \$3319 sg13cmos5l_nor2_1
* cell instance sg13cmos5l_nor2_1_15 r0 *1 0,0
Xsg13cmos5l_nor2_1_15 \$2869 \$4256 VPWR VGND \$4628 sg13cmos5l_nor2_1
* cell instance sg13cmos5l_nor2_1_16 r0 *1 0,0
Xsg13cmos5l_nor2_1_16 \$4257 \$4256 VPWR VGND \$4254 sg13cmos5l_nor2_1
* cell instance sg13cmos5l_nor2_1_17 r0 *1 0,0
Xsg13cmos5l_nor2_1_17 \$752 \$890 VPWR VGND \$753 sg13cmos5l_nor2_1
* cell instance sg13cmos5l_nor2_1_18 r0 *1 0,0
Xsg13cmos5l_nor2_1_18 \$6026 \$6417 VPWR VGND \$6416 sg13cmos5l_nor2_1
* cell instance sg13cmos5l_nor2_1_19 r0 *1 0,0
Xsg13cmos5l_nor2_1_19 \$16429 \$16428 VPWR VGND \$16427 sg13cmos5l_nor2_1
* cell instance sg13cmos5l_nor2_1_20 r0 *1 0,0
Xsg13cmos5l_nor2_1_20 \$17271 \$16428 VPWR VGND \$17270 sg13cmos5l_nor2_1
* cell instance sg13cmos5l_nor2_1_21 r0 *1 0,0
Xsg13cmos5l_nor2_1_21 \$3904 \$4256 VPWR VGND \$4615 sg13cmos5l_nor2_1
* cell instance sg13cmos5l_nor2_1_22 r0 *1 0,0
Xsg13cmos5l_nor2_1_22 \$7489 \$7240 VPWR VGND \$7715 sg13cmos5l_nor2_1
* cell instance sg13cmos5l_nor2_1_23 r0 *1 0,0
Xsg13cmos5l_nor2_1_23 \$15431 \$14404 VPWR VGND \$15317 sg13cmos5l_nor2_1
* cell instance sg13cmos5l_nor2_1_24 r0 *1 0,0
Xsg13cmos5l_nor2_1_24 \$3330 \$4256 VPWR VGND \$4918 sg13cmos5l_nor2_1
* cell instance sg13cmos5l_nor2_1_25 r0 *1 0,0
Xsg13cmos5l_nor2_1_25 \$14405 \$14404 VPWR VGND \$14403 sg13cmos5l_nor2_1
* cell instance sg13cmos5l_nor2_1_26 r0 *1 0,0
Xsg13cmos5l_nor2_1_26 \$1304 \$1305 VPWR VGND \$1306 sg13cmos5l_nor2_1
* cell instance sg13cmos5l_nor2_1_27 r0 *1 0,0
Xsg13cmos5l_nor2_1_27 \$10919 \$6789 VPWR VGND \$10918 sg13cmos5l_nor2_1
* cell instance sg13cmos5l_nor2_1_28 r0 *1 0,0
Xsg13cmos5l_nor2_1_28 \$6746 \$8556 VPWR VGND \$18740 sg13cmos5l_nor2_1
* cell instance sg13cmos5l_nor2_1_29 r0 *1 0,0
Xsg13cmos5l_nor2_1_29 \$238 \$240 VPWR VGND \$239 sg13cmos5l_nor2_1
* cell instance sg13cmos5l_nor2_1_30 r0 *1 0,0
Xsg13cmos5l_nor2_1_30 \$3109 \$4936 VPWR VGND \$5110 sg13cmos5l_nor2_1
* cell instance sg13cmos5l_nor2_1_31 r0 *1 0,0
Xsg13cmos5l_nor2_1_31 \$4081 \$4258 VPWR VGND \$4260 sg13cmos5l_nor2_1
* cell instance sg13cmos5l_nor2_1_32 r0 *1 0,0
Xsg13cmos5l_nor2_1_32 \$7322 \$6018 VPWR VGND \$7260 sg13cmos5l_nor2_1
* cell instance sg13cmos5l_nor2_1_33 r0 *1 0,0
Xsg13cmos5l_nor2_1_33 \$13962 \$14404 VPWR VGND \$13808 sg13cmos5l_nor2_1
* cell instance sg13cmos5l_nor2_1_34 r0 *1 0,0
Xsg13cmos5l_nor2_1_34 \$18971 \$14413 VPWR VGND \$18970 sg13cmos5l_nor2_1
* cell instance sg13cmos5l_nor2_1_35 r0 *1 0,0
Xsg13cmos5l_nor2_1_35 \$244 \$240 VPWR VGND \$242 sg13cmos5l_nor2_1
* cell instance sg13cmos5l_nor2_1_36 r0 *1 0,0
Xsg13cmos5l_nor2_1_36 \$2922 \$2685 VPWR VGND \$2687 sg13cmos5l_nor2_1
* cell instance sg13cmos5l_nor2_1_37 r0 *1 0,0
Xsg13cmos5l_nor2_1_37 \$368 \$370 VPWR VGND \$369 sg13cmos5l_nor2_1
* cell instance sg13cmos5l_nor2_1_38 r0 *1 0,0
Xsg13cmos5l_nor2_1_38 \$15929 \$16428 VPWR VGND \$15829 sg13cmos5l_nor2_1
* cell instance sg13cmos5l_nor2_1_39 r0 *1 0,0
Xsg13cmos5l_nor2_1_39 \$14888 \$14404 VPWR VGND \$14887 sg13cmos5l_nor2_1
* cell instance sg13cmos5l_nor2_1_40 r0 *1 0,0
Xsg13cmos5l_nor2_1_40 \$4794 \$4936 VPWR VGND \$4795 sg13cmos5l_nor2_1
* cell instance sg13cmos5l_nor2_1_41 r0 *1 0,0
Xsg13cmos5l_nor2_1_41 \$6035 \$6018 VPWR VGND \$6193 sg13cmos5l_nor2_1
* cell instance sg13cmos5l_nor2_1_42 r0 *1 0,0
Xsg13cmos5l_nor2_1_42 \$6422 \$6018 VPWR VGND \$6421 sg13cmos5l_nor2_1
* cell instance sg13cmos5l_nor2_1_43 r0 *1 0,0
Xsg13cmos5l_nor2_1_43 \$9664 \$7901 VPWR VGND \$19417 sg13cmos5l_nor2_1
* cell instance sg13cmos5l_nor2_1_44 r0 *1 0,0
Xsg13cmos5l_nor2_1_44 \$3334 \$4265 VPWR VGND \$4643 sg13cmos5l_nor2_1
* cell instance sg13cmos5l_nor2_1_45 r0 *1 0,0
Xsg13cmos5l_nor2_1_45 \$5633 \$10923 VPWR VGND \$16073 sg13cmos5l_nor2_1
* cell instance sg13cmos5l_nor2_1_46 r0 *1 0,0
Xsg13cmos5l_nor2_1_46 \$6850 \$7240 VPWR VGND \$6867 sg13cmos5l_nor2_1
* cell instance sg13cmos5l_nor2_1_47 r0 *1 0,0
Xsg13cmos5l_nor2_1_47 \$1769 \$1770 VPWR VGND \$1046 sg13cmos5l_nor2_1
* cell instance sg13cmos5l_nor2_1_48 r0 *1 0,0
Xsg13cmos5l_nor2_1_48 \$3717 \$4654 VPWR VGND \$5260 sg13cmos5l_nor2_1
* cell instance sg13cmos5l_nor2_1_49 r0 *1 0,0
Xsg13cmos5l_nor2_1_49 \$7541 \$17273 VPWR VGND \$19418 sg13cmos5l_nor2_1
* cell instance sg13cmos5l_nor2_1_50 r0 *1 0,0
Xsg13cmos5l_nor2_1_50 \$624 \$626 VPWR VGND \$625 sg13cmos5l_nor2_1
* cell instance sg13cmos5l_nor2_1_51 r0 *1 0,0
Xsg13cmos5l_nor2_1_51 \$372 \$240 VPWR VGND \$374 sg13cmos5l_nor2_1
* cell instance sg13cmos5l_nor2_1_52 r0 *1 0,0
Xsg13cmos5l_nor2_1_52 \$17991 \$16428 VPWR VGND \$18029 sg13cmos5l_nor2_1
* cell instance sg13cmos5l_nor2_1_53 r0 *1 0,0
Xsg13cmos5l_nor2_1_53 \$2131 \$2111 VPWR VGND \$1950 sg13cmos5l_nor2_1
* cell instance sg13cmos5l_nor2_1_54 r0 *1 0,0
Xsg13cmos5l_nor2_1_54 \$5147 \$5855 VPWR VGND \$6002 sg13cmos5l_nor2_1
* cell instance sg13cmos5l_nor2_1_55 r0 *1 0,0
Xsg13cmos5l_nor2_1_55 \$2312 \$1766 VPWR VGND \$1770 sg13cmos5l_nor2_1
* cell instance sg13cmos5l_nor2_1_56 r0 *1 0,0
Xsg13cmos5l_nor2_1_56 \$4269 \$4265 VPWR VGND \$4267 sg13cmos5l_nor2_1
* cell instance sg13cmos5l_nor2_1_57 r0 *1 0,0
Xsg13cmos5l_nor2_1_57 \$1326 \$3316 VPWR VGND \$1777 sg13cmos5l_nor2_1
* cell instance sg13cmos5l_nor2_1_58 r0 *1 0,0
Xsg13cmos5l_nor2_1_58 \$16433 \$15156 VPWR VGND \$15434 sg13cmos5l_nor2_1
* cell instance sg13cmos5l_nor2_1_59 r0 *1 0,0
Xsg13cmos5l_nor2_1_59 \$14411 \$15156 VPWR VGND \$14410 sg13cmos5l_nor2_1
* cell instance sg13cmos5l_nor2_1_60 r0 *1 0,0
Xsg13cmos5l_nor2_1_60 \$16954 \$14413 VPWR VGND \$16953 sg13cmos5l_nor2_1
* cell instance sg13cmos5l_nor2_1_61 r0 *1 0,0
Xsg13cmos5l_nor2_1_61 \$10770 \$5640 VPWR VGND \$17720 sg13cmos5l_nor2_1
* cell instance sg13cmos5l_nor2_1_62 r0 *1 0,0
Xsg13cmos5l_nor2_1_62 \$3713 \$3716 VPWR VGND \$3714 sg13cmos5l_nor2_1
* cell instance sg13cmos5l_nor2_1_63 r0 *1 0,0
Xsg13cmos5l_nor2_1_63 \$6851 \$6439 VPWR VGND \$17721 sg13cmos5l_nor2_1
* cell instance sg13cmos5l_nor2_1_64 r0 *1 0,0
Xsg13cmos5l_nor2_1_64 \$2135 \$4654 VPWR VGND \$4947 sg13cmos5l_nor2_1
* cell instance sg13cmos5l_nor2_1_65 r0 *1 0,0
Xsg13cmos5l_nor2_1_65 \$263 \$267 VPWR VGND \$80 sg13cmos5l_nor2_1
* cell instance sg13cmos5l_nor2_1_66 r0 *1 0,0
Xsg13cmos5l_nor2_1_66 \$4950 \$270 VPWR VGND \$4652 sg13cmos5l_nor2_1
* cell instance sg13cmos5l_nor2_1_67 r0 *1 0,0
Xsg13cmos5l_nor2_1_67 \$489 \$267 VPWR VGND \$383 sg13cmos5l_nor2_1
* cell instance sg13cmos5l_nor2_1_68 r0 *1 0,0
Xsg13cmos5l_nor2_1_68 \$16434 \$15156 VPWR VGND \$15435 sg13cmos5l_nor2_1
* cell instance sg13cmos5l_nor2_1_69 r0 *1 0,0
Xsg13cmos5l_nor2_1_69 \$7904 \$6775 VPWR VGND \$19338 sg13cmos5l_nor2_1
* cell instance sg13cmos5l_nor2_1_70 r0 *1 0,0
Xsg13cmos5l_nor2_1_70 \$15436 \$15156 VPWR VGND \$15166 sg13cmos5l_nor2_1
* cell instance sg13cmos5l_nor2_1_71 r0 *1 0,0
Xsg13cmos5l_nor2_1_71 \$16955 \$14413 VPWR VGND \$16949 sg13cmos5l_nor2_1
* cell instance sg13cmos5l_nor2_1_72 r0 *1 0,0
Xsg13cmos5l_nor2_1_72 \$1323 \$1201 VPWR VGND \$2320 sg13cmos5l_nor2_1
* cell instance sg13cmos5l_nor2_1_73 r0 *1 0,0
Xsg13cmos5l_nor2_1_73 \$78 \$240 VPWR VGND \$83 sg13cmos5l_nor2_1
* cell instance sg13cmos5l_nor2_1_74 r0 *1 0,0
Xsg13cmos5l_nor2_1_74 \$1612 \$1613 VPWR VGND \$1614 sg13cmos5l_nor2_1
* cell instance sg13cmos5l_nor2_1_75 r0 *1 0,0
Xsg13cmos5l_nor2_1_75 \$2320 \$1326 VPWR VGND \$2321 sg13cmos5l_nor2_1
* cell instance sg13cmos5l_nor2_1_76 r0 *1 0,0
Xsg13cmos5l_nor2_1_76 \$5865 \$11218 VPWR VGND \$15167 sg13cmos5l_nor2_1
* cell instance sg13cmos5l_nor2_1_77 r0 *1 0,0
Xsg13cmos5l_nor2_1_77 \$4281 \$270 VPWR VGND \$4408 sg13cmos5l_nor2_1
* cell instance sg13cmos5l_nor2_1_78 r0 *1 0,0
Xsg13cmos5l_nor2_1_78 \$4654 \$4655 VPWR VGND \$4656 sg13cmos5l_nor2_1
* cell instance sg13cmos5l_nor2_1_79 r0 *1 0,0
Xsg13cmos5l_nor2_1_79 \$5273 \$4654 VPWR VGND \$5271 sg13cmos5l_nor2_1
* cell instance sg13cmos5l_nor2_1_80 r0 *1 0,0
Xsg13cmos5l_nor2_1_80 \$921 \$783 VPWR VGND \$784 sg13cmos5l_nor2_1
* cell instance sg13cmos5l_nor2_1_81 r0 *1 0,0
Xsg13cmos5l_nor2_1_81 \$1964 \$1966 VPWR VGND \$1791 sg13cmos5l_nor2_1
* cell instance sg13cmos5l_nor2_1_82 r0 *1 0,0
Xsg13cmos5l_nor2_1_82 \$390 \$267 VPWR VGND \$272 sg13cmos5l_nor2_1
* cell instance sg13cmos5l_nor2_1_83 r0 *1 0,0
Xsg13cmos5l_nor2_1_83 \$1191 \$1616 VPWR VGND \$2136 sg13cmos5l_nor2_1
* cell instance sg13cmos5l_nor2_1_84 r0 *1 0,0
Xsg13cmos5l_nor2_1_84 \$14414 \$14413 VPWR VGND \$14412 sg13cmos5l_nor2_1
* cell instance sg13cmos5l_nor2_1_85 r0 *1 0,0
Xsg13cmos5l_nor2_1_85 \$4759 \$4851 VPWR VGND \$6251 sg13cmos5l_nor2_1
* cell instance sg13cmos5l_nor2_1_86 r0 *1 0,0
Xsg13cmos5l_nor2_1_86 \$4315 \$4851 VPWR VGND \$5795 sg13cmos5l_nor2_1
* cell instance sg13cmos5l_nor2_1_87 r0 *1 0,0
Xsg13cmos5l_nor2_1_87 \$3729 \$4092 VPWR VGND \$4280 sg13cmos5l_nor2_1
* cell instance sg13cmos5l_nor2_1_88 r0 *1 0,0
Xsg13cmos5l_nor2_1_88 \$92 \$267 VPWR VGND \$173 sg13cmos5l_nor2_1
* cell instance sg13cmos5l_nor2_1_89 r0 *1 0,0
Xsg13cmos5l_nor2_1_89 \$1057 \$1059 VPWR VGND \$1060 sg13cmos5l_nor2_1
* cell instance sg13cmos5l_nor2_1_90 r0 *1 0,0
Xsg13cmos5l_nor2_1_90 \$4315 \$4677 VPWR VGND \$6032 sg13cmos5l_nor2_1
* cell instance sg13cmos5l_nor2_1_91 r0 *1 0,0
Xsg13cmos5l_nor2_1_91 \$1965 \$1063 VPWR VGND \$1970 sg13cmos5l_nor2_1
* cell instance sg13cmos5l_nor2_1_92 r0 *1 0,0
Xsg13cmos5l_nor2_1_92 \$1326 \$1490 VPWR VGND \$1626 sg13cmos5l_nor2_1
* cell instance sg13cmos5l_nor2_1_93 r0 *1 0,0
Xsg13cmos5l_nor2_1_93 \$382 \$287 VPWR VGND \$286 sg13cmos5l_nor2_1
* cell instance sg13cmos5l_nor2_1_94 r0 *1 0,0
Xsg13cmos5l_nor2_1_94 \$395 \$644 VPWR VGND \$646 sg13cmos5l_nor2_1
* cell instance sg13cmos5l_nor2_1_95 r0 *1 0,0
Xsg13cmos5l_nor2_1_95 \$3529 \$3530 VPWR VGND \$3667 sg13cmos5l_nor2_1
* cell instance sg13cmos5l_nor2_1_96 r0 *1 0,0
Xsg13cmos5l_nor2_1_96 \$4759 \$4677 VPWR VGND \$5867 sg13cmos5l_nor2_1
* cell instance sg13cmos5l_nor2_1_97 r0 *1 0,0
Xsg13cmos5l_nor2_1_97 \$2324 \$1492 VPWR VGND \$3149 sg13cmos5l_nor2_1
* cell instance sg13cmos5l_nor2_1_98 r0 *1 0,0
Xsg13cmos5l_nor2_1_98 \$4297 \$4296 VPWR VGND \$2936 sg13cmos5l_nor2_1
* cell instance sg13cmos5l_nor2_1_99 r0 *1 0,0
Xsg13cmos5l_nor2_1_99 \$804 \$648 VPWR VGND \$803 sg13cmos5l_nor2_1
* cell instance sg13cmos5l_nor2_1_100 r0 *1 0,0
Xsg13cmos5l_nor2_1_100 \$4098 \$4104 VPWR VGND \$4298 sg13cmos5l_nor2_1
* cell instance sg13cmos5l_nor2_1_101 r0 *1 0,0
Xsg13cmos5l_nor2_1_101 \$1511 \$3139 VPWR VGND \$3150 sg13cmos5l_nor2_1
* cell instance sg13cmos5l_nor2_1_102 r0 *1 0,0
Xsg13cmos5l_nor2_1_102 \$1974 \$1977 VPWR VGND \$1629 sg13cmos5l_nor2_1
* cell instance sg13cmos5l_nor2_1_103 r0 *1 0,0
Xsg13cmos5l_nor2_1_103 \$2324 \$3360 VPWR VGND \$4283 sg13cmos5l_nor2_1
* cell instance sg13cmos5l_nor2_1_104 r0 *1 0,0
Xsg13cmos5l_nor2_1_104 \$2701 \$3360 VPWR VGND \$166 sg13cmos5l_nor2_1
* cell instance sg13cmos5l_nor2_1_105 r0 *1 0,0
Xsg13cmos5l_nor2_1_105 \$2319 \$287 VPWR VGND \$2333 sg13cmos5l_nor2_1
* cell instance sg13cmos5l_nor2_1_106 r0 *1 0,0
Xsg13cmos5l_nor2_1_106 \$1929 \$2505 VPWR VGND \$2719 sg13cmos5l_nor2_1
* cell instance sg13cmos5l_nor2_1_107 r0 *1 0,0
Xsg13cmos5l_nor2_1_107 \$3361 \$287 VPWR VGND \$3317 sg13cmos5l_nor2_1
* cell instance sg13cmos5l_nor2_1_108 r0 *1 0,0
Xsg13cmos5l_nor2_1_108 \$402 \$287 VPWR VGND \$403 sg13cmos5l_nor2_1
* cell instance sg13cmos5l_nor2_1_109 r0 *1 0,0
Xsg13cmos5l_nor2_1_109 \$1808 \$1337 VPWR VGND \$2953 sg13cmos5l_nor2_1
* cell instance sg13cmos5l_nor2_1_110 r0 *1 0,0
Xsg13cmos5l_nor2_1_110 \$1070 \$1808 VPWR VGND \$1226 sg13cmos5l_nor2_1
* cell instance sg13cmos5l_nor2_1_111 r0 *1 0,0
Xsg13cmos5l_nor2_1_111 \$652 \$192 VPWR VGND \$523 sg13cmos5l_nor2_1
* cell instance sg13cmos5l_nor2_1_112 r0 *1 0,0
Xsg13cmos5l_nor2_1_112 \$1511 \$1793 VPWR VGND \$1986 sg13cmos5l_nor2_1
* cell instance sg13cmos5l_nor2_1_113 r0 *1 0,0
Xsg13cmos5l_nor2_1_113 \$1643 \$4104 VPWR VGND \$4103 sg13cmos5l_nor2_1
* cell instance sg13cmos5l_nor2_1_114 r0 *1 0,0
Xsg13cmos5l_nor2_1_114 \$191 \$192 VPWR VGND \$193 sg13cmos5l_nor2_1
* cell instance sg13cmos5l_nor2_1_115 r0 *1 0,0
Xsg13cmos5l_nor2_1_115 \$3929 \$3744 VPWR VGND \$3930 sg13cmos5l_nor2_1
* cell instance sg13cmos5l_nor2_1_116 r0 *1 0,0
Xsg13cmos5l_nor2_1_116 \$3374 \$3744 VPWR VGND \$3743 sg13cmos5l_nor2_1
* cell instance sg13cmos5l_nor2_1_117 r0 *1 0,0
Xsg13cmos5l_nor2_1_117 \$1227 \$1168 VPWR VGND \$1228 sg13cmos5l_nor2_1
* cell instance sg13cmos5l_nor2_1_118 r0 *1 0,0
Xsg13cmos5l_nor2_1_118 \$659 \$660 VPWR VGND \$661 sg13cmos5l_nor2_1
* cell instance sg13cmos5l_nor2_1_119 r0 *1 0,0
Xsg13cmos5l_nor2_1_119 \$4315 \$4316 VPWR VGND \$4296 sg13cmos5l_nor2_1
* cell instance sg13cmos5l_nor2_1_120 r0 *1 0,0
Xsg13cmos5l_nor2_1_120 \$2959 \$2726 VPWR VGND \$2961 sg13cmos5l_nor2_1
* cell instance sg13cmos5l_nor2_1_121 r0 *1 0,0
Xsg13cmos5l_nor2_1_121 \$3538 \$3744 VPWR VGND \$3539 sg13cmos5l_nor2_1
* cell instance sg13cmos5l_nor2_1_122 r0 *1 0,0
Xsg13cmos5l_nor2_1_122 \$1794 \$1808 VPWR VGND \$1809 sg13cmos5l_nor2_1
* cell instance sg13cmos5l_nor2_1_123 r0 *1 0,0
Xsg13cmos5l_nor2_1_123 \$3937 \$3744 VPWR VGND \$3938 sg13cmos5l_nor2_1
* cell instance sg13cmos5l_nor2_1_124 r0 *1 0,0
Xsg13cmos5l_nor2_1_124 \$5084 \$5287 VPWR VGND \$5165 sg13cmos5l_nor2_1
* cell instance sg13cmos5l_nor2_1_125 r0 *1 0,0
Xsg13cmos5l_nor2_1_125 \$5084 \$4979 VPWR VGND \$4980 sg13cmos5l_nor2_1
* cell instance sg13cmos5l_nor2_1_126 r0 *1 0,0
Xsg13cmos5l_nor2_1_126 \$542 \$540 VPWR VGND \$668 sg13cmos5l_nor2_1
* cell instance sg13cmos5l_nor2_1_127 r0 *1 0,0
Xsg13cmos5l_nor2_1_127 \$3160 \$2966 VPWR VGND \$3164 sg13cmos5l_nor2_1
* cell instance sg13cmos5l_nor2_1_128 r0 *1 0,0
Xsg13cmos5l_nor2_1_128 \$1801 \$1808 VPWR VGND \$1513 sg13cmos5l_nor2_1
* cell instance sg13cmos5l_nor2_1_129 r0 *1 0,0
Xsg13cmos5l_nor2_1_129 \$4685 \$4759 VPWR VGND \$4854 sg13cmos5l_nor2_1
* cell instance sg13cmos5l_nor2_1_130 r0 *1 0,0
Xsg13cmos5l_nor2_1_130 \$1243 \$1244 VPWR VGND \$1086 sg13cmos5l_nor2_1
* cell instance sg13cmos5l_nor2_1_131 r0 *1 0,0
Xsg13cmos5l_nor2_1_131 \$2164 \$2002 VPWR VGND \$2150 sg13cmos5l_nor2_1
* cell instance sg13cmos5l_nor2_1_132 r0 *1 0,0
Xsg13cmos5l_nor2_1_132 \$1818 \$1820 VPWR VGND \$1819 sg13cmos5l_nor2_1
* cell instance sg13cmos5l_nor2_1_133 r0 *1 0,0
Xsg13cmos5l_nor2_1_133 \$2168 \$1244 VPWR VGND \$2003 sg13cmos5l_nor2_1
* cell instance sg13cmos5l_nor2_1_134 r0 *1 0,0
Xsg13cmos5l_nor2_1_134 \$1292 \$1358 VPWR VGND \$1247 sg13cmos5l_nor2_1
* cell instance sg13cmos5l_nor2_1_135 r0 *1 0,0
Xsg13cmos5l_nor2_1_135 \$2740 \$2742 VPWR VGND \$2528 sg13cmos5l_nor2_1
* cell instance sg13cmos5l_nor2_1_136 r0 *1 0,0
Xsg13cmos5l_nor2_1_136 \$4988 \$5287 VPWR VGND \$4989 sg13cmos5l_nor2_1
* cell instance sg13cmos5l_nor2_1_137 r0 *1 0,0
Xsg13cmos5l_nor2_1_137 \$2978 \$3764 VPWR VGND \$3954 sg13cmos5l_nor2_1
* cell instance sg13cmos5l_nor2_1_138 r0 *1 0,0
Xsg13cmos5l_nor2_1_138 \$5082 \$5529 VPWR VGND \$5528 sg13cmos5l_nor2_1
* cell instance sg13cmos5l_nor2_1_139 r0 *1 0,0
Xsg13cmos5l_nor2_1_139 \$1348 \$1244 VPWR VGND \$1252 sg13cmos5l_nor2_1
* cell instance sg13cmos5l_nor2_1_140 r0 *1 0,0
Xsg13cmos5l_nor2_1_140 \$3398 \$2985 VPWR VGND \$3399 sg13cmos5l_nor2_1
* cell instance sg13cmos5l_nor2_1_141 r0 *1 0,0
Xsg13cmos5l_nor2_1_141 \$3104 \$2985 VPWR VGND \$2984 sg13cmos5l_nor2_1
* cell instance sg13cmos5l_nor2_1_142 r0 *1 0,0
Xsg13cmos5l_nor2_1_142 \$5310 \$5308 VPWR VGND \$4859 sg13cmos5l_nor2_1
* cell instance sg13cmos5l_nor2_1_143 r0 *1 0,0
Xsg13cmos5l_nor2_1_143 \$1078 \$1244 VPWR VGND \$971 sg13cmos5l_nor2_1
* cell instance sg13cmos5l_nor2_1_144 r0 *1 0,0
Xsg13cmos5l_nor2_1_144 \$3189 \$2985 VPWR VGND \$3672 sg13cmos5l_nor2_1
* cell instance sg13cmos5l_nor2_1_145 r0 *1 0,0
Xsg13cmos5l_nor2_1_145 \$6195 \$4760 VPWR VGND \$6090 sg13cmos5l_nor2_1
* cell instance sg13cmos5l_nor2_1_146 r0 *1 0,0
Xsg13cmos5l_nor2_1_146 \$5686 \$5532 VPWR VGND \$5805 sg13cmos5l_nor2_1
* cell instance sg13cmos5l_nor2_1_147 r0 *1 0,0
Xsg13cmos5l_nor2_1_147 \$3432 \$4536 VPWR VGND \$6092 sg13cmos5l_nor2_1
* cell instance sg13cmos5l_nor2_1_148 r0 *1 0,0
Xsg13cmos5l_nor2_1_148 \$5010 \$4536 VPWR VGND \$2020 sg13cmos5l_nor2_1
* cell instance sg13cmos5l_nor2_1_149 r0 *1 0,0
Xsg13cmos5l_nor2_1_149 \$2545 \$2029 VPWR VGND \$2758 sg13cmos5l_nor2_1
* cell instance sg13cmos5l_nor2_1_150 r0 *1 0,0
Xsg13cmos5l_nor2_1_150 \$3570 \$3573 VPWR VGND \$3571 sg13cmos5l_nor2_1
* cell instance sg13cmos5l_nor2_1_151 r0 *1 0,0
Xsg13cmos5l_nor2_1_151 \$3965 \$4686 VPWR VGND \$4856 sg13cmos5l_nor2_1
* cell instance sg13cmos5l_nor2_1_152 r0 *1 0,0
Xsg13cmos5l_nor2_1_152 \$418 \$330 VPWR VGND \$417 sg13cmos5l_nor2_1
* cell instance sg13cmos5l_nor2_1_153 r0 *1 0,0
Xsg13cmos5l_nor2_1_153 \$330 \$1124 VPWR VGND \$1165 sg13cmos5l_nor2_1
* cell instance sg13cmos5l_nor2_1_154 r0 *1 0,0
Xsg13cmos5l_nor2_1_154 \$3965 \$4864 VPWR VGND \$4863 sg13cmos5l_nor2_1
* cell instance sg13cmos5l_nor2_1_155 r0 *1 0,0
Xsg13cmos5l_nor2_1_155 \$327 \$328 VPWR VGND \$325 sg13cmos5l_nor2_1
* cell instance sg13cmos5l_nor2_1_156 r0 *1 0,0
Xsg13cmos5l_nor2_1_156 \$66 \$95 VPWR VGND \$94 sg13cmos5l_nor2_1
* cell instance sg13cmos5l_nor2_1_157 r0 *1 0,0
Xsg13cmos5l_nor2_1_157 \$3318 \$2284 VPWR VGND \$3785 sg13cmos5l_nor2_1
* cell instance sg13cmos5l_nor2_1_158 r0 *1 0,0
Xsg13cmos5l_nor2_1_158 \$1125 \$1261 VPWR VGND \$600 sg13cmos5l_nor2_1
* cell instance sg13cmos5l_nor2_1_159 r0 *1 0,0
Xsg13cmos5l_nor2_1_159 \$333 \$437 VPWR VGND \$701 sg13cmos5l_nor2_1
* cell instance sg13cmos5l_nor2_1_160 r0 *1 0,0
Xsg13cmos5l_nor2_1_160 \$3197 \$3409 VPWR VGND \$3786 sg13cmos5l_nor2_1
* cell instance sg13cmos5l_nor2_1_161 r0 *1 0,0
Xsg13cmos5l_nor2_1_161 \$2382 \$2381 VPWR VGND \$2460 sg13cmos5l_nor2_1
* cell instance sg13cmos5l_nor2_1_162 r0 *1 0,0
Xsg13cmos5l_nor2_1_162 \$97 \$114 VPWR VGND \$202 sg13cmos5l_nor2_1
* cell instance sg13cmos5l_nor2_1_163 r0 *1 0,0
Xsg13cmos5l_nor2_1_163 \$201 \$68 VPWR VGND \$738 sg13cmos5l_nor2_1
* cell instance sg13cmos5l_nor2_1_164 r0 *1 0,0
Xsg13cmos5l_nor2_1_164 \$2570 \$2571 VPWR VGND \$2569 sg13cmos5l_nor2_1
* cell instance sg13cmos5l_nor2_1_165 r0 *1 0,0
Xsg13cmos5l_nor2_1_165 \$15 \$97 VPWR VGND \$101 sg13cmos5l_nor2_1
* cell instance sg13cmos5l_nor2_1_166 r0 *1 0,0
Xsg13cmos5l_nor2_1_166 \$66 \$333 VPWR VGND \$332 sg13cmos5l_nor2_1
* cell instance sg13cmos5l_nor2_1_167 r0 *1 0,0
Xsg13cmos5l_nor2_1_167 \$3966 \$3961 VPWR VGND \$3676 sg13cmos5l_nor2_1
* cell instance sg13cmos5l_nor2_1_168 r0 *1 0,0
Xsg13cmos5l_nor2_1_168 \$5007 \$3303 VPWR VGND \$5187 sg13cmos5l_nor2_1
* cell instance sg13cmos5l_nor2_1_169 r0 *1 0,0
Xsg13cmos5l_nor2_1_169 \$334 \$103 VPWR VGND \$331 sg13cmos5l_nor2_1
* cell instance sg13cmos5l_nor2_1_170 r0 *1 0,0
Xsg13cmos5l_nor2_1_170 \$66 \$423 VPWR VGND \$428 sg13cmos5l_nor2_1
* cell instance sg13cmos5l_nor2_1_171 r0 *1 0,0
Xsg13cmos5l_nor2_1_171 \$334 \$987 VPWR VGND \$1166 sg13cmos5l_nor2_1
* cell instance sg13cmos5l_nor2_1_172 r0 *1 0,0
Xsg13cmos5l_nor2_1_172 \$97 \$5 VPWR VGND \$354 sg13cmos5l_nor2_1
* cell instance sg13cmos5l_nor2_1_173 r0 *1 0,0
Xsg13cmos5l_nor2_1_173 \$4249 \$5007 VPWR VGND \$6211 sg13cmos5l_nor2_1
* cell instance sg13cmos5l_nor2_1_174 r0 *1 0,0
Xsg13cmos5l_nor2_1_174 \$334 \$419 VPWR VGND \$601 sg13cmos5l_nor2_1
* cell instance sg13cmos5l_nor2_1_175 r0 *1 0,0
Xsg13cmos5l_nor2_1_175 \$97 \$14 VPWR VGND \$109 sg13cmos5l_nor2_1
* cell instance sg13cmos5l_nor2_1_176 r0 *1 0,0
Xsg13cmos5l_nor2_1_176 \$65 \$12 VPWR VGND \$20 sg13cmos5l_nor2_1
* cell instance sg13cmos5l_nor2_1_177 r0 *1 0,0
Xsg13cmos5l_nor2_1_177 \$330 \$1267 VPWR VGND \$1394 sg13cmos5l_nor2_1
* cell instance sg13cmos5l_nor2_1_178 r0 *1 0,0
Xsg13cmos5l_nor2_1_178 \$2218 \$1930 VPWR VGND \$2219 sg13cmos5l_nor2_1
* cell instance sg13cmos5l_nor2_1_179 r0 *1 0,0
Xsg13cmos5l_nor2_1_179 \$1876 \$2391 VPWR VGND \$2389 sg13cmos5l_nor2_1
* cell instance sg13cmos5l_nor2_1_180 r0 *1 0,0
Xsg13cmos5l_nor2_1_180 \$210 \$110 VPWR VGND \$208 sg13cmos5l_nor2_1
* cell instance sg13cmos5l_nor2_1_181 r0 *1 0,0
Xsg13cmos5l_nor2_1_181 \$3318 \$3302 VPWR VGND \$3490 sg13cmos5l_nor2_1
* cell instance sg13cmos5l_nor2_1_182 r0 *1 0,0
Xsg13cmos5l_nor2_1_182 \$66 \$12 VPWR VGND \$22 sg13cmos5l_nor2_1
* cell instance sg13cmos5l_nor2_1_183 r0 *1 0,0
Xsg13cmos5l_nor2_1_183 \$1280 \$1000 VPWR VGND \$1028 sg13cmos5l_nor2_1
* cell instance sg13cmos5l_nor2_1_184 r0 *1 0,0
Xsg13cmos5l_nor2_1_184 \$334 \$26 VPWR VGND \$1556 sg13cmos5l_nor2_1
* cell instance sg13cmos5l_nor2_1_185 r0 *1 0,0
Xsg13cmos5l_nor2_1_185 \$4359 \$4927 VPWR VGND \$4773 sg13cmos5l_nor2_1
* cell instance sg13cmos5l_nor2_1_186 r0 *1 0,0
Xsg13cmos5l_nor2_1_186 \$23 \$68 VPWR VGND \$112 sg13cmos5l_nor2_1
* cell instance sg13cmos5l_nor2_1_187 r0 *1 0,0
Xsg13cmos5l_nor2_1_187 \$212 \$339 VPWR VGND \$341 sg13cmos5l_nor2_1
* cell instance sg13cmos5l_nor2_1_188 r0 *1 0,0
Xsg13cmos5l_nor2_1_188 \$2577 \$2578 VPWR VGND \$2214 sg13cmos5l_nor2_1
* cell instance sg13cmos5l_nor2_1_189 r0 *1 0,0
Xsg13cmos5l_nor2_1_189 \$10 \$5 VPWR VGND \$25 sg13cmos5l_nor2_1
* cell instance sg13cmos5l_nor2_1_190 r0 *1 0,0
Xsg13cmos5l_nor2_1_190 \$2776 \$3025 VPWR VGND \$3026 sg13cmos5l_nor2_1
* cell instance sg13cmos5l_nor2_1_191 r0 *1 0,0
Xsg13cmos5l_nor2_1_191 \$129 \$15 VPWR VGND \$1280 sg13cmos5l_nor2_1
* cell instance sg13cmos5l_nor2_1_192 r0 *1 0,0
Xsg13cmos5l_nor2_1_192 \$3416 \$3414 VPWR VGND \$3022 sg13cmos5l_nor2_1
* cell instance sg13cmos5l_nor2_1_193 r0 *1 0,0
Xsg13cmos5l_nor2_1_193 \$53 \$72 VPWR VGND \$436 sg13cmos5l_nor2_1
* cell instance sg13cmos5l_nor2_1_194 r0 *1 0,0
Xsg13cmos5l_nor2_1_194 \$4171 \$4172 VPWR VGND \$3966 sg13cmos5l_nor2_1
* cell instance sg13cmos5l_nor2_1_195 r0 *1 0,0
Xsg13cmos5l_nor2_1_195 \$3432 \$4927 VPWR VGND \$5189 sg13cmos5l_nor2_1
* cell instance sg13cmos5l_nor2_1_196 r0 *1 0,0
Xsg13cmos5l_nor2_1_196 \$4173 \$4172 VPWR VGND \$2208 sg13cmos5l_nor2_1
* cell instance sg13cmos5l_nor2_1_197 r0 *1 0,0
Xsg13cmos5l_nor2_1_197 \$5025 \$5203 VPWR VGND \$4925 sg13cmos5l_nor2_1
* cell instance sg13cmos5l_nor2_1_198 r0 *1 0,0
Xsg13cmos5l_nor2_1_198 \$5971 \$5575 VPWR VGND \$5974 sg13cmos5l_nor2_1
* cell instance sg13cmos5l_nor2_1_199 r0 *1 0,0
Xsg13cmos5l_nor2_1_199 \$1022 \$5 VPWR VGND \$1004 sg13cmos5l_nor2_1
* cell instance sg13cmos5l_nor2_1_200 r0 *1 0,0
Xsg13cmos5l_nor2_1_200 \$3971 \$3967 VPWR VGND \$3973 sg13cmos5l_nor2_1
* cell instance sg13cmos5l_nor2_1_201 r0 *1 0,0
Xsg13cmos5l_nor2_1_201 \$2218 \$2584 VPWR VGND \$2784 sg13cmos5l_nor2_1
* cell instance sg13cmos5l_nor2_1_202 r0 *1 0,0
Xsg13cmos5l_nor2_1_202 \$2218 \$3305 VPWR VGND \$3027 sg13cmos5l_nor2_1
* cell instance sg13cmos5l_nor2_1_203 r0 *1 0,0
Xsg13cmos5l_nor2_1_203 \$718 \$870 VPWR VGND \$739 sg13cmos5l_nor2_1
* cell instance sg13cmos5l_nor2_1_204 r0 *1 0,0
Xsg13cmos5l_nor2_1_204 \$65 \$95 VPWR VGND \$73 sg13cmos5l_nor2_1
* cell instance sg13cmos5l_nor2_1_205 r0 *1 0,0
Xsg13cmos5l_nor2_1_205 \$2590 \$2784 VPWR VGND \$2785 sg13cmos5l_nor2_1
* cell instance sg13cmos5l_nor2_1_206 r0 *1 0,0
Xsg13cmos5l_nor2_1_206 \$3216 \$3027 VPWR VGND \$3217 sg13cmos5l_nor2_1
* cell instance sg13cmos5l_nor2_1_207 r0 *1 0,0
Xsg13cmos5l_nor2_1_207 \$4880 \$4345 VPWR VGND \$5204 sg13cmos5l_nor2_1
* cell instance sg13cmos5l_nor2_1_208 r0 *1 0,0
Xsg13cmos5l_nor2_1_208 \$1027 \$1004 VPWR VGND \$1008 sg13cmos5l_nor2_1
* cell instance sg13cmos5l_nor2_1_209 r0 *1 0,0
Xsg13cmos5l_nor2_1_209 \$23 \$1280 VPWR VGND \$1278 sg13cmos5l_nor2_1
* cell instance sg13cmos5l_nor2_1_210 r0 *1 0,0
Xsg13cmos5l_nor2_1_210 \$4986 \$5755 VPWR VGND \$5980 sg13cmos5l_nor2_1
* cell instance sg13cmos5l_nor2_1_211 r0 *1 0,0
Xsg13cmos5l_nor2_1_211 \$1003 \$95 VPWR VGND \$871 sg13cmos5l_nor2_1
* cell instance sg13cmos5l_nor2_1_212 r0 *1 0,0
Xsg13cmos5l_nor2_1_212 \$36 \$345 VPWR VGND \$346 sg13cmos5l_nor2_1
* cell instance sg13cmos5l_nor2_1_213 r0 *1 0,0
Xsg13cmos5l_nor2_1_213 \$4418 \$4171 VPWR VGND \$5368 sg13cmos5l_nor2_1
* cell instance sg13cmos5l_nor2_1_214 r0 *1 0,0
Xsg13cmos5l_nor2_1_214 \$2801 \$3303 VPWR VGND \$3030 sg13cmos5l_nor2_1
* cell instance sg13cmos5l_nor2_1_215 r0 *1 0,0
Xsg13cmos5l_nor2_1_215 \$41 \$131 VPWR VGND \$1568 sg13cmos5l_nor2_1
* cell instance sg13cmos5l_nor2_1_216 r0 *1 0,0
Xsg13cmos5l_nor2_1_216 \$4417 \$4343 VPWR VGND \$5438 sg13cmos5l_nor2_1
* cell instance sg13cmos5l_nor2_1_217 r0 *1 0,0
Xsg13cmos5l_nor2_1_217 \$3219 \$3303 VPWR VGND \$3220 sg13cmos5l_nor2_1
* cell instance sg13cmos5l_nor2_1_218 r0 *1 0,0
Xsg13cmos5l_nor2_1_218 \$4344 \$4343 VPWR VGND \$5207 sg13cmos5l_nor2_1
* cell instance sg13cmos5l_nor2_1_219 r0 *1 0,0
Xsg13cmos5l_nor2_1_219 \$1268 \$69 VPWR VGND \$728 sg13cmos5l_nor2_1
* cell instance sg13cmos5l_nor2_1_220 r0 *1 0,0
Xsg13cmos5l_nor2_1_220 \$4881 \$5027 VPWR VGND \$5771 sg13cmos5l_nor2_1
* cell instance sg13cmos5l_nor2_1_221 r0 *1 0,0
Xsg13cmos5l_nor2_1_221 \$75 \$76 VPWR VGND \$730 sg13cmos5l_nor2_1
* cell instance sg13cmos5l_nor2_1_222 r0 *1 0,0
Xsg13cmos5l_nor2_1_222 \$4171 \$5027 VPWR VGND \$5580 sg13cmos5l_nor2_1
* cell instance sg13cmos5l_nor2_1_223 r0 *1 0,0
Xsg13cmos5l_nor2_1_223 \$600 \$349 VPWR VGND \$1267 sg13cmos5l_nor2_1
* cell instance sg13cmos5l_nor2_1_224 r0 *1 0,0
Xsg13cmos5l_nor2_1_224 \$5983 \$5984 VPWR VGND \$5982 sg13cmos5l_nor2_1
* cell instance sg13cmos5l_nor2_1_225 r0 *1 0,0
Xsg13cmos5l_nor2_1_225 \$5821 \$5374 VPWR VGND \$5983 sg13cmos5l_nor2_1
* cell instance sg13cmos5l_nor2_1_226 r0 *1 0,0
Xsg13cmos5l_nor2_1_226 \$72 \$25 VPWR VGND \$581 sg13cmos5l_nor2_1
* cell instance sg13cmos5l_nor2_1_227 r0 *1 0,0
Xsg13cmos5l_nor2_1_227 \$4125 \$5373 VPWR VGND \$5821 sg13cmos5l_nor2_1
* cell instance sg13cmos5l_nor2_1_228 r0 *1 0,0
Xsg13cmos5l_nor2_1_228 \$5759 \$5441 VPWR VGND \$5984 sg13cmos5l_nor2_1
* cell instance sg13cmos5l_nor2_1_229 r0 *1 0,0
Xsg13cmos5l_nor2_1_229 \$334 \$349 VPWR VGND \$1016 sg13cmos5l_nor2_1
* cell instance sg13cmos5l_nor2_1_230 r0 *1 0,0
Xsg13cmos5l_nor2_1_230 \$129 \$50 VPWR VGND \$707 sg13cmos5l_nor2_1
* cell instance sg13cmos5l_nor2_1_231 r0 *1 0,0
Xsg13cmos5l_nor2_1_231 \$56 \$3438 VPWR VGND \$5581 sg13cmos5l_nor2_1
* cell instance sg13cmos5l_nor2_1_232 r0 *1 0,0
Xsg13cmos5l_nor2_1_232 \$5374 \$5379 VPWR VGND \$5377 sg13cmos5l_nor2_1
* cell instance sg13cmos5l_nor2_1_233 r0 *1 0,0
Xsg13cmos5l_nor2_1_233 \$4046 \$3438 VPWR VGND \$5379 sg13cmos5l_nor2_1
* cell instance sg13cmos5l_nor2_1_234 r0 *1 0,0
Xsg13cmos5l_nor2_1_234 \$2786 \$5211 VPWR VGND \$5382 sg13cmos5l_nor2_1
* cell instance sg13cmos5l_nor2_1_235 r0 *1 0,0
Xsg13cmos5l_nor2_1_235 \$5386 \$5382 VPWR VGND \$5385 sg13cmos5l_nor2_1
* cell instance sg13cmos5l_nor2_1_236 r0 *1 0,0
Xsg13cmos5l_nor2_1_236 \$5583 \$5213 VPWR VGND \$5585 sg13cmos5l_nor2_1
* cell instance sg13cmos5l_nor2_1_237 r0 *1 0,0
Xsg13cmos5l_nor2_1_237 \$1359 \$5211 VPWR VGND \$5213 sg13cmos5l_nor2_1
* cell instance sg13cmos5l_nor2_1_238 r0 *1 0,0
Xsg13cmos5l_nor2_1_238 \$8324 \$8447 VPWR VGND \$8285 sg13cmos5l_nor2_1
* cell instance sg13cmos5l_nor2_1_239 r0 *1 0,0
Xsg13cmos5l_nor2_1_239 \$3023 \$5390 VPWR VGND \$5776 sg13cmos5l_nor2_1
* cell instance sg13cmos5l_nor2_1_240 r0 *1 0,0
Xsg13cmos5l_nor2_1_240 \$9580 \$5188 VPWR VGND \$9576 sg13cmos5l_nor2_1
* cell instance sg13cmos5l_nor2_1_241 r0 *1 0,0
Xsg13cmos5l_nor2_1_241 \$10305 \$8447 VPWR VGND \$10441 sg13cmos5l_nor2_1
* cell instance sg13cmos5l_nor2_1_242 r0 *1 0,0
Xsg13cmos5l_nor2_1_242 \$5374 \$5047 VPWR VGND \$5214 sg13cmos5l_nor2_1
* cell instance sg13cmos5l_nor2_1_243 r0 *1 0,0
Xsg13cmos5l_nor2_1_243 \$6855 \$5684 VPWR VGND \$7250 sg13cmos5l_nor2_1
* cell instance sg13cmos5l_nor2_1_244 r0 *1 0,0
Xsg13cmos5l_nor2_1_244 \$5391 \$6016 VPWR VGND \$5215 sg13cmos5l_nor2_1
* cell instance sg13cmos5l_nor2_1_245 r0 *1 0,0
Xsg13cmos5l_nor2_1_245 \$6711 \$6388 VPWR VGND \$6709 sg13cmos5l_nor2_1
* cell instance sg13cmos5l_nor2_1_246 r0 *1 0,0
Xsg13cmos5l_nor2_1_246 \$3023 \$5046 VPWR VGND \$5047 sg13cmos5l_nor2_1
* cell instance sg13cmos5l_nor2_1_247 r0 *1 0,0
Xsg13cmos5l_nor2_1_247 \$3686 \$3484 VPWR VGND \$3634 sg13cmos5l_nor2_1
* cell instance sg13cmos5l_nor2_1_248 r0 *1 0,0
Xsg13cmos5l_nor2_1_248 \$2803 \$4583 VPWR VGND \$4373 sg13cmos5l_nor2_1
* cell instance sg13cmos5l_nor2_1_249 r0 *1 0,0
Xsg13cmos5l_nor2_1_249 \$5441 \$5048 VPWR VGND \$5216 sg13cmos5l_nor2_1
* cell instance sg13cmos5l_nor2_1_250 r0 *1 0,0
Xsg13cmos5l_nor2_1_250 \$8003 \$8447 VPWR VGND \$7871 sg13cmos5l_nor2_1
* cell instance sg13cmos5l_nor2_1_251 r0 *1 0,0
Xsg13cmos5l_nor2_1_251 \$6857 \$6858 VPWR VGND \$6934 sg13cmos5l_nor2_1
* cell instance sg13cmos5l_nor2_1_252 r0 *1 0,0
Xsg13cmos5l_nor2_1_252 \$3313 \$3241 VPWR VGND \$3493 sg13cmos5l_nor2_1
* cell instance sg13cmos5l_nor2_1_253 r0 *1 0,0
Xsg13cmos5l_nor2_1_253 \$5050 \$4586 VPWR VGND \$5394 sg13cmos5l_nor2_1
* cell instance sg13cmos5l_nor2_1_254 r0 *1 0,0
Xsg13cmos5l_nor2_1_254 \$2230 \$4586 VPWR VGND \$6810 sg13cmos5l_nor2_1
* cell instance sg13cmos5l_nor2_1_255 r0 *1 0,0
Xsg13cmos5l_nor2_1_255 \$9093 \$8447 VPWR VGND \$9092 sg13cmos5l_nor2_1
* cell instance sg13cmos5l_nor2_1_256 r0 *1 0,0
Xsg13cmos5l_nor2_1_256 \$7450 \$7451 VPWR VGND \$6937 sg13cmos5l_nor2_1
* cell instance sg13cmos5l_nor2_1_257 r0 *1 0,0
Xsg13cmos5l_nor2_1_257 \$3268 \$3254 VPWR VGND \$3620 sg13cmos5l_nor2_1
* cell instance sg13cmos5l_nor2_1_258 r0 *1 0,0
Xsg13cmos5l_nor2_1_258 \$4056 \$3484 VPWR VGND \$4012 sg13cmos5l_nor2_1
* cell instance sg13cmos5l_nor2_1_259 r0 *1 0,0
Xsg13cmos5l_nor2_1_259 \$3315 \$3484 VPWR VGND \$3454 sg13cmos5l_nor2_1
* cell instance sg13cmos5l_nor2_1_260 r0 *1 0,0
Xsg13cmos5l_nor2_1_260 \$5441 \$5996 VPWR VGND \$5781 sg13cmos5l_nor2_1
* cell instance sg13cmos5l_nor2_1_261 r0 *1 0,0
Xsg13cmos5l_nor2_1_261 \$3110 \$4383 VPWR VGND \$6718 sg13cmos5l_nor2_1
* cell instance sg13cmos5l_nor2_1_262 r0 *1 0,0
Xsg13cmos5l_nor2_1_262 \$2466 \$5055 VPWR VGND \$5782 sg13cmos5l_nor2_1
* cell instance sg13cmos5l_nor2_1_263 r0 *1 0,0
Xsg13cmos5l_nor2_1_263 \$5374 \$5787 VPWR VGND \$5999 sg13cmos5l_nor2_1
* cell instance sg13cmos5l_nor2_1_264 r0 *1 0,0
Xsg13cmos5l_nor2_1_264 \$5399 \$5060 VPWR VGND \$5597 sg13cmos5l_nor2_1
* cell instance sg13cmos5l_nor2_1_265 r0 *1 0,0
Xsg13cmos5l_nor2_1_265 \$3 \$4383 VPWR VGND \$5787 sg13cmos5l_nor2_1
* cell instance sg13cmos5l_nor2_1_266 r0 *1 0,0
Xsg13cmos5l_nor2_1_266 \$5441 \$6000 VPWR VGND \$5998 sg13cmos5l_nor2_1
* cell instance sg13cmos5l_nor2_1_267 r0 *1 0,0
Xsg13cmos5l_nor2_1_267 \$5441 \$5600 VPWR VGND \$5785 sg13cmos5l_nor2_1
* cell instance sg13cmos5l_nor2b_1_0 r0 *1 0,0
Xsg13cmos5l_nor2b_1_0 \$7489 \$7322 VPWR VGND \$6417 sg13cmos5l_nor2b_1
* cell instance sg13cmos5l_nor2b_1_1 r0 *1 0,0
Xsg13cmos5l_nor2b_1_1 \$1326 \$2311 VPWR VGND \$3131 sg13cmos5l_nor2b_1
* cell instance sg13cmos5l_nor2b_1_2 r0 *1 0,0
Xsg13cmos5l_nor2b_1_2 \$6039 \$5147 VPWR VGND \$6037 sg13cmos5l_nor2b_1
* cell instance sg13cmos5l_nor2b_1_3 r0 *1 0,0
Xsg13cmos5l_nor2b_1_3 \$3524 \$1326 VPWR VGND \$3728 sg13cmos5l_nor2b_1
* cell instance sg13cmos5l_nor2b_1_4 r0 *1 0,0
Xsg13cmos5l_nor2b_1_4 \$2666 \$2497 VPWR VGND \$2713 sg13cmos5l_nor2b_1
* cell instance sg13cmos5l_nor2b_1_5 r0 *1 0,0
Xsg13cmos5l_nor2b_1_5 \$3352 \$3353 VPWR VGND \$2501 sg13cmos5l_nor2b_1
* cell instance sg13cmos5l_nor2b_1_6 r0 *1 0,0
Xsg13cmos5l_nor2b_1_6 \$2139 \$2710 VPWR VGND \$2715 sg13cmos5l_nor2b_1
* cell instance sg13cmos5l_nor2b_1_7 r0 *1 0,0
Xsg13cmos5l_nor2b_1_7 \$3353 \$4092 VPWR VGND \$2706 sg13cmos5l_nor2b_1
* cell instance sg13cmos5l_nor2b_1_8 r0 *1 0,0
Xsg13cmos5l_nor2b_1_8 \$3729 \$2135 VPWR VGND \$3735 sg13cmos5l_nor2b_1
* cell instance sg13cmos5l_nor2b_1_9 r0 *1 0,0
Xsg13cmos5l_nor2b_1_9 \$3360 \$4089 VPWR VGND \$4310 sg13cmos5l_nor2b_1
* cell instance sg13cmos5l_nor2b_1_10 r0 *1 0,0
Xsg13cmos5l_nor2b_1_10 \$3360 \$2875 VPWR VGND \$2347 sg13cmos5l_nor2b_1
* cell instance sg13cmos5l_nor2b_1_11 r0 *1 0,0
Xsg13cmos5l_nor2b_1_11 \$2884 \$3190 VPWR VGND \$2976 sg13cmos5l_nor2b_1
* cell instance sg13cmos5l_nor2b_1_12 r0 *1 0,0
Xsg13cmos5l_nor2b_1_12 \$62 \$60 VPWR VGND \$61 sg13cmos5l_nor2b_1
* cell instance sg13cmos5l_nor2b_1_13 r0 *1 0,0
Xsg13cmos5l_nor2b_1_13 \$60 \$62 VPWR VGND \$95 sg13cmos5l_nor2b_1
* cell instance sg13cmos5l_nor2b_1_14 r0 *1 0,0
Xsg13cmos5l_nor2b_1_14 \$2567 \$2382 VPWR VGND \$2566 sg13cmos5l_nor2b_1
* cell instance sg13cmos5l_nor2b_1_15 r0 *1 0,0
Xsg13cmos5l_nor2b_1_15 \$5345 \$5343 VPWR VGND \$5344 sg13cmos5l_nor2b_1
* cell instance sg13cmos5l_nor2b_1_16 r0 *1 0,0
Xsg13cmos5l_nor2b_1_16 \$3595 \$3197 VPWR VGND \$3302 sg13cmos5l_nor2b_1
* cell instance sg13cmos5l_nor2b_1_17 r0 *1 0,0
Xsg13cmos5l_nor2b_1_17 \$1278 \$1263 VPWR VGND \$1400 sg13cmos5l_nor2b_1
* cell instance sg13cmos5l_nor2b_1_18 r0 *1 0,0
Xsg13cmos5l_nor2b_1_18 \$5964 \$5960 VPWR VGND \$5963 sg13cmos5l_nor2b_1
* cell instance sg13cmos5l_nor2b_1_19 r0 *1 0,0
Xsg13cmos5l_nor2b_1_19 \$3605 \$3490 VPWR VGND \$3604 sg13cmos5l_nor2b_1
* cell instance sg13cmos5l_nor2b_1_20 r0 *1 0,0
Xsg13cmos5l_nor2b_1_20 \$4171 \$5207 VPWR VGND \$5758 sg13cmos5l_nor2b_1
* cell instance sg13cmos5l_nor2b_1_21 r0 *1 0,0
Xsg13cmos5l_nor2b_1_21 \$5203 \$5207 VPWR VGND \$5089 sg13cmos5l_nor2b_1
* cell instance sg13cmos5l_nor2b_1_22 r0 *1 0,0
Xsg13cmos5l_nor2b_1_22 \$34 \$53 VPWR VGND \$36 sg13cmos5l_nor2b_1
* cell instance sg13cmos5l_nor2b_1_23 r0 *1 0,0
Xsg13cmos5l_nor2b_1_23 \$5821 \$5759 VPWR VGND \$6165 sg13cmos5l_nor2b_1
* cell instance sg13cmos5l_nor2b_1_24 r0 *1 0,0
Xsg13cmos5l_nor2b_1_24 \$6176 \$6173 VPWR VGND \$6382 sg13cmos5l_nor2b_1
* cell instance sg13cmos5l_nor2b_1_25 r0 *1 0,0
Xsg13cmos5l_nor2b_1_25 \$6811 \$6812 VPWR VGND \$6710 sg13cmos5l_nor2b_1
* cell instance sg13cmos5l_nor2b_1_26 r0 *1 0,0
Xsg13cmos5l_nor2b_1_26 \$6402 \$6404 VPWR VGND \$6374 sg13cmos5l_nor2b_1
* cell instance sg13cmos5l_nor3_1_0 r0 *1 0,0
Xsg13cmos5l_nor3_1_0 \$1201 \$2312 \$1766 VPWR VGND \$1193 sg13cmos5l_nor3_1
* cell instance sg13cmos5l_nor3_1_1 r0 *1 0,0
Xsg13cmos5l_nor3_1_1 \$1963 \$1793 \$2095 VPWR VGND \$1964 sg13cmos5l_nor3_1
* cell instance sg13cmos5l_nor3_1_2 r0 *1 0,0
Xsg13cmos5l_nor3_1_2 \$1970 \$1792 \$1626 VPWR VGND \$1789 sg13cmos5l_nor3_1
* cell instance sg13cmos5l_nor3_1_3 r0 *1 0,0
Xsg13cmos5l_nor3_1_3 \$6055 \$5863 \$2947 VPWR VGND \$5874 sg13cmos5l_nor3_1
* cell instance sg13cmos5l_nor3_1_4 r0 *1 0,0
Xsg13cmos5l_nor3_1_4 \$3352 \$2489 \$3735 VPWR VGND \$3529 sg13cmos5l_nor3_1
* cell instance sg13cmos5l_nor3_1_5 r0 *1 0,0
Xsg13cmos5l_nor3_1_5 \$2936 \$2504 \$2946 VPWR VGND \$2947 sg13cmos5l_nor3_1
* cell instance sg13cmos5l_nor3_1_6 r0 *1 0,0
Xsg13cmos5l_nor3_1_6 \$5797 \$6048 \$3151 VPWR VGND \$5876 sg13cmos5l_nor3_1
* cell instance sg13cmos5l_nor3_1_7 r0 *1 0,0
Xsg13cmos5l_nor3_1_7 \$2936 \$3740 \$3742 VPWR VGND \$4041 sg13cmos5l_nor3_1
* cell instance sg13cmos5l_nor3_1_8 r0 *1 0,0
Xsg13cmos5l_nor3_1_8 \$1963 \$1793 \$1985 VPWR VGND \$1792 sg13cmos5l_nor3_1
* cell instance sg13cmos5l_nor3_1_9 r0 *1 0,0
Xsg13cmos5l_nor3_1_9 \$825 \$1808 \$1986 VPWR VGND \$1805 sg13cmos5l_nor3_1
* cell instance sg13cmos5l_nor3_1_10 r0 *1 0,0
Xsg13cmos5l_nor3_1_10 \$5874 \$6090 \$6089 VPWR VGND \$6091 sg13cmos5l_nor3_1
* cell instance sg13cmos5l_nor3_1_11 r0 *1 0,0
Xsg13cmos5l_nor3_1_11 \$3188 \$3189 \$3104 VPWR VGND \$2884 sg13cmos5l_nor3_1
* cell instance sg13cmos5l_nor3_1_12 r0 *1 0,0
Xsg13cmos5l_nor3_1_12 \$4984 \$5004 \$5005 VPWR VGND \$4991 sg13cmos5l_nor3_1
* cell instance sg13cmos5l_nor3_1_13 r0 *1 0,0
Xsg13cmos5l_nor3_1_13 \$3189 \$3104 \$2992 VPWR VGND \$3192 sg13cmos5l_nor3_1
* cell instance sg13cmos5l_nor3_1_14 r0 *1 0,0
Xsg13cmos5l_nor3_1_14 \$694 \$1136 \$1259 VPWR VGND \$1258 sg13cmos5l_nor3_1
* cell instance sg13cmos5l_nor3_1_15 r0 *1 0,0
Xsg13cmos5l_nor3_1_15 \$3570 \$3960 \$3961 VPWR VGND \$3410 sg13cmos5l_nor3_1
* cell instance sg13cmos5l_nor3_1_16 r0 *1 0,0
Xsg13cmos5l_nor3_1_16 \$694 \$851 \$852 VPWR VGND \$853 sg13cmos5l_nor3_1
* cell instance sg13cmos5l_nor3_1_17 r0 *1 0,0
Xsg13cmos5l_nor3_1_17 \$418 \$1165 \$1262 VPWR VGND \$1259 sg13cmos5l_nor3_1
* cell instance sg13cmos5l_nor3_1_18 r0 *1 0,0
Xsg13cmos5l_nor3_1_18 \$4537 \$4538 \$4761 VPWR VGND \$4687 sg13cmos5l_nor3_1
* cell instance sg13cmos5l_nor3_1_19 r0 *1 0,0
Xsg13cmos5l_nor3_1_19 \$3409 \$3200 \$3198 VPWR VGND \$3014 sg13cmos5l_nor3_1
* cell instance sg13cmos5l_nor3_1_20 r0 *1 0,0
Xsg13cmos5l_nor3_1_20 \$694 \$1390 \$1391 VPWR VGND \$1534 sg13cmos5l_nor3_1
* cell instance sg13cmos5l_nor3_1_21 r0 *1 0,0
Xsg13cmos5l_nor3_1_21 \$68 \$988 \$19 VPWR VGND \$1129 sg13cmos5l_nor3_1
* cell instance sg13cmos5l_nor3_1_22 r0 *1 0,0
Xsg13cmos5l_nor3_1_22 \$210 \$1129 \$1392 VPWR VGND \$1391 sg13cmos5l_nor3_1
* cell instance sg13cmos5l_nor3_1_23 r0 *1 0,0
Xsg13cmos5l_nor3_1_23 \$201 \$1266 \$333 VPWR VGND \$1392 sg13cmos5l_nor3_1
* cell instance sg13cmos5l_nor3_1_24 r0 *1 0,0
Xsg13cmos5l_nor3_1_24 \$10 \$15 \$5 VPWR VGND \$14 sg13cmos5l_nor3_1
* cell instance sg13cmos5l_nor3_1_25 r0 *1 0,0
Xsg13cmos5l_nor3_1_25 \$97 \$707 \$14 VPWR VGND \$698 sg13cmos5l_nor3_1
* cell instance sg13cmos5l_nor3_1_26 r0 *1 0,0
Xsg13cmos5l_nor3_1_26 \$5337 \$5007 \$4153 VPWR VGND \$6133 sg13cmos5l_nor3_1
* cell instance sg13cmos5l_nor3_1_27 r0 *1 0,0
Xsg13cmos5l_nor3_1_27 \$2382 \$2219 \$2389 VPWR VGND \$2390 sg13cmos5l_nor3_1
* cell instance sg13cmos5l_nor3_1_28 r0 *1 0,0
Xsg13cmos5l_nor3_1_28 \$330 \$22 \$328 VPWR VGND \$431 sg13cmos5l_nor3_1
* cell instance sg13cmos5l_nor3_1_29 r0 *1 0,0
Xsg13cmos5l_nor3_1_29 \$4359 \$4986 \$4877 VPWR VGND \$5018 sg13cmos5l_nor3_1
* cell instance sg13cmos5l_nor3_1_30 r0 *1 0,0
Xsg13cmos5l_nor3_1_30 \$864 \$1140 \$565 VPWR VGND \$1112 sg13cmos5l_nor3_1
* cell instance sg13cmos5l_nor3_1_31 r0 *1 0,0
Xsg13cmos5l_nor3_1_31 \$1268 \$866 \$1402 VPWR VGND \$1273 sg13cmos5l_nor3_1
* cell instance sg13cmos5l_nor3_1_32 r0 *1 0,0
Xsg13cmos5l_nor3_1_32 \$12 \$29 \$38 VPWR VGND \$37 sg13cmos5l_nor3_1
* cell instance sg13cmos5l_nor3_1_33 r0 *1 0,0
Xsg13cmos5l_nor3_1_33 \$220 \$94 \$109 VPWR VGND \$134 sg13cmos5l_nor3_1
* cell instance sg13cmos5l_nor3_1_34 r0 *1 0,0
Xsg13cmos5l_nor3_1_34 \$3833 \$5018 \$5024 VPWR VGND \$3491 sg13cmos5l_nor3_1
* cell instance sg13cmos5l_nor3_1_35 r0 *1 0,0
Xsg13cmos5l_nor3_1_35 \$1011 \$220 \$730 VPWR VGND \$1572 sg13cmos5l_nor3_1
* cell instance sg13cmos5l_nor3_1_36 r0 *1 0,0
Xsg13cmos5l_nor3_1_36 \$578 \$1280 \$730 VPWR VGND \$1279 sg13cmos5l_nor3_1
* cell instance sg13cmos5l_nor3_1_37 r0 *1 0,0
Xsg13cmos5l_nor3_1_37 \$4927 \$5025 \$4881 VPWR VGND \$4884 sg13cmos5l_nor3_1
* cell instance sg13cmos5l_nor3_1_38 r0 *1 0,0
Xsg13cmos5l_nor3_1_38 \$4881 \$5027 \$6212 VPWR VGND \$6370 sg13cmos5l_nor3_1
* cell instance sg13cmos5l_nor3_1_39 r0 *1 0,0
Xsg13cmos5l_nor3_1_39 \$4536 \$5025 \$4881 VPWR VGND \$5028 sg13cmos5l_nor3_1
* cell instance sg13cmos5l_nor3_1_40 r0 *1 0,0
Xsg13cmos5l_nor3_1_40 \$75 \$34 \$115 VPWR VGND \$349 sg13cmos5l_nor3_1
* cell instance sg13cmos5l_nor3_1_41 r0 *1 0,0
Xsg13cmos5l_nor3_1_41 \$581 \$1280 \$731 VPWR VGND \$732 sg13cmos5l_nor3_1
* cell instance sg13cmos5l_nor3_1_42 r0 *1 0,0
Xsg13cmos5l_nor3_1_42 \$4886 \$5376 \$5377 VPWR VGND \$5378 sg13cmos5l_nor3_1
* cell instance sg13cmos5l_nor3_1_43 r0 *1 0,0
Xsg13cmos5l_nor3_1_43 \$5776 \$6178 \$5827 VPWR VGND \$6208 sg13cmos5l_nor3_1
* cell instance sg13cmos5l_nor3_1_44 r0 *1 0,0
Xsg13cmos5l_nor3_1_44 \$5756 \$6709 \$6717 VPWR VGND \$6708 sg13cmos5l_nor3_1
* cell instance sg13cmos5l_nor3_1_45 r0 *1 0,0
Xsg13cmos5l_nor3_1_45 \$6181 \$6710 \$6385 VPWR VGND \$6387 sg13cmos5l_nor3_1
* cell instance sg13cmos5l_nor3_1_46 r0 *1 0,0
Xsg13cmos5l_nor3_1_46 \$5441 \$5386 \$5587 VPWR VGND \$5586 sg13cmos5l_nor3_1
* cell instance sg13cmos5l_nor3_1_47 r0 *1 0,0
Xsg13cmos5l_nor3_1_47 \$6857 \$6858 \$6859 VPWR VGND \$6152 sg13cmos5l_nor3_1
* cell instance sg13cmos5l_nor3_1_48 r0 *1 0,0
Xsg13cmos5l_nor3_1_48 \$6208 \$6187 \$6810 VPWR VGND \$6811 sg13cmos5l_nor3_1
* cell instance sg13cmos5l_nor3_1_49 r0 *1 0,0
Xsg13cmos5l_nor3_1_49 \$5403 \$5999 \$5998 VPWR VGND \$5997 sg13cmos5l_nor3_1
* cell instance sg13cmos5l_nor4_1_0 r0 *1 0,0
Xsg13cmos5l_nor4_1_0 \$2936 \$3144 \$2937 \$3142 VPWR VGND \$3143
+ sg13cmos5l_nor4_1
* cell instance sg13cmos5l_nor4_1_1 r0 *1 0,0
Xsg13cmos5l_nor4_1_1 \$2936 \$2940 \$2713 \$2942 VPWR VGND \$2941
+ sg13cmos5l_nor4_1
* cell instance sg13cmos5l_nor4_1_2 r0 *1 0,0
Xsg13cmos5l_nor4_1_2 \$2936 \$2948 \$2719 \$2720 VPWR VGND \$2950
+ sg13cmos5l_nor4_1
* cell instance sg13cmos5l_nor4_1_3 r0 *1 0,0
Xsg13cmos5l_nor4_1_3 \$4511 \$4678 \$4850 \$3299 VPWR VGND \$5148
+ sg13cmos5l_nor4_1
* cell instance sg13cmos5l_nor4_1_4 r0 *1 0,0
Xsg13cmos5l_nor4_1_4 \$4511 \$4678 \$4504 \$3299 VPWR VGND \$4839
+ sg13cmos5l_nor4_1
* cell instance sg13cmos5l_nor4_1_5 r0 *1 0,0
Xsg13cmos5l_nor4_1_5 \$2541 \$4678 \$4850 \$3299 VPWR VGND \$4757
+ sg13cmos5l_nor4_1
* cell instance sg13cmos5l_nor4_1_6 r0 *1 0,0
Xsg13cmos5l_nor4_1_6 \$2541 \$4678 \$4504 \$3299 VPWR VGND \$4318
+ sg13cmos5l_nor4_1
* cell instance sg13cmos5l_nor4_1_7 r0 *1 0,0
Xsg13cmos5l_nor4_1_7 \$2541 \$4678 \$4504 \$4510 VPWR VGND \$4676
+ sg13cmos5l_nor4_1
* cell instance sg13cmos5l_nor4_1_8 r0 *1 0,0
Xsg13cmos5l_nor4_1_8 \$4685 \$4760 \$4686 \$4315 VPWR VGND \$3960
+ sg13cmos5l_nor4_1
* cell instance sg13cmos5l_nor4_1_9 r0 *1 0,0
Xsg13cmos5l_nor4_1_9 \$2996 \$2375 \$2029 \$3105 VPWR VGND \$2997
+ sg13cmos5l_nor4_1
* cell instance sg13cmos5l_nor4_1_10 r0 *1 0,0
Xsg13cmos5l_nor4_1_10 \$4685 \$4759 \$4760 \$4686 VPWR VGND \$4537
+ sg13cmos5l_nor4_1
* cell instance sg13cmos5l_nor4_1_11 r0 *1 0,0
Xsg13cmos5l_nor4_1_11 \$4979 \$4760 \$3965 \$4686 VPWR VGND \$5007
+ sg13cmos5l_nor4_1
* cell instance sg13cmos5l_nor4_1_12 r0 *1 0,0
Xsg13cmos5l_nor4_1_12 \$4759 \$4760 \$4686 \$4316 VPWR VGND \$4761
+ sg13cmos5l_nor4_1
* cell instance sg13cmos5l_nor4_1_13 r0 *1 0,0
Xsg13cmos5l_nor4_1_13 \$3409 \$3318 \$3410 \$3194 VPWR VGND \$2547
+ sg13cmos5l_nor4_1
* cell instance sg13cmos5l_nor4_1_14 r0 *1 0,0
Xsg13cmos5l_nor4_1_14 \$4537 \$4538 \$3960 \$4761 VPWR VGND \$3592
+ sg13cmos5l_nor4_1
* cell instance sg13cmos5l_nor4_1_15 r0 *1 0,0
Xsg13cmos5l_nor4_1_15 \$694 \$418 \$330 \$1124 VPWR VGND \$1169
+ sg13cmos5l_nor4_1
* cell instance sg13cmos5l_nor4_1_16 r0 *1 0,0
Xsg13cmos5l_nor4_1_16 \$2763 \$2382 \$2284 \$4864 VPWR VGND \$4093
+ sg13cmos5l_nor4_1
* cell instance sg13cmos5l_nor4_1_17 r0 *1 0,0
Xsg13cmos5l_nor4_1_17 \$93 \$113 \$65 \$94 VPWR VGND \$199 sg13cmos5l_nor4_1
* cell instance sg13cmos5l_nor4_1_18 r0 *1 0,0
Xsg13cmos5l_nor4_1_18 \$2194 \$2198 \$3777 \$2378 VPWR VGND \$4151
+ sg13cmos5l_nor4_1
* cell instance sg13cmos5l_nor4_1_19 r0 *1 0,0
Xsg13cmos5l_nor4_1_19 \$2541 \$3550 \$4850 \$4510 VPWR VGND \$4876
+ sg13cmos5l_nor4_1
* cell instance sg13cmos5l_nor4_1_20 r0 *1 0,0
Xsg13cmos5l_nor4_1_20 \$3971 \$3967 \$2231 \$3303 VPWR VGND \$4153
+ sg13cmos5l_nor4_1
* cell instance sg13cmos5l_nor4_1_21 r0 *1 0,0
Xsg13cmos5l_nor4_1_21 \$4344 \$5026 \$4880 \$4345 VPWR VGND \$4681
+ sg13cmos5l_nor4_1
* cell instance sg13cmos5l_nor4_1_22 r0 *1 0,0
Xsg13cmos5l_nor4_1_22 \$4344 \$5026 \$4880 \$4704 VPWR VGND \$2195
+ sg13cmos5l_nor4_1
* cell instance sg13cmos5l_nor4_1_23 r0 *1 0,0
Xsg13cmos5l_nor4_1_23 \$222 \$122 \$134 \$224 VPWR VGND \$225 sg13cmos5l_nor4_1
* cell instance sg13cmos5l_nor4_1_24 r0 *1 0,0
Xsg13cmos5l_nor4_1_24 \$3416 \$2797 \$3233 \$2386 VPWR VGND \$3422
+ sg13cmos5l_nor4_1
* cell instance sg13cmos5l_nor4_1_25 r0 *1 0,0
Xsg13cmos5l_nor4_1_25 \$6370 \$6298 \$6371 \$6372 VPWR VGND \$4188
+ sg13cmos5l_nor4_1
* cell instance sg13cmos5l_nor4_1_26 r0 *1 0,0
Xsg13cmos5l_nor4_1_26 \$573 \$1280 \$204 \$349 VPWR VGND \$1283
+ sg13cmos5l_nor4_1
* cell instance sg13cmos5l_nor4_1_27 r0 *1 0,0
Xsg13cmos5l_nor4_1_27 \$6165 \$6377 \$6172 \$6382 VPWR VGND \$6383
+ sg13cmos5l_nor4_1
* cell instance sg13cmos5l_nor4_1_28 r0 *1 0,0
Xsg13cmos5l_nor4_1_28 \$5989 \$5980 \$5590 \$5990 VPWR VGND \$4581
+ sg13cmos5l_nor4_1
* cell instance sg13cmos5l_nor4_1_29 r0 *1 0,0
Xsg13cmos5l_nor4_1_29 \$5215 \$5216 \$5214 \$5217 VPWR VGND \$5043
+ sg13cmos5l_nor4_1
* cell instance sg13cmos5l_nor4_1_30 r0 *1 0,0
Xsg13cmos5l_nor4_1_30 \$6857 \$7181 \$7225 \$7130 VPWR VGND \$4249
+ sg13cmos5l_nor4_1
* cell instance sg13cmos5l_nor4_1_31 r0 *1 0,0
Xsg13cmos5l_nor4_1_31 \$6713 \$6374 \$6716 \$6390 VPWR VGND \$6717
+ sg13cmos5l_nor4_1
* cell instance sg13cmos5l_nor4_1_32 r0 *1 0,0
Xsg13cmos5l_nor4_1_32 \$2101 \$5780 \$5056 \$5781 VPWR VGND \$4893
+ sg13cmos5l_nor4_1
* cell instance sg13cmos5l_nor4_1_33 r0 *1 0,0
Xsg13cmos5l_nor4_1_33 \$4248 \$5402 \$5785 \$5595 VPWR VGND \$5829
+ sg13cmos5l_nor4_1
* cell instance sg13cmos5l_o21ai_1_0 r0 *1 0,0
Xsg13cmos5l_o21ai_1_0 \$232 \$1596 \$457 VPWR VGND \$2116 sg13cmos5l_o21ai_1
* cell instance sg13cmos5l_o21ai_1_1 r0 *1 0,0
Xsg13cmos5l_o21ai_1_1 \$6877 \$6736 \$6878 VPWR VGND \$6966 sg13cmos5l_o21ai_1
* cell instance sg13cmos5l_o21ai_1_2 r0 *1 0,0
Xsg13cmos5l_o21ai_1_2 \$189 \$1596 \$457 VPWR VGND \$1439 sg13cmos5l_o21ai_1
* cell instance sg13cmos5l_o21ai_1_3 r0 *1 0,0
Xsg13cmos5l_o21ai_1_3 \$228 \$1596 \$2298 VPWR VGND \$2303 sg13cmos5l_o21ai_1
* cell instance sg13cmos5l_o21ai_1_4 r0 *1 0,0
Xsg13cmos5l_o21ai_1_4 \$249 \$2914 \$2298 VPWR VGND \$2916 sg13cmos5l_o21ai_1
* cell instance sg13cmos5l_o21ai_1_5 r0 *1 0,0
Xsg13cmos5l_o21ai_1_5 \$367 \$610 \$457 VPWR VGND \$608 sg13cmos5l_o21ai_1
* cell instance sg13cmos5l_o21ai_1_6 r0 *1 0,0
Xsg13cmos5l_o21ai_1_6 \$228 \$610 \$457 VPWR VGND \$890 sg13cmos5l_o21ai_1
* cell instance sg13cmos5l_o21ai_1_7 r0 *1 0,0
Xsg13cmos5l_o21ai_1_7 \$1935 \$1460 \$1596 VPWR VGND \$1936 sg13cmos5l_o21ai_1
* cell instance sg13cmos5l_o21ai_1_8 r0 *1 0,0
Xsg13cmos5l_o21ai_1_8 \$367 \$2914 \$2298 VPWR VGND \$3901 sg13cmos5l_o21ai_1
* cell instance sg13cmos5l_o21ai_1_9 r0 *1 0,0
Xsg13cmos5l_o21ai_1_9 \$249 \$610 \$457 VPWR VGND \$1033 sg13cmos5l_o21ai_1
* cell instance sg13cmos5l_o21ai_1_10 r0 *1 0,0
Xsg13cmos5l_o21ai_1_10 \$7841 \$8820 \$8818 VPWR VGND \$9082 sg13cmos5l_o21ai_1
* cell instance sg13cmos5l_o21ai_1_11 r0 *1 0,0
Xsg13cmos5l_o21ai_1_11 \$3322 \$3325 \$2914 VPWR VGND \$3326 sg13cmos5l_o21ai_1
* cell instance sg13cmos5l_o21ai_1_12 r0 *1 0,0
Xsg13cmos5l_o21ai_1_12 \$3899 \$3325 \$2914 VPWR VGND \$3902 sg13cmos5l_o21ai_1
* cell instance sg13cmos5l_o21ai_1_13 r0 *1 0,0
Xsg13cmos5l_o21ai_1_13 \$5841 \$5842 \$5466 VPWR VGND \$5843 sg13cmos5l_o21ai_1
* cell instance sg13cmos5l_o21ai_1_14 r0 *1 0,0
Xsg13cmos5l_o21ai_1_14 \$611 \$613 \$610 VPWR VGND \$614 sg13cmos5l_o21ai_1
* cell instance sg13cmos5l_o21ai_1_15 r0 *1 0,0
Xsg13cmos5l_o21ai_1_15 \$1302 \$613 \$610 VPWR VGND \$1034 sg13cmos5l_o21ai_1
* cell instance sg13cmos5l_o21ai_1_16 r0 *1 0,0
Xsg13cmos5l_o21ai_1_16 \$1600 \$1460 \$1596 VPWR VGND \$1762 sg13cmos5l_o21ai_1
* cell instance sg13cmos5l_o21ai_1_17 r0 *1 0,0
Xsg13cmos5l_o21ai_1_17 \$1592 \$913 \$2310 VPWR VGND \$2124 sg13cmos5l_o21ai_1
* cell instance sg13cmos5l_o21ai_1_18 r0 *1 0,0
Xsg13cmos5l_o21ai_1_18 \$2119 \$2120 \$1596 VPWR VGND \$2305 sg13cmos5l_o21ai_1
* cell instance sg13cmos5l_o21ai_1_19 r0 *1 0,0
Xsg13cmos5l_o21ai_1_19 \$7841 \$8550 \$8453 VPWR VGND \$8547 sg13cmos5l_o21ai_1
* cell instance sg13cmos5l_o21ai_1_20 r0 *1 0,0
Xsg13cmos5l_o21ai_1_20 \$2679 \$2120 \$2914 VPWR VGND \$2919 sg13cmos5l_o21ai_1
* cell instance sg13cmos5l_o21ai_1_21 r0 *1 0,0
Xsg13cmos5l_o21ai_1_21 \$6736 \$6969 \$6881 VPWR VGND \$6884 sg13cmos5l_o21ai_1
* cell instance sg13cmos5l_o21ai_1_22 r0 *1 0,0
Xsg13cmos5l_o21ai_1_22 \$2524 \$17275 \$19485 VPWR VGND \$19519
+ sg13cmos5l_o21ai_1
* cell instance sg13cmos5l_o21ai_1_23 r0 *1 0,0
Xsg13cmos5l_o21ai_1_23 \$82 \$610 \$457 VPWR VGND \$1305 sg13cmos5l_o21ai_1
* cell instance sg13cmos5l_o21ai_1_24 r0 *1 0,0
Xsg13cmos5l_o21ai_1_24 \$82 \$2914 \$645 VPWR VGND \$3509 sg13cmos5l_o21ai_1
* cell instance sg13cmos5l_o21ai_1_25 r0 *1 0,0
Xsg13cmos5l_o21ai_1_25 \$7841 \$8551 \$8031 VPWR VGND \$8301 sg13cmos5l_o21ai_1
* cell instance sg13cmos5l_o21ai_1_26 r0 *1 0,0
Xsg13cmos5l_o21ai_1_26 \$3021 \$16437 \$19412 VPWR VGND \$19411
+ sg13cmos5l_o21ai_1
* cell instance sg13cmos5l_o21ai_1_27 r0 *1 0,0
Xsg13cmos5l_o21ai_1_27 \$1787 \$2914 \$2298 VPWR VGND \$4258 sg13cmos5l_o21ai_1
* cell instance sg13cmos5l_o21ai_1_28 r0 *1 0,0
Xsg13cmos5l_o21ai_1_28 \$7841 \$9196 \$8849 VPWR VGND \$9190 sg13cmos5l_o21ai_1
* cell instance sg13cmos5l_o21ai_1_29 r0 *1 0,0
Xsg13cmos5l_o21ai_1_29 \$2307 \$2925 \$3510 VPWR VGND \$3663 sg13cmos5l_o21ai_1
* cell instance sg13cmos5l_o21ai_1_30 r0 *1 0,0
Xsg13cmos5l_o21ai_1_30 \$1920 \$913 \$2128 VPWR VGND \$2483 sg13cmos5l_o21ai_1
* cell instance sg13cmos5l_o21ai_1_31 r0 *1 0,0
Xsg13cmos5l_o21ai_1_31 \$6886 \$6419 \$6229 VPWR VGND \$6226 sg13cmos5l_o21ai_1
* cell instance sg13cmos5l_o21ai_1_32 r0 *1 0,0
Xsg13cmos5l_o21ai_1_32 \$7841 \$9346 \$9421 VPWR VGND \$9510 sg13cmos5l_o21ai_1
* cell instance sg13cmos5l_o21ai_1_33 r0 *1 0,0
Xsg13cmos5l_o21ai_1_33 \$82 \$6032 \$6034 VPWR VGND \$5852 sg13cmos5l_o21ai_1
* cell instance sg13cmos5l_o21ai_1_34 r0 *1 0,0
Xsg13cmos5l_o21ai_1_34 \$2725 \$17275 \$17276 VPWR VGND \$17247
+ sg13cmos5l_o21ai_1
* cell instance sg13cmos5l_o21ai_1_35 r0 *1 0,0
Xsg13cmos5l_o21ai_1_35 \$7841 \$9531 \$9529 VPWR VGND \$9519 sg13cmos5l_o21ai_1
* cell instance sg13cmos5l_o21ai_1_36 r0 *1 0,0
Xsg13cmos5l_o21ai_1_36 \$1036 \$913 \$1035 VPWR VGND \$1037 sg13cmos5l_o21ai_1
* cell instance sg13cmos5l_o21ai_1_37 r0 *1 0,0
Xsg13cmos5l_o21ai_1_37 \$1787 \$1040 \$2298 VPWR VGND \$2685 sg13cmos5l_o21ai_1
* cell instance sg13cmos5l_o21ai_1_38 r0 *1 0,0
Xsg13cmos5l_o21ai_1_38 \$232 \$610 \$457 VPWR VGND \$370 sg13cmos5l_o21ai_1
* cell instance sg13cmos5l_o21ai_1_39 r0 *1 0,0
Xsg13cmos5l_o21ai_1_39 \$913 \$1445 \$1764 VPWR VGND \$1604 sg13cmos5l_o21ai_1
* cell instance sg13cmos5l_o21ai_1_40 r0 *1 0,0
Xsg13cmos5l_o21ai_1_40 \$913 \$2487 \$2488 VPWR VGND \$617 sg13cmos5l_o21ai_1
* cell instance sg13cmos5l_o21ai_1_41 r0 *1 0,0
Xsg13cmos5l_o21ai_1_41 \$2965 \$17275 \$19492 VPWR VGND \$19491
+ sg13cmos5l_o21ai_1
* cell instance sg13cmos5l_o21ai_1_42 r0 *1 0,0
Xsg13cmos5l_o21ai_1_42 \$11400 \$2001 \$11973 VPWR VGND \$9326
+ sg13cmos5l_o21ai_1
* cell instance sg13cmos5l_o21ai_1_43 r0 *1 0,0
Xsg13cmos5l_o21ai_1_43 \$4079 \$3325 \$1596 VPWR VGND \$4080 sg13cmos5l_o21ai_1
* cell instance sg13cmos5l_o21ai_1_44 r0 *1 0,0
Xsg13cmos5l_o21ai_1_44 \$11296 \$2725 \$12312 VPWR VGND \$8821
+ sg13cmos5l_o21ai_1
* cell instance sg13cmos5l_o21ai_1_45 r0 *1 0,0
Xsg13cmos5l_o21ai_1_45 \$906 \$613 \$610 VPWR VGND \$907 sg13cmos5l_o21ai_1
* cell instance sg13cmos5l_o21ai_1_46 r0 *1 0,0
Xsg13cmos5l_o21ai_1_46 \$189 \$623 \$457 VPWR VGND \$626 sg13cmos5l_o21ai_1
* cell instance sg13cmos5l_o21ai_1_47 r0 *1 0,0
Xsg13cmos5l_o21ai_1_47 \$11400 \$2524 \$11401 VPWR VGND \$11078
+ sg13cmos5l_o21ai_1
* cell instance sg13cmos5l_o21ai_1_48 r0 *1 0,0
Xsg13cmos5l_o21ai_1_48 \$3513 \$2307 \$3515 VPWR VGND \$3514 sg13cmos5l_o21ai_1
* cell instance sg13cmos5l_o21ai_1_49 r0 *1 0,0
Xsg13cmos5l_o21ai_1_49 \$1076 \$2312 \$1766 VPWR VGND \$2313 sg13cmos5l_o21ai_1
* cell instance sg13cmos5l_o21ai_1_50 r0 *1 0,0
Xsg13cmos5l_o21ai_1_50 \$1606 \$1460 \$623 VPWR VGND \$1311 sg13cmos5l_o21ai_1
* cell instance sg13cmos5l_o21ai_1_51 r0 *1 0,0
Xsg13cmos5l_o21ai_1_51 \$2281 \$1040 \$2298 VPWR VGND \$2111 sg13cmos5l_o21ai_1
* cell instance sg13cmos5l_o21ai_1_52 r0 *1 0,0
Xsg13cmos5l_o21ai_1_52 \$3132 \$3325 \$2914 VPWR VGND \$3516 sg13cmos5l_o21ai_1
* cell instance sg13cmos5l_o21ai_1_53 r0 *1 0,0
Xsg13cmos5l_o21ai_1_53 \$1359 \$17275 \$19044 VPWR VGND \$19319
+ sg13cmos5l_o21ai_1
* cell instance sg13cmos5l_o21ai_1_54 r0 *1 0,0
Xsg13cmos5l_o21ai_1_54 \$8041 \$8118 \$7894 VPWR VGND \$8042 sg13cmos5l_o21ai_1
* cell instance sg13cmos5l_o21ai_1_55 r0 *1 0,0
Xsg13cmos5l_o21ai_1_55 \$377 \$613 \$623 VPWR VGND \$378 sg13cmos5l_o21ai_1
* cell instance sg13cmos5l_o21ai_1_56 r0 *1 0,0
Xsg13cmos5l_o21ai_1_56 \$763 \$913 \$1194 VPWR VGND \$914 sg13cmos5l_o21ai_1
* cell instance sg13cmos5l_o21ai_1_57 r0 *1 0,0
Xsg13cmos5l_o21ai_1_57 \$2678 \$2307 \$3136 VPWR VGND \$3343 sg13cmos5l_o21ai_1
* cell instance sg13cmos5l_o21ai_1_58 r0 *1 0,0
Xsg13cmos5l_o21ai_1_58 \$1952 \$1460 \$1040 VPWR VGND \$1953 sg13cmos5l_o21ai_1
* cell instance sg13cmos5l_o21ai_1_59 r0 *1 0,0
Xsg13cmos5l_o21ai_1_59 \$539 \$16437 \$19498 VPWR VGND \$19497
+ sg13cmos5l_o21ai_1
* cell instance sg13cmos5l_o21ai_1_60 r0 *1 0,0
Xsg13cmos5l_o21ai_1_60 \$2281 \$3907 \$2298 VPWR VGND \$3716 sg13cmos5l_o21ai_1
* cell instance sg13cmos5l_o21ai_1_61 r0 *1 0,0
Xsg13cmos5l_o21ai_1_61 \$2699 \$2120 \$1040 VPWR VGND \$2698 sg13cmos5l_o21ai_1
* cell instance sg13cmos5l_o21ai_1_62 r0 *1 0,0
Xsg13cmos5l_o21ai_1_62 \$8041 \$9829 \$9602 VPWR VGND \$9534 sg13cmos5l_o21ai_1
* cell instance sg13cmos5l_o21ai_1_63 r0 *1 0,0
Xsg13cmos5l_o21ai_1_63 \$1032 \$876 \$2315 VPWR VGND \$2314 sg13cmos5l_o21ai_1
* cell instance sg13cmos5l_o21ai_1_64 r0 *1 0,0
Xsg13cmos5l_o21ai_1_64 \$915 \$632 \$623 VPWR VGND \$633 sg13cmos5l_o21ai_1
* cell instance sg13cmos5l_o21ai_1_65 r0 *1 0,0
Xsg13cmos5l_o21ai_1_65 \$1769 \$2307 \$3138 VPWR VGND \$3137 sg13cmos5l_o21ai_1
* cell instance sg13cmos5l_o21ai_1_66 r0 *1 0,0
Xsg13cmos5l_o21ai_1_66 \$2230 \$4978 \$17802 VPWR VGND \$17724
+ sg13cmos5l_o21ai_1
* cell instance sg13cmos5l_o21ai_1_67 r0 *1 0,0
Xsg13cmos5l_o21ai_1_67 \$876 \$778 \$780 VPWR VGND \$779 sg13cmos5l_o21ai_1
* cell instance sg13cmos5l_o21ai_1_68 r0 *1 0,0
Xsg13cmos5l_o21ai_1_68 \$11400 \$178 \$11975 VPWR VGND \$9505 sg13cmos5l_o21ai_1
* cell instance sg13cmos5l_o21ai_1_69 r0 *1 0,0
Xsg13cmos5l_o21ai_1_69 \$11296 \$2965 \$12315 VPWR VGND \$8823
+ sg13cmos5l_o21ai_1
* cell instance sg13cmos5l_o21ai_1_70 r0 *1 0,0
Xsg13cmos5l_o21ai_1_70 \$751 \$2701 \$3347 VPWR VGND \$3140 sg13cmos5l_o21ai_1
* cell instance sg13cmos5l_o21ai_1_71 r0 *1 0,0
Xsg13cmos5l_o21ai_1_71 \$7841 \$9644 \$9548 VPWR VGND \$9646 sg13cmos5l_o21ai_1
* cell instance sg13cmos5l_o21ai_1_72 r0 *1 0,0
Xsg13cmos5l_o21ai_1_72 \$1574 \$2701 \$2703 VPWR VGND \$2702 sg13cmos5l_o21ai_1
* cell instance sg13cmos5l_o21ai_1_73 r0 *1 0,0
Xsg13cmos5l_o21ai_1_73 \$8041 \$8579 \$8555 VPWR VGND \$8463 sg13cmos5l_o21ai_1
* cell instance sg13cmos5l_o21ai_1_74 r0 *1 0,0
Xsg13cmos5l_o21ai_1_74 \$178 \$16435 \$19323 VPWR VGND \$19430
+ sg13cmos5l_o21ai_1
* cell instance sg13cmos5l_o21ai_1_75 r0 *1 0,0
Xsg13cmos5l_o21ai_1_75 \$5682 \$58 \$12316 VPWR VGND \$9506 sg13cmos5l_o21ai_1
* cell instance sg13cmos5l_o21ai_1_76 r0 *1 0,0
Xsg13cmos5l_o21ai_1_76 \$8041 \$8049 \$8122 VPWR VGND \$8050 sg13cmos5l_o21ai_1
* cell instance sg13cmos5l_o21ai_1_77 r0 *1 0,0
Xsg13cmos5l_o21ai_1_77 \$58 \$18974 \$18749 VPWR VGND \$19326 sg13cmos5l_o21ai_1
* cell instance sg13cmos5l_o21ai_1_78 r0 *1 0,0
Xsg13cmos5l_o21ai_1_78 \$2524 \$18974 \$19510 VPWR VGND \$19509
+ sg13cmos5l_o21ai_1
* cell instance sg13cmos5l_o21ai_1_79 r0 *1 0,0
Xsg13cmos5l_o21ai_1_79 \$8041 \$9148 \$9079 VPWR VGND \$8860 sg13cmos5l_o21ai_1
* cell instance sg13cmos5l_o21ai_1_80 r0 *1 0,0
Xsg13cmos5l_o21ai_1_80 \$1478 \$629 \$599 VPWR VGND \$1479 sg13cmos5l_o21ai_1
* cell instance sg13cmos5l_o21ai_1_81 r0 *1 0,0
Xsg13cmos5l_o21ai_1_81 \$1787 \$599 \$645 VPWR VGND \$1613 sg13cmos5l_o21ai_1
* cell instance sg13cmos5l_o21ai_1_82 r0 *1 0,0
Xsg13cmos5l_o21ai_1_82 \$1965 \$1945 \$1324 VPWR VGND \$1966 sg13cmos5l_o21ai_1
* cell instance sg13cmos5l_o21ai_1_83 r0 *1 0,0
Xsg13cmos5l_o21ai_1_83 \$2001 \$16435 \$18236 VPWR VGND \$18750
+ sg13cmos5l_o21ai_1
* cell instance sg13cmos5l_o21ai_1_84 r0 *1 0,0
Xsg13cmos5l_o21ai_1_84 \$924 \$632 \$598 VPWR VGND \$920 sg13cmos5l_o21ai_1
* cell instance sg13cmos5l_o21ai_1_85 r0 *1 0,0
Xsg13cmos5l_o21ai_1_85 \$951 \$16435 \$16436 VPWR VGND \$16283
+ sg13cmos5l_o21ai_1
* cell instance sg13cmos5l_o21ai_1_86 r0 *1 0,0
Xsg13cmos5l_o21ai_1_86 \$2725 \$16435 \$17294 VPWR VGND \$17259
+ sg13cmos5l_o21ai_1
* cell instance sg13cmos5l_o21ai_1_87 r0 *1 0,0
Xsg13cmos5l_o21ai_1_87 \$951 \$16437 \$16438 VPWR VGND \$16036
+ sg13cmos5l_o21ai_1
* cell instance sg13cmos5l_o21ai_1_88 r0 *1 0,0
Xsg13cmos5l_o21ai_1_88 \$82 \$598 \$641 VPWR VGND \$783 sg13cmos5l_o21ai_1
* cell instance sg13cmos5l_o21ai_1_89 r0 *1 0,0
Xsg13cmos5l_o21ai_1_89 \$1323 \$1201 \$2312 VPWR VGND \$2322 sg13cmos5l_o21ai_1
* cell instance sg13cmos5l_o21ai_1_90 r0 *1 0,0
Xsg13cmos5l_o21ai_1_90 \$876 \$1616 \$1320 VPWR VGND \$1054 sg13cmos5l_o21ai_1
* cell instance sg13cmos5l_o21ai_1_91 r0 *1 0,0
Xsg13cmos5l_o21ai_1_91 \$11974 \$539 \$11976 VPWR VGND \$8554 sg13cmos5l_o21ai_1
* cell instance sg13cmos5l_o21ai_1_92 r0 *1 0,0
Xsg13cmos5l_o21ai_1_92 \$1963 \$2497 \$2494 VPWR VGND \$2489 sg13cmos5l_o21ai_1
* cell instance sg13cmos5l_o21ai_1_93 r0 *1 0,0
Xsg13cmos5l_o21ai_1_93 \$5641 \$3143 \$3432 VPWR VGND \$5645 sg13cmos5l_o21ai_1
* cell instance sg13cmos5l_o21ai_1_94 r0 *1 0,0
Xsg13cmos5l_o21ai_1_94 \$1324 \$2321 \$2136 VPWR VGND \$1968 sg13cmos5l_o21ai_1
* cell instance sg13cmos5l_o21ai_1_95 r0 *1 0,0
Xsg13cmos5l_o21ai_1_95 \$3717 \$1766 \$3527 VPWR VGND \$4038 sg13cmos5l_o21ai_1
* cell instance sg13cmos5l_o21ai_1_96 r0 *1 0,0
Xsg13cmos5l_o21ai_1_96 \$11974 \$951 \$12047 VPWR VGND \$10299
+ sg13cmos5l_o21ai_1
* cell instance sg13cmos5l_o21ai_1_97 r0 *1 0,0
Xsg13cmos5l_o21ai_1_97 \$2965 \$18974 \$19517 VPWR VGND \$19516
+ sg13cmos5l_o21ai_1
* cell instance sg13cmos5l_o21ai_1_98 r0 *1 0,0
Xsg13cmos5l_o21ai_1_98 \$935 \$632 \$598 VPWR VGND \$936 sg13cmos5l_o21ai_1
* cell instance sg13cmos5l_o21ai_1_99 r0 *1 0,0
Xsg13cmos5l_o21ai_1_99 \$5147 \$4962 \$4847 VPWR VGND \$5150 sg13cmos5l_o21ai_1
* cell instance sg13cmos5l_o21ai_1_100 r0 *1 0,0
Xsg13cmos5l_o21ai_1_100 \$2941 \$6258 \$3432 VPWR VGND \$6054 sg13cmos5l_o21ai_1
* cell instance sg13cmos5l_o21ai_1_101 r0 *1 0,0
Xsg13cmos5l_o21ai_1_101 \$367 \$598 \$645 VPWR VGND \$1059 sg13cmos5l_o21ai_1
* cell instance sg13cmos5l_o21ai_1_102 r0 *1 0,0
Xsg13cmos5l_o21ai_1_102 \$249 \$598 \$645 VPWR VGND \$644 sg13cmos5l_o21ai_1
* cell instance sg13cmos5l_o21ai_1_103 r0 *1 0,0
Xsg13cmos5l_o21ai_1_103 \$3524 \$2715 \$2716 VPWR VGND \$2942 sg13cmos5l_o21ai_1
* cell instance sg13cmos5l_o21ai_1_104 r0 *1 0,0
Xsg13cmos5l_o21ai_1_104 \$799 \$876 \$800 VPWR VGND \$497 sg13cmos5l_o21ai_1
* cell instance sg13cmos5l_o21ai_1_105 r0 *1 0,0
Xsg13cmos5l_o21ai_1_105 \$501 \$632 \$598 VPWR VGND \$394 sg13cmos5l_o21ai_1
* cell instance sg13cmos5l_o21ai_1_106 r0 *1 0,0
Xsg13cmos5l_o21ai_1_106 \$517 \$2324 \$2325 VPWR VGND \$2323 sg13cmos5l_o21ai_1
* cell instance sg13cmos5l_o21ai_1_107 r0 *1 0,0
Xsg13cmos5l_o21ai_1_107 \$505 \$1068 \$1968 VPWR VGND \$1971 sg13cmos5l_o21ai_1
* cell instance sg13cmos5l_o21ai_1_108 r0 *1 0,0
Xsg13cmos5l_o21ai_1_108 \$1494 \$807 \$598 VPWR VGND \$1627 sg13cmos5l_o21ai_1
* cell instance sg13cmos5l_o21ai_1_109 r0 *1 0,0
Xsg13cmos5l_o21ai_1_109 \$4671 \$4297 \$4670 VPWR VGND \$4662 sg13cmos5l_o21ai_1
* cell instance sg13cmos5l_o21ai_1_110 r0 *1 0,0
Xsg13cmos5l_o21ai_1_110 \$1628 \$1068 \$1493 VPWR VGND \$1621 sg13cmos5l_o21ai_1
* cell instance sg13cmos5l_o21ai_1_111 r0 *1 0,0
Xsg13cmos5l_o21ai_1_111 \$228 \$598 \$645 VPWR VGND \$648 sg13cmos5l_o21ai_1
* cell instance sg13cmos5l_o21ai_1_112 r0 *1 0,0
Xsg13cmos5l_o21ai_1_112 \$2281 \$599 \$645 VPWR VGND \$1977 sg13cmos5l_o21ai_1
* cell instance sg13cmos5l_o21ai_1_113 r0 *1 0,0
Xsg13cmos5l_o21ai_1_113 \$1070 \$1068 \$1067 VPWR VGND \$941 sg13cmos5l_o21ai_1
* cell instance sg13cmos5l_o21ai_1_114 r0 *1 0,0
Xsg13cmos5l_o21ai_1_114 \$3916 \$3524 \$2710 VPWR VGND \$3740 sg13cmos5l_o21ai_1
* cell instance sg13cmos5l_o21ai_1_115 r0 *1 0,0
Xsg13cmos5l_o21ai_1_115 \$811 \$807 \$1797 VPWR VGND \$805 sg13cmos5l_o21ai_1
* cell instance sg13cmos5l_o21ai_1_116 r0 *1 0,0
Xsg13cmos5l_o21ai_1_116 \$5869 \$4041 \$3432 VPWR VGND \$5516 sg13cmos5l_o21ai_1
* cell instance sg13cmos5l_o21ai_1_117 r0 *1 0,0
Xsg13cmos5l_o21ai_1_117 \$539 \$19480 \$19578 VPWR VGND \$19581
+ sg13cmos5l_o21ai_1
* cell instance sg13cmos5l_o21ai_1_118 r0 *1 0,0
Xsg13cmos5l_o21ai_1_118 \$2935 \$1981 \$2950 VPWR VGND \$2952 sg13cmos5l_o21ai_1
* cell instance sg13cmos5l_o21ai_1_119 r0 *1 0,0
Xsg13cmos5l_o21ai_1_119 \$1511 \$1765 \$1226 VPWR VGND \$1336 sg13cmos5l_o21ai_1
* cell instance sg13cmos5l_o21ai_1_120 r0 *1 0,0
Xsg13cmos5l_o21ai_1_120 \$1511 \$2489 \$2953 VPWR VGND \$2955 sg13cmos5l_o21ai_1
* cell instance sg13cmos5l_o21ai_1_121 r0 *1 0,0
Xsg13cmos5l_o21ai_1_121 \$1068 \$1337 \$1336 VPWR VGND \$1338 sg13cmos5l_o21ai_1
* cell instance sg13cmos5l_o21ai_1_122 r0 *1 0,0
Xsg13cmos5l_o21ai_1_122 \$1068 \$2709 \$2955 VPWR VGND \$2957 sg13cmos5l_o21ai_1
* cell instance sg13cmos5l_o21ai_1_123 r0 *1 0,0
Xsg13cmos5l_o21ai_1_123 \$178 \$5083 \$5161 VPWR VGND \$5160 sg13cmos5l_o21ai_1
* cell instance sg13cmos5l_o21ai_1_124 r0 *1 0,0
Xsg13cmos5l_o21ai_1_124 \$654 \$807 \$599 VPWR VGND \$655 sg13cmos5l_o21ai_1
* cell instance sg13cmos5l_o21ai_1_125 r0 *1 0,0
Xsg13cmos5l_o21ai_1_125 \$2722 \$1357 \$2724 VPWR VGND \$2723 sg13cmos5l_o21ai_1
* cell instance sg13cmos5l_o21ai_1_126 r0 *1 0,0
Xsg13cmos5l_o21ai_1_126 \$58 \$1230 \$541 VPWR VGND \$1168 sg13cmos5l_o21ai_1
* cell instance sg13cmos5l_o21ai_1_127 r0 *1 0,0
Xsg13cmos5l_o21ai_1_127 \$2725 \$2724 \$1823 VPWR VGND \$2726 sg13cmos5l_o21ai_1
* cell instance sg13cmos5l_o21ai_1_128 r0 *1 0,0
Xsg13cmos5l_o21ai_1_128 \$951 \$599 \$541 VPWR VGND \$660 sg13cmos5l_o21ai_1
* cell instance sg13cmos5l_o21ai_1_129 r0 *1 0,0
Xsg13cmos5l_o21ai_1_129 \$3150 \$3155 \$2455 VPWR VGND \$3156 sg13cmos5l_o21ai_1
* cell instance sg13cmos5l_o21ai_1_130 r0 *1 0,0
Xsg13cmos5l_o21ai_1_130 \$1341 \$807 \$1230 VPWR VGND \$1231 sg13cmos5l_o21ai_1
* cell instance sg13cmos5l_o21ai_1_131 r0 *1 0,0
Xsg13cmos5l_o21ai_1_131 \$5289 \$5163 \$5164 VPWR VGND \$5161 sg13cmos5l_o21ai_1
* cell instance sg13cmos5l_o21ai_1_132 r0 *1 0,0
Xsg13cmos5l_o21ai_1_132 \$5673 \$5526 \$5672 VPWR VGND \$5670 sg13cmos5l_o21ai_1
* cell instance sg13cmos5l_o21ai_1_133 r0 *1 0,0
Xsg13cmos5l_o21ai_1_133 \$411 \$413 \$599 VPWR VGND \$414 sg13cmos5l_o21ai_1
* cell instance sg13cmos5l_o21ai_1_134 r0 *1 0,0
Xsg13cmos5l_o21ai_1_134 \$825 \$956 \$950 VPWR VGND \$537 sg13cmos5l_o21ai_1
* cell instance sg13cmos5l_o21ai_1_135 r0 *1 0,0
Xsg13cmos5l_o21ai_1_135 \$539 \$599 \$541 VPWR VGND \$540 sg13cmos5l_o21ai_1
* cell instance sg13cmos5l_o21ai_1_136 r0 *1 0,0
Xsg13cmos5l_o21ai_1_136 \$5665 \$5673 \$5674 VPWR VGND \$5667 sg13cmos5l_o21ai_1
* cell instance sg13cmos5l_o21ai_1_137 r0 *1 0,0
Xsg13cmos5l_o21ai_1_137 \$1807 \$929 \$2724 VPWR VGND \$2963 sg13cmos5l_o21ai_1
* cell instance sg13cmos5l_o21ai_1_138 r0 *1 0,0
Xsg13cmos5l_o21ai_1_138 \$1079 \$413 \$1230 VPWR VGND \$1080 sg13cmos5l_o21ai_1
* cell instance sg13cmos5l_o21ai_1_139 r0 *1 0,0
Xsg13cmos5l_o21ai_1_139 \$6061 \$6085 \$4681 VPWR VGND \$6014 sg13cmos5l_o21ai_1
* cell instance sg13cmos5l_o21ai_1_140 r0 *1 0,0
Xsg13cmos5l_o21ai_1_140 \$1511 \$1644 \$1513 VPWR VGND \$1347 sg13cmos5l_o21ai_1
* cell instance sg13cmos5l_o21ai_1_141 r0 *1 0,0
Xsg13cmos5l_o21ai_1_141 \$1511 \$1185 \$1809 VPWR VGND \$1748 sg13cmos5l_o21ai_1
* cell instance sg13cmos5l_o21ai_1_142 r0 *1 0,0
Xsg13cmos5l_o21ai_1_142 \$189 \$1230 \$541 VPWR VGND \$1238 sg13cmos5l_o21ai_1
* cell instance sg13cmos5l_o21ai_1_143 r0 *1 0,0
Xsg13cmos5l_o21ai_1_143 \$6086 \$6085 \$4681 VPWR VGND \$6087 sg13cmos5l_o21ai_1
* cell instance sg13cmos5l_o21ai_1_144 r0 *1 0,0
Xsg13cmos5l_o21ai_1_144 \$4251 \$4623 \$4317 VPWR VGND \$4511 sg13cmos5l_o21ai_1
* cell instance sg13cmos5l_o21ai_1_145 r0 *1 0,0
Xsg13cmos5l_o21ai_1_145 \$2965 \$2724 \$1823 VPWR VGND \$2966 sg13cmos5l_o21ai_1
* cell instance sg13cmos5l_o21ai_1_146 r0 *1 0,0
Xsg13cmos5l_o21ai_1_146 \$1515 \$956 \$2352 VPWR VGND \$2353 sg13cmos5l_o21ai_1
* cell instance sg13cmos5l_o21ai_1_147 r0 *1 0,0
Xsg13cmos5l_o21ai_1_147 \$1801 \$956 \$1748 VPWR VGND \$1352 sg13cmos5l_o21ai_1
* cell instance sg13cmos5l_o21ai_1_148 r0 *1 0,0
Xsg13cmos5l_o21ai_1_148 \$5676 \$5677 \$4854 VPWR VGND \$5675 sg13cmos5l_o21ai_1
* cell instance sg13cmos5l_o21ai_1_149 r0 *1 0,0
Xsg13cmos5l_o21ai_1_149 \$2148 \$1357 \$2724 VPWR VGND \$2163 sg13cmos5l_o21ai_1
* cell instance sg13cmos5l_o21ai_1_150 r0 *1 0,0
Xsg13cmos5l_o21ai_1_150 \$4252 \$4623 \$4616 VPWR VGND \$4510 sg13cmos5l_o21ai_1
* cell instance sg13cmos5l_o21ai_1_151 r0 *1 0,0
Xsg13cmos5l_o21ai_1_151 \$1084 \$956 \$1649 VPWR VGND \$1650 sg13cmos5l_o21ai_1
* cell instance sg13cmos5l_o21ai_1_152 r0 *1 0,0
Xsg13cmos5l_o21ai_1_152 \$2458 \$1357 \$2724 VPWR VGND \$2526 sg13cmos5l_o21ai_1
* cell instance sg13cmos5l_o21ai_1_153 r0 *1 0,0
Xsg13cmos5l_o21ai_1_153 \$2001 \$2724 \$541 VPWR VGND \$2002 sg13cmos5l_o21ai_1
* cell instance sg13cmos5l_o21ai_1_154 r0 *1 0,0
Xsg13cmos5l_o21ai_1_154 \$1514 \$413 \$1230 VPWR VGND \$1246 sg13cmos5l_o21ai_1
* cell instance sg13cmos5l_o21ai_1_155 r0 *1 0,0
Xsg13cmos5l_o21ai_1_155 \$2524 \$2724 \$541 VPWR VGND \$2742 sg13cmos5l_o21ai_1
* cell instance sg13cmos5l_o21ai_1_156 r0 *1 0,0
Xsg13cmos5l_o21ai_1_156 \$4857 \$4623 \$4519 VPWR VGND \$4850 sg13cmos5l_o21ai_1
* cell instance sg13cmos5l_o21ai_1_157 r0 *1 0,0
Xsg13cmos5l_o21ai_1_157 \$178 \$1230 \$541 VPWR VGND \$1358 sg13cmos5l_o21ai_1
* cell instance sg13cmos5l_o21ai_1_158 r0 *1 0,0
Xsg13cmos5l_o21ai_1_158 \$6088 \$6085 \$4681 VPWR VGND \$6089 sg13cmos5l_o21ai_1
* cell instance sg13cmos5l_o21ai_1_159 r0 *1 0,0
Xsg13cmos5l_o21ai_1_159 \$1651 \$413 \$1230 VPWR VGND \$1738 sg13cmos5l_o21ai_1
* cell instance sg13cmos5l_o21ai_1_160 r0 *1 0,0
Xsg13cmos5l_o21ai_1_160 \$539 \$1230 \$1823 VPWR VGND \$1820 sg13cmos5l_o21ai_1
* cell instance sg13cmos5l_o21ai_1_161 r0 *1 0,0
Xsg13cmos5l_o21ai_1_161 \$3189 \$2001 \$4133 VPWR VGND \$3953 sg13cmos5l_o21ai_1
* cell instance sg13cmos5l_o21ai_1_162 r0 *1 0,0
Xsg13cmos5l_o21ai_1_162 \$3189 \$58 \$3956 VPWR VGND \$3957 sg13cmos5l_o21ai_1
* cell instance sg13cmos5l_o21ai_1_163 r0 *1 0,0
Xsg13cmos5l_o21ai_1_163 \$5163 \$5528 \$5083 VPWR VGND \$5318 sg13cmos5l_o21ai_1
* cell instance sg13cmos5l_o21ai_1_164 r0 *1 0,0
Xsg13cmos5l_o21ai_1_164 \$5010 \$5876 \$3052 VPWR VGND \$5365 sg13cmos5l_o21ai_1
* cell instance sg13cmos5l_o21ai_1_165 r0 *1 0,0
Xsg13cmos5l_o21ai_1_165 \$2466 \$5083 \$5673 VPWR VGND \$5685 sg13cmos5l_o21ai_1
* cell instance sg13cmos5l_o21ai_1_166 r0 *1 0,0
Xsg13cmos5l_o21ai_1_166 \$3297 \$3189 \$2980 VPWR VGND \$3190 sg13cmos5l_o21ai_1
* cell instance sg13cmos5l_o21ai_1_167 r0 *1 0,0
Xsg13cmos5l_o21ai_1_167 \$3318 \$3949 \$3959 VPWR VGND \$2736 sg13cmos5l_o21ai_1
* cell instance sg13cmos5l_o21ai_1_168 r0 *1 0,0
Xsg13cmos5l_o21ai_1_168 \$2541 \$2542 \$2544 VPWR VGND \$2543 sg13cmos5l_o21ai_1
* cell instance sg13cmos5l_o21ai_1_169 r0 *1 0,0
Xsg13cmos5l_o21ai_1_169 \$4046 \$5083 \$5318 VPWR VGND \$5317 sg13cmos5l_o21ai_1
* cell instance sg13cmos5l_o21ai_1_170 r0 *1 0,0
Xsg13cmos5l_o21ai_1_170 \$1839 \$1840 \$1841 VPWR VGND \$1656 sg13cmos5l_o21ai_1
* cell instance sg13cmos5l_o21ai_1_171 r0 *1 0,0
Xsg13cmos5l_o21ai_1_171 \$4986 \$4773 \$5006 VPWR VGND \$5005 sg13cmos5l_o21ai_1
* cell instance sg13cmos5l_o21ai_1_172 r0 *1 0,0
Xsg13cmos5l_o21ai_1_172 \$5531 \$5317 \$5688 VPWR VGND \$5806 sg13cmos5l_o21ai_1
* cell instance sg13cmos5l_o21ai_1_173 r0 *1 0,0
Xsg13cmos5l_o21ai_1_173 \$3525 \$3772 \$3774 VPWR VGND \$2759 sg13cmos5l_o21ai_1
* cell instance sg13cmos5l_o21ai_1_174 r0 *1 0,0
Xsg13cmos5l_o21ai_1_174 \$2024 \$2025 \$2026 VPWR VGND \$2102 sg13cmos5l_o21ai_1
* cell instance sg13cmos5l_o21ai_1_175 r0 *1 0,0
Xsg13cmos5l_o21ai_1_175 \$2759 \$2542 \$2757 VPWR VGND \$2546 sg13cmos5l_o21ai_1
* cell instance sg13cmos5l_o21ai_1_176 r0 *1 0,0
Xsg13cmos5l_o21ai_1_176 \$3188 \$3105 \$3570 VPWR VGND \$2998 sg13cmos5l_o21ai_1
* cell instance sg13cmos5l_o21ai_1_177 r0 *1 0,0
Xsg13cmos5l_o21ai_1_177 \$6267 \$3772 \$4144 VPWR VGND \$4332 sg13cmos5l_o21ai_1
* cell instance sg13cmos5l_o21ai_1_178 r0 *1 0,0
Xsg13cmos5l_o21ai_1_178 \$5492 \$5008 \$5424 VPWR VGND \$5544 sg13cmos5l_o21ai_1
* cell instance sg13cmos5l_o21ai_1_179 r0 *1 0,0
Xsg13cmos5l_o21ai_1_179 \$5337 \$5544 \$5810 VPWR VGND \$5917 sg13cmos5l_o21ai_1
* cell instance sg13cmos5l_o21ai_1_180 r0 *1 0,0
Xsg13cmos5l_o21ai_1_180 \$1854 \$1856 \$1924 VPWR VGND \$1857 sg13cmos5l_o21ai_1
* cell instance sg13cmos5l_o21ai_1_181 r0 *1 0,0
Xsg13cmos5l_o21ai_1_181 \$3409 \$3318 \$2197 VPWR VGND \$3407 sg13cmos5l_o21ai_1
* cell instance sg13cmos5l_o21ai_1_182 r0 *1 0,0
Xsg13cmos5l_o21ai_1_182 \$5527 \$5008 \$5330 VPWR VGND \$5546 sg13cmos5l_o21ai_1
* cell instance sg13cmos5l_o21ai_1_183 r0 *1 0,0
Xsg13cmos5l_o21ai_1_183 \$5337 \$5546 \$5699 VPWR VGND \$5698 sg13cmos5l_o21ai_1
* cell instance sg13cmos5l_o21ai_1_184 r0 *1 0,0
Xsg13cmos5l_o21ai_1_184 \$325 \$199 \$417 VPWR VGND \$326 sg13cmos5l_o21ai_1
* cell instance sg13cmos5l_o21ai_1_185 r0 *1 0,0
Xsg13cmos5l_o21ai_1_185 \$4149 \$3772 \$3963 VPWR VGND \$4331 sg13cmos5l_o21ai_1
* cell instance sg13cmos5l_o21ai_1_186 r0 *1 0,0
Xsg13cmos5l_o21ai_1_186 \$5337 \$5331 \$6113 VPWR VGND \$6112 sg13cmos5l_o21ai_1
* cell instance sg13cmos5l_o21ai_1_187 r0 *1 0,0
Xsg13cmos5l_o21ai_1_187 \$419 \$987 \$330 VPWR VGND \$985 sg13cmos5l_o21ai_1
* cell instance sg13cmos5l_o21ai_1_188 r0 *1 0,0
Xsg13cmos5l_o21ai_1_188 \$5082 \$5008 \$5191 VPWR VGND \$5331 sg13cmos5l_o21ai_1
* cell instance sg13cmos5l_o21ai_1_189 r0 *1 0,0
Xsg13cmos5l_o21ai_1_189 \$3010 \$2997 \$3197 VPWR VGND \$3196 sg13cmos5l_o21ai_1
* cell instance sg13cmos5l_o21ai_1_190 r0 *1 0,0
Xsg13cmos5l_o21ai_1_190 \$4537 \$4538 \$3785 VPWR VGND \$5008 sg13cmos5l_o21ai_1
* cell instance sg13cmos5l_o21ai_1_191 r0 *1 0,0
Xsg13cmos5l_o21ai_1_191 \$327 \$698 \$561 VPWR VGND \$699 sg13cmos5l_o21ai_1
* cell instance sg13cmos5l_o21ai_1_192 r0 *1 0,0
Xsg13cmos5l_o21ai_1_192 \$327 \$202 \$330 VPWR VGND \$205 sg13cmos5l_o21ai_1
* cell instance sg13cmos5l_o21ai_1_193 r0 *1 0,0
Xsg13cmos5l_o21ai_1_193 \$5611 \$5008 \$5332 VPWR VGND \$5427 sg13cmos5l_o21ai_1
* cell instance sg13cmos5l_o21ai_1_194 r0 *1 0,0
Xsg13cmos5l_o21ai_1_194 \$3965 \$4687 \$4335 VPWR VGND \$4689 sg13cmos5l_o21ai_1
* cell instance sg13cmos5l_o21ai_1_195 r0 *1 0,0
Xsg13cmos5l_o21ai_1_195 \$3014 \$3016 \$2764 VPWR VGND \$1894 sg13cmos5l_o21ai_1
* cell instance sg13cmos5l_o21ai_1_196 r0 *1 0,0
Xsg13cmos5l_o21ai_1_196 \$4955 \$5008 \$5192 VPWR VGND \$5333 sg13cmos5l_o21ai_1
* cell instance sg13cmos5l_o21ai_1_197 r0 *1 0,0
Xsg13cmos5l_o21ai_1_197 \$5334 \$5427 \$5336 VPWR VGND \$5335 sg13cmos5l_o21ai_1
* cell instance sg13cmos5l_o21ai_1_198 r0 *1 0,0
Xsg13cmos5l_o21ai_1_198 \$5337 \$5333 \$5339 VPWR VGND \$5338 sg13cmos5l_o21ai_1
* cell instance sg13cmos5l_o21ai_1_199 r0 *1 0,0
Xsg13cmos5l_o21ai_1_199 \$102 \$563 \$93 VPWR VGND \$415 sg13cmos5l_o21ai_1
* cell instance sg13cmos5l_o21ai_1_200 r0 *1 0,0
Xsg13cmos5l_o21ai_1_200 \$62 \$102 \$738 VPWR VGND \$861 sg13cmos5l_o21ai_1
* cell instance sg13cmos5l_o21ai_1_201 r0 *1 0,0
Xsg13cmos5l_o21ai_1_201 \$5322 \$5008 \$5193 VPWR VGND \$5340 sg13cmos5l_o21ai_1
* cell instance sg13cmos5l_o21ai_1_202 r0 *1 0,0
Xsg13cmos5l_o21ai_1_202 \$62 \$102 \$97 VPWR VGND \$426 sg13cmos5l_o21ai_1
* cell instance sg13cmos5l_o21ai_1_203 r0 *1 0,0
Xsg13cmos5l_o21ai_1_203 \$5334 \$5340 \$5561 VPWR VGND \$5560 sg13cmos5l_o21ai_1
* cell instance sg13cmos5l_o21ai_1_204 r0 *1 0,0
Xsg13cmos5l_o21ai_1_204 \$2209 \$2213 \$2046 VPWR VGND \$1125 sg13cmos5l_o21ai_1
* cell instance sg13cmos5l_o21ai_1_205 r0 *1 0,0
Xsg13cmos5l_o21ai_1_205 \$5418 \$5008 \$5194 VPWR VGND \$5341 sg13cmos5l_o21ai_1
* cell instance sg13cmos5l_o21ai_1_206 r0 *1 0,0
Xsg13cmos5l_o21ai_1_206 \$5337 \$5341 \$5945 VPWR VGND \$5944 sg13cmos5l_o21ai_1
* cell instance sg13cmos5l_o21ai_1_207 r0 *1 0,0
Xsg13cmos5l_o21ai_1_207 \$14 \$17 \$19 VPWR VGND \$18 sg13cmos5l_o21ai_1
* cell instance sg13cmos5l_o21ai_1_208 r0 *1 0,0
Xsg13cmos5l_o21ai_1_208 \$3110 \$2766 \$2767 VPWR VGND \$2571 sg13cmos5l_o21ai_1
* cell instance sg13cmos5l_o21ai_1_209 r0 *1 0,0
Xsg13cmos5l_o21ai_1_209 \$419 \$354 \$93 VPWR VGND \$430 sg13cmos5l_o21ai_1
* cell instance sg13cmos5l_o21ai_1_210 r0 *1 0,0
Xsg13cmos5l_o21ai_1_210 \$333 \$993 \$222 VPWR VGND \$994 sg13cmos5l_o21ai_1
* cell instance sg13cmos5l_o21ai_1_211 r0 *1 0,0
Xsg13cmos5l_o21ai_1_211 \$206 \$336 \$208 VPWR VGND \$337 sg13cmos5l_o21ai_1
* cell instance sg13cmos5l_o21ai_1_212 r0 *1 0,0
Xsg13cmos5l_o21ai_1_212 \$22 \$987 \$558 VPWR VGND \$1133 sg13cmos5l_o21ai_1
* cell instance sg13cmos5l_o21ai_1_213 r0 *1 0,0
Xsg13cmos5l_o21ai_1_213 \$871 \$860 \$558 VPWR VGND \$996 sg13cmos5l_o21ai_1
* cell instance sg13cmos5l_o21ai_1_214 r0 *1 0,0
Xsg13cmos5l_o21ai_1_214 \$2466 \$2766 \$2390 VPWR VGND \$2213 sg13cmos5l_o21ai_1
* cell instance sg13cmos5l_o21ai_1_215 r0 *1 0,0
Xsg13cmos5l_o21ai_1_215 \$600 \$431 \$712 VPWR VGND \$710 sg13cmos5l_o21ai_1
* cell instance sg13cmos5l_o21ai_1_216 r0 *1 0,0
Xsg13cmos5l_o21ai_1_216 \$333 \$211 \$418 VPWR VGND \$339 sg13cmos5l_o21ai_1
* cell instance sg13cmos5l_o21ai_1_217 r0 *1 0,0
Xsg13cmos5l_o21ai_1_217 \$113 \$67 \$860 VPWR VGND \$862 sg13cmos5l_o21ai_1
* cell instance sg13cmos5l_o21ai_1_218 r0 *1 0,0
Xsg13cmos5l_o21ai_1_218 \$1694 \$2770 \$3211 VPWR VGND \$3210 sg13cmos5l_o21ai_1
* cell instance sg13cmos5l_o21ai_1_219 r0 *1 0,0
Xsg13cmos5l_o21ai_1_219 \$3023 \$2766 \$2889 VPWR VGND \$3025 sg13cmos5l_o21ai_1
* cell instance sg13cmos5l_o21ai_1_220 r0 *1 0,0
Xsg13cmos5l_o21ai_1_220 \$57 \$433 \$24 VPWR VGND \$434 sg13cmos5l_o21ai_1
* cell instance sg13cmos5l_o21ai_1_221 r0 *1 0,0
Xsg13cmos5l_o21ai_1_221 \$62 \$25 \$112 VPWR VGND \$117 sg13cmos5l_o21ai_1
* cell instance sg13cmos5l_o21ai_1_222 r0 *1 0,0
Xsg13cmos5l_o21ai_1_222 \$2218 \$2225 \$2220 VPWR VGND \$2227 sg13cmos5l_o21ai_1
* cell instance sg13cmos5l_o21ai_1_223 r0 *1 0,0
Xsg13cmos5l_o21ai_1_223 \$4341 \$4170 \$4169 VPWR VGND \$4342 sg13cmos5l_o21ai_1
* cell instance sg13cmos5l_o21ai_1_224 r0 *1 0,0
Xsg13cmos5l_o21ai_1_224 \$4 \$439 \$569 VPWR VGND \$440 sg13cmos5l_o21ai_1
* cell instance sg13cmos5l_o21ai_1_225 r0 *1 0,0
Xsg13cmos5l_o21ai_1_225 \$68 \$19 \$27 VPWR VGND \$71 sg13cmos5l_o21ai_1
* cell instance sg13cmos5l_o21ai_1_226 r0 *1 0,0
Xsg13cmos5l_o21ai_1_226 \$1560 \$440 \$1579 VPWR VGND \$1705 sg13cmos5l_o21ai_1
* cell instance sg13cmos5l_o21ai_1_227 r0 *1 0,0
Xsg13cmos5l_o21ai_1_227 \$1280 \$1275 \$1144 VPWR VGND \$1276 sg13cmos5l_o21ai_1
* cell instance sg13cmos5l_o21ai_1_228 r0 *1 0,0
Xsg13cmos5l_o21ai_1_228 \$1011 \$75 \$1003 VPWR VGND \$1275 sg13cmos5l_o21ai_1
* cell instance sg13cmos5l_o21ai_1_229 r0 *1 0,0
Xsg13cmos5l_o21ai_1_229 \$343 \$570 \$441 VPWR VGND \$571 sg13cmos5l_o21ai_1
* cell instance sg13cmos5l_o21ai_1_230 r0 *1 0,0
Xsg13cmos5l_o21ai_1_230 \$3974 \$3975 \$3977 VPWR VGND \$3976 sg13cmos5l_o21ai_1
* cell instance sg13cmos5l_o21ai_1_231 r0 *1 0,0
Xsg13cmos5l_o21ai_1_231 \$2588 \$2391 \$2669 VPWR VGND \$3216 sg13cmos5l_o21ai_1
* cell instance sg13cmos5l_o21ai_1_232 r0 *1 0,0
Xsg13cmos5l_o21ai_1_232 \$2586 \$2391 \$2669 VPWR VGND \$2590 sg13cmos5l_o21ai_1
* cell instance sg13cmos5l_o21ai_1_233 r0 *1 0,0
Xsg13cmos5l_o21ai_1_233 \$2786 \$2766 \$2785 VPWR VGND \$2591 sg13cmos5l_o21ai_1
* cell instance sg13cmos5l_o21ai_1_234 r0 *1 0,0
Xsg13cmos5l_o21ai_1_234 \$57 \$73 \$41 VPWR VGND \$40 sg13cmos5l_o21ai_1
* cell instance sg13cmos5l_o21ai_1_235 r0 *1 0,0
Xsg13cmos5l_o21ai_1_235 \$76 \$25 \$94 VPWR VGND \$223 sg13cmos5l_o21ai_1
* cell instance sg13cmos5l_o21ai_1_236 r0 *1 0,0
Xsg13cmos5l_o21ai_1_236 \$4046 \$2766 \$3217 VPWR VGND \$3218 sg13cmos5l_o21ai_1
* cell instance sg13cmos5l_o21ai_1_237 r0 *1 0,0
Xsg13cmos5l_o21ai_1_237 \$23 \$115 \$343 VPWR VGND \$345 sg13cmos5l_o21ai_1
* cell instance sg13cmos5l_o21ai_1_238 r0 *1 0,0
Xsg13cmos5l_o21ai_1_238 \$31 \$40 \$44 VPWR VGND \$43 sg13cmos5l_o21ai_1
* cell instance sg13cmos5l_o21ai_1_239 r0 *1 0,0
Xsg13cmos5l_o21ai_1_239 \$2582 \$2591 \$2593 VPWR VGND \$2595 sg13cmos5l_o21ai_1
* cell instance sg13cmos5l_o21ai_1_240 r0 *1 0,0
Xsg13cmos5l_o21ai_1_240 \$3420 \$3218 \$3028 VPWR VGND \$2245 sg13cmos5l_o21ai_1
* cell instance sg13cmos5l_o21ai_1_241 r0 *1 0,0
Xsg13cmos5l_o21ai_1_241 \$343 \$37 \$46 VPWR VGND \$44 sg13cmos5l_o21ai_1
* cell instance sg13cmos5l_o21ai_1_242 r0 *1 0,0
Xsg13cmos5l_o21ai_1_242 \$34 \$68 \$578 VPWR VGND \$444 sg13cmos5l_o21ai_1
* cell instance sg13cmos5l_o21ai_1_243 r0 *1 0,0
Xsg13cmos5l_o21ai_1_243 \$3982 \$3975 \$3981 VPWR VGND \$4417 sg13cmos5l_o21ai_1
* cell instance sg13cmos5l_o21ai_1_244 r0 *1 0,0
Xsg13cmos5l_o21ai_1_244 \$4705 \$3975 \$4567 VPWR VGND \$4880 sg13cmos5l_o21ai_1
* cell instance sg13cmos5l_o21ai_1_245 r0 *1 0,0
Xsg13cmos5l_o21ai_1_245 \$5438 \$5368 \$3785 VPWR VGND \$5756 sg13cmos5l_o21ai_1
* cell instance sg13cmos5l_o21ai_1_246 r0 *1 0,0
Xsg13cmos5l_o21ai_1_246 \$3785 \$3422 \$3424 VPWR VGND \$3423 sg13cmos5l_o21ai_1
* cell instance sg13cmos5l_o21ai_1_247 r0 *1 0,0
Xsg13cmos5l_o21ai_1_247 \$578 \$48 \$343 VPWR VGND \$594 sg13cmos5l_o21ai_1
* cell instance sg13cmos5l_o21ai_1_248 r0 *1 0,0
Xsg13cmos5l_o21ai_1_248 \$5771 \$5368 \$6165 VPWR VGND \$5981 sg13cmos5l_o21ai_1
* cell instance sg13cmos5l_o21ai_1_249 r0 *1 0,0
Xsg13cmos5l_o21ai_1_249 \$578 \$730 \$600 VPWR VGND \$226 sg13cmos5l_o21ai_1
* cell instance sg13cmos5l_o21ai_1_250 r0 *1 0,0
Xsg13cmos5l_o21ai_1_250 \$1402 \$1279 \$69 VPWR VGND \$1406 sg13cmos5l_o21ai_1
* cell instance sg13cmos5l_o21ai_1_251 r0 *1 0,0
Xsg13cmos5l_o21ai_1_251 \$3777 \$4185 \$3416 VPWR VGND \$4347 sg13cmos5l_o21ai_1
* cell instance sg13cmos5l_o21ai_1_252 r0 *1 0,0
Xsg13cmos5l_o21ai_1_252 \$4706 \$3825 \$4707 VPWR VGND \$4704 sg13cmos5l_o21ai_1
* cell instance sg13cmos5l_o21ai_1_253 r0 *1 0,0
Xsg13cmos5l_o21ai_1_253 \$3608 \$3975 \$3607 VPWR VGND \$3223 sg13cmos5l_o21ai_1
* cell instance sg13cmos5l_o21ai_1_254 r0 *1 0,0
Xsg13cmos5l_o21ai_1_254 \$2194 \$4185 \$3416 VPWR VGND \$4348 sg13cmos5l_o21ai_1
* cell instance sg13cmos5l_o21ai_1_255 r0 *1 0,0
Xsg13cmos5l_o21ai_1_255 \$68 \$578 \$1014 VPWR VGND \$1013 sg13cmos5l_o21ai_1
* cell instance sg13cmos5l_o21ai_1_256 r0 *1 0,0
Xsg13cmos5l_o21ai_1_256 \$2378 \$4185 \$3416 VPWR VGND \$4186 sg13cmos5l_o21ai_1
* cell instance sg13cmos5l_o21ai_1_257 r0 *1 0,0
Xsg13cmos5l_o21ai_1_257 \$4188 \$4186 \$4189 VPWR VGND \$3822 sg13cmos5l_o21ai_1
* cell instance sg13cmos5l_o21ai_1_258 r0 *1 0,0
Xsg13cmos5l_o21ai_1_258 \$3492 \$3219 \$3833 VPWR VGND \$3612 sg13cmos5l_o21ai_1
* cell instance sg13cmos5l_o21ai_1_259 r0 *1 0,0
Xsg13cmos5l_o21ai_1_259 \$732 \$734 \$718 VPWR VGND \$696 sg13cmos5l_o21ai_1
* cell instance sg13cmos5l_o21ai_1_260 r0 *1 0,0
Xsg13cmos5l_o21ai_1_260 \$727 \$334 \$449 VPWR VGND \$734 sg13cmos5l_o21ai_1
* cell instance sg13cmos5l_o21ai_1_261 r0 *1 0,0
Xsg13cmos5l_o21ai_1_261 \$3236 \$3031 \$3491 VPWR VGND \$3613 sg13cmos5l_o21ai_1
* cell instance sg13cmos5l_o21ai_1_262 r0 *1 0,0
Xsg13cmos5l_o21ai_1_262 \$3824 \$3825 \$3985 VPWR VGND \$3826 sg13cmos5l_o21ai_1
* cell instance sg13cmos5l_o21ai_1_263 r0 *1 0,0
Xsg13cmos5l_o21ai_1_263 \$581 \$563 \$1016 VPWR VGND \$1018 sg13cmos5l_o21ai_1
* cell instance sg13cmos5l_o21ai_1_264 r0 *1 0,0
Xsg13cmos5l_o21ai_1_264 \$129 \$50 \$343 VPWR VGND \$448 sg13cmos5l_o21ai_1
* cell instance sg13cmos5l_o21ai_1_265 r0 *1 0,0
Xsg13cmos5l_o21ai_1_265 \$707 \$563 \$861 VPWR VGND \$1154 sg13cmos5l_o21ai_1
* cell instance sg13cmos5l_o21ai_1_266 r0 *1 0,0
Xsg13cmos5l_o21ai_1_266 \$131 \$1283 \$1576 VPWR VGND \$1281 sg13cmos5l_o21ai_1
* cell instance sg13cmos5l_o21ai_1_267 r0 *1 0,0
Xsg13cmos5l_o21ai_1_267 \$4353 \$3825 \$4350 VPWR VGND \$5026 sg13cmos5l_o21ai_1
* cell instance sg13cmos5l_o21ai_1_268 r0 *1 0,0
Xsg13cmos5l_o21ai_1_268 \$5762 \$5391 \$5378 VPWR VGND \$6378 sg13cmos5l_o21ai_1
* cell instance sg13cmos5l_o21ai_1_269 r0 *1 0,0
Xsg13cmos5l_o21ai_1_269 \$2803 \$3972 \$3828 VPWR VGND \$3988 sg13cmos5l_o21ai_1
* cell instance sg13cmos5l_o21ai_1_270 r0 *1 0,0
Xsg13cmos5l_o21ai_1_270 \$3833 \$4570 \$4568 VPWR VGND \$2629 sg13cmos5l_o21ai_1
* cell instance sg13cmos5l_o21ai_1_271 r0 *1 0,0
Xsg13cmos5l_o21ai_1_271 \$3550 \$4185 \$4712 VPWR VGND \$4570 sg13cmos5l_o21ai_1
* cell instance sg13cmos5l_o21ai_1_272 r0 *1 0,0
Xsg13cmos5l_o21ai_1_272 \$5374 \$5382 \$5209 VPWR VGND \$5383 sg13cmos5l_o21ai_1
* cell instance sg13cmos5l_o21ai_1_273 r0 *1 0,0
Xsg13cmos5l_o21ai_1_273 \$5379 \$5767 \$5388 VPWR VGND \$5823 sg13cmos5l_o21ai_1
* cell instance sg13cmos5l_o21ai_1_274 r0 *1 0,0
Xsg13cmos5l_o21ai_1_274 \$3972 \$2817 \$4571 VPWR VGND \$4713 sg13cmos5l_o21ai_1
* cell instance sg13cmos5l_o21ai_1_275 r0 *1 0,0
Xsg13cmos5l_o21ai_1_275 \$5388 \$5763 \$5771 VPWR VGND \$5770 sg13cmos5l_o21ai_1
* cell instance sg13cmos5l_o21ai_1_276 r0 *1 0,0
Xsg13cmos5l_o21ai_1_276 \$5441 \$5212 \$5242 VPWR VGND \$5040 sg13cmos5l_o21ai_1
* cell instance sg13cmos5l_o21ai_1_277 r0 *1 0,0
Xsg13cmos5l_o21ai_1_277 \$5771 \$5580 \$6016 VPWR VGND \$6174 sg13cmos5l_o21ai_1
* cell instance sg13cmos5l_o21ai_1_278 r0 *1 0,0
Xsg13cmos5l_o21ai_1_278 \$3972 \$2256 \$3999 VPWR VGND \$4001 sg13cmos5l_o21ai_1
* cell instance sg13cmos5l_o21ai_1_279 r0 *1 0,0
Xsg13cmos5l_o21ai_1_279 \$3972 \$2620 \$4362 VPWR VGND \$4363 sg13cmos5l_o21ai_1
* cell instance sg13cmos5l_o21ai_1_280 r0 *1 0,0
Xsg13cmos5l_o21ai_1_280 \$2541 \$4185 \$4889 VPWR VGND \$3840 sg13cmos5l_o21ai_1
* cell instance sg13cmos5l_o21ai_1_281 r0 *1 0,0
Xsg13cmos5l_o21ai_1_281 \$3833 \$3840 \$3834 VPWR VGND \$2644 sg13cmos5l_o21ai_1
* cell instance sg13cmos5l_o21ai_1_282 r0 *1 0,0
Xsg13cmos5l_o21ai_1_282 \$2276 \$3254 \$3313 VPWR VGND \$3445 sg13cmos5l_o21ai_1
* cell instance sg13cmos5l_o21ai_1_283 r0 *1 0,0
Xsg13cmos5l_o21ai_1_283 \$4581 \$4348 \$4724 VPWR VGND \$4583 sg13cmos5l_o21ai_1
* cell instance sg13cmos5l_o21ai_1_284 r0 *1 0,0
Xsg13cmos5l_o21ai_1_284 \$1359 \$5092 \$4185 VPWR VGND \$5217 sg13cmos5l_o21ai_1
* cell instance sg13cmos5l_o21ai_1_285 r0 *1 0,0
Xsg13cmos5l_o21ai_1_285 \$4728 \$4347 \$4727 VPWR VGND \$4740 sg13cmos5l_o21ai_1
* cell instance sg13cmos5l_o21ai_1_286 r0 *1 0,0
Xsg13cmos5l_o21ai_1_286 \$5587 \$6176 \$6178 VPWR VGND \$6185 sg13cmos5l_o21ai_1
* cell instance sg13cmos5l_o21ai_1_287 r0 *1 0,0
Xsg13cmos5l_o21ai_1_287 \$5441 \$5589 \$5221 VPWR VGND \$5590 sg13cmos5l_o21ai_1
* cell instance sg13cmos5l_o21ai_1_288 r0 *1 0,0
Xsg13cmos5l_o21ai_1_288 \$5991 \$5993 \$5994 VPWR VGND \$5990 sg13cmos5l_o21ai_1
* cell instance sg13cmos5l_o21ai_1_289 r0 *1 0,0
Xsg13cmos5l_o21ai_1_289 \$5592 \$5786 \$5438 VPWR VGND \$5779 sg13cmos5l_o21ai_1
* cell instance sg13cmos5l_o21ai_1_290 r0 *1 0,0
Xsg13cmos5l_o21ai_1_290 \$4386 \$4536 \$4359 VPWR VGND \$4585 sg13cmos5l_o21ai_1
* cell instance sg13cmos5l_o21ai_1_291 r0 *1 0,0
Xsg13cmos5l_o21ai_1_291 \$5374 \$5394 \$5396 VPWR VGND \$5395 sg13cmos5l_o21ai_1
* cell instance sg13cmos5l_o21ai_1_292 r0 *1 0,0
Xsg13cmos5l_o21ai_1_292 \$4386 \$3254 \$3268 VPWR VGND \$4732 sg13cmos5l_o21ai_1
* cell instance sg13cmos5l_o21ai_1_293 r0 *1 0,0
Xsg13cmos5l_o21ai_1_293 \$6208 \$6810 \$6187 VPWR VGND \$6812 sg13cmos5l_o21ai_1
* cell instance sg13cmos5l_o21ai_1_294 r0 *1 0,0
Xsg13cmos5l_o21ai_1_294 \$3688 \$3031 \$3268 VPWR VGND \$3856 sg13cmos5l_o21ai_1
* cell instance sg13cmos5l_o21ai_1_295 r0 *1 0,0
Xsg13cmos5l_o21ai_1_295 \$3677 \$5055 \$6812 VPWR VGND \$6415 sg13cmos5l_o21ai_1
* cell instance sg13cmos5l_o21ai_1_296 r0 *1 0,0
Xsg13cmos5l_o21ai_1_296 \$2658 \$3254 \$3268 VPWR VGND \$3456 sg13cmos5l_o21ai_1
* cell instance sg13cmos5l_o21ai_1_297 r0 *1 0,0
Xsg13cmos5l_o21ai_1_297 \$3894 \$3484 \$4014 VPWR VGND \$4018 sg13cmos5l_o21ai_1
* cell instance sg13cmos5l_o21ai_1_298 r0 *1 0,0
Xsg13cmos5l_o21ai_1_298 \$5391 \$6399 \$5829 VPWR VGND \$6389 sg13cmos5l_o21ai_1
* cell instance sg13cmos5l_o21ai_1_299 r0 *1 0,0
Xsg13cmos5l_o21ai_1_299 \$3110 \$5092 \$5035 VPWR VGND \$5402 sg13cmos5l_o21ai_1
* cell instance sg13cmos5l_o21ai_1_300 r0 *1 0,0
Xsg13cmos5l_o21ai_1_300 \$5057 \$3976 \$4342 VPWR VGND \$5058 sg13cmos5l_o21ai_1
* cell instance sg13cmos5l_o21ai_1_301 r0 *1 0,0
Xsg13cmos5l_o21ai_1_301 \$5391 \$6189 \$5997 VPWR VGND \$6371 sg13cmos5l_o21ai_1
* cell instance sg13cmos5l_o21ai_1_302 r0 *1 0,0
Xsg13cmos5l_o21ai_1_302 \$5374 \$5597 \$5404 VPWR VGND \$5595 sg13cmos5l_o21ai_1
* cell instance sg13cmos5l_or2_1_0 r0 *1 0,0
Xsg13cmos5l_or2_1_0 \$6026 \$5842 VPWR VGND \$6419 sg13cmos5l_or2_1
* cell instance sg13cmos5l_or2_1_1 r0 *1 0,0
Xsg13cmos5l_or2_1_1 \$1324 \$1410 VPWR VGND \$1492 sg13cmos5l_or2_1
* cell instance sg13cmos5l_or2_1_2 r0 *1 0,0
Xsg13cmos5l_or2_1_2 \$4297 \$4296 VPWR VGND \$3921 sg13cmos5l_or2_1
* cell instance sg13cmos5l_or2_1_3 r0 *1 0,0
Xsg13cmos5l_or2_1_3 \$2324 \$2330 VPWR VGND \$2332 sg13cmos5l_or2_1
* cell instance sg13cmos5l_or2_1_4 r0 *1 0,0
Xsg13cmos5l_or2_1_4 \$1076 \$2666 VPWR VGND \$2505 sg13cmos5l_or2_1
* cell instance sg13cmos5l_or2_1_5 r0 *1 0,0
Xsg13cmos5l_or2_1_5 \$4979 \$5677 VPWR VGND \$5673 sg13cmos5l_or2_1
* cell instance sg13cmos5l_or2_1_6 r0 *1 0,0
Xsg13cmos5l_or2_1_6 \$5680 \$5305 VPWR VGND \$5677 sg13cmos5l_or2_1
* cell instance sg13cmos5l_or2_1_7 r0 *1 0,0
Xsg13cmos5l_or2_1_7 \$5898 \$5684 VPWR VGND \$4520 sg13cmos5l_or2_1
* cell instance sg13cmos5l_or2_1_8 r0 *1 0,0
Xsg13cmos5l_or2_1_8 \$3570 \$3409 VPWR VGND \$2284 sg13cmos5l_or2_1
* cell instance sg13cmos5l_or2_1_9 r0 *1 0,0
Xsg13cmos5l_or2_1_9 \$2382 \$2381 VPWR VGND \$2386 sg13cmos5l_or2_1
* cell instance sg13cmos5l_or2_1_10 r0 *1 0,0
Xsg13cmos5l_or2_1_10 \$860 \$738 VPWR VGND \$858 sg13cmos5l_or2_1
* cell instance sg13cmos5l_or2_1_11 r0 *1 0,0
Xsg13cmos5l_or2_1_11 \$10 \$5 VPWR VGND \$102 sg13cmos5l_or2_1
* cell instance sg13cmos5l_or2_1_12 r0 *1 0,0
Xsg13cmos5l_or2_1_12 \$600 \$1273 VPWR VGND \$1142 sg13cmos5l_or2_1
* cell instance sg13cmos5l_or2_1_13 r0 *1 0,0
Xsg13cmos5l_or2_1_13 \$76 \$1275 VPWR VGND \$1405 sg13cmos5l_or2_1
* cell instance sg13cmos5l_or2_1_14 r0 *1 0,0
Xsg13cmos5l_or2_1_14 \$53 \$72 VPWR VGND \$50 sg13cmos5l_or2_1
* cell instance sg13cmos5l_or2_1_15 r0 *1 0,0
Xsg13cmos5l_or2_1_15 \$343 \$349 VPWR VGND \$336 sg13cmos5l_or2_1
* cell instance sg13cmos5l_or2_1_16 r0 *1 0,0
Xsg13cmos5l_or2_1_16 \$5583 \$5770 VPWR VGND \$5039 sg13cmos5l_or2_1
* cell instance sg13cmos5l_or2_1_17 r0 *1 0,0
Xsg13cmos5l_or2_1_17 \$5776 \$5827 VPWR VGND \$5988 sg13cmos5l_or2_1
* cell instance sg13cmos5l_or2_1_18 r0 *1 0,0
Xsg13cmos5l_or2_1_18 \$7452 \$7688 VPWR VGND \$7451 sg13cmos5l_or2_1
* cell instance sg13cmos5l_or3_1_0 r0 *1 0,0
Xsg13cmos5l_or3_1_0 \$983 \$4517 \$3781 VPWR VGND \$4317 sg13cmos5l_or3_1
* cell instance sg13cmos5l_or3_1_1 r0 *1 0,0
Xsg13cmos5l_or3_1_1 \$585 \$4517 \$3781 VPWR VGND \$4616 sg13cmos5l_or3_1
* cell instance sg13cmos5l_or3_1_2 r0 *1 0,0
Xsg13cmos5l_or3_1_2 \$802 \$4517 \$3781 VPWR VGND \$4519 sg13cmos5l_or3_1
* cell instance sg13cmos5l_or3_1_3 r0 *1 0,0
Xsg13cmos5l_or3_1_3 \$4143 \$4517 \$3781 VPWR VGND \$4144 sg13cmos5l_or3_1
* cell instance sg13cmos5l_or3_1_4 r0 *1 0,0
Xsg13cmos5l_or3_1_4 \$1385 \$4517 \$3781 VPWR VGND \$3774 sg13cmos5l_or3_1
* cell instance sg13cmos5l_or3_1_5 r0 *1 0,0
Xsg13cmos5l_or3_1_5 \$2189 \$1846 \$2027 VPWR VGND \$2029 sg13cmos5l_or3_1
* cell instance sg13cmos5l_or3_1_6 r0 *1 0,0
Xsg13cmos5l_or3_1_6 \$1742 \$4517 \$3781 VPWR VGND \$3963 sg13cmos5l_or3_1
* cell instance sg13cmos5l_or3_1_7 r0 *1 0,0
Xsg13cmos5l_or3_1_7 \$2381 \$2569 \$2566 VPWR VGND \$1550 sg13cmos5l_or3_1
* cell instance sg13cmos5l_or3_1_8 r0 *1 0,0
Xsg13cmos5l_or3_1_8 \$1898 \$3971 \$3967 VPWR VGND \$4169 sg13cmos5l_or3_1
* cell instance sg13cmos5l_or3_1_9 r0 *1 0,0
Xsg13cmos5l_or3_1_9 \$2060 \$3971 \$3967 VPWR VGND \$3977 sg13cmos5l_or3_1
* cell instance sg13cmos5l_or3_1_10 r0 *1 0,0
Xsg13cmos5l_or3_1_10 \$1894 \$1567 \$991 VPWR VGND \$1918 sg13cmos5l_or3_1
* cell instance sg13cmos5l_or3_1_11 r0 *1 0,0
Xsg13cmos5l_or3_1_11 \$4181 \$3971 \$3967 VPWR VGND \$3981 sg13cmos5l_or3_1
* cell instance sg13cmos5l_or3_1_12 r0 *1 0,0
Xsg13cmos5l_or3_1_12 \$864 \$225 \$1145 VPWR VGND \$1150 sg13cmos5l_or3_1
* cell instance sg13cmos5l_or3_1_13 r0 *1 0,0
Xsg13cmos5l_or3_1_13 \$4565 \$4535 \$3816 VPWR VGND \$4567 sg13cmos5l_or3_1
* cell instance sg13cmos5l_or3_1_14 r0 *1 0,0
Xsg13cmos5l_or3_1_14 \$2071 \$3971 \$3967 VPWR VGND \$3607 sg13cmos5l_or3_1
* cell instance sg13cmos5l_or3_1_15 r0 *1 0,0
Xsg13cmos5l_or3_1_15 \$4709 \$4535 \$3781 VPWR VGND \$4707 sg13cmos5l_or3_1
* cell instance sg13cmos5l_or3_1_16 r0 *1 0,0
Xsg13cmos5l_or3_1_16 \$1894 \$1296 \$1151 VPWR VGND \$1409 sg13cmos5l_or3_1
* cell instance sg13cmos5l_or3_1_17 r0 *1 0,0
Xsg13cmos5l_or3_1_17 \$2082 \$3971 \$3816 VPWR VGND \$4350 sg13cmos5l_or3_1
* cell instance sg13cmos5l_or3_1_18 r0 *1 0,0
Xsg13cmos5l_or3_1_18 \$3971 \$3967 \$3983 VPWR VGND \$3985 sg13cmos5l_or3_1
* cell instance sg13cmos5l_or3_1_19 r0 *1 0,0
Xsg13cmos5l_or3_1_19 \$5379 \$5388 \$5767 VPWR VGND \$5769 sg13cmos5l_or3_1
* cell instance sg13cmos5l_or3_1_20 r0 *1 0,0
Xsg13cmos5l_or3_1_20 \$5587 \$6176 \$6178 VPWR VGND \$6184 sg13cmos5l_or3_1
* cell instance sg13cmos5l_or4_1_0 r0 *1 0,0
Xsg13cmos5l_or4_1_0 \$2194 \$2198 \$3777 \$2378 VPWR VGND \$4759
+ sg13cmos5l_or4_1
* cell instance sg13cmos5l_or4_1_1 r0 *1 0,0
Xsg13cmos5l_or4_1_1 \$6165 \$6169 \$5385 \$6174 VPWR VGND \$6385
+ sg13cmos5l_or4_1
* cell instance sg13cmos5l_tiehi_0 r0 *1 0,0
Xsg13cmos5l_tiehi_0 \$6458 VPWR VGND sg13cmos5l_tiehi
* cell instance sg13cmos5l_tiehi_1 r0 *1 0,0
Xsg13cmos5l_tiehi_1 \$6473 VPWR VGND sg13cmos5l_tiehi
* cell instance sg13cmos5l_tiehi_2 r0 *1 0,0
Xsg13cmos5l_tiehi_2 \$6489 VPWR VGND sg13cmos5l_tiehi
* cell instance sg13cmos5l_tiehi_3 r0 *1 0,0
Xsg13cmos5l_tiehi_3 \$6296 VPWR VGND sg13cmos5l_tiehi
* cell instance sg13cmos5l_tiehi_4 r0 *1 0,0
Xsg13cmos5l_tiehi_4 \$6511 VPWR VGND sg13cmos5l_tiehi
* cell instance sg13cmos5l_tiehi_5 r0 *1 0,0
Xsg13cmos5l_tiehi_5 \$6527 VPWR VGND sg13cmos5l_tiehi
* cell instance sg13cmos5l_tiehi_6 r0 *1 0,0
Xsg13cmos5l_tiehi_6 \$6540 VPWR VGND sg13cmos5l_tiehi
* cell instance sg13cmos5l_tiehi_7 r0 *1 0,0
Xsg13cmos5l_tiehi_7 \$6556 VPWR VGND sg13cmos5l_tiehi
* cell instance sg13cmos5l_tiehi_8 r0 *1 0,0
Xsg13cmos5l_tiehi_8 \$6598 VPWR VGND sg13cmos5l_tiehi
* cell instance sg13cmos5l_tiehi_9 r0 *1 0,0
Xsg13cmos5l_tiehi_9 \$6605 VPWR VGND sg13cmos5l_tiehi
* cell instance sg13cmos5l_tiehi_10 r0 *1 0,0
Xsg13cmos5l_tiehi_10 \$6621 VPWR VGND sg13cmos5l_tiehi
* cell instance sg13cmos5l_tiehi_11 r0 *1 0,0
Xsg13cmos5l_tiehi_11 \$6637 VPWR VGND sg13cmos5l_tiehi
* cell instance sg13cmos5l_tiehi_12 r0 *1 0,0
Xsg13cmos5l_tiehi_12 \$6367 VPWR VGND sg13cmos5l_tiehi
* cell instance sg13cmos5l_tiehi_13 r0 *1 0,0
Xsg13cmos5l_tiehi_13 \$6659 VPWR VGND sg13cmos5l_tiehi
* cell instance sg13cmos5l_tiehi_14 r0 *1 0,0
Xsg13cmos5l_tiehi_14 \$6672 VPWR VGND sg13cmos5l_tiehi
* cell instance sg13cmos5l_tiehi_15 r0 *1 0,0
Xsg13cmos5l_tiehi_15 \$6684 VPWR VGND sg13cmos5l_tiehi
* cell instance sg13cmos5l_tiehi_16 r0 *1 0,0
Xsg13cmos5l_tiehi_16 \$6696 VPWR VGND sg13cmos5l_tiehi
* cell instance sg13cmos5l_tiehi_17 r0 *1 0,0
Xsg13cmos5l_tiehi_17 \$7513 VPWR VGND sg13cmos5l_tiehi
* cell instance sg13cmos5l_tielo_0 r0 *1 0,0
Xsg13cmos5l_tielo_0 \$6787 VPWR VGND sg13cmos5l_tielo
* cell instance sg13cmos5l_tielo_1 r0 *1 0,0
Xsg13cmos5l_tielo_1 \$6451 VPWR VGND sg13cmos5l_tielo
* cell instance sg13cmos5l_tielo_2 r0 *1 0,0
Xsg13cmos5l_tielo_2 \$6462 VPWR VGND sg13cmos5l_tielo
* cell instance sg13cmos5l_tielo_3 r0 *1 0,0
Xsg13cmos5l_tielo_3 \$6467 VPWR VGND sg13cmos5l_tielo
* cell instance sg13cmos5l_tielo_4 r0 *1 0,0
Xsg13cmos5l_tielo_4 \$6477 VPWR VGND sg13cmos5l_tielo
* cell instance sg13cmos5l_tielo_5 r0 *1 0,0
Xsg13cmos5l_tielo_5 \$6481 VPWR VGND sg13cmos5l_tielo
* cell instance sg13cmos5l_tielo_6 r0 *1 0,0
Xsg13cmos5l_tielo_6 \$6493 VPWR VGND sg13cmos5l_tielo
* cell instance sg13cmos5l_tielo_7 r0 *1 0,0
Xsg13cmos5l_tielo_7 \$6292 VPWR VGND sg13cmos5l_tielo
* cell instance sg13cmos5l_tielo_8 r0 *1 0,0
Xsg13cmos5l_tielo_8 \$6503 VPWR VGND sg13cmos5l_tielo
* cell instance sg13cmos5l_tielo_9 r0 *1 0,0
Xsg13cmos5l_tielo_9 \$6507 VPWR VGND sg13cmos5l_tielo
* cell instance sg13cmos5l_tielo_10 r0 *1 0,0
Xsg13cmos5l_tielo_10 \$6515 VPWR VGND sg13cmos5l_tielo
* cell instance sg13cmos5l_tielo_11 r0 *1 0,0
Xsg13cmos5l_tielo_11 \$6523 VPWR VGND sg13cmos5l_tielo
* cell instance sg13cmos5l_tielo_12 r0 *1 0,0
Xsg13cmos5l_tielo_12 \$6531 VPWR VGND sg13cmos5l_tielo
* cell instance sg13cmos5l_tielo_13 r0 *1 0,0
Xsg13cmos5l_tielo_13 \$6534 VPWR VGND sg13cmos5l_tielo
* cell instance sg13cmos5l_tielo_14 r0 *1 0,0
Xsg13cmos5l_tielo_14 \$6548 VPWR VGND sg13cmos5l_tielo
* cell instance sg13cmos5l_tielo_15 r0 *1 0,0
Xsg13cmos5l_tielo_15 \$6552 VPWR VGND sg13cmos5l_tielo
* cell instance sg13cmos5l_tielo_16 r0 *1 0,0
Xsg13cmos5l_tielo_16 \$6100 VPWR VGND sg13cmos5l_tielo
* cell instance sg13cmos5l_tielo_17 r0 *1 0,0
Xsg13cmos5l_tielo_17 \$6560 VPWR VGND sg13cmos5l_tielo
* cell instance sg13cmos5l_tielo_18 r0 *1 0,0
Xsg13cmos5l_tielo_18 \$6309 VPWR VGND sg13cmos5l_tielo
* cell instance sg13cmos5l_tielo_19 r0 *1 0,0
Xsg13cmos5l_tielo_19 \$6564 VPWR VGND sg13cmos5l_tielo
* cell instance sg13cmos5l_tielo_20 r0 *1 0,0
Xsg13cmos5l_tielo_20 \$6311 VPWR VGND sg13cmos5l_tielo
* cell instance sg13cmos5l_tielo_21 r0 *1 0,0
Xsg13cmos5l_tielo_21 \$7246 VPWR VGND sg13cmos5l_tielo
* cell instance sg13cmos5l_tielo_22 r0 *1 0,0
Xsg13cmos5l_tielo_22 \$6573 VPWR VGND sg13cmos5l_tielo
* cell instance sg13cmos5l_tielo_23 r0 *1 0,0
Xsg13cmos5l_tielo_23 \$5923 VPWR VGND sg13cmos5l_tielo
* cell instance sg13cmos5l_tielo_24 r0 *1 0,0
Xsg13cmos5l_tielo_24 \$6331 VPWR VGND sg13cmos5l_tielo
* cell instance sg13cmos5l_tielo_25 r0 *1 0,0
Xsg13cmos5l_tielo_25 \$5813 VPWR VGND sg13cmos5l_tielo
* cell instance sg13cmos5l_tielo_26 r0 *1 0,0
Xsg13cmos5l_tielo_26 \$6581 VPWR VGND sg13cmos5l_tielo
* cell instance sg13cmos5l_tielo_27 r0 *1 0,0
Xsg13cmos5l_tielo_27 \$6590 VPWR VGND sg13cmos5l_tielo
* cell instance sg13cmos5l_tielo_28 r0 *1 0,0
Xsg13cmos5l_tielo_28 \$6594 VPWR VGND sg13cmos5l_tielo
* cell instance sg13cmos5l_tielo_29 r0 *1 0,0
Xsg13cmos5l_tielo_29 \$6609 VPWR VGND sg13cmos5l_tielo
* cell instance sg13cmos5l_tielo_30 r0 *1 0,0
Xsg13cmos5l_tielo_30 \$6614 VPWR VGND sg13cmos5l_tielo
* cell instance sg13cmos5l_tielo_31 r0 *1 0,0
Xsg13cmos5l_tielo_31 \$6625 VPWR VGND sg13cmos5l_tielo
* cell instance sg13cmos5l_tielo_32 r0 *1 0,0
Xsg13cmos5l_tielo_32 \$6629 VPWR VGND sg13cmos5l_tielo
* cell instance sg13cmos5l_tielo_33 r0 *1 0,0
Xsg13cmos5l_tielo_33 \$6641 VPWR VGND sg13cmos5l_tielo
* cell instance sg13cmos5l_tielo_34 r0 *1 0,0
Xsg13cmos5l_tielo_34 \$6361 VPWR VGND sg13cmos5l_tielo
* cell instance sg13cmos5l_tielo_35 r0 *1 0,0
Xsg13cmos5l_tielo_35 \$6651 VPWR VGND sg13cmos5l_tielo
* cell instance sg13cmos5l_tielo_36 r0 *1 0,0
Xsg13cmos5l_tielo_36 \$6653 VPWR VGND sg13cmos5l_tielo
* cell instance sg13cmos5l_tielo_37 r0 *1 0,0
Xsg13cmos5l_tielo_37 \$6663 VPWR VGND sg13cmos5l_tielo
* cell instance sg13cmos5l_tielo_38 r0 *1 0,0
Xsg13cmos5l_tielo_38 \$6667 VPWR VGND sg13cmos5l_tielo
* cell instance sg13cmos5l_tielo_39 r0 *1 0,0
Xsg13cmos5l_tielo_39 \$6674 VPWR VGND sg13cmos5l_tielo
* cell instance sg13cmos5l_tielo_40 r0 *1 0,0
Xsg13cmos5l_tielo_40 \$6680 VPWR VGND sg13cmos5l_tielo
* cell instance sg13cmos5l_tielo_41 r0 *1 0,0
Xsg13cmos5l_tielo_41 \$6688 VPWR VGND sg13cmos5l_tielo
* cell instance sg13cmos5l_tielo_42 r0 *1 0,0
Xsg13cmos5l_tielo_42 \$6692 VPWR VGND sg13cmos5l_tielo
* cell instance sg13cmos5l_tielo_43 r0 *1 0,0
Xsg13cmos5l_tielo_43 \$6700 VPWR VGND sg13cmos5l_tielo
* cell instance sg13cmos5l_tielo_44 r0 *1 0,0
Xsg13cmos5l_tielo_44 \$6957 VPWR VGND sg13cmos5l_tielo
* cell instance sg13cmos5l_xnor2_1_0 r0 *1 0,0
Xsg13cmos5l_xnor2_1_0 \$6737 \$6875 VPWR VGND \$6877 sg13cmos5l_xnor2_1
* cell instance sg13cmos5l_xnor2_1_1 r0 *1 0,0
Xsg13cmos5l_xnor2_1_1 \$7456 \$6879 VPWR VGND \$6847 sg13cmos5l_xnor2_1
* cell instance sg13cmos5l_xnor2_1_2 r0 *1 0,0
Xsg13cmos5l_xnor2_1_2 \$6013 \$6441 VPWR VGND \$8848 sg13cmos5l_xnor2_1
* cell instance sg13cmos5l_xnor2_1_3 r0 *1 0,0
Xsg13cmos5l_xnor2_1_3 \$8336 \$8552 VPWR VGND \$8551 sg13cmos5l_xnor2_1
* cell instance sg13cmos5l_xnor2_1_4 r0 *1 0,0
Xsg13cmos5l_xnor2_1_4 \$3128 \$3129 VPWR VGND \$2920 sg13cmos5l_xnor2_1
* cell instance sg13cmos5l_xnor2_1_5 r0 *1 0,0
Xsg13cmos5l_xnor2_1_5 \$6849 \$6737 VPWR VGND \$6864 sg13cmos5l_xnor2_1
* cell instance sg13cmos5l_xnor2_1_6 r0 *1 0,0
Xsg13cmos5l_xnor2_1_6 \$9324 \$8848 VPWR VGND \$9142 sg13cmos5l_xnor2_1
* cell instance sg13cmos5l_xnor2_1_7 r0 *1 0,0
Xsg13cmos5l_xnor2_1_7 \$8336 \$8304 VPWR VGND \$8550 sg13cmos5l_xnor2_1
* cell instance sg13cmos5l_xnor2_1_8 r0 *1 0,0
Xsg13cmos5l_xnor2_1_8 \$6226 \$6033 VPWR VGND \$6233 sg13cmos5l_xnor2_1
* cell instance sg13cmos5l_xnor2_1_9 r0 *1 0,0
Xsg13cmos5l_xnor2_1_9 \$3511 \$3332 VPWR VGND \$3328 sg13cmos5l_xnor2_1
* cell instance sg13cmos5l_xnor2_1_10 r0 *1 0,0
Xsg13cmos5l_xnor2_1_10 \$9143 \$6832 VPWR VGND \$9324 sg13cmos5l_xnor2_1
* cell instance sg13cmos5l_xnor2_1_11 r0 *1 0,0
Xsg13cmos5l_xnor2_1_11 \$8553 \$8536 VPWR VGND \$8336 sg13cmos5l_xnor2_1
* cell instance sg13cmos5l_xnor2_1_12 r0 *1 0,0
Xsg13cmos5l_xnor2_1_12 \$6425 \$6888 VPWR VGND \$6848 sg13cmos5l_xnor2_1
* cell instance sg13cmos5l_xnor2_1_13 r0 *1 0,0
Xsg13cmos5l_xnor2_1_13 \$9323 \$8826 VPWR VGND \$9144 sg13cmos5l_xnor2_1
* cell instance sg13cmos5l_xnor2_1_14 r0 *1 0,0
Xsg13cmos5l_xnor2_1_14 \$9324 \$9828 VPWR VGND \$9599 sg13cmos5l_xnor2_1
* cell instance sg13cmos5l_xnor2_1_15 r0 *1 0,0
Xsg13cmos5l_xnor2_1_15 \$9142 \$9144 VPWR VGND \$9423 sg13cmos5l_xnor2_1
* cell instance sg13cmos5l_xnor2_1_16 r0 *1 0,0
Xsg13cmos5l_xnor2_1_16 \$9086 \$9599 VPWR VGND \$9531 sg13cmos5l_xnor2_1
* cell instance sg13cmos5l_xnor2_1_17 r0 *1 0,0
Xsg13cmos5l_xnor2_1_17 \$8554 \$8305 VPWR VGND \$8536 sg13cmos5l_xnor2_1
* cell instance sg13cmos5l_xnor2_1_18 r0 *1 0,0
Xsg13cmos5l_xnor2_1_18 \$9326 \$9423 VPWR VGND \$9346 sg13cmos5l_xnor2_1
* cell instance sg13cmos5l_xnor2_1_19 r0 *1 0,0
Xsg13cmos5l_xnor2_1_19 \$1045 \$371 VPWR VGND \$1182 sg13cmos5l_xnor2_1
* cell instance sg13cmos5l_xnor2_1_20 r0 *1 0,0
Xsg13cmos5l_xnor2_1_20 \$8821 \$8822 VPWR VGND \$8553 sg13cmos5l_xnor2_1
* cell instance sg13cmos5l_xnor2_1_21 r0 *1 0,0
Xsg13cmos5l_xnor2_1_21 \$11078 \$10137 VPWR VGND \$10298 sg13cmos5l_xnor2_1
* cell instance sg13cmos5l_xnor2_1_22 r0 *1 0,0
Xsg13cmos5l_xnor2_1_22 \$9828 \$10298 VPWR VGND \$9325 sg13cmos5l_xnor2_1
* cell instance sg13cmos5l_xnor2_1_23 r0 *1 0,0
Xsg13cmos5l_xnor2_1_23 \$1461 \$1463 VPWR VGND \$1313 sg13cmos5l_xnor2_1
* cell instance sg13cmos5l_xnor2_1_24 r0 *1 0,0
Xsg13cmos5l_xnor2_1_24 \$6434 \$8833 VPWR VGND \$8822 sg13cmos5l_xnor2_1
* cell instance sg13cmos5l_xnor2_1_25 r0 *1 0,0
Xsg13cmos5l_xnor2_1_25 \$8553 \$8537 VPWR VGND \$8118 sg13cmos5l_xnor2_1
* cell instance sg13cmos5l_xnor2_1_26 r0 *1 0,0
Xsg13cmos5l_xnor2_1_26 \$10297 \$9087 VPWR VGND \$10137 sg13cmos5l_xnor2_1
* cell instance sg13cmos5l_xnor2_1_27 r0 *1 0,0
Xsg13cmos5l_xnor2_1_27 \$9087 \$8344 VPWR VGND \$8537 sg13cmos5l_xnor2_1
* cell instance sg13cmos5l_xnor2_1_28 r0 *1 0,0
Xsg13cmos5l_xnor2_1_28 \$9328 \$9327 VPWR VGND \$9087 sg13cmos5l_xnor2_1
* cell instance sg13cmos5l_xnor2_1_29 r0 *1 0,0
Xsg13cmos5l_xnor2_1_29 \$7897 \$6726 VPWR VGND \$8344 sg13cmos5l_xnor2_1
* cell instance sg13cmos5l_xnor2_1_30 r0 *1 0,0
Xsg13cmos5l_xnor2_1_30 \$9325 \$8748 VPWR VGND \$8579 sg13cmos5l_xnor2_1
* cell instance sg13cmos5l_xnor2_1_31 r0 *1 0,0
Xsg13cmos5l_xnor2_1_31 \$9504 \$8238 VPWR VGND \$9427 sg13cmos5l_xnor2_1
* cell instance sg13cmos5l_xnor2_1_32 r0 *1 0,0
Xsg13cmos5l_xnor2_1_32 \$9546 \$8857 VPWR VGND \$9829 sg13cmos5l_xnor2_1
* cell instance sg13cmos5l_xnor2_1_33 r0 *1 0,0
Xsg13cmos5l_xnor2_1_33 \$9546 \$9828 VPWR VGND \$9644 sg13cmos5l_xnor2_1
* cell instance sg13cmos5l_xnor2_1_34 r0 *1 0,0
Xsg13cmos5l_xnor2_1_34 \$9505 \$9427 VPWR VGND \$9208 sg13cmos5l_xnor2_1
* cell instance sg13cmos5l_xnor2_1_35 r0 *1 0,0
Xsg13cmos5l_xnor2_1_35 \$7542 \$6839 VPWR VGND \$8238 sg13cmos5l_xnor2_1
* cell instance sg13cmos5l_xnor2_1_36 r0 *1 0,0
Xsg13cmos5l_xnor2_1_36 \$8304 \$9208 VPWR VGND \$9546 sg13cmos5l_xnor2_1
* cell instance sg13cmos5l_xnor2_1_37 r0 *1 0,0
Xsg13cmos5l_xnor2_1_37 \$9346 \$9830 VPWR VGND \$9086 sg13cmos5l_xnor2_1
* cell instance sg13cmos5l_xnor2_1_38 r0 *1 0,0
Xsg13cmos5l_xnor2_1_38 \$8238 \$8337 VPWR VGND \$8833 sg13cmos5l_xnor2_1
* cell instance sg13cmos5l_xnor2_1_39 r0 *1 0,0
Xsg13cmos5l_xnor2_1_39 \$8823 \$8461 VPWR VGND \$8304 sg13cmos5l_xnor2_1
* cell instance sg13cmos5l_xnor2_1_40 r0 *1 0,0
Xsg13cmos5l_xnor2_1_40 \$9346 \$8833 VPWR VGND \$8049 sg13cmos5l_xnor2_1
* cell instance sg13cmos5l_xnor2_1_41 r0 *1 0,0
Xsg13cmos5l_xnor2_1_41 \$1049 \$1048 VPWR VGND \$919 sg13cmos5l_xnor2_1
* cell instance sg13cmos5l_xnor2_1_42 r0 *1 0,0
Xsg13cmos5l_xnor2_1_42 \$5873 \$6466 VPWR VGND \$8337 sg13cmos5l_xnor2_1
* cell instance sg13cmos5l_xnor2_1_43 r0 *1 0,0
Xsg13cmos5l_xnor2_1_43 \$9506 \$9550 VPWR VGND \$9828 sg13cmos5l_xnor2_1
* cell instance sg13cmos5l_xnor2_1_44 r0 *1 0,0
Xsg13cmos5l_xnor2_1_44 \$2935 \$2704 VPWR VGND \$3726 sg13cmos5l_xnor2_1
* cell instance sg13cmos5l_xnor2_1_45 r0 *1 0,0
Xsg13cmos5l_xnor2_1_45 \$2935 \$2933 VPWR VGND \$3142 sg13cmos5l_xnor2_1
* cell instance sg13cmos5l_xnor2_1_46 r0 *1 0,0
Xsg13cmos5l_xnor2_1_46 \$8539 \$6870 VPWR VGND \$8826 sg13cmos5l_xnor2_1
* cell instance sg13cmos5l_xnor2_1_47 r0 *1 0,0
Xsg13cmos5l_xnor2_1_47 \$3352 \$4663 VPWR VGND \$4655 sg13cmos5l_xnor2_1
* cell instance sg13cmos5l_xnor2_1_48 r0 *1 0,0
Xsg13cmos5l_xnor2_1_48 \$8826 \$8868 VPWR VGND \$9329 sg13cmos5l_xnor2_1
* cell instance sg13cmos5l_xnor2_1_49 r0 *1 0,0
Xsg13cmos5l_xnor2_1_49 \$6260 \$6919 VPWR VGND \$8868 sg13cmos5l_xnor2_1
* cell instance sg13cmos5l_xnor2_1_50 r0 *1 0,0
Xsg13cmos5l_xnor2_1_50 \$10299 \$10300 VPWR VGND \$9830 sg13cmos5l_xnor2_1
* cell instance sg13cmos5l_xnor2_1_51 r0 *1 0,0
Xsg13cmos5l_xnor2_1_51 \$2935 \$3731 VPWR VGND \$4040 sg13cmos5l_xnor2_1
* cell instance sg13cmos5l_xnor2_1_52 r0 *1 0,0
Xsg13cmos5l_xnor2_1_52 \$3733 \$3287 VPWR VGND \$4096 sg13cmos5l_xnor2_1
* cell instance sg13cmos5l_xnor2_1_53 r0 *1 0,0
Xsg13cmos5l_xnor2_1_53 \$2935 \$2328 VPWR VGND \$2946 sg13cmos5l_xnor2_1
* cell instance sg13cmos5l_xnor2_1_54 r0 *1 0,0
Xsg13cmos5l_xnor2_1_54 \$1077 \$1235 VPWR VGND \$1232 sg13cmos5l_xnor2_1
* cell instance sg13cmos5l_xnor2_1_55 r0 *1 0,0
Xsg13cmos5l_xnor2_1_55 \$2167 \$2354 VPWR VGND \$2165 sg13cmos5l_xnor2_1
* cell instance sg13cmos5l_xnor2_1_56 r0 *1 0,0
Xsg13cmos5l_xnor2_1_56 \$1808 \$2976 VPWR VGND \$2978 sg13cmos5l_xnor2_1
* cell instance sg13cmos5l_xnor2_1_57 r0 *1 0,0
Xsg13cmos5l_xnor2_1_57 \$3297 \$2141 VPWR VGND \$3956 sg13cmos5l_xnor2_1
* cell instance sg13cmos5l_xnor2_1_58 r0 *1 0,0
Xsg13cmos5l_xnor2_1_58 \$3398 \$3567 VPWR VGND \$3569 sg13cmos5l_xnor2_1
* cell instance sg13cmos5l_xnor2_1_59 r0 *1 0,0
Xsg13cmos5l_xnor2_1_59 \$5565 \$5343 VPWR VGND \$5568 sg13cmos5l_xnor2_1
* cell instance sg13cmos5l_xnor2_1_60 r0 *1 0,0
Xsg13cmos5l_xnor2_1_60 \$2567 \$2106 VPWR VGND \$2388 sg13cmos5l_xnor2_1
* cell instance sg13cmos5l_xnor2_1_61 r0 *1 0,0
Xsg13cmos5l_xnor2_1_61 \$2221 \$2214 VPWR VGND \$2225 sg13cmos5l_xnor2_1
* cell instance sg13cmos5l_xnor2_1_62 r0 *1 0,0
Xsg13cmos5l_xnor2_1_62 \$2577 \$2578 VPWR VGND \$2773 sg13cmos5l_xnor2_1
* cell instance sg13cmos5l_xnor2_1_63 r0 *1 0,0
Xsg13cmos5l_xnor2_1_63 \$5576 \$5960 VPWR VGND \$5734 sg13cmos5l_xnor2_1
* cell instance sg13cmos5l_xnor2_1_64 r0 *1 0,0
Xsg13cmos5l_xnor2_1_64 \$4046 \$3438 VPWR VGND \$5762 sg13cmos5l_xnor2_1
* cell instance sg13cmos5l_xnor2_1_65 r0 *1 0,0
Xsg13cmos5l_xnor2_1_65 \$6016 \$5585 VPWR VGND \$5584 sg13cmos5l_xnor2_1
* cell instance sg13cmos5l_xnor2_1_66 r0 *1 0,0
Xsg13cmos5l_xnor2_1_66 \$2786 \$5211 VPWR VGND \$5388 sg13cmos5l_xnor2_1
* cell instance sg13cmos5l_xnor2_1_67 r0 *1 0,0
Xsg13cmos5l_xnor2_1_67 \$7455 \$7998 VPWR VGND \$7874 sg13cmos5l_xnor2_1
* cell instance sg13cmos5l_xnor2_1_68 r0 *1 0,0
Xsg13cmos5l_xnor2_1_68 \$2230 \$4586 VPWR VGND \$6178 sg13cmos5l_xnor2_1
* cell instance sg13cmos5l_xnor2_1_69 r0 *1 0,0
Xsg13cmos5l_xnor2_1_69 \$7181 \$6937 VPWR VGND \$7182 sg13cmos5l_xnor2_1
* cell instance sg13cmos5l_xnor2_1_70 r0 *1 0,0
Xsg13cmos5l_xnor2_1_70 \$7454 \$7688 VPWR VGND \$7732 sg13cmos5l_xnor2_1
* cell instance sg13cmos5l_xnor2_1_71 r0 *1 0,0
Xsg13cmos5l_xnor2_1_71 \$7453 \$7451 VPWR VGND \$7526 sg13cmos5l_xnor2_1
* cell instance sg13cmos5l_xnor2_1_72 r0 *1 0,0
Xsg13cmos5l_xnor2_1_72 \$6189 \$6415 VPWR VGND \$6212 sg13cmos5l_xnor2_1
* cell instance sg13cmos5l_xnor2_1_73 r0 *1 0,0
Xsg13cmos5l_xnor2_1_73 \$6399 \$6400 VPWR VGND \$6711 sg13cmos5l_xnor2_1
* cell instance sg13cmos5l_xnor2_1_74 r0 *1 0,0
Xsg13cmos5l_xnor2_1_74 \$5399 \$5060 VPWR VGND \$6399 sg13cmos5l_xnor2_1
* cell instance sg13cmos5l_xor2_1_0 r0 *1 0,0
Xsg13cmos5l_xor2_1_0 \$6882 \$6880 VPWR VGND \$6969 sg13cmos5l_xor2_1
* cell instance sg13cmos5l_xor2_1_1 r0 *1 0,0
Xsg13cmos5l_xor2_1_1 \$6226 \$6416 VPWR VGND \$6735 sg13cmos5l_xor2_1
* cell instance sg13cmos5l_xor2_1_2 r0 *1 0,0
Xsg13cmos5l_xor2_1_2 \$2124 \$2126 VPWR VGND \$2121 sg13cmos5l_xor2_1
* cell instance sg13cmos5l_xor2_1_3 r0 *1 0,0
Xsg13cmos5l_xor2_1_3 \$2483 \$2681 VPWR VGND \$2481 sg13cmos5l_xor2_1
* cell instance sg13cmos5l_xor2_1_4 r0 *1 0,0
Xsg13cmos5l_xor2_1_4 \$3663 \$3903 VPWR VGND \$4075 sg13cmos5l_xor2_1
* cell instance sg13cmos5l_xor2_1_5 r0 *1 0,0
Xsg13cmos5l_xor2_1_5 \$617 \$459 VPWR VGND \$616 sg13cmos5l_xor2_1
* cell instance sg13cmos5l_xor2_1_6 r0 *1 0,0
Xsg13cmos5l_xor2_1_6 \$1641 \$1604 VPWR VGND \$1602 sg13cmos5l_xor2_1
* cell instance sg13cmos5l_xor2_1_7 r0 *1 0,0
Xsg13cmos5l_xor2_1_7 \$9142 \$9325 VPWR VGND \$9196 sg13cmos5l_xor2_1
* cell instance sg13cmos5l_xor2_1_8 r0 *1 0,0
Xsg13cmos5l_xor2_1_8 \$9142 \$8238 VPWR VGND \$8552 sg13cmos5l_xor2_1
* cell instance sg13cmos5l_xor2_1_9 r0 *1 0,0
Xsg13cmos5l_xor2_1_9 \$1037 \$1187 VPWR VGND \$1188 sg13cmos5l_xor2_1
* cell instance sg13cmos5l_xor2_1_10 r0 *1 0,0
Xsg13cmos5l_xor2_1_10 \$8039 \$9324 VPWR VGND \$8305 sg13cmos5l_xor2_1
* cell instance sg13cmos5l_xor2_1_11 r0 *1 0,0
Xsg13cmos5l_xor2_1_11 \$9086 \$8553 VPWR VGND \$8820 sg13cmos5l_xor2_1
* cell instance sg13cmos5l_xor2_1_12 r0 *1 0,0
Xsg13cmos5l_xor2_1_12 \$3514 \$4262 VPWR VGND \$4082 sg13cmos5l_xor2_1
* cell instance sg13cmos5l_xor2_1_13 r0 *1 0,0
Xsg13cmos5l_xor2_1_13 \$8833 \$9087 VPWR VGND \$8857 sg13cmos5l_xor2_1
* cell instance sg13cmos5l_xor2_1_14 r0 *1 0,0
Xsg13cmos5l_xor2_1_14 \$4084 \$3343 VPWR VGND \$3910 sg13cmos5l_xor2_1
* cell instance sg13cmos5l_xor2_1_15 r0 *1 0,0
Xsg13cmos5l_xor2_1_15 \$8826 \$8537 VPWR VGND \$8748 sg13cmos5l_xor2_1
* cell instance sg13cmos5l_xor2_1_16 r0 *1 0,0
Xsg13cmos5l_xor2_1_16 \$914 \$476 VPWR VGND \$477 sg13cmos5l_xor2_1
* cell instance sg13cmos5l_xor2_1_17 r0 *1 0,0
Xsg13cmos5l_xor2_1_17 \$2314 \$2317 VPWR VGND \$2132 sg13cmos5l_xor2_1
* cell instance sg13cmos5l_xor2_1_18 r0 *1 0,0
Xsg13cmos5l_xor2_1_18 \$3344 \$3137 VPWR VGND \$2929 sg13cmos5l_xor2_1
* cell instance sg13cmos5l_xor2_1_19 r0 *1 0,0
Xsg13cmos5l_xor2_1_19 \$8345 \$8537 VPWR VGND \$8461 sg13cmos5l_xor2_1
* cell instance sg13cmos5l_xor2_1_20 r0 *1 0,0
Xsg13cmos5l_xor2_1_20 \$779 \$351 VPWR VGND \$777 sg13cmos5l_xor2_1
* cell instance sg13cmos5l_xor2_1_21 r0 *1 0,0
Xsg13cmos5l_xor2_1_21 \$9329 \$8304 VPWR VGND \$9148 sg13cmos5l_xor2_1
* cell instance sg13cmos5l_xor2_1_22 r0 *1 0,0
Xsg13cmos5l_xor2_1_22 \$9552 \$9329 VPWR VGND \$9550 sg13cmos5l_xor2_1
* cell instance sg13cmos5l_xor2_1_23 r0 *1 0,0
Xsg13cmos5l_xor2_1_23 \$1619 \$1621 VPWR VGND \$1618 sg13cmos5l_xor2_1
* cell instance sg13cmos5l_xor2_1_24 r0 *1 0,0
Xsg13cmos5l_xor2_1_24 \$494 \$1054 VPWR VGND \$1056 sg13cmos5l_xor2_1
* cell instance sg13cmos5l_xor2_1_25 r0 *1 0,0
Xsg13cmos5l_xor2_1_25 \$10926 \$9329 VPWR VGND \$10300 sg13cmos5l_xor2_1
* cell instance sg13cmos5l_xor2_1_26 r0 *1 0,0
Xsg13cmos5l_xor2_1_26 \$2935 \$2498 VPWR VGND \$2940 sg13cmos5l_xor2_1
* cell instance sg13cmos5l_xor2_1_27 r0 *1 0,0
Xsg13cmos5l_xor2_1_27 \$495 \$497 VPWR VGND \$500 sg13cmos5l_xor2_1
* cell instance sg13cmos5l_xor2_1_28 r0 *1 0,0
Xsg13cmos5l_xor2_1_28 \$1969 \$1971 VPWR VGND \$2098 sg13cmos5l_xor2_1
* cell instance sg13cmos5l_xor2_1_29 r0 *1 0,0
Xsg13cmos5l_xor2_1_29 \$939 \$941 VPWR VGND \$808 sg13cmos5l_xor2_1
* cell instance sg13cmos5l_xor2_1_30 r0 *1 0,0
Xsg13cmos5l_xor2_1_30 \$2935 \$1334 VPWR VGND \$3742 sg13cmos5l_xor2_1
* cell instance sg13cmos5l_xor2_1_31 r0 *1 0,0
Xsg13cmos5l_xor2_1_31 \$408 \$1338 VPWR VGND \$883 sg13cmos5l_xor2_1
* cell instance sg13cmos5l_xor2_1_32 r0 *1 0,0
Xsg13cmos5l_xor2_1_32 \$3377 \$3156 VPWR VGND \$3379 sg13cmos5l_xor2_1
* cell instance sg13cmos5l_xor2_1_33 r0 *1 0,0
Xsg13cmos5l_xor2_1_33 \$410 \$537 VPWR VGND \$590 sg13cmos5l_xor2_1
* cell instance sg13cmos5l_xor2_1_34 r0 *1 0,0
Xsg13cmos5l_xor2_1_34 \$3157 \$2957 VPWR VGND \$3289 sg13cmos5l_xor2_1
* cell instance sg13cmos5l_xor2_1_35 r0 *1 0,0
Xsg13cmos5l_xor2_1_35 \$2737 \$2353 VPWR VGND \$2878 sg13cmos5l_xor2_1
* cell instance sg13cmos5l_xor2_1_36 r0 *1 0,0
Xsg13cmos5l_xor2_1_36 \$3943 \$1812 VPWR VGND \$4043 sg13cmos5l_xor2_1
* cell instance sg13cmos5l_xor2_1_37 r0 *1 0,0
Xsg13cmos5l_xor2_1_37 \$1242 \$1352 VPWR VGND \$1420 sg13cmos5l_xor2_1
* cell instance sg13cmos5l_xor2_1_38 r0 *1 0,0
Xsg13cmos5l_xor2_1_38 \$1814 \$1650 VPWR VGND \$1817 sg13cmos5l_xor2_1
* cell instance sg13cmos5l_xor2_1_39 r0 *1 0,0
Xsg13cmos5l_xor2_1_39 \$3010 \$2215 VPWR VGND \$3020 sg13cmos5l_xor2_1
* cell instance sg13cmos5l_xor2_1_40 r0 *1 0,0
Xsg13cmos5l_xor2_1_40 \$5571 \$5569 VPWR VGND \$5198 sg13cmos5l_xor2_1
* cell instance sg13cmos5l_xor2_1_41 r0 *1 0,0
Xsg13cmos5l_xor2_1_41 \$5723 \$5732 VPWR VGND \$5579 sg13cmos5l_xor2_1
* cell instance sg13cmos5l_xor2_1_42 r0 *1 0,0
Xsg13cmos5l_xor2_1_42 \$1694 \$2588 VPWR VGND \$3305 sg13cmos5l_xor2_1
* cell instance sg13cmos5l_xor2_1_43 r0 *1 0,0
Xsg13cmos5l_xor2_1_43 \$5970 \$6152 VPWR VGND \$6154 sg13cmos5l_xor2_1
* cell instance sg13cmos5l_xor2_1_44 r0 *1 0,0
Xsg13cmos5l_xor2_1_44 \$5759 \$5762 VPWR VGND \$6377 sg13cmos5l_xor2_1
* cell instance sg13cmos5l_xor2_1_45 r0 *1 0,0
Xsg13cmos5l_xor2_1_45 \$5762 \$5760 VPWR VGND \$6169 sg13cmos5l_xor2_1
* cell instance sg13cmos5l_xor2_1_46 r0 *1 0,0
Xsg13cmos5l_xor2_1_46 \$6178 \$5988 VPWR VGND \$6181 sg13cmos5l_xor2_1
* cell instance sg13cmos5l_xor2_1_47 r0 *1 0,0
Xsg13cmos5l_xor2_1_47 \$6399 \$6405 VPWR VGND \$6716 sg13cmos5l_xor2_1
.ENDS tt_um_2amlogic_protocol_emulator

* cell sg13cmos5l_xor2_1
* pin A
* pin B
* pin VDD
* pin VSS
* pin X
.SUBCKT sg13cmos5l_xor2_1 A B VDD VSS X
.ENDS sg13cmos5l_xor2_1

* cell sg13cmos5l_xnor2_1
* pin A
* pin B
* pin VDD
* pin VSS
* pin Y
.SUBCKT sg13cmos5l_xnor2_1 A B VDD VSS Y
.ENDS sg13cmos5l_xnor2_1

* cell sg13cmos5l_tielo
* pin L_LO
* pin VDD
* pin VSS
.SUBCKT sg13cmos5l_tielo L_LO VDD VSS
.ENDS sg13cmos5l_tielo

* cell sg13cmos5l_tiehi
* pin L_HI
* pin VDD
* pin VSS
.SUBCKT sg13cmos5l_tiehi L_HI VDD VSS
.ENDS sg13cmos5l_tiehi

* cell sg13cmos5l_or4_1
* pin A
* pin B
* pin C
* pin D
* pin VDD
* pin VSS
* pin X
.SUBCKT sg13cmos5l_or4_1 A B C D VDD VSS X
.ENDS sg13cmos5l_or4_1

* cell sg13cmos5l_or3_1
* pin A
* pin B
* pin C
* pin VDD
* pin VSS
* pin X
.SUBCKT sg13cmos5l_or3_1 A B C VDD VSS X
.ENDS sg13cmos5l_or3_1

* cell sg13cmos5l_or2_1
* pin A
* pin B
* pin VDD
* pin VSS
* pin X
.SUBCKT sg13cmos5l_or2_1 A B VDD VSS X
.ENDS sg13cmos5l_or2_1

* cell sg13cmos5l_o21ai_1
* pin A1
* pin A2
* pin B1
* pin VDD
* pin VSS
* pin Y
.SUBCKT sg13cmos5l_o21ai_1 A1 A2 B1 VDD VSS Y
.ENDS sg13cmos5l_o21ai_1

* cell sg13cmos5l_nor4_1
* pin A
* pin B
* pin C
* pin D
* pin VDD
* pin VSS
* pin Y
.SUBCKT sg13cmos5l_nor4_1 A B C D VDD VSS Y
.ENDS sg13cmos5l_nor4_1

* cell sg13cmos5l_nor3_1
* pin A
* pin B
* pin C
* pin VDD
* pin VSS
* pin Y
.SUBCKT sg13cmos5l_nor3_1 A B C VDD VSS Y
.ENDS sg13cmos5l_nor3_1

* cell sg13cmos5l_nor2b_1
* pin A
* pin B_N
* pin VDD
* pin VSS
* pin Y
.SUBCKT sg13cmos5l_nor2b_1 A B_N VDD VSS Y
.ENDS sg13cmos5l_nor2b_1

* cell sg13cmos5l_nor2_1
* pin A
* pin B
* pin VDD
* pin VSS
* pin Y
.SUBCKT sg13cmos5l_nor2_1 A B VDD VSS Y
.ENDS sg13cmos5l_nor2_1

* cell sg13cmos5l_nand4_1
* pin A
* pin B
* pin C
* pin D
* pin VDD
* pin VSS
* pin Y
.SUBCKT sg13cmos5l_nand4_1 A B C D VDD VSS Y
.ENDS sg13cmos5l_nand4_1

* cell sg13cmos5l_nand3b_1
* pin A_N
* pin B
* pin C
* pin VDD
* pin VSS
* pin Y
.SUBCKT sg13cmos5l_nand3b_1 A_N B C VDD VSS Y
.ENDS sg13cmos5l_nand3b_1

* cell sg13cmos5l_nand3_1
* pin A
* pin B
* pin C
* pin VDD
* pin VSS
* pin Y
.SUBCKT sg13cmos5l_nand3_1 A B C VDD VSS Y
.ENDS sg13cmos5l_nand3_1

* cell sg13cmos5l_nand2b_1
* pin A_N
* pin B
* pin VDD
* pin VSS
* pin Y
.SUBCKT sg13cmos5l_nand2b_1 A_N B VDD VSS Y
.ENDS sg13cmos5l_nand2b_1

* cell sg13cmos5l_nand2_1
* pin A
* pin B
* pin VDD
* pin VSS
* pin Y
.SUBCKT sg13cmos5l_nand2_1 A B VDD VSS Y
.ENDS sg13cmos5l_nand2_1

* cell sg13cmos5l_mux4_1
* pin A0
* pin A1
* pin A2
* pin A3
* pin S0
* pin S1
* pin VDD
* pin VSS
* pin X
.SUBCKT sg13cmos5l_mux4_1 A0 A1 A2 A3 S0 S1 VDD VSS X
.ENDS sg13cmos5l_mux4_1

* cell sg13cmos5l_mux2_1
* pin A0
* pin A1
* pin S
* pin VDD
* pin VSS
* pin X
.SUBCKT sg13cmos5l_mux2_1 A0 A1 S VDD VSS X
.ENDS sg13cmos5l_mux2_1

* cell sg13cmos5l_inv_8
* pin A
* pin VDD
* pin VSS
* pin Y
.SUBCKT sg13cmos5l_inv_8 A VDD VSS Y
.ENDS sg13cmos5l_inv_8

* cell sg13cmos5l_inv_4
* pin A
* pin VDD
* pin VSS
* pin Y
.SUBCKT sg13cmos5l_inv_4 A VDD VSS Y
.ENDS sg13cmos5l_inv_4

* cell sg13cmos5l_inv_2
* pin A
* pin VDD
* pin VSS
* pin Y
.SUBCKT sg13cmos5l_inv_2 A VDD VSS Y
.ENDS sg13cmos5l_inv_2

* cell sg13cmos5l_inv_1
* pin A
* pin VDD
* pin VSS
* pin Y
.SUBCKT sg13cmos5l_inv_1 A VDD VSS Y
.ENDS sg13cmos5l_inv_1

* cell sg13cmos5l_fill_2
* pin VDD
* pin VSS
.SUBCKT sg13cmos5l_fill_2 VDD VSS
.ENDS sg13cmos5l_fill_2

* cell sg13cmos5l_fill_1
* pin VDD
* pin VSS
.SUBCKT sg13cmos5l_fill_1 VDD VSS
.ENDS sg13cmos5l_fill_1

* cell sg13cmos5l_dlygate4sd3_1
* pin A
* pin VDD
* pin VSS
* pin X
.SUBCKT sg13cmos5l_dlygate4sd3_1 A VDD VSS X
.ENDS sg13cmos5l_dlygate4sd3_1

* cell sg13cmos5l_dfrbpq_1
* pin CLK
* pin D
* pin Q
* pin RESET_B
* pin VDD
* pin VSS
.SUBCKT sg13cmos5l_dfrbpq_1 CLK D Q RESET_B VDD VSS
.ENDS sg13cmos5l_dfrbpq_1

* cell sg13cmos5l_decap_8
* pin VDD
* pin VSS
.SUBCKT sg13cmos5l_decap_8 VDD VSS
.ENDS sg13cmos5l_decap_8

* cell sg13cmos5l_decap_4
* pin VDD
* pin VSS
.SUBCKT sg13cmos5l_decap_4 VDD VSS
.ENDS sg13cmos5l_decap_4

* cell sg13cmos5l_buf_8
* pin A
* pin VDD
* pin VSS
* pin X
.SUBCKT sg13cmos5l_buf_8 A VDD VSS X
.ENDS sg13cmos5l_buf_8

* cell sg13cmos5l_buf_4
* pin A
* pin VDD
* pin VSS
* pin X
.SUBCKT sg13cmos5l_buf_4 A VDD VSS X
.ENDS sg13cmos5l_buf_4

* cell sg13cmos5l_buf_1
* pin A
* pin VDD
* pin VSS
* pin X
.SUBCKT sg13cmos5l_buf_1 A VDD VSS X
.ENDS sg13cmos5l_buf_1

* cell sg13cmos5l_antennanp
* pin A
* pin VDD
* pin VSS
.SUBCKT sg13cmos5l_antennanp A VDD VSS
.ENDS sg13cmos5l_antennanp

* cell sg13cmos5l_and4_1
* pin A
* pin B
* pin C
* pin D
* pin VDD
* pin VSS
* pin X
.SUBCKT sg13cmos5l_and4_1 A B C D VDD VSS X
.ENDS sg13cmos5l_and4_1

* cell sg13cmos5l_and3_1
* pin A
* pin B
* pin C
* pin VDD
* pin VSS
* pin X
.SUBCKT sg13cmos5l_and3_1 A B C VDD VSS X
.ENDS sg13cmos5l_and3_1

* cell sg13cmos5l_and2_1
* pin A
* pin B
* pin VDD
* pin VSS
* pin X
.SUBCKT sg13cmos5l_and2_1 A B VDD VSS X
.ENDS sg13cmos5l_and2_1

* cell sg13cmos5l_a22oi_1
* pin A1
* pin A2
* pin B1
* pin B2
* pin VDD
* pin VSS
* pin Y
.SUBCKT sg13cmos5l_a22oi_1 A1 A2 B1 B2 VDD VSS Y
.ENDS sg13cmos5l_a22oi_1

* cell sg13cmos5l_a221oi_1
* pin A1
* pin A2
* pin B1
* pin B2
* pin C1
* pin VDD
* pin VSS
* pin Y
.SUBCKT sg13cmos5l_a221oi_1 A1 A2 B1 B2 C1 VDD VSS Y
.ENDS sg13cmos5l_a221oi_1

* cell sg13cmos5l_a21oi_1
* pin A1
* pin A2
* pin B1
* pin VDD
* pin VSS
* pin Y
.SUBCKT sg13cmos5l_a21oi_1 A1 A2 B1 VDD VSS Y
.ENDS sg13cmos5l_a21oi_1

* cell sg13cmos5l_a21o_1
* pin A1
* pin A2
* pin B1
* pin VDD
* pin VSS
* pin X
.SUBCKT sg13cmos5l_a21o_1 A1 A2 B1 VDD VSS X
.ENDS sg13cmos5l_a21o_1

* cell RM_IHPSG13_1P_256x16_c2_bm_bist
* pin A_ADDR<0>
* pin A_ADDR<1>
* pin A_ADDR<2>
* pin A_ADDR<3>
* pin A_ADDR<4>
* pin A_ADDR<5>
* pin A_ADDR<6>
* pin A_ADDR<7>
* pin A_BIST_ADDR<0>
* pin A_BIST_ADDR<1>
* pin A_BIST_ADDR<2>
* pin A_BIST_ADDR<3>
* pin A_BIST_ADDR<4>
* pin A_BIST_ADDR<5>
* pin A_BIST_ADDR<6>
* pin A_BIST_ADDR<7>
* pin A_BIST_BM<0>
* pin A_BIST_BM<10>
* pin A_BIST_BM<11>
* pin A_BIST_BM<12>
* pin A_BIST_BM<13>
* pin A_BIST_BM<14>
* pin A_BIST_BM<15>
* pin A_BIST_BM<1>
* pin A_BIST_BM<2>
* pin A_BIST_BM<3>
* pin A_BIST_BM<4>
* pin A_BIST_BM<5>
* pin A_BIST_BM<6>
* pin A_BIST_BM<7>
* pin A_BIST_BM<8>
* pin A_BIST_BM<9>
* pin A_BIST_CLK
* pin A_BIST_DIN<0>
* pin A_BIST_DIN<10>
* pin A_BIST_DIN<11>
* pin A_BIST_DIN<12>
* pin A_BIST_DIN<13>
* pin A_BIST_DIN<14>
* pin A_BIST_DIN<15>
* pin A_BIST_DIN<1>
* pin A_BIST_DIN<2>
* pin A_BIST_DIN<3>
* pin A_BIST_DIN<4>
* pin A_BIST_DIN<5>
* pin A_BIST_DIN<6>
* pin A_BIST_DIN<7>
* pin A_BIST_DIN<8>
* pin A_BIST_DIN<9>
* pin A_BIST_EN
* pin A_BIST_MEN
* pin A_BIST_REN
* pin A_BIST_WEN
* pin A_BM<0>
* pin A_BM<10>
* pin A_BM<11>
* pin A_BM<12>
* pin A_BM<13>
* pin A_BM<14>
* pin A_BM<15>
* pin A_BM<1>
* pin A_BM<2>
* pin A_BM<3>
* pin A_BM<4>
* pin A_BM<5>
* pin A_BM<6>
* pin A_BM<7>
* pin A_BM<8>
* pin A_BM<9>
* pin A_CLK
* pin A_DIN<0>
* pin A_DIN<10>
* pin A_DIN<11>
* pin A_DIN<12>
* pin A_DIN<13>
* pin A_DIN<14>
* pin A_DIN<15>
* pin A_DIN<1>
* pin A_DIN<2>
* pin A_DIN<3>
* pin A_DIN<4>
* pin A_DIN<5>
* pin A_DIN<6>
* pin A_DIN<7>
* pin A_DIN<8>
* pin A_DIN<9>
* pin A_DLY
* pin A_DOUT<0>
* pin A_DOUT<10>
* pin A_DOUT<11>
* pin A_DOUT<12>
* pin A_DOUT<13>
* pin A_DOUT<14>
* pin A_DOUT<15>
* pin A_DOUT<1>
* pin A_DOUT<2>
* pin A_DOUT<3>
* pin A_DOUT<4>
* pin A_DOUT<5>
* pin A_DOUT<6>
* pin A_DOUT<7>
* pin A_DOUT<8>
* pin A_DOUT<9>
* pin A_MEN
* pin A_REN
* pin A_WEN
* pin VDD!
* pin VDDARRAY!
* pin VSS!
.SUBCKT RM_IHPSG13_1P_256x16_c2_bm_bist A_ADDR<0> A_ADDR<1> A_ADDR<2> A_ADDR<3>
+ A_ADDR<4> A_ADDR<5> A_ADDR<6> A_ADDR<7> A_BIST_ADDR<0> A_BIST_ADDR<1>
+ A_BIST_ADDR<2> A_BIST_ADDR<3> A_BIST_ADDR<4> A_BIST_ADDR<5> A_BIST_ADDR<6>
+ A_BIST_ADDR<7> A_BIST_BM<0> A_BIST_BM<10> A_BIST_BM<11> A_BIST_BM<12>
+ A_BIST_BM<13> A_BIST_BM<14> A_BIST_BM<15> A_BIST_BM<1> A_BIST_BM<2>
+ A_BIST_BM<3> A_BIST_BM<4> A_BIST_BM<5> A_BIST_BM<6> A_BIST_BM<7> A_BIST_BM<8>
+ A_BIST_BM<9> A_BIST_CLK A_BIST_DIN<0> A_BIST_DIN<10> A_BIST_DIN<11>
+ A_BIST_DIN<12> A_BIST_DIN<13> A_BIST_DIN<14> A_BIST_DIN<15> A_BIST_DIN<1>
+ A_BIST_DIN<2> A_BIST_DIN<3> A_BIST_DIN<4> A_BIST_DIN<5> A_BIST_DIN<6>
+ A_BIST_DIN<7> A_BIST_DIN<8> A_BIST_DIN<9> A_BIST_EN A_BIST_MEN A_BIST_REN
+ A_BIST_WEN A_BM<0> A_BM<10> A_BM<11> A_BM<12> A_BM<13> A_BM<14> A_BM<15>
+ A_BM<1> A_BM<2> A_BM<3> A_BM<4> A_BM<5> A_BM<6> A_BM<7> A_BM<8> A_BM<9> A_CLK
+ A_DIN<0> A_DIN<10> A_DIN<11> A_DIN<12> A_DIN<13> A_DIN<14> A_DIN<15> A_DIN<1>
+ A_DIN<2> A_DIN<3> A_DIN<4> A_DIN<5> A_DIN<6> A_DIN<7> A_DIN<8> A_DIN<9> A_DLY
+ A_DOUT<0> A_DOUT<10> A_DOUT<11> A_DOUT<12> A_DOUT<13> A_DOUT<14> A_DOUT<15>
+ A_DOUT<1> A_DOUT<2> A_DOUT<3> A_DOUT<4> A_DOUT<5> A_DOUT<6> A_DOUT<7>
+ A_DOUT<8> A_DOUT<9> A_MEN A_REN A_WEN VDD! VDDARRAY! VSS!
.ENDS RM_IHPSG13_1P_256x16_c2_bm_bist
