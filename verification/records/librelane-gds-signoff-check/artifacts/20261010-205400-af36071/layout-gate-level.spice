* extracted by klt extract --deck sg13cmos5l

* cell tt_um_2amlogic_protocol_emulator
* pin VGND
* pin VPWR
* pin clk
* pin rst_n
* pin ui_in[0]
* pin ui_in[1]
* pin ui_in[2]
* pin ui_in[3]
* pin ui_in[4]
* pin ui_in[5]
* pin ui_in[6]
* pin ui_in[7]
* pin uio_in[0]
* pin uio_in[1]
* pin uio_in[2]
* pin uio_in[3]
* pin uio_in[4]
* pin uio_in[5]
* pin uio_in[6]
* pin uio_in[7]
* pin uio_oe[0]
* pin uio_oe[1]
* pin uio_oe[2]
* pin uio_oe[3]
* pin uio_oe[4]
* pin uio_oe[5]
* pin uio_oe[6]
* pin uio_oe[7]
* pin uio_out[0]
* pin uio_out[1]
* pin uio_out[2]
* pin uio_out[3]
* pin uio_out[4]
* pin uio_out[5]
* pin uio_out[6]
* pin uio_out[7]
* pin uo_out[0]
* pin uo_out[1]
* pin uo_out[2]
* pin uo_out[3]
* pin uo_out[4]
* pin uo_out[5]
* pin uo_out[6]
* pin uo_out[7]
* pin ena
.SUBCKT tt_um_2amlogic_protocol_emulator VGND VPWR clk rst_n ui_in[0] ui_in[1]
+ ui_in[2] ui_in[3] ui_in[4] ui_in[5] ui_in[6] ui_in[7] uio_in[0] uio_in[1]
+ uio_in[2] uio_in[3] uio_in[4] uio_in[5] uio_in[6] uio_in[7] uio_oe[0]
+ uio_oe[1] uio_oe[2] uio_oe[3] uio_oe[4] uio_oe[5] uio_oe[6] uio_oe[7]
+ uio_out[0] uio_out[1] uio_out[2] uio_out[3] uio_out[4] uio_out[5] uio_out[6]
+ uio_out[7] uo_out[0] uo_out[1] uo_out[2] uo_out[3] uo_out[4] uo_out[5]
+ uo_out[6] uo_out[7] ena
* cell instance RM_IHPSG13_1P_256x16_c2_bm_bist_0 r0 *1 0,0
XRM_IHPSG13_1P_256x16_c2_bm_bist_0 \$5803 \$5971 \$6205 \$6197 \$6201 \$5989
+ \$5962 \$5789 \$5976 \$5804 \$5980 \$5984 \$5996 \$5992 \$5586 \$5778 \$6339
+ \$6242 \$6254 \$6266 \$6278 \$6017 \$6295 \$6111 \$6340 \$6341 \$6342 \$6343
+ \$6344 \$6345 \$6217 \$6007 \$5888 \$6609 \$6246 \$6258 \$6270 \$6346 \$6022
+ \$6577 \$6106 \$6120 \$6131 \$6142 \$6154 \$6165 \$6175 \$6221 \$6011 \$6906
+ \$6188 \$5798 \$5794 \$6102 \$6576 \$6249 \$6261 \$6273 \$6284 \$6291 \$6110
+ \$6127 \$6138 \$6149 \$6160 \$6171 \$6182 \$6212 \$6228 \$6185 \$6575 \$6410
+ \$6411 \$6503 \$6504 \$6547 \$6619 \$6544 \$6638 \$6408 \$6574 \$6543 \$6501
+ \$5955 \$6225 \$6235 \$6208 \$3250 \$970 \$1718 \$2288 \$2583 \$3481 \$2906
+ \$3426 \$3046 \$3760 \$3943 \$2715 \$2883 \$5943 \$2744 \$2106 \$5582 \$5348
+ \$6116 VPWR VPWR VGND RM_IHPSG13_1P_256x16_c2_bm_bist
* cell instance sg13cmos5l_a21o_1_0 r0 *1 0,0
Xsg13cmos5l_a21o_1_0 \$5479 \$4871 \$5287 VPWR VGND \$5272 sg13cmos5l_a21o_1
* cell instance sg13cmos5l_a21o_1_1 r0 *1 0,0
Xsg13cmos5l_a21o_1_1 \$2509 \$2506 \$2392 VPWR VGND \$2396 sg13cmos5l_a21o_1
* cell instance sg13cmos5l_a21o_1_2 r0 *1 0,0
Xsg13cmos5l_a21o_1_2 \$2682 \$2676 \$2392 VPWR VGND \$2399 sg13cmos5l_a21o_1
* cell instance sg13cmos5l_a21o_1_3 r0 *1 0,0
Xsg13cmos5l_a21o_1_3 \$3595 \$3748 \$2392 VPWR VGND \$3744 sg13cmos5l_a21o_1
* cell instance sg13cmos5l_a21o_1_4 r0 *1 0,0
Xsg13cmos5l_a21o_1_4 \$3413 \$3704 \$3593 VPWR VGND \$3753 sg13cmos5l_a21o_1
* cell instance sg13cmos5l_a21o_1_5 r0 *1 0,0
Xsg13cmos5l_a21o_1_5 \$2688 \$2679 \$2684 VPWR VGND \$2518 sg13cmos5l_a21o_1
* cell instance sg13cmos5l_a21o_1_6 r0 *1 0,0
Xsg13cmos5l_a21o_1_6 \$3413 \$3704 \$3402 VPWR VGND \$3567 sg13cmos5l_a21o_1
* cell instance sg13cmos5l_a21o_1_7 r0 *1 0,0
Xsg13cmos5l_a21o_1_7 \$3019 \$2679 \$3198 VPWR VGND \$3016 sg13cmos5l_a21o_1
* cell instance sg13cmos5l_a21o_1_8 r0 *1 0,0
Xsg13cmos5l_a21o_1_8 \$2719 \$3025 \$3008 VPWR VGND \$3405 sg13cmos5l_a21o_1
* cell instance sg13cmos5l_a21o_1_9 r0 *1 0,0
Xsg13cmos5l_a21o_1_9 \$9928 \$5745 \$5309 VPWR VGND \$8151 sg13cmos5l_a21o_1
* cell instance sg13cmos5l_a21o_1_10 r0 *1 0,0
Xsg13cmos5l_a21o_1_10 \$3614 \$3433 \$4214 VPWR VGND \$4218 sg13cmos5l_a21o_1
* cell instance sg13cmos5l_a21o_1_11 r0 *1 0,0
Xsg13cmos5l_a21o_1_11 \$5757 \$5692 \$5949 VPWR VGND \$6090 sg13cmos5l_a21o_1
* cell instance sg13cmos5l_a21o_1_12 r0 *1 0,0
Xsg13cmos5l_a21o_1_12 \$5544 \$5692 \$5951 VPWR VGND \$5952 sg13cmos5l_a21o_1
* cell instance sg13cmos5l_a21o_1_13 r0 *1 0,0
Xsg13cmos5l_a21o_1_13 \$96 \$109 \$91 VPWR VGND \$97 sg13cmos5l_a21o_1
* cell instance sg13cmos5l_a21o_1_14 r0 *1 0,0
Xsg13cmos5l_a21o_1_14 \$4935 \$5692 \$5550 VPWR VGND \$5548 sg13cmos5l_a21o_1
* cell instance sg13cmos5l_a21o_1_15 r0 *1 0,0
Xsg13cmos5l_a21o_1_15 \$4560 \$4665 \$3957 VPWR VGND \$4237 sg13cmos5l_a21o_1
* cell instance sg13cmos5l_a21o_1_16 r0 *1 0,0
Xsg13cmos5l_a21o_1_16 \$3129 \$4110 \$4325 VPWR VGND \$4236 sg13cmos5l_a21o_1
* cell instance sg13cmos5l_a21o_1_17 r0 *1 0,0
Xsg13cmos5l_a21o_1_17 \$434 \$292 \$274 VPWR VGND \$431 sg13cmos5l_a21o_1
* cell instance sg13cmos5l_a21o_1_18 r0 *1 0,0
Xsg13cmos5l_a21o_1_18 \$5575 \$5692 \$229 VPWR VGND \$5742 sg13cmos5l_a21o_1
* cell instance sg13cmos5l_a21o_1_19 r0 *1 0,0
Xsg13cmos5l_a21o_1_19 \$3066 \$3423 \$2049 VPWR VGND \$3082 sg13cmos5l_a21o_1
* cell instance sg13cmos5l_a21o_1_20 r0 *1 0,0
Xsg13cmos5l_a21o_1_20 \$252 \$1206 \$1448 VPWR VGND \$1564 sg13cmos5l_a21o_1
* cell instance sg13cmos5l_a21o_1_21 r0 *1 0,0
Xsg13cmos5l_a21o_1_21 \$4590 \$3448 \$4409 VPWR VGND \$4587 sg13cmos5l_a21o_1
* cell instance sg13cmos5l_a21o_1_22 r0 *1 0,0
Xsg13cmos5l_a21o_1_22 \$27 \$289 \$3 VPWR VGND \$112 sg13cmos5l_a21o_1
* cell instance sg13cmos5l_a21o_1_23 r0 *1 0,0
Xsg13cmos5l_a21o_1_23 \$1802 \$2139 \$37 VPWR VGND \$2140 sg13cmos5l_a21o_1
* cell instance sg13cmos5l_a21o_1_24 r0 *1 0,0
Xsg13cmos5l_a21o_1_24 \$1 \$2021 \$2143 VPWR VGND \$2274 sg13cmos5l_a21o_1
* cell instance sg13cmos5l_a21o_1_25 r0 *1 0,0
Xsg13cmos5l_a21o_1_25 \$1096 \$1443 \$70 VPWR VGND \$1571 sg13cmos5l_a21o_1
* cell instance sg13cmos5l_a21o_1_26 r0 *1 0,0
Xsg13cmos5l_a21o_1_26 \$677 \$917 \$680 VPWR VGND \$828 sg13cmos5l_a21o_1
* cell instance sg13cmos5l_a21o_1_27 r0 *1 0,0
Xsg13cmos5l_a21o_1_27 \$6 \$51 \$31 VPWR VGND \$129 sg13cmos5l_a21o_1
* cell instance sg13cmos5l_a21o_1_28 r0 *1 0,0
Xsg13cmos5l_a21o_1_28 \$1575 \$961 \$1653 VPWR VGND \$1576 sg13cmos5l_a21o_1
* cell instance sg13cmos5l_a21o_1_29 r0 *1 0,0
Xsg13cmos5l_a21o_1_29 \$973 \$1718 \$1721 VPWR VGND \$402 sg13cmos5l_a21o_1
* cell instance sg13cmos5l_a21o_1_30 r0 *1 0,0
Xsg13cmos5l_a21o_1_30 \$973 \$2106 \$2052 VPWR VGND \$1381 sg13cmos5l_a21o_1
* cell instance sg13cmos5l_a21o_1_31 r0 *1 0,0
Xsg13cmos5l_a21o_1_31 \$1165 \$1106 \$1103 VPWR VGND \$858 sg13cmos5l_a21o_1
* cell instance sg13cmos5l_a21o_1_32 r0 *1 0,0
Xsg13cmos5l_a21o_1_32 \$2156 \$2583 \$2589 VPWR VGND \$1821 sg13cmos5l_a21o_1
* cell instance sg13cmos5l_a21o_1_33 r0 *1 0,0
Xsg13cmos5l_a21o_1_33 \$850 \$970 \$1480 VPWR VGND \$592 sg13cmos5l_a21o_1
* cell instance sg13cmos5l_a21o_1_34 r0 *1 0,0
Xsg13cmos5l_a21o_1_34 \$2910 \$2980 \$3138 VPWR VGND \$1740 sg13cmos5l_a21o_1
* cell instance sg13cmos5l_a21o_1_35 r0 *1 0,0
Xsg13cmos5l_a21o_1_35 \$1371 \$1246 \$1243 VPWR VGND \$1229 sg13cmos5l_a21o_1
* cell instance sg13cmos5l_a21o_1_36 r0 *1 0,0
Xsg13cmos5l_a21o_1_36 \$1125 \$875 \$1251 VPWR VGND \$14498 sg13cmos5l_a21o_1
* cell instance sg13cmos5l_a21o_1_37 r0 *1 0,0
Xsg13cmos5l_a21o_1_37 \$8194 \$8196 \$5646 VPWR VGND \$5093 sg13cmos5l_a21o_1
* cell instance sg13cmos5l_a21o_1_38 r0 *1 0,0
Xsg13cmos5l_a21o_1_38 \$3869 \$5003 \$3868 VPWR VGND \$4318 sg13cmos5l_a21o_1
* cell instance sg13cmos5l_a21o_1_39 r0 *1 0,0
Xsg13cmos5l_a21o_1_39 \$4425 \$3313 \$3869 VPWR VGND \$4457 sg13cmos5l_a21o_1
* cell instance sg13cmos5l_a21o_1_40 r0 *1 0,0
Xsg13cmos5l_a21o_1_40 \$1261 \$1126 \$879 VPWR VGND \$1818 sg13cmos5l_a21o_1
* cell instance sg13cmos5l_a21o_1_41 r0 *1 0,0
Xsg13cmos5l_a21o_1_41 \$1275 \$1133 \$1134 VPWR VGND \$1272 sg13cmos5l_a21o_1
* cell instance sg13cmos5l_a21o_1_42 r0 *1 0,0
Xsg13cmos5l_a21o_1_42 \$1975 \$1763 \$2084 VPWR VGND \$2299 sg13cmos5l_a21o_1
* cell instance sg13cmos5l_a21oi_1_0 r0 *1 0,0
Xsg13cmos5l_a21oi_1_0 \$2700 \$6561 \$7171 VPWR VGND \$7804 sg13cmos5l_a21oi_1
* cell instance sg13cmos5l_a21oi_1_1 r0 *1 0,0
Xsg13cmos5l_a21oi_1_1 \$66 \$1430 \$4 VPWR VGND \$792 sg13cmos5l_a21oi_1
* cell instance sg13cmos5l_a21oi_1_2 r0 *1 0,0
Xsg13cmos5l_a21oi_1_2 \$1055 \$1053 \$258 VPWR VGND \$1051 sg13cmos5l_a21oi_1
* cell instance sg13cmos5l_a21oi_1_3 r0 *1 0,0
Xsg13cmos5l_a21oi_1_3 \$3019 \$6561 \$6555 VPWR VGND \$6554 sg13cmos5l_a21oi_1
* cell instance sg13cmos5l_a21oi_1_4 r0 *1 0,0
Xsg13cmos5l_a21oi_1_4 \$3235 \$7165 \$8215 VPWR VGND \$8230 sg13cmos5l_a21oi_1
* cell instance sg13cmos5l_a21oi_1_5 r0 *1 0,0
Xsg13cmos5l_a21oi_1_5 \$157 \$523 \$652 VPWR VGND \$653 sg13cmos5l_a21oi_1
* cell instance sg13cmos5l_a21oi_1_6 r0 *1 0,0
Xsg13cmos5l_a21oi_1_6 \$2700 \$5045 \$6372 VPWR VGND \$6360 sg13cmos5l_a21oi_1
* cell instance sg13cmos5l_a21oi_1_7 r0 *1 0,0
Xsg13cmos5l_a21oi_1_7 \$3019 \$7210 \$7209 VPWR VGND \$7376 sg13cmos5l_a21oi_1
* cell instance sg13cmos5l_a21oi_1_8 r0 *1 0,0
Xsg13cmos5l_a21oi_1_8 \$2818 \$6561 \$7808 VPWR VGND \$7807 sg13cmos5l_a21oi_1
* cell instance sg13cmos5l_a21oi_1_9 r0 *1 0,0
Xsg13cmos5l_a21oi_1_9 \$1666 \$1546 \$1543 VPWR VGND \$1544 sg13cmos5l_a21oi_1
* cell instance sg13cmos5l_a21oi_1_10 r0 *1 0,0
Xsg13cmos5l_a21oi_1_10 \$2392 \$2505 \$2388 VPWR VGND \$2390 sg13cmos5l_a21oi_1
* cell instance sg13cmos5l_a21oi_1_11 r0 *1 0,0
Xsg13cmos5l_a21oi_1_11 \$5337 \$18792 \$18927 VPWR VGND \$18791
+ sg13cmos5l_a21oi_1
* cell instance sg13cmos5l_a21oi_1_12 r0 *1 0,0
Xsg13cmos5l_a21oi_1_12 \$2392 \$3591 \$2388 VPWR VGND \$3742 sg13cmos5l_a21oi_1
* cell instance sg13cmos5l_a21oi_1_13 r0 *1 0,0
Xsg13cmos5l_a21oi_1_13 \$2700 \$7210 \$7377 VPWR VGND \$7492 sg13cmos5l_a21oi_1
* cell instance sg13cmos5l_a21oi_1_14 r0 *1 0,0
Xsg13cmos5l_a21oi_1_14 \$3222 \$3389 \$2392 VPWR VGND \$3220 sg13cmos5l_a21oi_1
* cell instance sg13cmos5l_a21oi_1_15 r0 *1 0,0
Xsg13cmos5l_a21oi_1_15 \$260 \$943 \$259 VPWR VGND \$1176 sg13cmos5l_a21oi_1
* cell instance sg13cmos5l_a21oi_1_16 r0 *1 0,0
Xsg13cmos5l_a21oi_1_16 \$3019 \$5045 \$6375 VPWR VGND \$6374 sg13cmos5l_a21oi_1
* cell instance sg13cmos5l_a21oi_1_17 r0 *1 0,0
Xsg13cmos5l_a21oi_1_17 \$5337 \$6561 \$6560 VPWR VGND \$6807 sg13cmos5l_a21oi_1
* cell instance sg13cmos5l_a21oi_1_18 r0 *1 0,0
Xsg13cmos5l_a21oi_1_18 uio_out[7] \$8494 \$8420 VPWR VGND uio_oe[7]
+ sg13cmos5l_a21oi_1
* cell instance sg13cmos5l_a21oi_1_19 r0 *1 0,0
Xsg13cmos5l_a21oi_1_19 \$3235 \$18792 \$16102 VPWR VGND \$16005
+ sg13cmos5l_a21oi_1
* cell instance sg13cmos5l_a21oi_1_20 r0 *1 0,0
Xsg13cmos5l_a21oi_1_20 \$1055 \$1669 \$1779 VPWR VGND \$1547 sg13cmos5l_a21oi_1
* cell instance sg13cmos5l_a21oi_1_21 r0 *1 0,0
Xsg13cmos5l_a21oi_1_21 uio_out[4] \$6094 \$7712 VPWR VGND uio_oe[4]
+ sg13cmos5l_a21oi_1
* cell instance sg13cmos5l_a21oi_1_22 r0 *1 0,0
Xsg13cmos5l_a21oi_1_22 uio_out[6] \$8219 \$19237 VPWR VGND uio_oe[6]
+ sg13cmos5l_a21oi_1
* cell instance sg13cmos5l_a21oi_1_23 r0 *1 0,0
Xsg13cmos5l_a21oi_1_23 \$2678 \$7165 \$6566 VPWR VGND \$6567 sg13cmos5l_a21oi_1
* cell instance sg13cmos5l_a21oi_1_24 r0 *1 0,0
Xsg13cmos5l_a21oi_1_24 \$649 \$524 \$1058 VPWR VGND \$1057 sg13cmos5l_a21oi_1
* cell instance sg13cmos5l_a21oi_1_25 r0 *1 0,0
Xsg13cmos5l_a21oi_1_25 \$2818 \$5293 \$5721 VPWR VGND \$5908 sg13cmos5l_a21oi_1
* cell instance sg13cmos5l_a21oi_1_26 r0 *1 0,0
Xsg13cmos5l_a21oi_1_26 \$5337 \$5045 \$6378 VPWR VGND \$6082 sg13cmos5l_a21oi_1
* cell instance sg13cmos5l_a21oi_1_27 r0 *1 0,0
Xsg13cmos5l_a21oi_1_27 \$2818 \$18792 \$17331 VPWR VGND \$17140
+ sg13cmos5l_a21oi_1
* cell instance sg13cmos5l_a21oi_1_28 r0 *1 0,0
Xsg13cmos5l_a21oi_1_28 \$2688 \$5293 \$5292 VPWR VGND \$5061 sg13cmos5l_a21oi_1
* cell instance sg13cmos5l_a21oi_1_29 r0 *1 0,0
Xsg13cmos5l_a21oi_1_29 \$801 \$797 \$70 VPWR VGND \$799 sg13cmos5l_a21oi_1
* cell instance sg13cmos5l_a21oi_1_30 r0 *1 0,0
Xsg13cmos5l_a21oi_1_30 \$3751 \$7561 \$7810 VPWR VGND \$7809 sg13cmos5l_a21oi_1
* cell instance sg13cmos5l_a21oi_1_31 r0 *1 0,0
Xsg13cmos5l_a21oi_1_31 \$3751 \$5293 \$5454 VPWR VGND \$5487 sg13cmos5l_a21oi_1
* cell instance sg13cmos5l_a21oi_1_32 r0 *1 0,0
Xsg13cmos5l_a21oi_1_32 uio_out[5] \$7491 \$7378 VPWR VGND uio_oe[5]
+ sg13cmos5l_a21oi_1
* cell instance sg13cmos5l_a21oi_1_33 r0 *1 0,0
Xsg13cmos5l_a21oi_1_33 \$3751 \$2679 \$3749 VPWR VGND \$3748 sg13cmos5l_a21oi_1
* cell instance sg13cmos5l_a21oi_1_34 r0 *1 0,0
Xsg13cmos5l_a21oi_1_34 \$3914 \$4372 \$4512 VPWR VGND \$4370 sg13cmos5l_a21oi_1
* cell instance sg13cmos5l_a21oi_1_35 r0 *1 0,0
Xsg13cmos5l_a21oi_1_35 \$2643 \$3025 \$3008 VPWR VGND \$3221 sg13cmos5l_a21oi_1
* cell instance sg13cmos5l_a21oi_1_36 r0 *1 0,0
Xsg13cmos5l_a21oi_1_36 \$35 \$42 \$66 VPWR VGND \$57 sg13cmos5l_a21oi_1
* cell instance sg13cmos5l_a21oi_1_37 r0 *1 0,0
Xsg13cmos5l_a21oi_1_37 \$2688 \$7165 \$6924 VPWR VGND \$6925 sg13cmos5l_a21oi_1
* cell instance sg13cmos5l_a21oi_1_38 r0 *1 0,0
Xsg13cmos5l_a21oi_1_38 uio_out[3] \$6930 \$18690 VPWR VGND uio_oe[3]
+ sg13cmos5l_a21oi_1
* cell instance sg13cmos5l_a21oi_1_39 r0 *1 0,0
Xsg13cmos5l_a21oi_1_39 \$3396 \$3025 \$3008 VPWR VGND \$3001 sg13cmos5l_a21oi_1
* cell instance sg13cmos5l_a21oi_1_40 r0 *1 0,0
Xsg13cmos5l_a21oi_1_40 \$1058 \$1073 \$258 VPWR VGND \$1548 sg13cmos5l_a21oi_1
* cell instance sg13cmos5l_a21oi_1_41 r0 *1 0,0
Xsg13cmos5l_a21oi_1_41 \$3009 \$3025 \$3008 VPWR VGND \$2823 sg13cmos5l_a21oi_1
* cell instance sg13cmos5l_a21oi_1_42 r0 *1 0,0
Xsg13cmos5l_a21oi_1_42 \$3751 \$17692 \$18691 VPWR VGND \$18798
+ sg13cmos5l_a21oi_1
* cell instance sg13cmos5l_a21oi_1_43 r0 *1 0,0
Xsg13cmos5l_a21oi_1_43 \$1063 \$1302 \$931 VPWR VGND \$1182 sg13cmos5l_a21oi_1
* cell instance sg13cmos5l_a21oi_1_44 r0 *1 0,0
Xsg13cmos5l_a21oi_1_44 \$3708 \$3025 \$3008 VPWR VGND \$3594 sg13cmos5l_a21oi_1
* cell instance sg13cmos5l_a21oi_1_45 r0 *1 0,0
Xsg13cmos5l_a21oi_1_45 \$2392 \$2516 \$2388 VPWR VGND \$2514 sg13cmos5l_a21oi_1
* cell instance sg13cmos5l_a21oi_1_46 r0 *1 0,0
Xsg13cmos5l_a21oi_1_46 uio_out[2] \$8008 \$16863 VPWR VGND uio_oe[2]
+ sg13cmos5l_a21oi_1
* cell instance sg13cmos5l_a21oi_1_47 r0 *1 0,0
Xsg13cmos5l_a21oi_1_47 \$2516 \$2503 \$2683 VPWR VGND \$2684 sg13cmos5l_a21oi_1
* cell instance sg13cmos5l_a21oi_1_48 r0 *1 0,0
Xsg13cmos5l_a21oi_1_48 \$5906 \$5099 \$5500 VPWR VGND \$5922 sg13cmos5l_a21oi_1
* cell instance sg13cmos5l_a21oi_1_49 r0 *1 0,0
Xsg13cmos5l_a21oi_1_49 \$2678 \$5293 \$5501 VPWR VGND \$5502 sg13cmos5l_a21oi_1
* cell instance sg13cmos5l_a21oi_1_50 r0 *1 0,0
Xsg13cmos5l_a21oi_1_50 \$6396 \$5745 \$5500 VPWR VGND \$6394 sg13cmos5l_a21oi_1
* cell instance sg13cmos5l_a21oi_1_51 r0 *1 0,0
Xsg13cmos5l_a21oi_1_51 \$262 \$264 \$4 VPWR VGND \$161 sg13cmos5l_a21oi_1
* cell instance sg13cmos5l_a21oi_1_52 r0 *1 0,0
Xsg13cmos5l_a21oi_1_52 \$4214 \$4212 \$4525 VPWR VGND \$4524 sg13cmos5l_a21oi_1
* cell instance sg13cmos5l_a21oi_1_53 r0 *1 0,0
Xsg13cmos5l_a21oi_1_53 \$1196 \$264 \$1316 VPWR VGND \$1315 sg13cmos5l_a21oi_1
* cell instance sg13cmos5l_a21oi_1_54 r0 *1 0,0
Xsg13cmos5l_a21oi_1_54 \$2688 \$18792 \$19245 VPWR VGND \$19246
+ sg13cmos5l_a21oi_1
* cell instance sg13cmos5l_a21oi_1_55 r0 *1 0,0
Xsg13cmos5l_a21oi_1_55 \$1648 \$683 \$1779 VPWR VGND \$1434 sg13cmos5l_a21oi_1
* cell instance sg13cmos5l_a21oi_1_56 r0 *1 0,0
Xsg13cmos5l_a21oi_1_56 \$2678 \$17692 \$17691 VPWR VGND \$17334
+ sg13cmos5l_a21oi_1
* cell instance sg13cmos5l_a21oi_1_57 r0 *1 0,0
Xsg13cmos5l_a21oi_1_57 uio_out[0] \$5307 \$19886 VPWR VGND uio_oe[0]
+ sg13cmos5l_a21oi_1
* cell instance sg13cmos5l_a21oi_1_58 r0 *1 0,0
Xsg13cmos5l_a21oi_1_58 \$8494 \$5305 \$21 VPWR VGND \$6401 sg13cmos5l_a21oi_1
* cell instance sg13cmos5l_a21oi_1_59 r0 *1 0,0
Xsg13cmos5l_a21oi_1_59 uio_out[1] \$5513 \$6905 VPWR VGND uio_oe[1]
+ sg13cmos5l_a21oi_1
* cell instance sg13cmos5l_a21oi_1_60 r0 *1 0,0
Xsg13cmos5l_a21oi_1_60 \$20042 \$20001 \$20016 VPWR VGND \$20050
+ sg13cmos5l_a21oi_1
* cell instance sg13cmos5l_a21oi_1_61 r0 *1 0,0
Xsg13cmos5l_a21oi_1_61 \$4214 \$4095 \$4213 VPWR VGND \$4094 sg13cmos5l_a21oi_1
* cell instance sg13cmos5l_a21oi_1_62 r0 *1 0,0
Xsg13cmos5l_a21oi_1_62 \$2719 \$2640 \$3930 VPWR VGND \$4091 sg13cmos5l_a21oi_1
* cell instance sg13cmos5l_a21oi_1_63 r0 *1 0,0
Xsg13cmos5l_a21oi_1_63 \$3026 \$2640 \$3930 VPWR VGND \$3738 sg13cmos5l_a21oi_1
* cell instance sg13cmos5l_a21oi_1_64 r0 *1 0,0
Xsg13cmos5l_a21oi_1_64 \$651 \$1553 \$1536 VPWR VGND \$1649 sg13cmos5l_a21oi_1
* cell instance sg13cmos5l_a21oi_1_65 r0 *1 0,0
Xsg13cmos5l_a21oi_1_65 \$5734 \$5692 \$5500 VPWR VGND \$6400 sg13cmos5l_a21oi_1
* cell instance sg13cmos5l_a21oi_1_66 r0 *1 0,0
Xsg13cmos5l_a21oi_1_66 \$267 \$1438 \$1677 VPWR VGND \$1553 sg13cmos5l_a21oi_1
* cell instance sg13cmos5l_a21oi_1_67 r0 *1 0,0
Xsg13cmos5l_a21oi_1_67 \$806 \$421 \$171 VPWR VGND \$1321 sg13cmos5l_a21oi_1
* cell instance sg13cmos5l_a21oi_1_68 r0 *1 0,0
Xsg13cmos5l_a21oi_1_68 \$2248 \$421 \$1880 VPWR VGND \$2118 sg13cmos5l_a21oi_1
* cell instance sg13cmos5l_a21oi_1_69 r0 *1 0,0
Xsg13cmos5l_a21oi_1_69 \$79 \$2 \$164 VPWR VGND \$22 sg13cmos5l_a21oi_1
* cell instance sg13cmos5l_a21oi_1_70 r0 *1 0,0
Xsg13cmos5l_a21oi_1_70 \$4097 \$3935 \$3433 VPWR VGND \$4375 sg13cmos5l_a21oi_1
* cell instance sg13cmos5l_a21oi_1_71 r0 *1 0,0
Xsg13cmos5l_a21oi_1_71 \$1336 \$2025 \$2120 VPWR VGND \$2121 sg13cmos5l_a21oi_1
* cell instance sg13cmos5l_a21oi_1_72 r0 *1 0,0
Xsg13cmos5l_a21oi_1_72 \$2529 \$3230 \$3416 VPWR VGND \$3417 sg13cmos5l_a21oi_1
* cell instance sg13cmos5l_a21oi_1_73 r0 *1 0,0
Xsg13cmos5l_a21oi_1_73 \$649 \$23 \$660 VPWR VGND \$531 sg13cmos5l_a21oi_1
* cell instance sg13cmos5l_a21oi_1_74 r0 *1 0,0
Xsg13cmos5l_a21oi_1_74 \$525 \$539 \$411 VPWR VGND \$808 sg13cmos5l_a21oi_1
* cell instance sg13cmos5l_a21oi_1_75 r0 *1 0,0
Xsg13cmos5l_a21oi_1_75 \$57 \$23 \$82 VPWR VGND \$81 sg13cmos5l_a21oi_1
* cell instance sg13cmos5l_a21oi_1_76 r0 *1 0,0
Xsg13cmos5l_a21oi_1_76 \$3892 \$4911 \$5500 VPWR VGND \$5518 sg13cmos5l_a21oi_1
* cell instance sg13cmos5l_a21oi_1_77 r0 *1 0,0
Xsg13cmos5l_a21oi_1_77 \$276 \$963 \$82 VPWR VGND \$272 sg13cmos5l_a21oi_1
* cell instance sg13cmos5l_a21oi_1_78 r0 *1 0,0
Xsg13cmos5l_a21oi_1_78 \$3235 \$2679 \$3231 VPWR VGND \$3233 sg13cmos5l_a21oi_1
* cell instance sg13cmos5l_a21oi_1_79 r0 *1 0,0
Xsg13cmos5l_a21oi_1_79 \$1326 \$1685 \$91 VPWR VGND \$1794 sg13cmos5l_a21oi_1
* cell instance sg13cmos5l_a21oi_1_80 r0 *1 0,0
Xsg13cmos5l_a21oi_1_80 \$1892 \$2026 \$1671 VPWR VGND \$1897 sg13cmos5l_a21oi_1
* cell instance sg13cmos5l_a21oi_1_81 r0 *1 0,0
Xsg13cmos5l_a21oi_1_81 \$3420 \$3025 \$3930 VPWR VGND \$3419 sg13cmos5l_a21oi_1
* cell instance sg13cmos5l_a21oi_1_82 r0 *1 0,0
Xsg13cmos5l_a21oi_1_82 \$802 \$806 \$290 VPWR VGND \$1326 sg13cmos5l_a21oi_1
* cell instance sg13cmos5l_a21oi_1_83 r0 *1 0,0
Xsg13cmos5l_a21oi_1_83 \$1439 \$1650 \$1441 VPWR VGND \$1555 sg13cmos5l_a21oi_1
* cell instance sg13cmos5l_a21oi_1_84 r0 *1 0,0
Xsg13cmos5l_a21oi_1_84 \$795 \$813 \$251 VPWR VGND \$811 sg13cmos5l_a21oi_1
* cell instance sg13cmos5l_a21oi_1_85 r0 *1 0,0
Xsg13cmos5l_a21oi_1_85 \$533 \$2125 \$1892 VPWR VGND \$2126 sg13cmos5l_a21oi_1
* cell instance sg13cmos5l_a21oi_1_86 r0 *1 0,0
Xsg13cmos5l_a21oi_1_86 \$91 \$2540 \$2126 VPWR VGND \$2542 sg13cmos5l_a21oi_1
* cell instance sg13cmos5l_a21oi_1_87 r0 *1 0,0
Xsg13cmos5l_a21oi_1_87 \$44 \$285 \$164 VPWR VGND \$283 sg13cmos5l_a21oi_1
* cell instance sg13cmos5l_a21oi_1_88 r0 *1 0,0
Xsg13cmos5l_a21oi_1_88 \$1690 \$1687 \$91 VPWR VGND \$1688 sg13cmos5l_a21oi_1
* cell instance sg13cmos5l_a21oi_1_89 r0 *1 0,0
Xsg13cmos5l_a21oi_1_89 \$89 \$90 \$251 VPWR VGND \$85 sg13cmos5l_a21oi_1
* cell instance sg13cmos5l_a21oi_1_90 r0 *1 0,0
Xsg13cmos5l_a21oi_1_90 \$164 \$662 \$646 VPWR VGND \$538 sg13cmos5l_a21oi_1
* cell instance sg13cmos5l_a21oi_1_91 r0 *1 0,0
Xsg13cmos5l_a21oi_1_91 \$164 \$289 \$103 VPWR VGND \$287 sg13cmos5l_a21oi_1
* cell instance sg13cmos5l_a21oi_1_92 r0 *1 0,0
Xsg13cmos5l_a21oi_1_92 \$2858 \$2717 \$3777 VPWR VGND \$1817 sg13cmos5l_a21oi_1
* cell instance sg13cmos5l_a21oi_1_93 r0 *1 0,0
Xsg13cmos5l_a21oi_1_93 \$1439 \$1334 \$37 VPWR VGND \$1332 sg13cmos5l_a21oi_1
* cell instance sg13cmos5l_a21oi_1_94 r0 *1 0,0
Xsg13cmos5l_a21oi_1_94 \$267 \$1070 \$2549 VPWR VGND \$2550 sg13cmos5l_a21oi_1
* cell instance sg13cmos5l_a21oi_1_95 r0 *1 0,0
Xsg13cmos5l_a21oi_1_95 \$289 \$117 \$411 VPWR VGND \$665 sg13cmos5l_a21oi_1
* cell instance sg13cmos5l_a21oi_1_96 r0 *1 0,0
Xsg13cmos5l_a21oi_1_96 \$1191 \$260 \$171 VPWR VGND \$1334 sg13cmos5l_a21oi_1
* cell instance sg13cmos5l_a21oi_1_97 r0 *1 0,0
Xsg13cmos5l_a21oi_1_97 \$97 \$667 \$815 VPWR VGND \$810 sg13cmos5l_a21oi_1
* cell instance sg13cmos5l_a21oi_1_98 r0 *1 0,0
Xsg13cmos5l_a21oi_1_98 \$2268 \$2550 \$1692 VPWR VGND \$2552 sg13cmos5l_a21oi_1
* cell instance sg13cmos5l_a21oi_1_99 r0 *1 0,0
Xsg13cmos5l_a21oi_1_99 \$169 \$425 \$251 VPWR VGND \$423 sg13cmos5l_a21oi_1
* cell instance sg13cmos5l_a21oi_1_100 r0 *1 0,0
Xsg13cmos5l_a21oi_1_100 \$4424 \$4911 \$5500 VPWR VGND \$5545 sg13cmos5l_a21oi_1
* cell instance sg13cmos5l_a21oi_1_101 r0 *1 0,0
Xsg13cmos5l_a21oi_1_101 \$6 \$158 \$47 VPWR VGND \$169 sg13cmos5l_a21oi_1
* cell instance sg13cmos5l_a21oi_1_102 r0 *1 0,0
Xsg13cmos5l_a21oi_1_102 \$1340 \$916 \$936 VPWR VGND \$1418 sg13cmos5l_a21oi_1
* cell instance sg13cmos5l_a21oi_1_103 r0 *1 0,0
Xsg13cmos5l_a21oi_1_103 \$5337 \$3087 \$5336 VPWR VGND \$5338 sg13cmos5l_a21oi_1
* cell instance sg13cmos5l_a21oi_1_104 r0 *1 0,0
Xsg13cmos5l_a21oi_1_104 \$1910 \$2030 \$2001 VPWR VGND \$2028 sg13cmos5l_a21oi_1
* cell instance sg13cmos5l_a21oi_1_105 r0 *1 0,0
Xsg13cmos5l_a21oi_1_105 \$2722 \$798 \$132 VPWR VGND \$2555 sg13cmos5l_a21oi_1
* cell instance sg13cmos5l_a21oi_1_106 r0 *1 0,0
Xsg13cmos5l_a21oi_1_106 \$2678 \$3087 \$4943 VPWR VGND \$4944 sg13cmos5l_a21oi_1
* cell instance sg13cmos5l_a21oi_1_107 r0 *1 0,0
Xsg13cmos5l_a21oi_1_107 \$267 \$2032 \$819 VPWR VGND \$2030 sg13cmos5l_a21oi_1
* cell instance sg13cmos5l_a21oi_1_108 r0 *1 0,0
Xsg13cmos5l_a21oi_1_108 \$683 \$1443 \$1779 VPWR VGND \$1693 sg13cmos5l_a21oi_1
* cell instance sg13cmos5l_a21oi_1_109 r0 *1 0,0
Xsg13cmos5l_a21oi_1_109 \$1194 \$1907 \$1442 VPWR VGND \$1192 sg13cmos5l_a21oi_1
* cell instance sg13cmos5l_a21oi_1_110 r0 *1 0,0
Xsg13cmos5l_a21oi_1_110 \$814 \$1192 \$950 VPWR VGND \$949 sg13cmos5l_a21oi_1
* cell instance sg13cmos5l_a21oi_1_111 r0 *1 0,0
Xsg13cmos5l_a21oi_1_111 \$1905 \$807 \$2032 VPWR VGND \$2033 sg13cmos5l_a21oi_1
* cell instance sg13cmos5l_a21oi_1_112 r0 *1 0,0
Xsg13cmos5l_a21oi_1_112 \$1496 \$4562 \$4666 VPWR VGND \$4564 sg13cmos5l_a21oi_1
* cell instance sg13cmos5l_a21oi_1_113 r0 *1 0,0
Xsg13cmos5l_a21oi_1_113 \$3052 \$3066 \$3067 VPWR VGND \$3068 sg13cmos5l_a21oi_1
* cell instance sg13cmos5l_a21oi_1_114 r0 *1 0,0
Xsg13cmos5l_a21oi_1_114 \$3266 \$3436 \$3264 VPWR VGND \$3067 sg13cmos5l_a21oi_1
* cell instance sg13cmos5l_a21oi_1_115 r0 *1 0,0
Xsg13cmos5l_a21oi_1_115 \$1082 \$105 \$70 VPWR VGND \$1560 sg13cmos5l_a21oi_1
* cell instance sg13cmos5l_a21oi_1_116 r0 *1 0,0
Xsg13cmos5l_a21oi_1_116 \$2722 \$1905 \$435 VPWR VGND \$2548 sg13cmos5l_a21oi_1
* cell instance sg13cmos5l_a21oi_1_117 r0 *1 0,0
Xsg13cmos5l_a21oi_1_117 \$4110 \$4403 \$4556 VPWR VGND \$4407 sg13cmos5l_a21oi_1
* cell instance sg13cmos5l_a21oi_1_118 r0 *1 0,0
Xsg13cmos5l_a21oi_1_118 \$2688 \$3087 \$5135 VPWR VGND \$5136 sg13cmos5l_a21oi_1
* cell instance sg13cmos5l_a21oi_1_119 r0 *1 0,0
Xsg13cmos5l_a21oi_1_119 \$48 \$260 \$174 VPWR VGND \$292 sg13cmos5l_a21oi_1
* cell instance sg13cmos5l_a21oi_1_120 r0 *1 0,0
Xsg13cmos5l_a21oi_1_120 \$4571 \$6545 \$4560 VPWR VGND \$2901 sg13cmos5l_a21oi_1
* cell instance sg13cmos5l_a21oi_1_121 r0 *1 0,0
Xsg13cmos5l_a21oi_1_121 \$3066 \$4119 \$4230 VPWR VGND \$4111 sg13cmos5l_a21oi_1
* cell instance sg13cmos5l_a21oi_1_122 r0 *1 0,0
Xsg13cmos5l_a21oi_1_122 \$1809 \$1810 \$1779 VPWR VGND \$1699 sg13cmos5l_a21oi_1
* cell instance sg13cmos5l_a21oi_1_123 r0 *1 0,0
Xsg13cmos5l_a21oi_1_123 \$937 \$1810 \$1316 VPWR VGND \$2271 sg13cmos5l_a21oi_1
* cell instance sg13cmos5l_a21oi_1_124 r0 *1 0,0
Xsg13cmos5l_a21oi_1_124 \$2117 \$1092 \$1444 VPWR VGND \$1445 sg13cmos5l_a21oi_1
* cell instance sg13cmos5l_a21oi_1_125 r0 *1 0,0
Xsg13cmos5l_a21oi_1_125 \$100 \$50 \$1082 VPWR VGND \$27 sg13cmos5l_a21oi_1
* cell instance sg13cmos5l_a21oi_1_126 r0 *1 0,0
Xsg13cmos5l_a21oi_1_126 \$7 \$943 \$1082 VPWR VGND \$177 sg13cmos5l_a21oi_1
* cell instance sg13cmos5l_a21oi_1_127 r0 *1 0,0
Xsg13cmos5l_a21oi_1_127 \$3019 \$4562 \$3954 VPWR VGND \$3445 sg13cmos5l_a21oi_1
* cell instance sg13cmos5l_a21oi_1_128 r0 *1 0,0
Xsg13cmos5l_a21oi_1_128 \$672 \$539 \$660 VPWR VGND \$817 sg13cmos5l_a21oi_1
* cell instance sg13cmos5l_a21oi_1_129 r0 *1 0,0
Xsg13cmos5l_a21oi_1_129 \$954 \$1081 \$551 VPWR VGND \$1087 sg13cmos5l_a21oi_1
* cell instance sg13cmos5l_a21oi_1_130 r0 *1 0,0
Xsg13cmos5l_a21oi_1_130 \$1052 \$1695 \$1099 VPWR VGND \$1811 sg13cmos5l_a21oi_1
* cell instance sg13cmos5l_a21oi_1_131 r0 *1 0,0
Xsg13cmos5l_a21oi_1_131 \$11 \$547 \$70 VPWR VGND \$438 sg13cmos5l_a21oi_1
* cell instance sg13cmos5l_a21oi_1_132 r0 *1 0,0
Xsg13cmos5l_a21oi_1_132 \$3957 \$3956 \$3448 VPWR VGND \$3630 sg13cmos5l_a21oi_1
* cell instance sg13cmos5l_a21oi_1_133 r0 *1 0,0
Xsg13cmos5l_a21oi_1_133 \$294 \$32 \$4 VPWR VGND \$110 sg13cmos5l_a21oi_1
* cell instance sg13cmos5l_a21oi_1_134 r0 *1 0,0
Xsg13cmos5l_a21oi_1_134 \$3957 \$4411 \$4249 VPWR VGND \$4409 sg13cmos5l_a21oi_1
* cell instance sg13cmos5l_a21oi_1_135 r0 *1 0,0
Xsg13cmos5l_a21oi_1_135 \$2700 \$3087 \$3098 VPWR VGND \$3099 sg13cmos5l_a21oi_1
* cell instance sg13cmos5l_a21oi_1_136 r0 *1 0,0
Xsg13cmos5l_a21oi_1_136 \$1811 \$1701 \$669 VPWR VGND \$1566 sg13cmos5l_a21oi_1
* cell instance sg13cmos5l_a21oi_1_137 r0 *1 0,0
Xsg13cmos5l_a21oi_1_137 \$1082 \$1090 \$252 VPWR VGND \$823 sg13cmos5l_a21oi_1
* cell instance sg13cmos5l_a21oi_1_138 r0 *1 0,0
Xsg13cmos5l_a21oi_1_138 \$3642 \$3630 \$3632 VPWR VGND \$3631 sg13cmos5l_a21oi_1
* cell instance sg13cmos5l_a21oi_1_139 r0 *1 0,0
Xsg13cmos5l_a21oi_1_139 \$4250 \$3791 \$3789 VPWR VGND \$3788 sg13cmos5l_a21oi_1
* cell instance sg13cmos5l_a21oi_1_140 r0 *1 0,0
Xsg13cmos5l_a21oi_1_140 \$1919 \$2121 \$2039 VPWR VGND \$2136 sg13cmos5l_a21oi_1
* cell instance sg13cmos5l_a21oi_1_141 r0 *1 0,0
Xsg13cmos5l_a21oi_1_141 \$3961 \$4248 \$3641 VPWR VGND \$3959 sg13cmos5l_a21oi_1
* cell instance sg13cmos5l_a21oi_1_142 r0 *1 0,0
Xsg13cmos5l_a21oi_1_142 \$547 \$117 \$551 VPWR VGND \$553 sg13cmos5l_a21oi_1
* cell instance sg13cmos5l_a21oi_1_143 r0 *1 0,0
Xsg13cmos5l_a21oi_1_143 \$78 \$3 \$70 VPWR VGND \$827 sg13cmos5l_a21oi_1
* cell instance sg13cmos5l_a21oi_1_144 r0 *1 0,0
Xsg13cmos5l_a21oi_1_144 \$4558 \$4116 \$4252 VPWR VGND \$4117 sg13cmos5l_a21oi_1
* cell instance sg13cmos5l_a21oi_1_145 r0 *1 0,0
Xsg13cmos5l_a21oi_1_145 \$128 \$125 \$121 VPWR VGND \$126 sg13cmos5l_a21oi_1
* cell instance sg13cmos5l_a21oi_1_146 r0 *1 0,0
Xsg13cmos5l_a21oi_1_146 \$2150 \$2977 \$3111 VPWR VGND \$3114 sg13cmos5l_a21oi_1
* cell instance sg13cmos5l_a21oi_1_147 r0 *1 0,0
Xsg13cmos5l_a21oi_1_147 \$38 \$1186 \$252 VPWR VGND \$1346 sg13cmos5l_a21oi_1
* cell instance sg13cmos5l_a21oi_1_148 r0 *1 0,0
Xsg13cmos5l_a21oi_1_148 \$1913 \$688 \$52 VPWR VGND \$1344 sg13cmos5l_a21oi_1
* cell instance sg13cmos5l_a21oi_1_149 r0 *1 0,0
Xsg13cmos5l_a21oi_1_149 \$1469 \$3641 \$4256 VPWR VGND \$4257 sg13cmos5l_a21oi_1
* cell instance sg13cmos5l_a21oi_1_150 r0 *1 0,0
Xsg13cmos5l_a21oi_1_150 \$4250 \$4257 \$4329 VPWR VGND \$4259 sg13cmos5l_a21oi_1
* cell instance sg13cmos5l_a21oi_1_151 r0 *1 0,0
Xsg13cmos5l_a21oi_1_151 \$442 \$126 \$70 VPWR VGND \$440 sg13cmos5l_a21oi_1
* cell instance sg13cmos5l_a21oi_1_152 r0 *1 0,0
Xsg13cmos5l_a21oi_1_152 \$61 \$1925 \$936 VPWR VGND \$1924 sg13cmos5l_a21oi_1
* cell instance sg13cmos5l_a21oi_1_153 r0 *1 0,0
Xsg13cmos5l_a21oi_1_153 \$176 \$1422 \$551 VPWR VGND \$1349 sg13cmos5l_a21oi_1
* cell instance sg13cmos5l_a21oi_1_154 r0 *1 0,0
Xsg13cmos5l_a21oi_1_154 \$100 \$446 \$2554 VPWR VGND \$1925 sg13cmos5l_a21oi_1
* cell instance sg13cmos5l_a21oi_1_155 r0 *1 0,0
Xsg13cmos5l_a21oi_1_155 \$2748 \$2745 \$2746 VPWR VGND \$458 sg13cmos5l_a21oi_1
* cell instance sg13cmos5l_a21oi_1_156 r0 *1 0,0
Xsg13cmos5l_a21oi_1_156 \$555 \$949 \$681 VPWR VGND \$961 sg13cmos5l_a21oi_1
* cell instance sg13cmos5l_a21oi_1_157 r0 *1 0,0
Xsg13cmos5l_a21oi_1_157 \$683 \$556 \$4 VPWR VGND \$686 sg13cmos5l_a21oi_1
* cell instance sg13cmos5l_a21oi_1_158 r0 *1 0,0
Xsg13cmos5l_a21oi_1_158 \$118 \$52 \$38 VPWR VGND \$547 sg13cmos5l_a21oi_1
* cell instance sg13cmos5l_a21oi_1_159 r0 *1 0,0
Xsg13cmos5l_a21oi_1_159 \$3973 \$1605 \$4052 VPWR VGND \$3974 sg13cmos5l_a21oi_1
* cell instance sg13cmos5l_a21oi_1_160 r0 *1 0,0
Xsg13cmos5l_a21oi_1_160 \$118 \$306 \$157 VPWR VGND \$965 sg13cmos5l_a21oi_1
* cell instance sg13cmos5l_a21oi_1_161 r0 *1 0,0
Xsg13cmos5l_a21oi_1_161 \$445 \$558 \$174 VPWR VGND \$555 sg13cmos5l_a21oi_1
* cell instance sg13cmos5l_a21oi_1_162 r0 *1 0,0
Xsg13cmos5l_a21oi_1_162 \$119 \$116 \$120 VPWR VGND \$175 sg13cmos5l_a21oi_1
* cell instance sg13cmos5l_a21oi_1_163 r0 *1 0,0
Xsg13cmos5l_a21oi_1_163 \$64 \$2977 \$4607 VPWR VGND \$4677 sg13cmos5l_a21oi_1
* cell instance sg13cmos5l_a21oi_1_164 r0 *1 0,0
Xsg13cmos5l_a21oi_1_164 \$3973 \$1469 \$3978 VPWR VGND \$3979 sg13cmos5l_a21oi_1
* cell instance sg13cmos5l_a21oi_1_165 r0 *1 0,0
Xsg13cmos5l_a21oi_1_165 \$120 \$1065 \$134 VPWR VGND \$133 sg13cmos5l_a21oi_1
* cell instance sg13cmos5l_a21oi_1_166 r0 *1 0,0
Xsg13cmos5l_a21oi_1_166 \$833 \$561 \$4 VPWR VGND \$831 sg13cmos5l_a21oi_1
* cell instance sg13cmos5l_a21oi_1_167 r0 *1 0,0
Xsg13cmos5l_a21oi_1_167 \$1710 \$964 \$168 VPWR VGND \$1101 sg13cmos5l_a21oi_1
* cell instance sg13cmos5l_a21oi_1_168 r0 *1 0,0
Xsg13cmos5l_a21oi_1_168 \$560 \$445 \$4 VPWR VGND \$312 sg13cmos5l_a21oi_1
* cell instance sg13cmos5l_a21oi_1_169 r0 *1 0,0
Xsg13cmos5l_a21oi_1_169 \$3976 \$2977 \$4426 VPWR VGND \$4427 sg13cmos5l_a21oi_1
* cell instance sg13cmos5l_a21oi_1_170 r0 *1 0,0
Xsg13cmos5l_a21oi_1_170 \$445 \$442 \$4 VPWR VGND \$447 sg13cmos5l_a21oi_1
* cell instance sg13cmos5l_a21oi_1_171 r0 *1 0,0
Xsg13cmos5l_a21oi_1_171 \$4622 \$4799 \$4857 VPWR VGND \$4613 sg13cmos5l_a21oi_1
* cell instance sg13cmos5l_a21oi_1_172 r0 *1 0,0
Xsg13cmos5l_a21oi_1_172 \$2440 \$3134 \$3303 VPWR VGND \$3304 sg13cmos5l_a21oi_1
* cell instance sg13cmos5l_a21oi_1_173 r0 *1 0,0
Xsg13cmos5l_a21oi_1_173 \$3441 \$3478 \$3304 VPWR VGND \$1106 sg13cmos5l_a21oi_1
* cell instance sg13cmos5l_a21oi_1_174 r0 *1 0,0
Xsg13cmos5l_a21oi_1_174 \$5038 \$4273 \$5519 VPWR VGND \$5205 sg13cmos5l_a21oi_1
* cell instance sg13cmos5l_a21oi_1_175 r0 *1 0,0
Xsg13cmos5l_a21oi_1_175 \$2908 \$2440 \$3300 VPWR VGND \$3303 sg13cmos5l_a21oi_1
* cell instance sg13cmos5l_a21oi_1_176 r0 *1 0,0
Xsg13cmos5l_a21oi_1_176 \$1833 \$1303 \$1357 VPWR VGND \$1359 sg13cmos5l_a21oi_1
* cell instance sg13cmos5l_a21oi_1_177 r0 *1 0,0
Xsg13cmos5l_a21oi_1_177 \$3973 \$2361 \$4052 VPWR VGND \$3985 sg13cmos5l_a21oi_1
* cell instance sg13cmos5l_a21oi_1_178 r0 *1 0,0
Xsg13cmos5l_a21oi_1_178 \$3705 \$2308 \$3711 VPWR VGND \$3801 sg13cmos5l_a21oi_1
* cell instance sg13cmos5l_a21oi_1_179 r0 *1 0,0
Xsg13cmos5l_a21oi_1_179 \$4813 \$5636 \$5098 VPWR VGND \$5830 sg13cmos5l_a21oi_1
* cell instance sg13cmos5l_a21oi_1_180 r0 *1 0,0
Xsg13cmos5l_a21oi_1_180 \$1166 \$1226 \$1109 VPWR VGND \$1224 sg13cmos5l_a21oi_1
* cell instance sg13cmos5l_a21oi_1_181 r0 *1 0,0
Xsg13cmos5l_a21oi_1_181 \$564 \$647 \$563 VPWR VGND \$693 sg13cmos5l_a21oi_1
* cell instance sg13cmos5l_a21oi_1_182 r0 *1 0,0
Xsg13cmos5l_a21oi_1_182 \$1234 \$1229 \$1167 VPWR VGND \$1226 sg13cmos5l_a21oi_1
* cell instance sg13cmos5l_a21oi_1_183 r0 *1 0,0
Xsg13cmos5l_a21oi_1_183 \$4274 \$4272 \$4125 VPWR VGND \$4335 sg13cmos5l_a21oi_1
* cell instance sg13cmos5l_a21oi_1_184 r0 *1 0,0
Xsg13cmos5l_a21oi_1_184 \$1234 \$1229 \$1231 VPWR VGND \$1230 sg13cmos5l_a21oi_1
* cell instance sg13cmos5l_a21oi_1_185 r0 *1 0,0
Xsg13cmos5l_a21oi_1_185 \$2591 \$2292 \$2578 VPWR VGND \$2589 sg13cmos5l_a21oi_1
* cell instance sg13cmos5l_a21oi_1_186 r0 *1 0,0
Xsg13cmos5l_a21oi_1_186 \$326 \$2754 \$3307 VPWR VGND \$2908 sg13cmos5l_a21oi_1
* cell instance sg13cmos5l_a21oi_1_187 r0 *1 0,0
Xsg13cmos5l_a21oi_1_187 \$1937 \$1224 \$1819 VPWR VGND \$1936 sg13cmos5l_a21oi_1
* cell instance sg13cmos5l_a21oi_1_188 r0 *1 0,0
Xsg13cmos5l_a21oi_1_188 \$1724 \$2169 \$2163 VPWR VGND \$2292 sg13cmos5l_a21oi_1
* cell instance sg13cmos5l_a21oi_1_189 r0 *1 0,0
Xsg13cmos5l_a21oi_1_189 \$1724 \$1488 \$1589 VPWR VGND \$1590 sg13cmos5l_a21oi_1
* cell instance sg13cmos5l_a21oi_1_190 r0 *1 0,0
Xsg13cmos5l_a21oi_1_190 \$1933 \$1593 \$1940 VPWR VGND \$1939 sg13cmos5l_a21oi_1
* cell instance sg13cmos5l_a21oi_1_191 r0 *1 0,0
Xsg13cmos5l_a21oi_1_191 \$4457 \$4617 \$4615 VPWR VGND \$4619 sg13cmos5l_a21oi_1
* cell instance sg13cmos5l_a21oi_1_192 r0 *1 0,0
Xsg13cmos5l_a21oi_1_192 \$853 \$565 \$972 VPWR VGND \$851 sg13cmos5l_a21oi_1
* cell instance sg13cmos5l_a21oi_1_193 r0 *1 0,0
Xsg13cmos5l_a21oi_1_193 \$573 \$988 \$457 VPWR VGND \$571 sg13cmos5l_a21oi_1
* cell instance sg13cmos5l_a21oi_1_194 r0 *1 0,0
Xsg13cmos5l_a21oi_1_194 \$3310 \$3377 \$3140 VPWR VGND \$3311 sg13cmos5l_a21oi_1
* cell instance sg13cmos5l_a21oi_1_195 r0 *1 0,0
Xsg13cmos5l_a21oi_1_195 \$1824 \$2648 \$2766 VPWR VGND \$2911 sg13cmos5l_a21oi_1
* cell instance sg13cmos5l_a21oi_1_196 r0 *1 0,0
Xsg13cmos5l_a21oi_1_196 \$1237 \$1485 \$1236 VPWR VGND \$1483 sg13cmos5l_a21oi_1
* cell instance sg13cmos5l_a21oi_1_197 r0 *1 0,0
Xsg13cmos5l_a21oi_1_197 \$1881 \$4617 \$4449 VPWR VGND \$4624 sg13cmos5l_a21oi_1
* cell instance sg13cmos5l_a21oi_1_198 r0 *1 0,0
Xsg13cmos5l_a21oi_1_198 \$1605 \$3496 \$2654 VPWR VGND \$3495 sg13cmos5l_a21oi_1
* cell instance sg13cmos5l_a21oi_1_199 r0 *1 0,0
Xsg13cmos5l_a21oi_1_199 \$4815 \$4682 \$4683 VPWR VGND \$4814 sg13cmos5l_a21oi_1
* cell instance sg13cmos5l_a21oi_1_200 r0 *1 0,0
Xsg13cmos5l_a21oi_1_200 \$862 \$985 \$858 VPWR VGND \$787 sg13cmos5l_a21oi_1
* cell instance sg13cmos5l_a21oi_1_201 r0 *1 0,0
Xsg13cmos5l_a21oi_1_201 \$1469 \$3496 \$3715 VPWR VGND \$4134 sg13cmos5l_a21oi_1
* cell instance sg13cmos5l_a21oi_1_202 r0 *1 0,0
Xsg13cmos5l_a21oi_1_202 \$3499 \$2985 \$3496 VPWR VGND \$3319 sg13cmos5l_a21oi_1
* cell instance sg13cmos5l_a21oi_1_203 r0 *1 0,0
Xsg13cmos5l_a21oi_1_203 \$1477 \$1245 \$1236 VPWR VGND \$1489 sg13cmos5l_a21oi_1
* cell instance sg13cmos5l_a21oi_1_204 r0 *1 0,0
Xsg13cmos5l_a21oi_1_204 \$4000 \$3661 \$3496 VPWR VGND \$4001 sg13cmos5l_a21oi_1
* cell instance sg13cmos5l_a21oi_1_205 r0 *1 0,0
Xsg13cmos5l_a21oi_1_205 \$1494 \$2606 \$2654 VPWR VGND \$3144 sg13cmos5l_a21oi_1
* cell instance sg13cmos5l_a21oi_1_206 r0 *1 0,0
Xsg13cmos5l_a21oi_1_206 \$4815 \$4819 \$4683 VPWR VGND \$4999 sg13cmos5l_a21oi_1
* cell instance sg13cmos5l_a21oi_1_207 r0 *1 0,0
Xsg13cmos5l_a21oi_1_207 \$3654 \$3661 \$3496 VPWR VGND \$3664 sg13cmos5l_a21oi_1
* cell instance sg13cmos5l_a21oi_1_208 r0 *1 0,0
Xsg13cmos5l_a21oi_1_208 \$2073 \$1355 \$1424 VPWR VGND \$2071 sg13cmos5l_a21oi_1
* cell instance sg13cmos5l_a21oi_1_209 r0 *1 0,0
Xsg13cmos5l_a21oi_1_209 \$1356 \$6039 \$5891 VPWR VGND \$6037 sg13cmos5l_a21oi_1
* cell instance sg13cmos5l_a21oi_1_210 r0 *1 0,0
Xsg13cmos5l_a21oi_1_210 \$4466 \$5003 \$4685 VPWR VGND \$5421 sg13cmos5l_a21oi_1
* cell instance sg13cmos5l_a21oi_1_211 r0 *1 0,0
Xsg13cmos5l_a21oi_1_211 \$1494 \$3496 \$3715 VPWR VGND \$3667 sg13cmos5l_a21oi_1
* cell instance sg13cmos5l_a21oi_1_212 r0 *1 0,0
Xsg13cmos5l_a21oi_1_212 \$4149 \$5470 \$6039 VPWR VGND \$6347 sg13cmos5l_a21oi_1
* cell instance sg13cmos5l_a21oi_1_213 r0 *1 0,0
Xsg13cmos5l_a21oi_1_213 \$64 \$9009 \$9008 VPWR VGND \$9010 sg13cmos5l_a21oi_1
* cell instance sg13cmos5l_a21oi_1_214 r0 *1 0,0
Xsg13cmos5l_a21oi_1_214 \$2180 \$6039 \$7190 VPWR VGND \$7527 sg13cmos5l_a21oi_1
* cell instance sg13cmos5l_a21oi_1_215 r0 *1 0,0
Xsg13cmos5l_a21oi_1_215 \$3148 \$2985 \$2606 VPWR VGND \$3154 sg13cmos5l_a21oi_1
* cell instance sg13cmos5l_a21oi_1_216 r0 *1 0,0
Xsg13cmos5l_a21oi_1_216 \$1247 \$9183 \$9241 VPWR VGND \$9181 sg13cmos5l_a21oi_1
* cell instance sg13cmos5l_a21oi_1_217 r0 *1 0,0
Xsg13cmos5l_a21oi_1_217 \$1477 \$2606 \$2654 VPWR VGND \$2806 sg13cmos5l_a21oi_1
* cell instance sg13cmos5l_a21oi_1_218 r0 *1 0,0
Xsg13cmos5l_a21oi_1_218 \$1247 \$9009 \$11262 VPWR VGND \$11230
+ sg13cmos5l_a21oi_1
* cell instance sg13cmos5l_a21oi_1_219 r0 *1 0,0
Xsg13cmos5l_a21oi_1_219 \$1247 \$12050 \$12255 VPWR VGND \$12556
+ sg13cmos5l_a21oi_1
* cell instance sg13cmos5l_a21oi_1_220 r0 *1 0,0
Xsg13cmos5l_a21oi_1_220 \$1247 \$16365 \$16662 VPWR VGND \$16663
+ sg13cmos5l_a21oi_1
* cell instance sg13cmos5l_a21oi_1_221 r0 *1 0,0
Xsg13cmos5l_a21oi_1_221 \$1247 \$13476 \$13843 VPWR VGND \$14489
+ sg13cmos5l_a21oi_1
* cell instance sg13cmos5l_a21oi_1_222 r0 *1 0,0
Xsg13cmos5l_a21oi_1_222 \$1125 \$875 \$1251 VPWR VGND \$1256 sg13cmos5l_a21oi_1
* cell instance sg13cmos5l_a21oi_1_223 r0 *1 0,0
Xsg13cmos5l_a21oi_1_223 \$2922 \$4007 \$4294 VPWR VGND \$3712 sg13cmos5l_a21oi_1
* cell instance sg13cmos5l_a21oi_1_224 r0 *1 0,0
Xsg13cmos5l_a21oi_1_224 \$1469 \$1355 \$1424 VPWR VGND \$1379 sg13cmos5l_a21oi_1
* cell instance sg13cmos5l_a21oi_1_225 r0 *1 0,0
Xsg13cmos5l_a21oi_1_225 \$1977 \$1355 \$1424 VPWR VGND \$1955 sg13cmos5l_a21oi_1
* cell instance sg13cmos5l_a21oi_1_226 r0 *1 0,0
Xsg13cmos5l_a21oi_1_226 \$4455 \$5470 \$5657 VPWR VGND \$5656 sg13cmos5l_a21oi_1
* cell instance sg13cmos5l_a21oi_1_227 r0 *1 0,0
Xsg13cmos5l_a21oi_1_227 \$3865 \$6579 \$6505 VPWR VGND \$6578 sg13cmos5l_a21oi_1
* cell instance sg13cmos5l_a21oi_1_228 r0 *1 0,0
Xsg13cmos5l_a21oi_1_228 \$6513 \$6043 \$6039 VPWR VGND \$7351 sg13cmos5l_a21oi_1
* cell instance sg13cmos5l_a21oi_1_229 r0 *1 0,0
Xsg13cmos5l_a21oi_1_229 \$785 \$564 \$1126 VPWR VGND \$1125 sg13cmos5l_a21oi_1
* cell instance sg13cmos5l_a21oi_1_230 r0 *1 0,0
Xsg13cmos5l_a21oi_1_230 \$8779 \$8798 \$5646 VPWR VGND \$5550 sg13cmos5l_a21oi_1
* cell instance sg13cmos5l_a21oi_1_231 r0 *1 0,0
Xsg13cmos5l_a21oi_1_231 \$1244 \$9009 \$9424 VPWR VGND \$10004
+ sg13cmos5l_a21oi_1
* cell instance sg13cmos5l_a21oi_1_232 r0 *1 0,0
Xsg13cmos5l_a21oi_1_232 \$1605 \$5657 \$5891 VPWR VGND \$5659 sg13cmos5l_a21oi_1
* cell instance sg13cmos5l_a21oi_1_233 r0 *1 0,0
Xsg13cmos5l_a21oi_1_233 \$2361 \$6039 \$5891 VPWR VGND \$6580 sg13cmos5l_a21oi_1
* cell instance sg13cmos5l_a21oi_1_234 r0 *1 0,0
Xsg13cmos5l_a21oi_1_234 \$6512 \$5470 \$6039 VPWR VGND \$7352 sg13cmos5l_a21oi_1
* cell instance sg13cmos5l_a21oi_1_235 r0 *1 0,0
Xsg13cmos5l_a21oi_1_235 \$64 \$13476 \$12557 VPWR VGND \$13475
+ sg13cmos5l_a21oi_1
* cell instance sg13cmos5l_a21oi_1_236 r0 *1 0,0
Xsg13cmos5l_a21oi_1_236 \$605 \$740 \$579 VPWR VGND \$739 sg13cmos5l_a21oi_1
* cell instance sg13cmos5l_a21oi_1_237 r0 *1 0,0
Xsg13cmos5l_a21oi_1_237 \$1261 \$988 \$1258 VPWR VGND \$1259 sg13cmos5l_a21oi_1
* cell instance sg13cmos5l_a21oi_1_238 r0 *1 0,0
Xsg13cmos5l_a21oi_1_238 \$1244 \$16365 \$17659 VPWR VGND \$18480
+ sg13cmos5l_a21oi_1
* cell instance sg13cmos5l_a21oi_1_239 r0 *1 0,0
Xsg13cmos5l_a21oi_1_239 \$4821 \$4822 \$4812 VPWR VGND \$4817 sg13cmos5l_a21oi_1
* cell instance sg13cmos5l_a21oi_1_240 r0 *1 0,0
Xsg13cmos5l_a21oi_1_240 \$1494 \$2618 \$3715 VPWR VGND \$3672 sg13cmos5l_a21oi_1
* cell instance sg13cmos5l_a21oi_1_241 r0 *1 0,0
Xsg13cmos5l_a21oi_1_241 \$1469 \$2606 \$2654 VPWR VGND \$2604 sg13cmos5l_a21oi_1
* cell instance sg13cmos5l_a21oi_1_242 r0 *1 0,0
Xsg13cmos5l_a21oi_1_242 \$3859 \$2985 \$2618 VPWR VGND \$4013 sg13cmos5l_a21oi_1
* cell instance sg13cmos5l_a21oi_1_243 r0 *1 0,0
Xsg13cmos5l_a21oi_1_243 \$1494 \$5657 \$5891 VPWR VGND \$6299 sg13cmos5l_a21oi_1
* cell instance sg13cmos5l_a21oi_1_244 r0 *1 0,0
Xsg13cmos5l_a21oi_1_244 \$14498 \$16365 \$14690 VPWR VGND \$15720
+ sg13cmos5l_a21oi_1
* cell instance sg13cmos5l_a21oi_1_245 r0 *1 0,0
Xsg13cmos5l_a21oi_1_245 \$1244 \$12050 \$11880 VPWR VGND \$11710
+ sg13cmos5l_a21oi_1
* cell instance sg13cmos5l_a21oi_1_246 r0 *1 0,0
Xsg13cmos5l_a21oi_1_246 \$3835 \$3148 \$4159 VPWR VGND \$4156 sg13cmos5l_a21oi_1
* cell instance sg13cmos5l_a21oi_1_247 r0 *1 0,0
Xsg13cmos5l_a21oi_1_247 \$1244 \$13476 \$14191 VPWR VGND \$13846
+ sg13cmos5l_a21oi_1
* cell instance sg13cmos5l_a21oi_1_248 r0 *1 0,0
Xsg13cmos5l_a21oi_1_248 \$1261 \$1126 \$879 VPWR VGND \$1838 sg13cmos5l_a21oi_1
* cell instance sg13cmos5l_a21oi_1_249 r0 *1 0,0
Xsg13cmos5l_a21oi_1_249 \$8505 \$8506 \$5646 VPWR VGND \$5517 sg13cmos5l_a21oi_1
* cell instance sg13cmos5l_a21oi_1_250 r0 *1 0,0
Xsg13cmos5l_a21oi_1_250 \$2818 \$9183 \$9242 VPWR VGND \$9243 sg13cmos5l_a21oi_1
* cell instance sg13cmos5l_a21oi_1_251 r0 *1 0,0
Xsg13cmos5l_a21oi_1_251 \$3976 \$9009 \$10601 VPWR VGND \$11234
+ sg13cmos5l_a21oi_1
* cell instance sg13cmos5l_a21oi_1_252 r0 *1 0,0
Xsg13cmos5l_a21oi_1_252 \$64 \$12050 \$13000 VPWR VGND \$12892
+ sg13cmos5l_a21oi_1
* cell instance sg13cmos5l_a21oi_1_253 r0 *1 0,0
Xsg13cmos5l_a21oi_1_253 \$2922 \$2985 \$2606 VPWR VGND \$2934 sg13cmos5l_a21oi_1
* cell instance sg13cmos5l_a21oi_1_254 r0 *1 0,0
Xsg13cmos5l_a21oi_1_254 \$55 \$16365 \$16321 VPWR VGND \$16473
+ sg13cmos5l_a21oi_1
* cell instance sg13cmos5l_a21oi_1_255 r0 *1 0,0
Xsg13cmos5l_a21oi_1_255 \$6303 \$5470 \$5657 VPWR VGND \$6304 sg13cmos5l_a21oi_1
* cell instance sg13cmos5l_a21oi_1_256 r0 *1 0,0
Xsg13cmos5l_a21oi_1_256 \$5427 \$5666 \$5657 VPWR VGND \$5432 sg13cmos5l_a21oi_1
* cell instance sg13cmos5l_a21oi_1_257 r0 *1 0,0
Xsg13cmos5l_a21oi_1_257 \$1471 \$6039 \$6590 VPWR VGND \$6852 sg13cmos5l_a21oi_1
* cell instance sg13cmos5l_a21oi_1_258 r0 *1 0,0
Xsg13cmos5l_a21oi_1_258 \$2073 \$3496 \$6590 VPWR VGND \$7531 sg13cmos5l_a21oi_1
* cell instance sg13cmos5l_a21oi_1_259 r0 *1 0,0
Xsg13cmos5l_a21oi_1_259 \$1244 \$9183 \$9427 VPWR VGND \$9428 sg13cmos5l_a21oi_1
* cell instance sg13cmos5l_a21oi_1_260 r0 *1 0,0
Xsg13cmos5l_a21oi_1_260 \$64 \$14614 \$17842 VPWR VGND \$17843
+ sg13cmos5l_a21oi_1
* cell instance sg13cmos5l_a21oi_1_261 r0 *1 0,0
Xsg13cmos5l_a21oi_1_261 \$2609 \$2655 \$2606 VPWR VGND \$2776 sg13cmos5l_a21oi_1
* cell instance sg13cmos5l_a21oi_1_262 r0 *1 0,0
Xsg13cmos5l_a21oi_1_262 \$2946 \$4168 \$5004 VPWR VGND \$4012 sg13cmos5l_a21oi_1
* cell instance sg13cmos5l_a21oi_1_263 r0 *1 0,0
Xsg13cmos5l_a21oi_1_263 \$4826 \$4822 \$2474 VPWR VGND \$4825 sg13cmos5l_a21oi_1
* cell instance sg13cmos5l_a21oi_1_264 r0 *1 0,0
Xsg13cmos5l_a21oi_1_264 \$1469 \$5657 \$5230 VPWR VGND \$5231 sg13cmos5l_a21oi_1
* cell instance sg13cmos5l_a21oi_1_265 r0 *1 0,0
Xsg13cmos5l_a21oi_1_265 \$6515 \$7354 \$4291 VPWR VGND \$7533 sg13cmos5l_a21oi_1
* cell instance sg13cmos5l_a21oi_1_266 r0 *1 0,0
Xsg13cmos5l_a21oi_1_266 \$1960 \$564 \$1126 VPWR VGND \$2081 sg13cmos5l_a21oi_1
* cell instance sg13cmos5l_a21oi_1_267 r0 *1 0,0
Xsg13cmos5l_a21oi_1_267 \$6550 \$7354 \$6039 VPWR VGND \$7168 sg13cmos5l_a21oi_1
* cell instance sg13cmos5l_a21oi_1_268 r0 *1 0,0
Xsg13cmos5l_a21oi_1_268 \$3976 \$13003 \$13703 VPWR VGND \$13850
+ sg13cmos5l_a21oi_1
* cell instance sg13cmos5l_a21oi_1_269 r0 *1 0,0
Xsg13cmos5l_a21oi_1_269 \$923 \$901 \$1126 VPWR VGND \$1275 sg13cmos5l_a21oi_1
* cell instance sg13cmos5l_a21oi_1_270 r0 *1 0,0
Xsg13cmos5l_a21oi_1_270 \$8508 \$8509 \$5646 VPWR VGND \$5309 sg13cmos5l_a21oi_1
* cell instance sg13cmos5l_a21oi_1_271 r0 *1 0,0
Xsg13cmos5l_a21oi_1_271 \$1477 \$2618 \$2311 VPWR VGND \$3351 sg13cmos5l_a21oi_1
* cell instance sg13cmos5l_a21oi_1_272 r0 *1 0,0
Xsg13cmos5l_a21oi_1_272 \$55 \$9789 \$9430 VPWR VGND \$9432 sg13cmos5l_a21oi_1
* cell instance sg13cmos5l_a21oi_1_273 r0 *1 0,0
Xsg13cmos5l_a21oi_1_273 \$3976 \$11903 \$11714 VPWR VGND \$12260
+ sg13cmos5l_a21oi_1
* cell instance sg13cmos5l_a21oi_1_274 r0 *1 0,0
Xsg13cmos5l_a21oi_1_274 \$2150 \$14614 \$14764 VPWR VGND \$15353
+ sg13cmos5l_a21oi_1
* cell instance sg13cmos5l_a21oi_1_275 r0 *1 0,0
Xsg13cmos5l_a21oi_1_275 \$3347 \$2655 \$2618 VPWR VGND \$3539 sg13cmos5l_a21oi_1
* cell instance sg13cmos5l_a21oi_1_276 r0 *1 0,0
Xsg13cmos5l_a21oi_1_276 \$3235 \$9789 \$10931 VPWR VGND \$10604
+ sg13cmos5l_a21oi_1
* cell instance sg13cmos5l_a21oi_1_277 r0 *1 0,0
Xsg13cmos5l_a21oi_1_277 \$2316 \$2655 \$2618 VPWR VGND \$2614 sg13cmos5l_a21oi_1
* cell instance sg13cmos5l_a21oi_1_278 r0 *1 0,0
Xsg13cmos5l_a21oi_1_278 \$3751 \$9026 \$9024 VPWR VGND \$9025 sg13cmos5l_a21oi_1
* cell instance sg13cmos5l_a21oi_1_279 r0 *1 0,0
Xsg13cmos5l_a21oi_1_279 \$3976 \$16365 \$17665 VPWR VGND \$17846
+ sg13cmos5l_a21oi_1
* cell instance sg13cmos5l_a21oi_1_280 r0 *1 0,0
Xsg13cmos5l_a21oi_1_280 \$1469 \$2618 \$2311 VPWR VGND \$2315 sg13cmos5l_a21oi_1
* cell instance sg13cmos5l_a21oi_1_281 r0 *1 0,0
Xsg13cmos5l_a21oi_1_281 \$9622 \$14614 \$16324 VPWR VGND \$16090
+ sg13cmos5l_a21oi_1
* cell instance sg13cmos5l_a21oi_1_282 r0 *1 0,0
Xsg13cmos5l_a21oi_1_282 \$1356 \$2606 \$2471 VPWR VGND \$2470 sg13cmos5l_a21oi_1
* cell instance sg13cmos5l_a21oi_1_283 r0 *1 0,0
Xsg13cmos5l_a21oi_1_283 \$1851 \$579 \$740 VPWR VGND \$1762 sg13cmos5l_a21oi_1
* cell instance sg13cmos5l_a21oi_1_284 r0 *1 0,0
Xsg13cmos5l_a21oi_1_284 \$2941 \$4826 \$2929 VPWR VGND \$5006 sg13cmos5l_a21oi_1
* cell instance sg13cmos5l_a21oi_1_285 r0 *1 0,0
Xsg13cmos5l_a21oi_1_285 \$14498 \$13003 \$14329 VPWR VGND \$14617
+ sg13cmos5l_a21oi_1
* cell instance sg13cmos5l_a21oi_1_286 r0 *1 0,0
Xsg13cmos5l_a21oi_1_286 \$1765 \$989 \$1762 VPWR VGND \$1763 sg13cmos5l_a21oi_1
* cell instance sg13cmos5l_a21oi_1_287 r0 *1 0,0
Xsg13cmos5l_a21oi_1_287 \$1975 \$1763 \$2084 VPWR VGND \$1977 sg13cmos5l_a21oi_1
* cell instance sg13cmos5l_a21oi_1_288 r0 *1 0,0
Xsg13cmos5l_a21oi_1_288 \$1367 \$5868 \$5230 VPWR VGND \$5866 sg13cmos5l_a21oi_1
* cell instance sg13cmos5l_a21oi_1_289 r0 *1 0,0
Xsg13cmos5l_a21oi_1_289 \$8525 \$8784 \$5646 VPWR VGND \$5951 sg13cmos5l_a21oi_1
* cell instance sg13cmos5l_a21oi_1_290 r0 *1 0,0
Xsg13cmos5l_a21oi_1_290 \$2474 \$2655 \$2606 VPWR VGND \$2622 sg13cmos5l_a21oi_1
* cell instance sg13cmos5l_a21oi_1_291 r0 *1 0,0
Xsg13cmos5l_a21oi_1_291 \$1356 \$2482 \$2471 VPWR VGND \$3357 sg13cmos5l_a21oi_1
* cell instance sg13cmos5l_a21oi_1_292 r0 *1 0,0
Xsg13cmos5l_a21oi_1_292 \$6522 \$7354 \$4628 VPWR VGND \$7666 sg13cmos5l_a21oi_1
* cell instance sg13cmos5l_a21oi_1_293 r0 *1 0,0
Xsg13cmos5l_a21oi_1_293 \$9622 \$9789 \$9411 VPWR VGND \$9436 sg13cmos5l_a21oi_1
* cell instance sg13cmos5l_a21oi_1_294 r0 *1 0,0
Xsg13cmos5l_a21oi_1_294 \$4826 \$4490 \$4833 VPWR VGND \$4834 sg13cmos5l_a21oi_1
* cell instance sg13cmos5l_a21oi_1_295 r0 *1 0,0
Xsg13cmos5l_a21oi_1_295 \$55 \$13003 \$13002 VPWR VGND \$12908
+ sg13cmos5l_a21oi_1
* cell instance sg13cmos5l_a21oi_1_296 r0 *1 0,0
Xsg13cmos5l_a21oi_1_296 \$4127 \$3869 \$3868 VPWR VGND \$4024 sg13cmos5l_a21oi_1
* cell instance sg13cmos5l_a21oi_1_297 r0 *1 0,0
Xsg13cmos5l_a21oi_1_297 \$2946 \$2628 \$2482 VPWR VGND \$3545 sg13cmos5l_a21oi_1
* cell instance sg13cmos5l_a21oi_1_298 r0 *1 0,0
Xsg13cmos5l_a21oi_1_298 \$2150 \$9789 \$10932 VPWR VGND \$10606
+ sg13cmos5l_a21oi_1
* cell instance sg13cmos5l_a21oi_1_299 r0 *1 0,0
Xsg13cmos5l_a21oi_1_299 \$7972 \$7996 \$4554 VPWR VGND \$21 sg13cmos5l_a21oi_1
* cell instance sg13cmos5l_a21oi_1_300 r0 *1 0,0
Xsg13cmos5l_a21oi_1_300 \$1471 \$5868 \$6590 VPWR VGND \$6591 sg13cmos5l_a21oi_1
* cell instance sg13cmos5l_a21oi_1_301 r0 *1 0,0
Xsg13cmos5l_a21oi_1_301 \$5864 \$5666 \$5868 VPWR VGND \$6317 sg13cmos5l_a21oi_1
* cell instance sg13cmos5l_a21oi_1_302 r0 *1 0,0
Xsg13cmos5l_a21oi_1_302 \$55 \$9026 \$9028 VPWR VGND \$9029 sg13cmos5l_a21oi_1
* cell instance sg13cmos5l_a21oi_1_303 r0 *1 0,0
Xsg13cmos5l_a21oi_1_303 \$6589 \$7354 \$5868 VPWR VGND \$7355 sg13cmos5l_a21oi_1
* cell instance sg13cmos5l_a21oi_1_304 r0 *1 0,0
Xsg13cmos5l_a21oi_1_304 \$55 \$11903 \$11904 VPWR VGND \$11717
+ sg13cmos5l_a21oi_1
* cell instance sg13cmos5l_a21oi_1_305 r0 *1 0,0
Xsg13cmos5l_a21oi_1_305 \$2073 \$5657 \$7200 VPWR VGND \$7669 sg13cmos5l_a21oi_1
* cell instance sg13cmos5l_a21oi_1_306 r0 *1 0,0
Xsg13cmos5l_a21oi_1_306 \$1471 \$2482 \$2471 VPWR VGND \$2371 sg13cmos5l_a21oi_1
* cell instance sg13cmos5l_a21oi_1_307 r0 *1 0,0
Xsg13cmos5l_a21oi_1_307 \$3188 \$4168 \$5678 VPWR VGND \$727 sg13cmos5l_a21oi_1
* cell instance sg13cmos5l_a21oi_1_308 r0 *1 0,0
Xsg13cmos5l_a21oi_1_308 \$8786 \$8810 \$5646 VPWR VGND \$5949 sg13cmos5l_a21oi_1
* cell instance sg13cmos5l_a21oi_1_309 r0 *1 0,0
Xsg13cmos5l_a21oi_1_309 \$2807 \$2628 \$2625 VPWR VGND \$2626 sg13cmos5l_a21oi_1
* cell instance sg13cmos5l_a21oi_1_310 r0 *1 0,0
Xsg13cmos5l_a21oi_1_310 \$3659 \$2628 \$3548 VPWR VGND \$3549 sg13cmos5l_a21oi_1
* cell instance sg13cmos5l_a21oi_1_311 r0 *1 0,0
Xsg13cmos5l_a21oi_1_311 \$8137 \$7999 \$4554 VPWR VGND \$229 sg13cmos5l_a21oi_1
* cell instance sg13cmos5l_a21oi_1_312 r0 *1 0,0
Xsg13cmos5l_a21oi_1_312 \$4030 \$3534 \$2482 VPWR VGND \$4172 sg13cmos5l_a21oi_1
* cell instance sg13cmos5l_a21oi_1_313 r0 *1 0,0
Xsg13cmos5l_a21oi_1_313 \$4833 \$5666 \$2625 VPWR VGND \$6059 sg13cmos5l_a21oi_1
* cell instance sg13cmos5l_a21oi_1_314 r0 *1 0,0
Xsg13cmos5l_a21oi_1_314 \$3235 \$9183 \$9628 VPWR VGND \$9440 sg13cmos5l_a21oi_1
* cell instance sg13cmos5l_a21oi_1_315 r0 *1 0,0
Xsg13cmos5l_a21oi_1_315 \$1471 \$2625 \$2471 VPWR VGND \$2787 sg13cmos5l_a21oi_1
* cell instance sg13cmos5l_a21oi_1_316 r0 *1 0,0
Xsg13cmos5l_a21oi_1_316 \$2180 \$2482 \$3536 VPWR VGND \$3876 sg13cmos5l_a21oi_1
* cell instance sg13cmos5l_a21oi_1_317 r0 *1 0,0
Xsg13cmos5l_a21oi_1_317 \$2073 \$4454 \$3536 VPWR VGND \$4641 sg13cmos5l_a21oi_1
* cell instance sg13cmos5l_a21oi_1_318 r0 *1 0,0
Xsg13cmos5l_a21oi_1_318 \$14498 \$12050 \$10608 VPWR VGND \$10609
+ sg13cmos5l_a21oi_1
* cell instance sg13cmos5l_a21oi_1_319 r0 *1 0,0
Xsg13cmos5l_a21oi_1_319 \$2361 \$2482 \$2471 VPWR VGND \$2947 sg13cmos5l_a21oi_1
* cell instance sg13cmos5l_a21oi_1_320 r0 *1 0,0
Xsg13cmos5l_a21oi_1_320 \$2073 \$2618 \$3354 VPWR VGND \$3552 sg13cmos5l_a21oi_1
* cell instance sg13cmos5l_a21oi_1_321 r0 *1 0,0
Xsg13cmos5l_a21oi_1_321 \$2180 \$2625 \$5230 VPWR VGND \$5009 sg13cmos5l_a21oi_1
* cell instance sg13cmos5l_a21oi_1_322 r0 *1 0,0
Xsg13cmos5l_a21oi_1_322 \$2361 \$5868 \$6590 VPWR VGND \$6526 sg13cmos5l_a21oi_1
* cell instance sg13cmos5l_a21oi_1_323 r0 *1 0,0
Xsg13cmos5l_a21oi_1_323 \$2150 \$9026 \$9030 VPWR VGND \$9031 sg13cmos5l_a21oi_1
* cell instance sg13cmos5l_a21oi_1_324 r0 *1 0,0
Xsg13cmos5l_a21oi_1_324 \$5337 \$9026 \$9383 VPWR VGND \$9382 sg13cmos5l_a21oi_1
* cell instance sg13cmos5l_a21oi_1_325 r0 *1 0,0
Xsg13cmos5l_a21oi_1_325 \$9622 \$11903 \$11412 VPWR VGND \$11720
+ sg13cmos5l_a21oi_1
* cell instance sg13cmos5l_a21oi_1_326 r0 *1 0,0
Xsg13cmos5l_a21oi_1_326 \$2150 \$11903 \$12223 VPWR VGND \$12913
+ sg13cmos5l_a21oi_1
* cell instance sg13cmos5l_a21oi_1_327 r0 *1 0,0
Xsg13cmos5l_a21oi_1_327 \$2340 \$2628 \$2482 VPWR VGND \$2341 sg13cmos5l_a21oi_1
* cell instance sg13cmos5l_a21oi_1_328 r0 *1 0,0
Xsg13cmos5l_a21oi_1_328 \$2150 \$13003 \$13480 VPWR VGND \$13398
+ sg13cmos5l_a21oi_1
* cell instance sg13cmos5l_a21oi_1_329 r0 *1 0,0
Xsg13cmos5l_a21oi_1_329 \$9622 \$13476 \$14619 VPWR VGND \$14522
+ sg13cmos5l_a21oi_1
* cell instance sg13cmos5l_a21oi_1_330 r0 *1 0,0
Xsg13cmos5l_a21oi_1_330 \$2308 \$5868 \$7200 VPWR VGND \$7675 sg13cmos5l_a21oi_1
* cell instance sg13cmos5l_a21oi_1_331 r0 *1 0,0
Xsg13cmos5l_a21oi_1_331 \$3188 \$2628 \$2482 VPWR VGND \$3363 sg13cmos5l_a21oi_1
* cell instance sg13cmos5l_a21oi_1_332 r0 *1 0,0
Xsg13cmos5l_a21oi_1_332 \$6520 \$6617 \$5868 VPWR VGND \$7202 sg13cmos5l_a21oi_1
* cell instance sg13cmos5l_a21oi_1_333 r0 *1 0,0
Xsg13cmos5l_a21oi_1_333 \$2361 \$2625 \$5230 VPWR VGND \$6063 sg13cmos5l_a21oi_1
* cell instance sg13cmos5l_a21oi_1_334 r0 *1 0,0
Xsg13cmos5l_a21oi_1_334 \$6599 \$6617 \$5868 VPWR VGND \$6800 sg13cmos5l_a21oi_1
* cell instance sg13cmos5l_a21oi_1_335 r0 *1 0,0
Xsg13cmos5l_a21oi_1_335 \$4839 \$5666 \$2625 VPWR VGND \$5683 sg13cmos5l_a21oi_1
* cell instance sg13cmos5l_a21oi_1_336 r0 *1 0,0
Xsg13cmos5l_a21oi_1_336 \$4638 \$3534 \$2625 VPWR VGND \$4848 sg13cmos5l_a21oi_1
* cell instance sg13cmos5l_a221oi_1_0 r0 *1 0,0
Xsg13cmos5l_a221oi_1_0 \$1 \$1189 \$1306 \$792 \$522 VPWR VGND \$1409
+ sg13cmos5l_a221oi_1
* cell instance sg13cmos5l_a221oi_1_1 r0 *1 0,0
Xsg13cmos5l_a221oi_1_1 \$68 \$2015 \$2021 \$6 \$522 VPWR VGND \$2011
+ sg13cmos5l_a221oi_1
* cell instance sg13cmos5l_a221oi_1_2 r0 *1 0,0
Xsg13cmos5l_a221oi_1_2 \$2700 \$2679 \$2677 \$3388 \$3217 VPWR VGND \$3389
+ sg13cmos5l_a221oi_1
* cell instance sg13cmos5l_a221oi_1_3 r0 *1 0,0
Xsg13cmos5l_a221oi_1_3 \$2678 \$2679 \$2677 \$2673 \$2504 VPWR VGND \$2506
+ sg13cmos5l_a221oi_1
* cell instance sg13cmos5l_a221oi_1_4 r0 *1 0,0
Xsg13cmos5l_a221oi_1_4 \$2818 \$2679 \$2677 \$2960 \$2815 VPWR VGND \$2676
+ sg13cmos5l_a221oi_1
* cell instance sg13cmos5l_a221oi_1_5 r0 *1 0,0
Xsg13cmos5l_a221oi_1_5 \$4874 \$5290 \$5286 \$5479 \$4877 VPWR VGND \$5287
+ sg13cmos5l_a221oi_1
* cell instance sg13cmos5l_a221oi_1_6 r0 *1 0,0
Xsg13cmos5l_a221oi_1_6 \$2386 \$2400 \$2399 \$2389 \$2393 VPWR VGND \$662
+ sg13cmos5l_a221oi_1
* cell instance sg13cmos5l_a221oi_1_7 r0 *1 0,0
Xsg13cmos5l_a221oi_1_7 \$2396 \$2390 \$2402 \$2386 \$2403 VPWR VGND \$419
+ sg13cmos5l_a221oi_1
* cell instance sg13cmos5l_a221oi_1_8 r0 *1 0,0
Xsg13cmos5l_a221oi_1_8 \$2513 \$2514 \$2402 \$2386 \$2403 VPWR VGND \$1058
+ sg13cmos5l_a221oi_1
* cell instance sg13cmos5l_a221oi_1_9 r0 *1 0,0
Xsg13cmos5l_a221oi_1_9 \$1789 \$1667 \$1548 \$294 \$936 VPWR VGND \$1672
+ sg13cmos5l_a221oi_1
* cell instance sg13cmos5l_a221oi_1_10 r0 *1 0,0
Xsg13cmos5l_a221oi_1_10 \$1789 \$1667 \$1888 \$1887 \$936 VPWR VGND \$1885
+ sg13cmos5l_a221oi_1
* cell instance sg13cmos5l_a221oi_1_11 r0 *1 0,0
Xsg13cmos5l_a221oi_1_11 \$6920 \$3758 \$5745 \$6482 \$5500 VPWR VGND \$6480
+ sg13cmos5l_a221oi_1
* cell instance sg13cmos5l_a221oi_1_12 r0 *1 0,0
Xsg13cmos5l_a221oi_1_12 \$806 \$937 \$805 \$1173 \$936 VPWR VGND \$270
+ sg13cmos5l_a221oi_1
* cell instance sg13cmos5l_a221oi_1_13 r0 *1 0,0
Xsg13cmos5l_a221oi_1_13 \$3399 \$3229 \$3406 \$3402 \$3405 VPWR VGND \$3404
+ sg13cmos5l_a221oi_1
* cell instance sg13cmos5l_a221oi_1_14 r0 *1 0,0
Xsg13cmos5l_a221oi_1_14 \$1412 \$1794 \$1670 \$1792 \$1676 VPWR VGND \$1790
+ sg13cmos5l_a221oi_1
* cell instance sg13cmos5l_a221oi_1_15 r0 *1 0,0
Xsg13cmos5l_a221oi_1_15 \$265 \$270 \$269 \$267 \$651 VPWR VGND \$382
+ sg13cmos5l_a221oi_1
* cell instance sg13cmos5l_a221oi_1_16 r0 *1 0,0
Xsg13cmos5l_a221oi_1_16 \$6569 \$3758 \$5099 \$5687 \$5517 VPWR VGND \$4915
+ sg13cmos5l_a221oi_1
* cell instance sg13cmos5l_a221oi_1_17 r0 *1 0,0
Xsg13cmos5l_a221oi_1_17 \$406 \$260 \$806 \$659 \$650 VPWR VGND \$269
+ sg13cmos5l_a221oi_1
* cell instance sg13cmos5l_a221oi_1_18 r0 *1 0,0
Xsg13cmos5l_a221oi_1_18 \$2694 \$3229 \$3406 \$2832 \$3028 VPWR VGND \$2829
+ sg13cmos5l_a221oi_1
* cell instance sg13cmos5l_a221oi_1_19 r0 *1 0,0
Xsg13cmos5l_a221oi_1_19 \$2308 \$2679 \$2677 \$2832 \$2828 VPWR VGND \$2830
+ sg13cmos5l_a221oi_1
* cell instance sg13cmos5l_a221oi_1_20 r0 *1 0,0
Xsg13cmos5l_a221oi_1_20 \$6496 \$5692 \$5305 \$6930 \$8151 VPWR VGND \$5520
+ sg13cmos5l_a221oi_1
* cell instance sg13cmos5l_a221oi_1_21 r0 *1 0,0
Xsg13cmos5l_a221oi_1_21 \$9331 \$5701 \$5305 \$5513 \$4908 VPWR VGND \$5265
+ sg13cmos5l_a221oi_1
* cell instance sg13cmos5l_a221oi_1_22 r0 *1 0,0
Xsg13cmos5l_a221oi_1_22 \$1336 \$1795 \$1683 \$267 \$1318 VPWR VGND \$1796
+ sg13cmos5l_a221oi_1
* cell instance sg13cmos5l_a221oi_1_23 r0 *1 0,0
Xsg13cmos5l_a221oi_1_23 \$2217 \$4911 \$5305 \$7491 \$6090 VPWR VGND \$5944
+ sg13cmos5l_a221oi_1
* cell instance sg13cmos5l_a221oi_1_24 r0 *1 0,0
Xsg13cmos5l_a221oi_1_24 \$9046 \$5745 \$4911 \$4734 \$5742 VPWR VGND \$5741
+ sg13cmos5l_a221oi_1
* cell instance sg13cmos5l_a221oi_1_25 r0 *1 0,0
Xsg13cmos5l_a221oi_1_25 \$1326 \$1188 \$1323 \$1321 \$91 VPWR VGND \$1414
+ sg13cmos5l_a221oi_1
* cell instance sg13cmos5l_a221oi_1_26 r0 *1 0,0
Xsg13cmos5l_a221oi_1_26 \$5310 \$5692 \$5305 \$5307 \$5097 VPWR VGND \$4725
+ sg13cmos5l_a221oi_1
* cell instance sg13cmos5l_a221oi_1_27 r0 *1 0,0
Xsg13cmos5l_a221oi_1_27 \$2892 \$4911 \$5305 \$6094 \$5952 VPWR VGND \$6089
+ sg13cmos5l_a221oi_1
* cell instance sg13cmos5l_a221oi_1_28 r0 *1 0,0
Xsg13cmos5l_a221oi_1_28 \$251 \$75 \$81 \$267 \$85 VPWR VGND \$84
+ sg13cmos5l_a221oi_1
* cell instance sg13cmos5l_a221oi_1_29 r0 *1 0,0
Xsg13cmos5l_a221oi_1_29 \$24 \$20 \$3 \$657 \$533 VPWR VGND \$534
+ sg13cmos5l_a221oi_1
* cell instance sg13cmos5l_a221oi_1_30 r0 *1 0,0
Xsg13cmos5l_a221oi_1_30 \$657 \$3 \$1058 \$1073 \$533 VPWR VGND \$1071
+ sg13cmos5l_a221oi_1
* cell instance sg13cmos5l_a221oi_1_31 r0 *1 0,0
Xsg13cmos5l_a221oi_1_31 \$2248 \$539 \$937 \$283 \$1892 VPWR VGND \$1900
+ sg13cmos5l_a221oi_1
* cell instance sg13cmos5l_a221oi_1_32 r0 *1 0,0
Xsg13cmos5l_a221oi_1_32 \$561 \$1907 \$1686 \$937 \$290 VPWR VGND \$2261
+ sg13cmos5l_a221oi_1
* cell instance sg13cmos5l_a221oi_1_33 r0 *1 0,0
Xsg13cmos5l_a221oi_1_33 \$19890 \$4405 \$5469 \$20151 \$4560 VPWR VGND \$5769
+ sg13cmos5l_a221oi_1
* cell instance sg13cmos5l_a221oi_1_34 r0 *1 0,0
Xsg13cmos5l_a221oi_1_34 \$1076 \$1332 \$1338 \$1336 \$1318 VPWR VGND \$815
+ sg13cmos5l_a221oi_1
* cell instance sg13cmos5l_a221oi_1_35 r0 *1 0,0
Xsg13cmos5l_a221oi_1_35 \$5300 \$5099 \$5264 \$4594 \$5548 VPWR VGND \$5547
+ sg13cmos5l_a221oi_1
* cell instance sg13cmos5l_a221oi_1_36 r0 *1 0,0
Xsg13cmos5l_a221oi_1_36 \$24 \$1186 \$1052 \$1695 \$285 VPWR VGND \$946
+ sg13cmos5l_a221oi_1
* cell instance sg13cmos5l_a221oi_1_37 r0 *1 0,0
Xsg13cmos5l_a221oi_1_37 \$1336 \$2269 \$1080 \$274 \$2424 VPWR VGND \$2423
+ sg13cmos5l_a221oi_1
* cell instance sg13cmos5l_a221oi_1_38 r0 *1 0,0
Xsg13cmos5l_a221oi_1_38 \$52 \$128 \$1306 \$176 \$93 VPWR VGND \$950
+ sg13cmos5l_a221oi_1
* cell instance sg13cmos5l_a221oi_1_39 r0 *1 0,0
Xsg13cmos5l_a221oi_1_39 \$2554 \$1912 \$963 \$1430 \$936 VPWR VGND \$1696
+ sg13cmos5l_a221oi_1
* cell instance sg13cmos5l_a221oi_1_40 r0 *1 0,0
Xsg13cmos5l_a221oi_1_40 \$823 \$106 \$545 \$2554 \$669 VPWR VGND \$820
+ sg13cmos5l_a221oi_1
* cell instance sg13cmos5l_a221oi_1_41 r0 *1 0,0
Xsg13cmos5l_a221oi_1_41 \$1879 \$1200 \$1195 \$1088 \$959 VPWR VGND \$1203
+ sg13cmos5l_a221oi_1
* cell instance sg13cmos5l_a221oi_1_42 r0 *1 0,0
Xsg13cmos5l_a221oi_1_42 \$1879 \$2042 \$1903 \$1336 \$819 VPWR VGND \$2039
+ sg13cmos5l_a221oi_1
* cell instance sg13cmos5l_a221oi_1_43 r0 *1 0,0
Xsg13cmos5l_a221oi_1_43 \$108 \$438 \$261 \$112 \$110 VPWR VGND \$109
+ sg13cmos5l_a221oi_1
* cell instance sg13cmos5l_a221oi_1_44 r0 *1 0,0
Xsg13cmos5l_a221oi_1_44 \$2556 \$1344 \$132 \$52 \$2722 VPWR VGND \$2561
+ sg13cmos5l_a221oi_1
* cell instance sg13cmos5l_a221oi_1_45 r0 *1 0,0
Xsg13cmos5l_a221oi_1_45 \$1196 \$823 \$1915 \$1811 \$171 VPWR VGND \$1916
+ sg13cmos5l_a221oi_1
* cell instance sg13cmos5l_a221oi_1_46 r0 *1 0,0
Xsg13cmos5l_a221oi_1_46 \$671 \$553 \$544 \$551 \$674 VPWR VGND \$549
+ sg13cmos5l_a221oi_1
* cell instance sg13cmos5l_a221oi_1_47 r0 *1 0,0
Xsg13cmos5l_a221oi_1_47 \$648 \$958 \$1568 \$1566 \$959 VPWR VGND \$1653
+ sg13cmos5l_a221oi_1
* cell instance sg13cmos5l_a221oi_1_48 r0 *1 0,0
Xsg13cmos5l_a221oi_1_48 \$551 \$675 \$671 \$553 \$674 VPWR VGND \$673
+ sg13cmos5l_a221oi_1
* cell instance sg13cmos5l_a221oi_1_49 r0 *1 0,0
Xsg13cmos5l_a221oi_1_49 \$78 \$125 \$27 \$289 \$121 VPWR VGND \$122
+ sg13cmos5l_a221oi_1
* cell instance sg13cmos5l_a221oi_1_50 r0 *1 0,0
Xsg13cmos5l_a221oi_1_50 \$180 \$300 \$297 \$252 \$674 VPWR VGND \$388
+ sg13cmos5l_a221oi_1
* cell instance sg13cmos5l_a221oi_1_51 r0 *1 0,0
Xsg13cmos5l_a221oi_1_51 \$431 \$529 \$679 \$682 \$681 VPWR VGND \$680
+ sg13cmos5l_a221oi_1
* cell instance sg13cmos5l_a221oi_1_52 r0 *1 0,0
Xsg13cmos5l_a221oi_1_52 \$180 \$300 \$291 \$252 \$674 VPWR VGND \$253
+ sg13cmos5l_a221oi_1
* cell instance sg13cmos5l_a221oi_1_53 r0 *1 0,0
Xsg13cmos5l_a221oi_1_53 \$1092 \$176 \$1095 \$1099 \$669 VPWR VGND \$1097
+ sg13cmos5l_a221oi_1
* cell instance sg13cmos5l_a221oi_1_54 r0 *1 0,0
Xsg13cmos5l_a221oi_1_54 \$1336 \$2046 \$1704 \$1924 \$819 VPWR VGND \$2043
+ sg13cmos5l_a221oi_1
* cell instance sg13cmos5l_a221oi_1_55 r0 *1 0,0
Xsg13cmos5l_a221oi_1_55 \$969 \$1582 \$1096 \$1548 \$669 VPWR VGND \$1579
+ sg13cmos5l_a221oi_1
* cell instance sg13cmos5l_a221oi_1_56 r0 *1 0,0
Xsg13cmos5l_a221oi_1_56 \$48 \$283 \$307 \$38 \$93 VPWR VGND \$311
+ sg13cmos5l_a221oi_1
* cell instance sg13cmos5l_a221oi_1_57 r0 *1 0,0
Xsg13cmos5l_a221oi_1_57 \$833 \$134 \$672 \$283 \$4 VPWR VGND \$834
+ sg13cmos5l_a221oi_1
* cell instance sg13cmos5l_a221oi_1_58 r0 *1 0,0
Xsg13cmos5l_a221oi_1_58 \$2056 \$1424 \$2053 \$1730 \$973 VPWR VGND \$2052
+ sg13cmos5l_a221oi_1
* cell instance sg13cmos5l_a221oi_1_59 r0 *1 0,0
Xsg13cmos5l_a221oi_1_59 \$1471 \$1355 \$1459 \$1469 \$1424 VPWR VGND \$1467
+ sg13cmos5l_a221oi_1
* cell instance sg13cmos5l_a221oi_1_60 r0 *1 0,0
Xsg13cmos5l_a221oi_1_60 \$1817 \$1424 \$1720 \$1722 \$973 VPWR VGND \$1721
+ sg13cmos5l_a221oi_1
* cell instance sg13cmos5l_a221oi_1_61 r0 *1 0,0
Xsg13cmos5l_a221oi_1_61 \$4052 \$3801 \$3800 \$3985 \$3982 VPWR VGND \$4057
+ sg13cmos5l_a221oi_1
* cell instance sg13cmos5l_a221oi_1_62 r0 *1 0,0
Xsg13cmos5l_a221oi_1_62 \$1477 \$1459 \$1242 \$1361 \$1424 VPWR VGND \$1474
+ sg13cmos5l_a221oi_1
* cell instance sg13cmos5l_a221oi_1_63 r0 *1 0,0
Xsg13cmos5l_a221oi_1_63 \$3048 \$1424 \$1425 \$1590 \$973 VPWR VGND \$1480
+ sg13cmos5l_a221oi_1
* cell instance sg13cmos5l_a221oi_1_64 r0 *1 0,0
Xsg13cmos5l_a221oi_1_64 \$1365 \$1237 \$1235 \$1230 \$1362 VPWR VGND \$1425
+ sg13cmos5l_a221oi_1
* cell instance sg13cmos5l_a221oi_1_65 r0 *1 0,0
Xsg13cmos5l_a221oi_1_65 \$577 \$985 \$919 \$850 \$858 VPWR VGND \$348
+ sg13cmos5l_a221oi_1
* cell instance sg13cmos5l_a221oi_1_66 r0 *1 0,0
Xsg13cmos5l_a221oi_1_66 \$986 \$985 \$983 \$850 \$858 VPWR VGND \$199
+ sg13cmos5l_a221oi_1
* cell instance sg13cmos5l_a221oi_1_67 r0 *1 0,0
Xsg13cmos5l_a221oi_1_67 \$1824 \$1725 \$1735 \$1724 \$1732 VPWR VGND \$1730
+ sg13cmos5l_a221oi_1
* cell instance sg13cmos5l_a221oi_1_68 r0 *1 0,0
Xsg13cmos5l_a221oi_1_68 \$1724 \$2916 \$2761 \$1824 \$2770 VPWR VGND \$2982
+ sg13cmos5l_a221oi_1
* cell instance sg13cmos5l_a221oi_1_69 r0 *1 0,0
Xsg13cmos5l_a221oi_1_69 \$1477 \$1355 \$1361 \$921 \$1827 VPWR VGND \$1828
+ sg13cmos5l_a221oi_1
* cell instance sg13cmos5l_a221oi_1_70 r0 *1 0,0
Xsg13cmos5l_a221oi_1_70 \$2180 \$1355 \$1459 \$1838 \$2176 VPWR VGND \$2177
+ sg13cmos5l_a221oi_1
* cell instance sg13cmos5l_a221oi_1_71 r0 *1 0,0
Xsg13cmos5l_a221oi_1_71 \$2180 \$1459 \$1001 \$2585 \$2159 VPWR VGND \$2450
+ sg13cmos5l_a221oi_1
* cell instance sg13cmos5l_a221oi_1_72 r0 *1 0,0
Xsg13cmos5l_a221oi_1_72 \$242 \$989 \$870 \$399 \$739 VPWR VGND \$879
+ sg13cmos5l_a221oi_1
* cell instance sg13cmos5l_a221oi_1_73 r0 *1 0,0
Xsg13cmos5l_a221oi_1_73 \$4465 \$4166 \$4631 \$4022 \$3868 VPWR VGND \$4169
+ sg13cmos5l_a221oi_1
* cell instance sg13cmos5l_a221oi_1_74 r0 *1 0,0
Xsg13cmos5l_a221oi_1_74 \$4465 \$4153 \$4492 \$3869 \$4618 VPWR VGND \$4344
+ sg13cmos5l_a221oi_1
* cell instance sg13cmos5l_a221oi_1_75 r0 *1 0,0
Xsg13cmos5l_a221oi_1_75 \$4311 \$4169 \$4634 \$4344 \$4306 VPWR VGND \$4159
+ sg13cmos5l_a221oi_1
* cell instance sg13cmos5l_a22oi_1_0 r0 *1 0,0
Xsg13cmos5l_a22oi_1_0 \$4199 \$3739 \$4201 \$3914 VPWR VGND \$4192
+ sg13cmos5l_a22oi_1
* cell instance sg13cmos5l_a22oi_1_1 r0 *1 0,0
Xsg13cmos5l_a22oi_1_1 \$4320 \$4483 \$4362 \$3914 VPWR VGND \$4495
+ sg13cmos5l_a22oi_1
* cell instance sg13cmos5l_a22oi_1_2 r0 *1 0,0
Xsg13cmos5l_a22oi_1_2 \$3914 \$4085 \$3912 \$3918 VPWR VGND \$3902
+ sg13cmos5l_a22oi_1
* cell instance sg13cmos5l_a22oi_1_3 r0 *1 0,0
Xsg13cmos5l_a22oi_1_3 \$4507 \$4483 \$4368 \$3914 VPWR VGND \$4509
+ sg13cmos5l_a22oi_1
* cell instance sg13cmos5l_a22oi_1_4 r0 *1 0,0
Xsg13cmos5l_a22oi_1_4 \$261 \$1309 \$1181 \$6 VPWR VGND \$1302
+ sg13cmos5l_a22oi_1
* cell instance sg13cmos5l_a22oi_1_5 r0 *1 0,0
Xsg13cmos5l_a22oi_1_5 \$2396 \$2390 \$2399 \$2389 VPWR VGND \$2017
+ sg13cmos5l_a22oi_1
* cell instance sg13cmos5l_a22oi_1_6 r0 *1 0,0
Xsg13cmos5l_a22oi_1_6 \$8790 \$8492 \$8774 \$6477 VPWR VGND \$8495
+ sg13cmos5l_a22oi_1
* cell instance sg13cmos5l_a22oi_1_7 r0 *1 0,0
Xsg13cmos5l_a22oi_1_7 \$2643 \$4092 \$4088 \$4087 VPWR VGND \$4361
+ sg13cmos5l_a22oi_1
* cell instance sg13cmos5l_a22oi_1_8 r0 *1 0,0
Xsg13cmos5l_a22oi_1_8 \$4087 \$4373 \$4092 \$3009 VPWR VGND \$4372
+ sg13cmos5l_a22oi_1
* cell instance sg13cmos5l_a22oi_1_9 r0 *1 0,0
Xsg13cmos5l_a22oi_1_9 \$930 \$1314 \$1060 \$1313 VPWR VGND \$1312
+ sg13cmos5l_a22oi_1
* cell instance sg13cmos5l_a22oi_1_10 r0 *1 0,0
Xsg13cmos5l_a22oi_1_10 \$1 \$414 \$412 \$413 VPWR VGND \$76 sg13cmos5l_a22oi_1
* cell instance sg13cmos5l_a22oi_1_11 r0 *1 0,0
Xsg13cmos5l_a22oi_1_11 \$6477 \$9307 \$7913 \$8775 VPWR VGND \$8791
+ sg13cmos5l_a22oi_1
* cell instance sg13cmos5l_a22oi_1_12 r0 *1 0,0
Xsg13cmos5l_a22oi_1_12 \$8411 \$5745 \$5701 \$9283 VPWR VGND \$5096
+ sg13cmos5l_a22oi_1
* cell instance sg13cmos5l_a22oi_1_13 r0 *1 0,0
Xsg13cmos5l_a22oi_1_13 \$7812 \$3758 \$5701 \$8007 VPWR VGND \$5515
+ sg13cmos5l_a22oi_1
* cell instance sg13cmos5l_a22oi_1_14 r0 *1 0,0
Xsg13cmos5l_a22oi_1_14 \$8142 \$4398 \$5745 \$9042 VPWR VGND \$6402
+ sg13cmos5l_a22oi_1
* cell instance sg13cmos5l_a22oi_1_15 r0 *1 0,0
Xsg13cmos5l_a22oi_1_15 \$8018 \$3758 \$5745 \$8431 VPWR VGND \$5542
+ sg13cmos5l_a22oi_1
* cell instance sg13cmos5l_a22oi_1_16 r0 *1 0,0
Xsg13cmos5l_a22oi_1_16 \$7705 \$3758 \$5701 \$8531 VPWR VGND \$7096
+ sg13cmos5l_a22oi_1
* cell instance sg13cmos5l_a22oi_1_17 r0 *1 0,0
Xsg13cmos5l_a22oi_1_17 \$18 \$3 \$2 \$43 VPWR VGND \$19 sg13cmos5l_a22oi_1
* cell instance sg13cmos5l_a22oi_1_18 r0 *1 0,0
Xsg13cmos5l_a22oi_1_18 \$5903 \$5099 \$5264 \$3471 VPWR VGND \$5925
+ sg13cmos5l_a22oi_1
* cell instance sg13cmos5l_a22oi_1_19 r0 *1 0,0
Xsg13cmos5l_a22oi_1_19 \$4087 \$4209 \$4222 \$4092 VPWR VGND \$4212
+ sg13cmos5l_a22oi_1
* cell instance sg13cmos5l_a22oi_1_20 r0 *1 0,0
Xsg13cmos5l_a22oi_1_20 \$5728 \$4903 \$5074 \$4894 VPWR VGND \$5073
+ sg13cmos5l_a22oi_1
* cell instance sg13cmos5l_a22oi_1_21 r0 *1 0,0
Xsg13cmos5l_a22oi_1_21 \$20 \$163 \$161 \$7 VPWR VGND \$74 sg13cmos5l_a22oi_1
* cell instance sg13cmos5l_a22oi_1_22 r0 *1 0,0
Xsg13cmos5l_a22oi_1_22 \$526 \$163 \$528 \$524 VPWR VGND \$529
+ sg13cmos5l_a22oi_1
* cell instance sg13cmos5l_a22oi_1_23 r0 *1 0,0
Xsg13cmos5l_a22oi_1_23 \$5926 \$4398 \$5264 \$4586 VPWR VGND \$5928
+ sg13cmos5l_a22oi_1
* cell instance sg13cmos5l_a22oi_1_24 r0 *1 0,0
Xsg13cmos5l_a22oi_1_24 \$11700 \$5701 \$5305 \$8008 VPWR VGND \$5546
+ sg13cmos5l_a22oi_1
* cell instance sg13cmos5l_a22oi_1_25 r0 *1 0,0
Xsg13cmos5l_a22oi_1_25 \$8218 \$5701 \$5305 \$8219 VPWR VGND \$5929
+ sg13cmos5l_a22oi_1
* cell instance sg13cmos5l_a22oi_1_26 r0 *1 0,0
Xsg13cmos5l_a22oi_1_26 \$6397 \$5701 \$5264 \$5158 VPWR VGND \$6399
+ sg13cmos5l_a22oi_1
* cell instance sg13cmos5l_a22oi_1_27 r0 *1 0,0
Xsg13cmos5l_a22oi_1_27 \$796 \$1173 \$806 \$413 VPWR VGND \$1185
+ sg13cmos5l_a22oi_1
* cell instance sg13cmos5l_a22oi_1_28 r0 *1 0,0
Xsg13cmos5l_a22oi_1_28 \$4902 \$4871 \$4905 \$4901 VPWR VGND \$5076
+ sg13cmos5l_a22oi_1
* cell instance sg13cmos5l_a22oi_1_29 r0 *1 0,0
Xsg13cmos5l_a22oi_1_29 \$7814 \$7913 \$8880 \$6477 VPWR VGND \$7815
+ sg13cmos5l_a22oi_1
* cell instance sg13cmos5l_a22oi_1_30 r0 *1 0,0
Xsg13cmos5l_a22oi_1_30 \$3396 \$4092 \$4216 \$3930 VPWR VGND \$4095
+ sg13cmos5l_a22oi_1
* cell instance sg13cmos5l_a22oi_1_31 r0 *1 0,0
Xsg13cmos5l_a22oi_1_31 \$5297 \$5099 \$5264 \$4247 VPWR VGND \$5303
+ sg13cmos5l_a22oi_1
* cell instance sg13cmos5l_a22oi_1_32 r0 *1 0,0
Xsg13cmos5l_a22oi_1_32 \$2529 \$3229 \$3406 \$3412 VPWR VGND \$3414
+ sg13cmos5l_a22oi_1
* cell instance sg13cmos5l_a22oi_1_33 r0 *1 0,0
Xsg13cmos5l_a22oi_1_33 \$5738 \$5701 \$5264 \$3289 VPWR VGND \$5740
+ sg13cmos5l_a22oi_1
* cell instance sg13cmos5l_a22oi_1_34 r0 *1 0,0
Xsg13cmos5l_a22oi_1_34 \$3419 \$3414 \$3417 \$3930 VPWR VGND \$3232
+ sg13cmos5l_a22oi_1
* cell instance sg13cmos5l_a22oi_1_35 r0 *1 0,0
Xsg13cmos5l_a22oi_1_35 \$4719 \$3758 \$5264 \$4558 VPWR VGND \$4726
+ sg13cmos5l_a22oi_1
* cell instance sg13cmos5l_a22oi_1_36 r0 *1 0,0
Xsg13cmos5l_a22oi_1_36 \$4896 \$5099 \$4911 \$4914 VPWR VGND \$4913
+ sg13cmos5l_a22oi_1
* cell instance sg13cmos5l_a22oi_1_37 r0 *1 0,0
Xsg13cmos5l_a22oi_1_37 \$1671 \$20 \$1686 \$1189 VPWR VGND \$1685
+ sg13cmos5l_a22oi_1
* cell instance sg13cmos5l_a22oi_1_38 r0 *1 0,0
Xsg13cmos5l_a22oi_1_38 \$24 \$20 \$3 \$44 VPWR VGND \$25 sg13cmos5l_a22oi_1
* cell instance sg13cmos5l_a22oi_1_39 r0 *1 0,0
Xsg13cmos5l_a22oi_1_39 \$651 \$2542 \$2423 \$1417 VPWR VGND \$2546
+ sg13cmos5l_a22oi_1
* cell instance sg13cmos5l_a22oi_1_40 r0 *1 0,0
Xsg13cmos5l_a22oi_1_40 \$796 \$1173 \$1189 \$260 VPWR VGND \$1331
+ sg13cmos5l_a22oi_1
* cell instance sg13cmos5l_a22oi_1_41 r0 *1 0,0
Xsg13cmos5l_a22oi_1_41 \$1171 \$1196 \$1546 \$1330 VPWR VGND \$1903
+ sg13cmos5l_a22oi_1
* cell instance sg13cmos5l_a22oi_1_42 r0 *1 0,0
Xsg13cmos5l_a22oi_1_42 \$1666 \$1548 \$1537 \$1559 VPWR VGND \$1338
+ sg13cmos5l_a22oi_1
* cell instance sg13cmos5l_a22oi_1_43 r0 *1 0,0
Xsg13cmos5l_a22oi_1_43 \$18 \$3 \$27 \$2 VPWR VGND \$28 sg13cmos5l_a22oi_1
* cell instance sg13cmos5l_a22oi_1_44 r0 *1 0,0
Xsg13cmos5l_a22oi_1_44 \$4940 \$4911 \$5264 \$4116 VPWR VGND \$4486
+ sg13cmos5l_a22oi_1
* cell instance sg13cmos5l_a22oi_1_45 r0 *1 0,0
Xsg13cmos5l_a22oi_1_45 \$3052 \$3236 \$3255 \$3373 VPWR VGND \$3256
+ sg13cmos5l_a22oi_1
* cell instance sg13cmos5l_a22oi_1_46 r0 *1 0,0
Xsg13cmos5l_a22oi_1_46 \$426 \$541 \$427 \$428 VPWR VGND \$425
+ sg13cmos5l_a22oi_1
* cell instance sg13cmos5l_a22oi_1_47 r0 *1 0,0
Xsg13cmos5l_a22oi_1_47 \$1194 \$1073 \$1189 \$102 VPWR VGND \$1443
+ sg13cmos5l_a22oi_1
* cell instance sg13cmos5l_a22oi_1_48 r0 *1 0,0
Xsg13cmos5l_a22oi_1_48 \$16693 \$3615 \$5469 \$20254 VPWR VGND \$6545
+ sg13cmos5l_a22oi_1
* cell instance sg13cmos5l_a22oi_1_49 r0 *1 0,0
Xsg13cmos5l_a22oi_1_49 \$1453 \$105 \$798 \$69 VPWR VGND \$1807
+ sg13cmos5l_a22oi_1
* cell instance sg13cmos5l_a22oi_1_50 r0 *1 0,0
Xsg13cmos5l_a22oi_1_50 \$6 \$2133 \$2132 \$426 VPWR VGND \$2131
+ sg13cmos5l_a22oi_1
* cell instance sg13cmos5l_a22oi_1_51 r0 *1 0,0
Xsg13cmos5l_a22oi_1_51 \$11 \$1065 \$1430 \$1082 VPWR VGND \$1085
+ sg13cmos5l_a22oi_1
* cell instance sg13cmos5l_a22oi_1_52 r0 *1 0,0
Xsg13cmos5l_a22oi_1_52 \$12730 \$4405 \$5469 \$20177 VPWR VGND \$4614
+ sg13cmos5l_a22oi_1
* cell instance sg13cmos5l_a22oi_1_53 r0 *1 0,0
Xsg13cmos5l_a22oi_1_53 \$2308 \$4562 \$3954 \$4114 VPWR VGND \$4113
+ sg13cmos5l_a22oi_1
* cell instance sg13cmos5l_a22oi_1_54 r0 *1 0,0
Xsg13cmos5l_a22oi_1_54 \$1700 \$1652 \$1564 \$1203 VPWR VGND \$1565
+ sg13cmos5l_a22oi_1
* cell instance sg13cmos5l_a22oi_1_55 r0 *1 0,0
Xsg13cmos5l_a22oi_1_55 \$104 \$125 \$1052 \$283 VPWR VGND \$297
+ sg13cmos5l_a22oi_1
* cell instance sg13cmos5l_a22oi_1_56 r0 *1 0,0
Xsg13cmos5l_a22oi_1_56 \$1356 \$3641 \$4248 \$3959 VPWR VGND \$3797
+ sg13cmos5l_a22oi_1
* cell instance sg13cmos5l_a22oi_1_57 r0 *1 0,0
Xsg13cmos5l_a22oi_1_57 \$2275 \$2273 \$2140 \$2043 VPWR VGND \$2277
+ sg13cmos5l_a22oi_1
* cell instance sg13cmos5l_a22oi_1_58 r0 *1 0,0
Xsg13cmos5l_a22oi_1_58 \$827 \$968 \$831 \$969 VPWR VGND \$184
+ sg13cmos5l_a22oi_1
* cell instance sg13cmos5l_a22oi_1_59 r0 *1 0,0
Xsg13cmos5l_a22oi_1_59 \$450 \$8 \$390 \$959 VPWR VGND \$690 sg13cmos5l_a22oi_1
* cell instance sg13cmos5l_a22oi_1_60 r0 *1 0,0
Xsg13cmos5l_a22oi_1_60 \$1724 \$2064 \$1934 \$1824 VPWR VGND \$2059
+ sg13cmos5l_a22oi_1
* cell instance sg13cmos5l_a22oi_1_61 r0 *1 0,0
Xsg13cmos5l_a22oi_1_61 \$1824 \$1588 \$1595 \$1724 VPWR VGND \$1722
+ sg13cmos5l_a22oi_1
* cell instance sg13cmos5l_a22oi_1_62 r0 *1 0,0
Xsg13cmos5l_a22oi_1_62 \$1361 \$1008 \$1933 \$1365 VPWR VGND \$1935
+ sg13cmos5l_a22oi_1
* cell instance sg13cmos5l_a22oi_1_63 r0 *1 0,0
Xsg13cmos5l_a22oi_1_63 \$5039 \$5216 \$4130 \$4287 VPWR VGND \$5214
+ sg13cmos5l_a22oi_1
* cell instance sg13cmos5l_a22oi_1_64 r0 *1 0,0
Xsg13cmos5l_a22oi_1_64 \$2654 \$3499 \$3318 \$3495 VPWR VGND \$3498
+ sg13cmos5l_a22oi_1
* cell instance sg13cmos5l_a22oi_1_65 r0 *1 0,0
Xsg13cmos5l_a22oi_1_65 \$3715 \$4000 \$3999 \$4134 VPWR VGND \$3991
+ sg13cmos5l_a22oi_1
* cell instance sg13cmos5l_a22oi_1_66 r0 *1 0,0
Xsg13cmos5l_a22oi_1_66 \$2361 \$1459 \$1964 \$1361 VPWR VGND \$2601
+ sg13cmos5l_a22oi_1
* cell instance sg13cmos5l_a22oi_1_67 r0 *1 0,0
Xsg13cmos5l_a22oi_1_67 \$2654 \$3148 \$3146 \$3144 VPWR VGND \$3147
+ sg13cmos5l_a22oi_1
* cell instance sg13cmos5l_a22oi_1_68 r0 *1 0,0
Xsg13cmos5l_a22oi_1_68 \$5891 \$4149 \$6036 \$6037 VPWR VGND \$6024
+ sg13cmos5l_a22oi_1
* cell instance sg13cmos5l_a22oi_1_69 r0 *1 0,0
Xsg13cmos5l_a22oi_1_69 \$3715 \$3654 \$3663 \$3667 VPWR VGND \$3666
+ sg13cmos5l_a22oi_1
* cell instance sg13cmos5l_a22oi_1_70 r0 *1 0,0
Xsg13cmos5l_a22oi_1_70 \$486 \$989 \$870 \$483 VPWR VGND \$875
+ sg13cmos5l_a22oi_1
* cell instance sg13cmos5l_a22oi_1_71 r0 *1 0,0
Xsg13cmos5l_a22oi_1_71 \$2654 \$2922 \$2920 \$2806 VPWR VGND \$2921
+ sg13cmos5l_a22oi_1
* cell instance sg13cmos5l_a22oi_1_72 r0 *1 0,0
Xsg13cmos5l_a22oi_1_72 \$3499 \$4009 \$5039 \$4455 VPWR VGND \$4295
+ sg13cmos5l_a22oi_1
* cell instance sg13cmos5l_a22oi_1_73 r0 *1 0,0
Xsg13cmos5l_a22oi_1_73 \$7190 \$6513 \$7191 \$7527 VPWR VGND \$7528
+ sg13cmos5l_a22oi_1
* cell instance sg13cmos5l_a22oi_1_74 r0 *1 0,0
Xsg13cmos5l_a22oi_1_74 \$3895 \$4009 \$4007 \$3336 VPWR VGND \$4008
+ sg13cmos5l_a22oi_1
* cell instance sg13cmos5l_a22oi_1_75 r0 *1 0,0
Xsg13cmos5l_a22oi_1_75 \$5891 \$4455 \$5843 \$5659 VPWR VGND \$5845
+ sg13cmos5l_a22oi_1
* cell instance sg13cmos5l_a22oi_1_76 r0 *1 0,0
Xsg13cmos5l_a22oi_1_76 \$1361 \$1245 \$1459 \$1496 VPWR VGND \$1503
+ sg13cmos5l_a22oi_1
* cell instance sg13cmos5l_a22oi_1_77 r0 *1 0,0
Xsg13cmos5l_a22oi_1_77 \$5891 \$6512 \$6851 \$6580 VPWR VGND \$6777
+ sg13cmos5l_a22oi_1
* cell instance sg13cmos5l_a22oi_1_78 r0 *1 0,0
Xsg13cmos5l_a22oi_1_78 \$8237 \$7957 \$5039 \$8222 VPWR VGND \$8194
+ sg13cmos5l_a22oi_1
* cell instance sg13cmos5l_a22oi_1_79 r0 *1 0,0
Xsg13cmos5l_a22oi_1_79 \$4000 \$4009 \$5039 \$5427 VPWR VGND \$5224
+ sg13cmos5l_a22oi_1
* cell instance sg13cmos5l_a22oi_1_80 r0 *1 0,0
Xsg13cmos5l_a22oi_1_80 \$8223 \$4304 \$4011 \$8224 VPWR VGND \$8196
+ sg13cmos5l_a22oi_1
* cell instance sg13cmos5l_a22oi_1_81 r0 *1 0,0
Xsg13cmos5l_a22oi_1_81 \$8799 \$7957 \$5039 \$8800 VPWR VGND \$8798
+ sg13cmos5l_a22oi_1
* cell instance sg13cmos5l_a22oi_1_82 r0 *1 0,0
Xsg13cmos5l_a22oi_1_82 \$3715 \$3859 \$3850 \$3672 VPWR VGND \$3851
+ sg13cmos5l_a22oi_1
* cell instance sg13cmos5l_a22oi_1_83 r0 *1 0,0
Xsg13cmos5l_a22oi_1_83 \$3865 \$6582 \$5700 \$6581 VPWR VGND \$6613
+ sg13cmos5l_a22oi_1
* cell instance sg13cmos5l_a22oi_1_84 r0 *1 0,0
Xsg13cmos5l_a22oi_1_84 \$2654 \$2609 \$2608 \$2604 VPWR VGND \$2454
+ sg13cmos5l_a22oi_1
* cell instance sg13cmos5l_a22oi_1_85 r0 *1 0,0
Xsg13cmos5l_a22oi_1_85 \$5891 \$6303 \$6423 \$6299 VPWR VGND \$6302
+ sg13cmos5l_a22oi_1
* cell instance sg13cmos5l_a22oi_1_86 r0 *1 0,0
Xsg13cmos5l_a22oi_1_86 \$8802 \$7957 \$8781 \$8803 VPWR VGND \$8505
+ sg13cmos5l_a22oi_1
* cell instance sg13cmos5l_a22oi_1_87 r0 *1 0,0
Xsg13cmos5l_a22oi_1_87 \$8487 \$4011 \$6518 \$8507 VPWR VGND \$8506
+ sg13cmos5l_a22oi_1
* cell instance sg13cmos5l_a22oi_1_88 r0 *1 0,0
Xsg13cmos5l_a22oi_1_88 \$4149 \$4009 \$4007 \$2474 VPWR VGND \$4824
+ sg13cmos5l_a22oi_1
* cell instance sg13cmos5l_a22oi_1_89 r0 *1 0,0
Xsg13cmos5l_a22oi_1_89 \$8804 \$8781 \$4011 \$8780 VPWR VGND \$8779
+ sg13cmos5l_a22oi_1
* cell instance sg13cmos5l_a22oi_1_90 r0 *1 0,0
Xsg13cmos5l_a22oi_1_90 \$5230 \$5427 \$5431 \$5231 VPWR VGND \$5434
+ sg13cmos5l_a22oi_1
* cell instance sg13cmos5l_a22oi_1_91 r0 *1 0,0
Xsg13cmos5l_a22oi_1_91 \$6590 \$6550 \$6853 \$6852 VPWR VGND \$6780
+ sg13cmos5l_a22oi_1
* cell instance sg13cmos5l_a22oi_1_92 r0 *1 0,0
Xsg13cmos5l_a22oi_1_92 \$6590 \$6515 \$7661 \$7531 VPWR VGND \$7532
+ sg13cmos5l_a22oi_1
* cell instance sg13cmos5l_a22oi_1_93 r0 *1 0,0
Xsg13cmos5l_a22oi_1_93 \$504 \$989 \$870 \$243 VPWR VGND \$1133
+ sg13cmos5l_a22oi_1
* cell instance sg13cmos5l_a22oi_1_94 r0 *1 0,0
Xsg13cmos5l_a22oi_1_94 \$1617 \$989 \$870 \$1620 VPWR VGND \$1622
+ sg13cmos5l_a22oi_1
* cell instance sg13cmos5l_a22oi_1_95 r0 *1 0,0
Xsg13cmos5l_a22oi_1_95 \$2079 \$1126 \$2081 \$1622 VPWR VGND \$2078
+ sg13cmos5l_a22oi_1
* cell instance sg13cmos5l_a22oi_1_96 r0 *1 0,0
Xsg13cmos5l_a22oi_1_96 \$3683 \$4168 \$4828 \$4829 VPWR VGND \$4629
+ sg13cmos5l_a22oi_1
* cell instance sg13cmos5l_a22oi_1_97 r0 *1 0,0
Xsg13cmos5l_a22oi_1_97 \$2311 \$2316 \$2313 \$2315 VPWR VGND \$2314
+ sg13cmos5l_a22oi_1
* cell instance sg13cmos5l_a22oi_1_98 r0 *1 0,0
Xsg13cmos5l_a22oi_1_98 \$2311 \$3347 \$3350 \$3351 VPWR VGND \$3342
+ sg13cmos5l_a22oi_1
* cell instance sg13cmos5l_a22oi_1_99 r0 *1 0,0
Xsg13cmos5l_a22oi_1_99 \$2316 \$4168 \$4007 \$2609 VPWR VGND \$4157
+ sg13cmos5l_a22oi_1
* cell instance sg13cmos5l_a22oi_1_100 r0 *1 0,0
Xsg13cmos5l_a22oi_1_100 \$8805 \$6523 \$4011 \$8782 VPWR VGND \$8508
+ sg13cmos5l_a22oi_1
* cell instance sg13cmos5l_a22oi_1_101 r0 *1 0,0
Xsg13cmos5l_a22oi_1_101 \$8806 \$8781 \$6518 \$8783 VPWR VGND \$8509
+ sg13cmos5l_a22oi_1
* cell instance sg13cmos5l_a22oi_1_102 r0 *1 0,0
Xsg13cmos5l_a22oi_1_102 \$4468 \$4635 \$4633 \$4631 VPWR VGND \$4634
+ sg13cmos5l_a22oi_1
* cell instance sg13cmos5l_a22oi_1_103 r0 *1 0,0
Xsg13cmos5l_a22oi_1_103 \$6513 \$6523 \$6518 \$6520 VPWR VGND \$5672
+ sg13cmos5l_a22oi_1
* cell instance sg13cmos5l_a22oi_1_104 r0 *1 0,0
Xsg13cmos5l_a22oi_1_104 \$2471 \$2474 \$2472 \$2470 VPWR VGND \$2473
+ sg13cmos5l_a22oi_1
* cell instance sg13cmos5l_a22oi_1_105 r0 *1 0,0
Xsg13cmos5l_a22oi_1_105 \$3354 \$2946 \$3356 \$3357 VPWR VGND \$3173
+ sg13cmos5l_a22oi_1
* cell instance sg13cmos5l_a22oi_1_106 r0 *1 0,0
Xsg13cmos5l_a22oi_1_106 \$6515 \$6523 \$4828 \$6522 VPWR VGND \$6054
+ sg13cmos5l_a22oi_1
* cell instance sg13cmos5l_a22oi_1_107 r0 *1 0,0
Xsg13cmos5l_a22oi_1_107 \$6550 \$6523 \$6518 \$6589 VPWR VGND \$5676
+ sg13cmos5l_a22oi_1
* cell instance sg13cmos5l_a22oi_1_108 r0 *1 0,0
Xsg13cmos5l_a22oi_1_108 \$7971 \$7957 \$4828 \$8014 VPWR VGND \$7972
+ sg13cmos5l_a22oi_1
* cell instance sg13cmos5l_a22oi_1_109 r0 *1 0,0
Xsg13cmos5l_a22oi_1_109 \$5230 \$5864 \$5870 \$5866 VPWR VGND \$5871
+ sg13cmos5l_a22oi_1
* cell instance sg13cmos5l_a22oi_1_110 r0 *1 0,0
Xsg13cmos5l_a22oi_1_110 \$4007 \$5235 \$4024 \$4168 VPWR VGND \$5650
+ sg13cmos5l_a22oi_1
* cell instance sg13cmos5l_a22oi_1_111 r0 *1 0,0
Xsg13cmos5l_a22oi_1_111 \$6590 \$6589 \$6859 \$6591 VPWR VGND \$6792
+ sg13cmos5l_a22oi_1
* cell instance sg13cmos5l_a22oi_1_112 r0 *1 0,0
Xsg13cmos5l_a22oi_1_112 \$7200 \$6522 \$7539 \$7669 VPWR VGND \$7668
+ sg13cmos5l_a22oi_1
* cell instance sg13cmos5l_a22oi_1_113 r0 *1 0,0
Xsg13cmos5l_a22oi_1_113 \$9790 \$6523 \$4011 \$8785 VPWR VGND \$8784
+ sg13cmos5l_a22oi_1
* cell instance sg13cmos5l_a22oi_1_114 r0 *1 0,0
Xsg13cmos5l_a22oi_1_114 \$4468 \$4469 \$4345 \$3869 VPWR VGND \$4311
+ sg13cmos5l_a22oi_1
* cell instance sg13cmos5l_a22oi_1_115 r0 *1 0,0
Xsg13cmos5l_a22oi_1_115 \$4026 \$4028 \$3578 \$4186 VPWR VGND \$3872
+ sg13cmos5l_a22oi_1
* cell instance sg13cmos5l_a22oi_1_116 r0 *1 0,0
Xsg13cmos5l_a22oi_1_116 \$8807 \$8781 \$6518 \$8808 VPWR VGND \$8525
+ sg13cmos5l_a22oi_1
* cell instance sg13cmos5l_a22oi_1_117 r0 *1 0,0
Xsg13cmos5l_a22oi_1_117 \$3659 \$4168 \$4011 \$4638 VPWR VGND \$4637
+ sg13cmos5l_a22oi_1
* cell instance sg13cmos5l_a22oi_1_118 r0 *1 0,0
Xsg13cmos5l_a22oi_1_118 \$2340 \$4168 \$4007 \$2807 VPWR VGND \$5677
+ sg13cmos5l_a22oi_1
* cell instance sg13cmos5l_a22oi_1_119 r0 *1 0,0
Xsg13cmos5l_a22oi_1_119 \$6512 \$6523 \$6518 \$6599 VPWR VGND \$6320
+ sg13cmos5l_a22oi_1
* cell instance sg13cmos5l_a22oi_1_120 r0 *1 0,0
Xsg13cmos5l_a22oi_1_120 \$8239 \$6523 \$4003 \$8226 VPWR VGND \$8137
+ sg13cmos5l_a22oi_1
* cell instance sg13cmos5l_a22oi_1_121 r0 *1 0,0
Xsg13cmos5l_a22oi_1_121 \$4030 \$4168 \$4007 \$4839 VPWR VGND \$5448
+ sg13cmos5l_a22oi_1
* cell instance sg13cmos5l_a22oi_1_122 r0 *1 0,0
Xsg13cmos5l_a22oi_1_122 \$2471 \$2807 \$2785 \$2787 VPWR VGND \$2786
+ sg13cmos5l_a22oi_1
* cell instance sg13cmos5l_a22oi_1_123 r0 *1 0,0
Xsg13cmos5l_a22oi_1_123 \$8240 \$8781 \$4003 \$8227 VPWR VGND \$7996
+ sg13cmos5l_a22oi_1
* cell instance sg13cmos5l_a22oi_1_124 r0 *1 0,0
Xsg13cmos5l_a22oi_1_124 \$3536 \$4030 \$4032 \$3876 VPWR VGND \$4033
+ sg13cmos5l_a22oi_1
* cell instance sg13cmos5l_a22oi_1_125 r0 *1 0,0
Xsg13cmos5l_a22oi_1_125 \$8811 \$6523 \$4011 \$8787 VPWR VGND \$8810
+ sg13cmos5l_a22oi_1
* cell instance sg13cmos5l_a22oi_1_126 r0 *1 0,0
Xsg13cmos5l_a22oi_1_126 \$3354 \$3659 \$3693 \$3552 VPWR VGND \$3551
+ sg13cmos5l_a22oi_1
* cell instance sg13cmos5l_a22oi_1_127 r0 *1 0,0
Xsg13cmos5l_a22oi_1_127 \$2471 \$2340 \$2338 \$2371 VPWR VGND \$2339
+ sg13cmos5l_a22oi_1
* cell instance sg13cmos5l_a22oi_1_128 r0 *1 0,0
Xsg13cmos5l_a22oi_1_128 \$5230 \$4833 \$6449 \$6063 VPWR VGND \$6062
+ sg13cmos5l_a22oi_1
* cell instance sg13cmos5l_a22oi_1_129 r0 *1 0,0
Xsg13cmos5l_a22oi_1_129 \$7200 \$6520 \$7674 \$7675 VPWR VGND \$7543
+ sg13cmos5l_a22oi_1
* cell instance sg13cmos5l_a22oi_1_130 r0 *1 0,0
Xsg13cmos5l_a22oi_1_130 \$4026 \$6524 \$6862 \$5043 VPWR VGND \$6799
+ sg13cmos5l_a22oi_1
* cell instance sg13cmos5l_a22oi_1_131 r0 *1 0,0
Xsg13cmos5l_a22oi_1_131 \$3536 \$4638 \$4644 \$4641 VPWR VGND \$4645
+ sg13cmos5l_a22oi_1
* cell instance sg13cmos5l_a22oi_1_132 r0 *1 0,0
Xsg13cmos5l_a22oi_1_132 \$6590 \$6599 \$6597 \$6526 VPWR VGND \$6598
+ sg13cmos5l_a22oi_1
* cell instance sg13cmos5l_a22oi_1_133 r0 *1 0,0
Xsg13cmos5l_a22oi_1_133 \$5230 \$4839 \$5011 \$5009 VPWR VGND \$5012
+ sg13cmos5l_a22oi_1
* cell instance sg13cmos5l_a22oi_1_134 r0 *1 0,0
Xsg13cmos5l_a22oi_1_134 \$8228 \$8781 \$6518 \$8229 VPWR VGND \$7999
+ sg13cmos5l_a22oi_1
* cell instance sg13cmos5l_a22oi_1_135 r0 *1 0,0
Xsg13cmos5l_a22oi_1_135 \$3354 \$3188 \$3189 \$2947 VPWR VGND \$2992
+ sg13cmos5l_a22oi_1
* cell instance sg13cmos5l_a22oi_1_136 r0 *1 0,0
Xsg13cmos5l_a22oi_1_136 \$8812 \$8781 \$6518 \$8788 VPWR VGND \$8786
+ sg13cmos5l_a22oi_1
* cell instance sg13cmos5l_and2_1_0 r0 *1 0,0
Xsg13cmos5l_and2_1_0 \$67 \$406 VPWR VGND \$1189 sg13cmos5l_and2_1
* cell instance sg13cmos5l_and2_1_1 r0 *1 0,0
Xsg13cmos5l_and2_1_1 \$4325 \$4398 VPWR VGND \$7561 sg13cmos5l_and2_1
* cell instance sg13cmos5l_and2_1_2 r0 *1 0,0
Xsg13cmos5l_and2_1_2 \$4367 \$4522 VPWR VGND \$4376 sg13cmos5l_and2_1
* cell instance sg13cmos5l_and2_1_3 r0 *1 0,0
Xsg13cmos5l_and2_1_3 \$4325 \$5099 VPWR VGND \$5727 sg13cmos5l_and2_1
* cell instance sg13cmos5l_and2_1_4 r0 *1 0,0
Xsg13cmos5l_and2_1_4 \$4325 \$4663 VPWR VGND \$7507 sg13cmos5l_and2_1
* cell instance sg13cmos5l_and2_1_5 r0 *1 0,0
Xsg13cmos5l_and2_1_5 \$6479 \$7505 VPWR VGND \$7813 sg13cmos5l_and2_1
* cell instance sg13cmos5l_and2_1_6 r0 *1 0,0
Xsg13cmos5l_and2_1_6 \$4045 \$3928 VPWR VGND \$2510 sg13cmos5l_and2_1
* cell instance sg13cmos5l_and2_1_7 r0 *1 0,0
Xsg13cmos5l_and2_1_7 \$267 \$2022 VPWR VGND \$1792 sg13cmos5l_and2_1
* cell instance sg13cmos5l_and2_1_8 r0 *1 0,0
Xsg13cmos5l_and2_1_8 \$3026 \$3025 VPWR VGND \$3028 sg13cmos5l_and2_1
* cell instance sg13cmos5l_and2_1_9 r0 *1 0,0
Xsg13cmos5l_and2_1_9 \$2111 \$802 VPWR VGND \$421 sg13cmos5l_and2_1
* cell instance sg13cmos5l_and2_1_10 r0 *1 0,0
Xsg13cmos5l_and2_1_10 \$2827 \$3031 VPWR VGND \$2837 sg13cmos5l_and2_1
* cell instance sg13cmos5l_and2_1_11 r0 *1 0,0
Xsg13cmos5l_and2_1_11 \$3939 \$4397 VPWR VGND \$4398 sg13cmos5l_and2_1
* cell instance sg13cmos5l_and2_1_12 r0 *1 0,0
Xsg13cmos5l_and2_1_12 \$4913 \$4726 VPWR VGND \$4727 sg13cmos5l_and2_1
* cell instance sg13cmos5l_and2_1_13 r0 *1 0,0
Xsg13cmos5l_and2_1_13 \$4064 \$4397 VPWR VGND \$4911 sg13cmos5l_and2_1
* cell instance sg13cmos5l_and2_1_14 r0 *1 0,0
Xsg13cmos5l_and2_1_14 \$3945 \$3939 VPWR VGND \$3947 sg13cmos5l_and2_1
* cell instance sg13cmos5l_and2_1_15 r0 *1 0,0
Xsg13cmos5l_and2_1_15 \$3615 \$3783 VPWR VGND \$4100 sg13cmos5l_and2_1
* cell instance sg13cmos5l_and2_1_16 r0 *1 0,0
Xsg13cmos5l_and2_1_16 \$3129 \$4100 VPWR VGND \$4325 sg13cmos5l_and2_1
* cell instance sg13cmos5l_and2_1_17 r0 *1 0,0
Xsg13cmos5l_and2_1_17 \$100 \$1905 VPWR VGND \$1191 sg13cmos5l_and2_1
* cell instance sg13cmos5l_and2_1_18 r0 *1 0,0
Xsg13cmos5l_and2_1_18 \$3066 \$3434 VPWR VGND \$3436 sg13cmos5l_and2_1
* cell instance sg13cmos5l_and2_1_19 r0 *1 0,0
Xsg13cmos5l_and2_1_19 \$4064 \$4324 VPWR VGND \$4403 sg13cmos5l_and2_1
* cell instance sg13cmos5l_and2_1_20 r0 *1 0,0
Xsg13cmos5l_and2_1_20 \$5500 \$2434 VPWR VGND \$5469 sg13cmos5l_and2_1
* cell instance sg13cmos5l_and2_1_21 r0 *1 0,0
Xsg13cmos5l_and2_1_21 \$3614 \$3934 VPWR VGND \$4119 sg13cmos5l_and2_1
* cell instance sg13cmos5l_and2_1_22 r0 *1 0,0
Xsg13cmos5l_and2_1_22 \$3441 \$3951 VPWR VGND \$4110 sg13cmos5l_and2_1
* cell instance sg13cmos5l_and2_1_23 r0 *1 0,0
Xsg13cmos5l_and2_1_23 \$4237 \$4236 VPWR VGND \$4250 sg13cmos5l_and2_1
* cell instance sg13cmos5l_and2_1_24 r0 *1 0,0
Xsg13cmos5l_and2_1_24 \$3762 \$3622 VPWR VGND \$1103 sg13cmos5l_and2_1
* cell instance sg13cmos5l_and2_1_25 r0 *1 0,0
Xsg13cmos5l_and2_1_25 \$175 \$305 VPWR VGND \$181 sg13cmos5l_and2_1
* cell instance sg13cmos5l_and2_1_26 r0 *1 0,0
Xsg13cmos5l_and2_1_26 \$4325 \$4323 VPWR VGND \$4421 sg13cmos5l_and2_1
* cell instance sg13cmos5l_and2_1_27 r0 *1 0,0
Xsg13cmos5l_and2_1_27 \$306 \$157 VPWR VGND \$968 sg13cmos5l_and2_1
* cell instance sg13cmos5l_and2_1_28 r0 *1 0,0
Xsg13cmos5l_and2_1_28 \$4972 \$5191 VPWR VGND \$4988 sg13cmos5l_and2_1
* cell instance sg13cmos5l_and2_1_29 r0 *1 0,0
Xsg13cmos5l_and2_1_29 \$5191 \$4774 VPWR VGND \$4990 sg13cmos5l_and2_1
* cell instance sg13cmos5l_and2_1_30 r0 *1 0,0
Xsg13cmos5l_and2_1_30 \$2437 \$2439 VPWR VGND \$2159 sg13cmos5l_and2_1
* cell instance sg13cmos5l_and2_1_31 r0 *1 0,0
Xsg13cmos5l_and2_1_31 \$2440 \$2108 VPWR VGND \$1824 sg13cmos5l_and2_1
* cell instance sg13cmos5l_and2_1_32 r0 *1 0,0
Xsg13cmos5l_and2_1_32 \$1471 \$1008 VPWR VGND \$1940 sg13cmos5l_and2_1
* cell instance sg13cmos5l_and2_1_33 r0 *1 0,0
Xsg13cmos5l_and2_1_33 \$2156 \$3481 VPWR VGND \$3138 sg13cmos5l_and2_1
* cell instance sg13cmos5l_and2_1_34 r0 *1 0,0
Xsg13cmos5l_and2_1_34 \$4288 \$4004 VPWR VGND \$4451 sg13cmos5l_and2_1
* cell instance sg13cmos5l_and2_1_35 r0 *1 0,0
Xsg13cmos5l_and2_1_35 \$1240 \$1242 VPWR VGND \$1236 sg13cmos5l_and2_1
* cell instance sg13cmos5l_and2_1_36 r0 *1 0,0
Xsg13cmos5l_and2_1_36 \$4060 \$4147 VPWR VGND \$5003 sg13cmos5l_and2_1
* cell instance sg13cmos5l_and2_1_37 r0 *1 0,0
Xsg13cmos5l_and2_1_37 \$1361 \$2173 VPWR VGND \$2176 sg13cmos5l_and2_1
* cell instance sg13cmos5l_and2_1_38 r0 *1 0,0
Xsg13cmos5l_and2_1_38 \$4685 \$4466 VPWR VGND \$3869 sg13cmos5l_and2_1
* cell instance sg13cmos5l_and2_1_39 r0 *1 0,0
Xsg13cmos5l_and2_1_39 \$579 \$1020 VPWR VGND \$989 sg13cmos5l_and2_1
* cell instance sg13cmos5l_and3_1_0 r0 *1 0,0
Xsg13cmos5l_and3_1_0 \$4561 \$4590 \$4252 VPWR VGND \$4248 sg13cmos5l_and3_1
* cell instance sg13cmos5l_and4_1_0 r0 *1 0,0
Xsg13cmos5l_and4_1_0 \$3014 \$3015 \$3012 \$2825 VPWR VGND \$2517
+ sg13cmos5l_and4_1
* cell instance sg13cmos5l_and4_1_1 r0 *1 0,0
Xsg13cmos5l_and4_1_1 \$3945 \$3615 \$3783 \$4064 VPWR VGND \$3934
+ sg13cmos5l_and4_1
* cell instance sg13cmos5l_and4_1_2 r0 *1 0,0
Xsg13cmos5l_and4_1_2 \$3616 \$3618 \$3615 \$3783 VPWR VGND \$3619
+ sg13cmos5l_and4_1
* cell instance sg13cmos5l_and4_1_3 r0 *1 0,0
Xsg13cmos5l_and4_1_3 \$3618 \$4049 \$3441 \$3951 VPWR VGND \$3266
+ sg13cmos5l_and4_1
* cell instance sg13cmos5l_and4_1_4 r0 *1 0,0
Xsg13cmos5l_and4_1_4 \$435 \$546 \$545 \$437 VPWR VGND \$281 sg13cmos5l_and4_1
* cell instance sg13cmos5l_and4_1_5 r0 *1 0,0
Xsg13cmos5l_and4_1_5 \$833 \$2556 \$1052 \$561 VPWR VGND \$2021
+ sg13cmos5l_and4_1
* cell instance sg13cmos5l_and4_1_6 r0 *1 0,0
Xsg13cmos5l_and4_1_6 \$4967 \$4769 \$5375 \$4980 VPWR VGND \$5191
+ sg13cmos5l_and4_1
* cell instance sg13cmos5l_and4_1_7 r0 *1 0,0
Xsg13cmos5l_and4_1_7 \$2434 \$2432 \$2435 \$2436 VPWR VGND \$1459
+ sg13cmos5l_and4_1
* cell instance sg13cmos5l_and4_1_8 r0 *1 0,0
Xsg13cmos5l_and4_1_8 \$1358 \$1597 \$1493 \$1489 VPWR VGND \$1598
+ sg13cmos5l_and4_1
* cell instance sg13cmos5l_antennanp_0 r0 *1 0,0
Xsg13cmos5l_antennanp_0 \$5951 VPWR VGND sg13cmos5l_antennanp
* cell instance sg13cmos5l_antennanp_1 r0 *1 0,0
Xsg13cmos5l_antennanp_1 \$5337 VPWR VGND sg13cmos5l_antennanp
* cell instance sg13cmos5l_antennanp_2 r0 *1 0,0
Xsg13cmos5l_antennanp_2 \$649 VPWR VGND sg13cmos5l_antennanp
* cell instance sg13cmos5l_antennanp_3 r0 *1 0,0
Xsg13cmos5l_antennanp_3 \$4554 VPWR VGND sg13cmos5l_antennanp
* cell instance sg13cmos5l_antennanp_4 r0 *1 0,0
Xsg13cmos5l_antennanp_4 \$282 VPWR VGND sg13cmos5l_antennanp
* cell instance sg13cmos5l_buf_1_0 r0 *1 0,0
Xsg13cmos5l_buf_1_0 \$8217 VPWR VGND \$8214 sg13cmos5l_buf_1
* cell instance sg13cmos5l_buf_1_1 r0 *1 0,0
Xsg13cmos5l_buf_1_1 \$1171 VPWR VGND \$258 sg13cmos5l_buf_1
* cell instance sg13cmos5l_buf_1_2 r0 *1 0,0
Xsg13cmos5l_buf_1_2 \$173 VPWR VGND \$1052 sg13cmos5l_buf_1
* cell instance sg13cmos5l_buf_1_3 r0 *1 0,0
Xsg13cmos5l_buf_1_3 \$151 VPWR VGND \$4 sg13cmos5l_buf_1
* cell instance sg13cmos5l_buf_1_4 r0 *1 0,0
Xsg13cmos5l_buf_1_4 \$12 VPWR VGND \$1173 sg13cmos5l_buf_1
* cell instance sg13cmos5l_buf_1_5 r0 *1 0,0
Xsg13cmos5l_buf_1_5 \$2385 VPWR VGND \$1671 sg13cmos5l_buf_1
* cell instance sg13cmos5l_buf_1_6 r0 *1 0,0
Xsg13cmos5l_buf_1_6 \$12927 VPWR VGND \$11894 sg13cmos5l_buf_1
* cell instance sg13cmos5l_buf_1_7 r0 *1 0,0
Xsg13cmos5l_buf_1_7 \$1671 VPWR VGND \$154 sg13cmos5l_buf_1
* cell instance sg13cmos5l_buf_1_8 r0 *1 0,0
Xsg13cmos5l_buf_1_8 \$19423 VPWR VGND \$15071 sg13cmos5l_buf_1
* cell instance sg13cmos5l_buf_1_9 r0 *1 0,0
Xsg13cmos5l_buf_1_9 \$6383 VPWR VGND \$6356 sg13cmos5l_buf_1
* cell instance sg13cmos5l_buf_1_10 r0 *1 0,0
Xsg13cmos5l_buf_1_10 \$39 VPWR VGND \$261 sg13cmos5l_buf_1
* cell instance sg13cmos5l_buf_1_11 r0 *1 0,0
Xsg13cmos5l_buf_1_11 \$1171 VPWR VGND \$1789 sg13cmos5l_buf_1
* cell instance sg13cmos5l_buf_1_12 r0 *1 0,0
Xsg13cmos5l_buf_1_12 \$826 VPWR VGND \$1 sg13cmos5l_buf_1
* cell instance sg13cmos5l_buf_1_13 r0 *1 0,0
Xsg13cmos5l_buf_1_13 \$419 VPWR VGND \$406 sg13cmos5l_buf_1
* cell instance sg13cmos5l_buf_1_14 r0 *1 0,0
Xsg13cmos5l_buf_1_14 \$2234 VPWR VGND \$1171 sg13cmos5l_buf_1
* cell instance sg13cmos5l_buf_1_15 r0 *1 0,0
Xsg13cmos5l_buf_1_15 \$6476 VPWR VGND \$8851 sg13cmos5l_buf_1
* cell instance sg13cmos5l_buf_1_16 r0 *1 0,0
Xsg13cmos5l_buf_1_16 \$12425 VPWR VGND \$13223 sg13cmos5l_buf_1
* cell instance sg13cmos5l_buf_1_17 r0 *1 0,0
Xsg13cmos5l_buf_1_17 \$12425 VPWR VGND \$12049 sg13cmos5l_buf_1
* cell instance sg13cmos5l_buf_1_18 r0 *1 0,0
Xsg13cmos5l_buf_1_18 \$1433 VPWR VGND \$153 sg13cmos5l_buf_1
* cell instance sg13cmos5l_buf_1_19 r0 *1 0,0
Xsg13cmos5l_buf_1_19 \$2395 VPWR VGND \$2707 sg13cmos5l_buf_1
* cell instance sg13cmos5l_buf_1_20 r0 *1 0,0
Xsg13cmos5l_buf_1_20 \$2707 VPWR VGND \$1801 sg13cmos5l_buf_1
* cell instance sg13cmos5l_buf_1_21 r0 *1 0,0
Xsg13cmos5l_buf_1_21 \$7165 VPWR VGND \$6561 sg13cmos5l_buf_1
* cell instance sg13cmos5l_buf_1_22 r0 *1 0,0
Xsg13cmos5l_buf_1_22 \$1801 VPWR VGND \$1433 sg13cmos5l_buf_1
* cell instance sg13cmos5l_buf_1_23 r0 *1 0,0
Xsg13cmos5l_buf_1_23 \$7507 VPWR VGND \$7210 sg13cmos5l_buf_1
* cell instance sg13cmos5l_buf_1_24 r0 *1 0,0
Xsg13cmos5l_buf_1_24 \$79 VPWR VGND \$35 sg13cmos5l_buf_1
* cell instance sg13cmos5l_buf_1_25 r0 *1 0,0
Xsg13cmos5l_buf_1_25 \$2017 VPWR VGND \$796 sg13cmos5l_buf_1
* cell instance sg13cmos5l_buf_1_26 r0 *1 0,0
Xsg13cmos5l_buf_1_26 \$2240 VPWR VGND \$664 sg13cmos5l_buf_1
* cell instance sg13cmos5l_buf_1_27 r0 *1 0,0
Xsg13cmos5l_buf_1_27 \$2662 VPWR VGND \$4350 sg13cmos5l_buf_1
* cell instance sg13cmos5l_buf_1_28 r0 *1 0,0
Xsg13cmos5l_buf_1_28 \$1664 VPWR VGND \$66 sg13cmos5l_buf_1
* cell instance sg13cmos5l_buf_1_29 r0 *1 0,0
Xsg13cmos5l_buf_1_29 \$276 VPWR VGND \$2111 sg13cmos5l_buf_1
* cell instance sg13cmos5l_buf_1_30 r0 *1 0,0
Xsg13cmos5l_buf_1_30 \$7913 VPWR VGND \$8492 sg13cmos5l_buf_1
* cell instance sg13cmos5l_buf_1_31 r0 *1 0,0
Xsg13cmos5l_buf_1_31 \$40 VPWR VGND \$78 sg13cmos5l_buf_1
* cell instance sg13cmos5l_buf_1_32 r0 *1 0,0
Xsg13cmos5l_buf_1_32 \$9 VPWR VGND \$103 sg13cmos5l_buf_1
* cell instance sg13cmos5l_buf_1_33 r0 *1 0,0
Xsg13cmos5l_buf_1_33 \$2110 VPWR VGND \$285 sg13cmos5l_buf_1
* cell instance sg13cmos5l_buf_1_34 r0 *1 0,0
Xsg13cmos5l_buf_1_34 \$13482 VPWR VGND \$11898 sg13cmos5l_buf_1
* cell instance sg13cmos5l_buf_1_35 r0 *1 0,0
Xsg13cmos5l_buf_1_35 \$8217 VPWR VGND \$6383 sg13cmos5l_buf_1
* cell instance sg13cmos5l_buf_1_36 r0 *1 0,0
Xsg13cmos5l_buf_1_36 \$16695 VPWR VGND \$17324 sg13cmos5l_buf_1
* cell instance sg13cmos5l_buf_1_37 r0 *1 0,0
Xsg13cmos5l_buf_1_37 \$662 VPWR VGND \$802 sg13cmos5l_buf_1
* cell instance sg13cmos5l_buf_1_38 r0 *1 0,0
Xsg13cmos5l_buf_1_38 \$2245 VPWR VGND \$276 sg13cmos5l_buf_1
* cell instance sg13cmos5l_buf_1_39 r0 *1 0,0
Xsg13cmos5l_buf_1_39 \$285 VPWR VGND \$42 sg13cmos5l_buf_1
* cell instance sg13cmos5l_buf_1_40 r0 *1 0,0
Xsg13cmos5l_buf_1_40 \$2247 VPWR VGND \$2248 sg13cmos5l_buf_1
* cell instance sg13cmos5l_buf_1_41 r0 *1 0,0
Xsg13cmos5l_buf_1_41 \$1664 VPWR VGND \$524 sg13cmos5l_buf_1
* cell instance sg13cmos5l_buf_1_42 r0 *1 0,0
Xsg13cmos5l_buf_1_42 \$44 VPWR VGND \$1882 sg13cmos5l_buf_1
* cell instance sg13cmos5l_buf_1_43 r0 *1 0,0
Xsg13cmos5l_buf_1_43 \$17324 VPWR VGND \$17322 sg13cmos5l_buf_1
* cell instance sg13cmos5l_buf_1_44 r0 *1 0,0
Xsg13cmos5l_buf_1_44 \$19970 VPWR VGND \$6502 sg13cmos5l_buf_1
* cell instance sg13cmos5l_buf_1_45 r0 *1 0,0
Xsg13cmos5l_buf_1_45 \$2401 VPWR VGND \$649 sg13cmos5l_buf_1
* cell instance sg13cmos5l_buf_1_46 r0 *1 0,0
Xsg13cmos5l_buf_1_46 \$4233 VPWR VGND \$12425 sg13cmos5l_buf_1
* cell instance sg13cmos5l_buf_1_47 r0 *1 0,0
Xsg13cmos5l_buf_1_47 \$2112 VPWR VGND \$44 sg13cmos5l_buf_1
* cell instance sg13cmos5l_buf_1_48 r0 *1 0,0
Xsg13cmos5l_buf_1_48 \$2109 VPWR VGND \$2247 sg13cmos5l_buf_1
* cell instance sg13cmos5l_buf_1_49 r0 *1 0,0
Xsg13cmos5l_buf_1_49 \$4856 VPWR VGND \$2662 sg13cmos5l_buf_1
* cell instance sg13cmos5l_buf_1_50 r0 *1 0,0
Xsg13cmos5l_buf_1_50 \$2248 VPWR VGND \$1664 sg13cmos5l_buf_1
* cell instance sg13cmos5l_buf_1_51 r0 *1 0,0
Xsg13cmos5l_buf_1_51 \$4375 VPWR VGND \$3914 sg13cmos5l_buf_1
* cell instance sg13cmos5l_buf_1_52 r0 *1 0,0
Xsg13cmos5l_buf_1_52 \$6479 VPWR VGND \$6476 sg13cmos5l_buf_1
* cell instance sg13cmos5l_buf_1_53 r0 *1 0,0
Xsg13cmos5l_buf_1_53 \$7561 VPWR VGND \$7165 sg13cmos5l_buf_1
* cell instance sg13cmos5l_buf_1_54 r0 *1 0,0
Xsg13cmos5l_buf_1_54 \$5568 VPWR VGND \$6479 sg13cmos5l_buf_1
* cell instance sg13cmos5l_buf_1_55 r0 *1 0,0
Xsg13cmos5l_buf_1_55 \$14872 VPWR VGND \$4045 sg13cmos5l_buf_1
* cell instance sg13cmos5l_buf_1_56 r0 *1 0,0
Xsg13cmos5l_buf_1_56 \$6489 VPWR VGND \$8217 sg13cmos5l_buf_1
* cell instance sg13cmos5l_buf_1_57 r0 *1 0,0
Xsg13cmos5l_buf_1_57 \$1442 VPWR VGND \$259 sg13cmos5l_buf_1
* cell instance sg13cmos5l_buf_1_58 r0 *1 0,0
Xsg13cmos5l_buf_1_58 \$664 VPWR VGND \$36 sg13cmos5l_buf_1
* cell instance sg13cmos5l_buf_1_59 r0 *1 0,0
Xsg13cmos5l_buf_1_59 \$44 VPWR VGND \$67 sg13cmos5l_buf_1
* cell instance sg13cmos5l_buf_1_60 r0 *1 0,0
Xsg13cmos5l_buf_1_60 \$62 VPWR VGND \$11900 sg13cmos5l_buf_1
* cell instance sg13cmos5l_buf_1_61 r0 *1 0,0
Xsg13cmos5l_buf_1_61 \$1065 VPWR VGND \$2 sg13cmos5l_buf_1
* cell instance sg13cmos5l_buf_1_62 r0 *1 0,0
Xsg13cmos5l_buf_1_62 \$2115 VPWR VGND \$1065 sg13cmos5l_buf_1
* cell instance sg13cmos5l_buf_1_63 r0 *1 0,0
Xsg13cmos5l_buf_1_63 \$12720 VPWR VGND \$11740 sg13cmos5l_buf_1
* cell instance sg13cmos5l_buf_1_64 r0 *1 0,0
Xsg13cmos5l_buf_1_64 \$17 VPWR VGND \$18 sg13cmos5l_buf_1
* cell instance sg13cmos5l_buf_1_65 r0 *1 0,0
Xsg13cmos5l_buf_1_65 \$3614 VPWR VGND \$4087 sg13cmos5l_buf_1
* cell instance sg13cmos5l_buf_1_66 r0 *1 0,0
Xsg13cmos5l_buf_1_66 \$5045 VPWR VGND \$5293 sg13cmos5l_buf_1
* cell instance sg13cmos5l_buf_1_67 r0 *1 0,0
Xsg13cmos5l_buf_1_67 \$17324 VPWR VGND \$12927 sg13cmos5l_buf_1
* cell instance sg13cmos5l_buf_1_68 r0 *1 0,0
Xsg13cmos5l_buf_1_68 \$2422 VPWR VGND \$2386 sg13cmos5l_buf_1
* cell instance sg13cmos5l_buf_1_69 r0 *1 0,0
Xsg13cmos5l_buf_1_69 \$5727 VPWR VGND \$5045 sg13cmos5l_buf_1
* cell instance sg13cmos5l_buf_1_70 r0 *1 0,0
Xsg13cmos5l_buf_1_70 \$7210 VPWR VGND \$17692 sg13cmos5l_buf_1
* cell instance sg13cmos5l_buf_1_71 r0 *1 0,0
Xsg13cmos5l_buf_1_71 \$305 VPWR VGND \$525 sg13cmos5l_buf_1
* cell instance sg13cmos5l_buf_1_72 r0 *1 0,0
Xsg13cmos5l_buf_1_72 \$125 VPWR VGND \$3 sg13cmos5l_buf_1
* cell instance sg13cmos5l_buf_1_73 r0 *1 0,0
Xsg13cmos5l_buf_1_73 \$7210 VPWR VGND \$18792 sg13cmos5l_buf_1
* cell instance sg13cmos5l_buf_1_74 r0 *1 0,0
Xsg13cmos5l_buf_1_74 \$1433 VPWR VGND \$43 sg13cmos5l_buf_1
* cell instance sg13cmos5l_buf_1_75 r0 *1 0,0
Xsg13cmos5l_buf_1_75 \$925 VPWR VGND \$937 sg13cmos5l_buf_1
* cell instance sg13cmos5l_buf_1_76 r0 *1 0,0
Xsg13cmos5l_buf_1_76 \$1171 VPWR VGND \$646 sg13cmos5l_buf_1
* cell instance sg13cmos5l_buf_1_77 r0 *1 0,0
Xsg13cmos5l_buf_1_77 \$276 VPWR VGND \$65 sg13cmos5l_buf_1
* cell instance sg13cmos5l_buf_1_78 r0 *1 0,0
Xsg13cmos5l_buf_1_78 \$1890 VPWR VGND \$79 sg13cmos5l_buf_1
* cell instance sg13cmos5l_buf_1_79 r0 *1 0,0
Xsg13cmos5l_buf_1_79 \$3958 VPWR VGND \$3705 sg13cmos5l_buf_1
* cell instance sg13cmos5l_buf_1_80 r0 *1 0,0
Xsg13cmos5l_buf_1_80 \$7813 VPWR VGND \$7913 sg13cmos5l_buf_1
* cell instance sg13cmos5l_buf_1_81 r0 *1 0,0
Xsg13cmos5l_buf_1_81 \$2253 VPWR VGND \$931 sg13cmos5l_buf_1
* cell instance sg13cmos5l_buf_1_82 r0 *1 0,0
Xsg13cmos5l_buf_1_82 \$12720 VPWR VGND \$11741 sg13cmos5l_buf_1
* cell instance sg13cmos5l_buf_1_83 r0 *1 0,0
Xsg13cmos5l_buf_1_83 \$2420 VPWR VGND \$2253 sg13cmos5l_buf_1
* cell instance sg13cmos5l_buf_1_84 r0 *1 0,0
Xsg13cmos5l_buf_1_84 \$1067 VPWR VGND \$1336 sg13cmos5l_buf_1
* cell instance sg13cmos5l_buf_1_85 r0 *1 0,0
Xsg13cmos5l_buf_1_85 \$5340 VPWR VGND \$6489 sg13cmos5l_buf_1
* cell instance sg13cmos5l_buf_1_86 r0 *1 0,0
Xsg13cmos5l_buf_1_86 \$5346 VPWR VGND \$20043 sg13cmos5l_buf_1
* cell instance sg13cmos5l_buf_1_87 r0 *1 0,0
Xsg13cmos5l_buf_1_87 \$5134 VPWR VGND \$19423 sg13cmos5l_buf_1
* cell instance sg13cmos5l_buf_1_88 r0 *1 0,0
Xsg13cmos5l_buf_1_88 \$819 VPWR VGND \$1318 sg13cmos5l_buf_1
* cell instance sg13cmos5l_buf_1_89 r0 *1 0,0
Xsg13cmos5l_buf_1_89 \$20019 VPWR VGND \$5346 sg13cmos5l_buf_1
* cell instance sg13cmos5l_buf_1_90 r0 *1 0,0
Xsg13cmos5l_buf_1_90 \$16695 VPWR VGND \$14543 sg13cmos5l_buf_1
* cell instance sg13cmos5l_buf_1_91 r0 *1 0,0
Xsg13cmos5l_buf_1_91 \$4375 VPWR VGND \$4214 sg13cmos5l_buf_1
* cell instance sg13cmos5l_buf_1_92 r0 *1 0,0
Xsg13cmos5l_buf_1_92 \$5340 VPWR VGND \$16695 sg13cmos5l_buf_1
* cell instance sg13cmos5l_buf_1_93 r0 *1 0,0
Xsg13cmos5l_buf_1_93 \$4385 VPWR VGND \$3614 sg13cmos5l_buf_1
* cell instance sg13cmos5l_buf_1_94 r0 *1 0,0
Xsg13cmos5l_buf_1_94 \$2251 VPWR VGND \$806 sg13cmos5l_buf_1
* cell instance sg13cmos5l_buf_1_95 r0 *1 0,0
Xsg13cmos5l_buf_1_95 \$5346 VPWR VGND \$14035 sg13cmos5l_buf_1
* cell instance sg13cmos5l_buf_1_96 r0 *1 0,0
Xsg13cmos5l_buf_1_96 \$171 VPWR VGND \$152 sg13cmos5l_buf_1
* cell instance sg13cmos5l_buf_1_97 r0 *1 0,0
Xsg13cmos5l_buf_1_97 \$20043 VPWR VGND \$15076 sg13cmos5l_buf_1
* cell instance sg13cmos5l_buf_1_98 r0 *1 0,0
Xsg13cmos5l_buf_1_98 \$2520 VPWR VGND \$171 sg13cmos5l_buf_1
* cell instance sg13cmos5l_buf_1_99 r0 *1 0,0
Xsg13cmos5l_buf_1_99 \$12730 VPWR VGND \$12720 sg13cmos5l_buf_1
* cell instance sg13cmos5l_buf_1_100 r0 *1 0,0
Xsg13cmos5l_buf_1_100 \$1202 VPWR VGND \$819 sg13cmos5l_buf_1
* cell instance sg13cmos5l_buf_1_101 r0 *1 0,0
Xsg13cmos5l_buf_1_101 \$3614 VPWR VGND \$3930 sg13cmos5l_buf_1
* cell instance sg13cmos5l_buf_1_102 r0 *1 0,0
Xsg13cmos5l_buf_1_102 \$4551 VPWR VGND \$5701 sg13cmos5l_buf_1
* cell instance sg13cmos5l_buf_1_103 r0 *1 0,0
Xsg13cmos5l_buf_1_103 \$2691 VPWR VGND \$2392 sg13cmos5l_buf_1
* cell instance sg13cmos5l_buf_1_104 r0 *1 0,0
Xsg13cmos5l_buf_1_104 \$4856 VPWR VGND \$2705 sg13cmos5l_buf_1
* cell instance sg13cmos5l_buf_1_105 r0 *1 0,0
Xsg13cmos5l_buf_1_105 \$2422 VPWR VGND \$2827 sg13cmos5l_buf_1
* cell instance sg13cmos5l_buf_1_106 r0 *1 0,0
Xsg13cmos5l_buf_1_106 \$1671 VPWR VGND \$533 sg13cmos5l_buf_1
* cell instance sg13cmos5l_buf_1_107 r0 *1 0,0
Xsg13cmos5l_buf_1_107 \$4663 VPWR VGND \$5305 sg13cmos5l_buf_1
* cell instance sg13cmos5l_buf_1_108 r0 *1 0,0
Xsg13cmos5l_buf_1_108 \$259 VPWR VGND \$290 sg13cmos5l_buf_1
* cell instance sg13cmos5l_buf_1_109 r0 *1 0,0
Xsg13cmos5l_buf_1_109 \$20006 VPWR VGND \$5340 sg13cmos5l_buf_1
* cell instance sg13cmos5l_buf_1_110 r0 *1 0,0
Xsg13cmos5l_buf_1_110 \$4731 VPWR VGND \$5745 sg13cmos5l_buf_1
* cell instance sg13cmos5l_buf_1_111 r0 *1 0,0
Xsg13cmos5l_buf_1_111 \$3236 VPWR VGND \$3066 sg13cmos5l_buf_1
* cell instance sg13cmos5l_buf_1_112 r0 *1 0,0
Xsg13cmos5l_buf_1_112 \$4856 VPWR VGND \$5507 sg13cmos5l_buf_1
* cell instance sg13cmos5l_buf_1_113 r0 *1 0,0
Xsg13cmos5l_buf_1_113 \$3423 VPWR VGND \$2679 sg13cmos5l_buf_1
* cell instance sg13cmos5l_buf_1_114 r0 *1 0,0
Xsg13cmos5l_buf_1_114 \$37 VPWR VGND \$251 sg13cmos5l_buf_1
* cell instance sg13cmos5l_buf_1_115 r0 *1 0,0
Xsg13cmos5l_buf_1_115 \$2225 VPWR VGND \$4856 sg13cmos5l_buf_1
* cell instance sg13cmos5l_buf_1_116 r0 *1 0,0
Xsg13cmos5l_buf_1_116 \$5340 VPWR VGND \$2225 sg13cmos5l_buf_1
* cell instance sg13cmos5l_buf_1_117 r0 *1 0,0
Xsg13cmos5l_buf_1_117 \$4398 VPWR VGND \$3758 sg13cmos5l_buf_1
* cell instance sg13cmos5l_buf_1_118 r0 *1 0,0
Xsg13cmos5l_buf_1_118 \$4102 VPWR VGND \$3939 sg13cmos5l_buf_1
* cell instance sg13cmos5l_buf_1_119 r0 *1 0,0
Xsg13cmos5l_buf_1_119 \$1801 VPWR VGND \$24 sg13cmos5l_buf_1
* cell instance sg13cmos5l_buf_1_120 r0 *1 0,0
Xsg13cmos5l_buf_1_120 \$5528 VPWR VGND \$3248 sg13cmos5l_buf_1
* cell instance sg13cmos5l_buf_1_121 r0 *1 0,0
Xsg13cmos5l_buf_1_121 \$2253 VPWR VGND \$91 sg13cmos5l_buf_1
* cell instance sg13cmos5l_buf_1_122 r0 *1 0,0
Xsg13cmos5l_buf_1_122 \$1890 VPWR VGND \$50 sg13cmos5l_buf_1
* cell instance sg13cmos5l_buf_1_123 r0 *1 0,0
Xsg13cmos5l_buf_1_123 \$681 VPWR VGND \$651 sg13cmos5l_buf_1
* cell instance sg13cmos5l_buf_1_124 r0 *1 0,0
Xsg13cmos5l_buf_1_124 \$2248 VPWR VGND \$164 sg13cmos5l_buf_1
* cell instance sg13cmos5l_buf_1_125 r0 *1 0,0
Xsg13cmos5l_buf_1_125 \$2251 VPWR VGND \$1907 sg13cmos5l_buf_1
* cell instance sg13cmos5l_buf_1_126 r0 *1 0,0
Xsg13cmos5l_buf_1_126 \$168 VPWR VGND \$93 sg13cmos5l_buf_1
* cell instance sg13cmos5l_buf_1_127 r0 *1 0,0
Xsg13cmos5l_buf_1_127 \$3043 VPWR VGND \$3941 sg13cmos5l_buf_1
* cell instance sg13cmos5l_buf_1_128 r0 *1 0,0
Xsg13cmos5l_buf_1_128 \$3043 VPWR VGND \$2717 sg13cmos5l_buf_1
* cell instance sg13cmos5l_buf_1_129 r0 *1 0,0
Xsg13cmos5l_buf_1_129 uio_in[7] VPWR VGND \$20152 sg13cmos5l_buf_1
* cell instance sg13cmos5l_buf_1_130 r0 *1 0,0
Xsg13cmos5l_buf_1_130 uio_in[6] VPWR VGND \$20157 sg13cmos5l_buf_1
* cell instance sg13cmos5l_buf_1_131 r0 *1 0,0
Xsg13cmos5l_buf_1_131 \$3427 VPWR VGND \$3396 sg13cmos5l_buf_1
* cell instance sg13cmos5l_buf_1_132 r0 *1 0,0
Xsg13cmos5l_buf_1_132 uio_in[5] VPWR VGND \$20160 sg13cmos5l_buf_1
* cell instance sg13cmos5l_buf_1_133 r0 *1 0,0
Xsg13cmos5l_buf_1_133 \$5125 VPWR VGND \$2862 sg13cmos5l_buf_1
* cell instance sg13cmos5l_buf_1_134 r0 *1 0,0
Xsg13cmos5l_buf_1_134 uio_in[4] VPWR VGND \$20164 sg13cmos5l_buf_1
* cell instance sg13cmos5l_buf_1_135 r0 *1 0,0
Xsg13cmos5l_buf_1_135 \$2017 VPWR VGND \$1905 sg13cmos5l_buf_1
* cell instance sg13cmos5l_buf_1_136 r0 *1 0,0
Xsg13cmos5l_buf_1_136 \$2112 VPWR VGND \$100 sg13cmos5l_buf_1
* cell instance sg13cmos5l_buf_1_137 r0 *1 0,0
Xsg13cmos5l_buf_1_137 \$3947 VPWR VGND \$5692 sg13cmos5l_buf_1
* cell instance sg13cmos5l_buf_1_138 r0 *1 0,0
Xsg13cmos5l_buf_1_138 \$2219 VPWR VGND \$3043 sg13cmos5l_buf_1
* cell instance sg13cmos5l_buf_1_139 r0 *1 0,0
Xsg13cmos5l_buf_1_139 uio_in[3] VPWR VGND \$20169 sg13cmos5l_buf_1
* cell instance sg13cmos5l_buf_1_140 r0 *1 0,0
Xsg13cmos5l_buf_1_140 \$4665 VPWR VGND \$5264 sg13cmos5l_buf_1
* cell instance sg13cmos5l_buf_1_141 r0 *1 0,0
Xsg13cmos5l_buf_1_141 \$2385 VPWR VGND \$2554 sg13cmos5l_buf_1
* cell instance sg13cmos5l_buf_1_142 r0 *1 0,0
Xsg13cmos5l_buf_1_142 uio_in[2] VPWR VGND \$20172 sg13cmos5l_buf_1
* cell instance sg13cmos5l_buf_1_143 r0 *1 0,0
Xsg13cmos5l_buf_1_143 \$2802 VPWR VGND \$3087 sg13cmos5l_buf_1
* cell instance sg13cmos5l_buf_1_144 r0 *1 0,0
Xsg13cmos5l_buf_1_144 \$39 VPWR VGND \$428 sg13cmos5l_buf_1
* cell instance sg13cmos5l_buf_1_145 r0 *1 0,0
Xsg13cmos5l_buf_1_145 \$2247 VPWR VGND \$1082 sg13cmos5l_buf_1
* cell instance sg13cmos5l_buf_1_146 r0 *1 0,0
Xsg13cmos5l_buf_1_146 \$3947 VPWR VGND \$3957 sg13cmos5l_buf_1
* cell instance sg13cmos5l_buf_1_147 r0 *1 0,0
Xsg13cmos5l_buf_1_147 \$1375 VPWR VGND \$2678 sg13cmos5l_buf_1
* cell instance sg13cmos5l_buf_1_148 r0 *1 0,0
Xsg13cmos5l_buf_1_148 uio_in[1] VPWR VGND \$20177 sg13cmos5l_buf_1
* cell instance sg13cmos5l_buf_1_149 r0 *1 0,0
Xsg13cmos5l_buf_1_149 \$2247 VPWR VGND \$2722 sg13cmos5l_buf_1
* cell instance sg13cmos5l_buf_1_150 r0 *1 0,0
Xsg13cmos5l_buf_1_150 \$4102 VPWR VGND \$3618 sg13cmos5l_buf_1
* cell instance sg13cmos5l_buf_1_151 r0 *1 0,0
Xsg13cmos5l_buf_1_151 uio_in[0] VPWR VGND \$20254 sg13cmos5l_buf_1
* cell instance sg13cmos5l_buf_1_152 r0 *1 0,0
Xsg13cmos5l_buf_1_152 \$3950 VPWR VGND \$4562 sg13cmos5l_buf_1
* cell instance sg13cmos5l_buf_1_153 r0 *1 0,0
Xsg13cmos5l_buf_1_153 \$2234 VPWR VGND \$435 sg13cmos5l_buf_1
* cell instance sg13cmos5l_buf_1_154 r0 *1 0,0
Xsg13cmos5l_buf_1_154 \$2110 VPWR VGND \$1453 sg13cmos5l_buf_1
* cell instance sg13cmos5l_buf_1_155 r0 *1 0,0
Xsg13cmos5l_buf_1_155 ui_in[7] VPWR VGND \$19996 sg13cmos5l_buf_1
* cell instance sg13cmos5l_buf_1_156 r0 *1 0,0
Xsg13cmos5l_buf_1_156 \$4405 VPWR VGND \$3615 sg13cmos5l_buf_1
* cell instance sg13cmos5l_buf_1_157 r0 *1 0,0
Xsg13cmos5l_buf_1_157 ui_in[6] VPWR VGND \$20183 sg13cmos5l_buf_1
* cell instance sg13cmos5l_buf_1_158 r0 *1 0,0
Xsg13cmos5l_buf_1_158 ui_in[5] VPWR VGND \$20255 sg13cmos5l_buf_1
* cell instance sg13cmos5l_buf_1_159 r0 *1 0,0
Xsg13cmos5l_buf_1_159 \$17 VPWR VGND \$128 sg13cmos5l_buf_1
* cell instance sg13cmos5l_buf_1_160 r0 *1 0,0
Xsg13cmos5l_buf_1_160 \$2047 VPWR VGND \$5500 sg13cmos5l_buf_1
* cell instance sg13cmos5l_buf_1_161 r0 *1 0,0
Xsg13cmos5l_buf_1_161 ui_in[4] VPWR VGND \$20114 sg13cmos5l_buf_1
* cell instance sg13cmos5l_buf_1_162 r0 *1 0,0
Xsg13cmos5l_buf_1_162 \$2245 VPWR VGND \$1913 sg13cmos5l_buf_1
* cell instance sg13cmos5l_buf_1_163 r0 *1 0,0
Xsg13cmos5l_buf_1_163 \$584 VPWR VGND \$2688 sg13cmos5l_buf_1
* cell instance sg13cmos5l_buf_1_164 r0 *1 0,0
Xsg13cmos5l_buf_1_164 ui_in[3] VPWR VGND \$20189 sg13cmos5l_buf_1
* cell instance sg13cmos5l_buf_1_165 r0 *1 0,0
Xsg13cmos5l_buf_1_165 \$2707 VPWR VGND \$102 sg13cmos5l_buf_1
* cell instance sg13cmos5l_buf_1_166 r0 *1 0,0
Xsg13cmos5l_buf_1_166 ui_in[2] VPWR VGND \$20192 sg13cmos5l_buf_1
* cell instance sg13cmos5l_buf_1_167 r0 *1 0,0
Xsg13cmos5l_buf_1_167 \$3442 VPWR VGND \$3622 sg13cmos5l_buf_1
* cell instance sg13cmos5l_buf_1_168 r0 *1 0,0
Xsg13cmos5l_buf_1_168 \$2748 VPWR VGND \$3052 sg13cmos5l_buf_1
* cell instance sg13cmos5l_buf_1_169 r0 *1 0,0
Xsg13cmos5l_buf_1_169 \$78 VPWR VGND \$105 sg13cmos5l_buf_1
* cell instance sg13cmos5l_buf_1_170 r0 *1 0,0
Xsg13cmos5l_buf_1_170 \$2885 VPWR VGND \$2049 sg13cmos5l_buf_1
* cell instance sg13cmos5l_buf_1_171 r0 *1 0,0
Xsg13cmos5l_buf_1_171 ui_in[1] VPWR VGND \$12730 sg13cmos5l_buf_1
* cell instance sg13cmos5l_buf_1_172 r0 *1 0,0
Xsg13cmos5l_buf_1_172 ui_in[0] VPWR VGND \$16693 sg13cmos5l_buf_1
* cell instance sg13cmos5l_buf_1_173 r0 *1 0,0
Xsg13cmos5l_buf_1_173 rst_n VPWR VGND \$20006 sg13cmos5l_buf_1
* cell instance sg13cmos5l_buf_1_174 r0 *1 0,0
Xsg13cmos5l_buf_1_174 \$1202 VPWR VGND \$959 sg13cmos5l_buf_1
* cell instance sg13cmos5l_buf_1_175 r0 *1 0,0
Xsg13cmos5l_buf_1_175 \$2299 VPWR VGND \$3019 sg13cmos5l_buf_1
* cell instance sg13cmos5l_buf_1_176 r0 *1 0,0
Xsg13cmos5l_buf_1_176 \$5125 VPWR VGND \$4579 sg13cmos5l_buf_1
* cell instance sg13cmos5l_buf_1_177 r0 *1 0,0
Xsg13cmos5l_buf_1_177 \$5340 VPWR VGND \$5125 sg13cmos5l_buf_1
* cell instance sg13cmos5l_buf_1_178 r0 *1 0,0
Xsg13cmos5l_buf_1_178 \$435 VPWR VGND \$1099 sg13cmos5l_buf_1
* cell instance sg13cmos5l_buf_1_179 r0 *1 0,0
Xsg13cmos5l_buf_1_179 \$2240 VPWR VGND \$52 sg13cmos5l_buf_1
* cell instance sg13cmos5l_buf_1_180 r0 *1 0,0
Xsg13cmos5l_buf_1_180 \$2253 VPWR VGND \$1879 sg13cmos5l_buf_1
* cell instance sg13cmos5l_buf_1_181 r0 *1 0,0
Xsg13cmos5l_buf_1_181 \$100 VPWR VGND \$119 sg13cmos5l_buf_1
* cell instance sg13cmos5l_buf_1_182 r0 *1 0,0
Xsg13cmos5l_buf_1_182 \$1099 VPWR VGND \$551 sg13cmos5l_buf_1
* cell instance sg13cmos5l_buf_1_183 r0 *1 0,0
Xsg13cmos5l_buf_1_183 \$5125 VPWR VGND \$3073 sg13cmos5l_buf_1
* cell instance sg13cmos5l_buf_1_184 r0 *1 0,0
Xsg13cmos5l_buf_1_184 \$1818 VPWR VGND \$2700 sg13cmos5l_buf_1
* cell instance sg13cmos5l_buf_1_185 r0 *1 0,0
Xsg13cmos5l_buf_1_185 \$2401 VPWR VGND \$688 sg13cmos5l_buf_1
* cell instance sg13cmos5l_buf_1_186 r0 *1 0,0
Xsg13cmos5l_buf_1_186 \$2247 VPWR VGND \$833 sg13cmos5l_buf_1
* cell instance sg13cmos5l_buf_1_187 r0 *1 0,0
Xsg13cmos5l_buf_1_187 \$3950 VPWR VGND \$3641 sg13cmos5l_buf_1
* cell instance sg13cmos5l_buf_1_188 r0 *1 0,0
Xsg13cmos5l_buf_1_188 \$1453 VPWR VGND \$116 sg13cmos5l_buf_1
* cell instance sg13cmos5l_buf_1_189 r0 *1 0,0
Xsg13cmos5l_buf_1_189 \$833 VPWR VGND \$38 sg13cmos5l_buf_1
* cell instance sg13cmos5l_buf_1_190 r0 *1 0,0
Xsg13cmos5l_buf_1_190 \$2253 VPWR VGND \$648 sg13cmos5l_buf_1
* cell instance sg13cmos5l_buf_1_191 r0 *1 0,0
Xsg13cmos5l_buf_1_191 \$171 VPWR VGND \$674 sg13cmos5l_buf_1
* cell instance sg13cmos5l_buf_1_192 r0 *1 0,0
Xsg13cmos5l_buf_1_192 \$1913 VPWR VGND \$118 sg13cmos5l_buf_1
* cell instance sg13cmos5l_buf_1_193 r0 *1 0,0
Xsg13cmos5l_buf_1_193 \$3113 VPWR VGND \$2217 sg13cmos5l_buf_1
* cell instance sg13cmos5l_buf_1_194 r0 *1 0,0
Xsg13cmos5l_buf_1_194 \$2554 VPWR VGND \$252 sg13cmos5l_buf_1
* cell instance sg13cmos5l_buf_1_195 r0 *1 0,0
Xsg13cmos5l_buf_1_195 \$2802 VPWR VGND \$2977 sg13cmos5l_buf_1
* cell instance sg13cmos5l_buf_1_196 r0 *1 0,0
Xsg13cmos5l_buf_1_196 \$174 VPWR VGND \$37 sg13cmos5l_buf_1
* cell instance sg13cmos5l_buf_1_197 r0 *1 0,0
Xsg13cmos5l_buf_1_197 \$2707 VPWR VGND \$120 sg13cmos5l_buf_1
* cell instance sg13cmos5l_buf_1_198 r0 *1 0,0
Xsg13cmos5l_buf_1_198 \$5035 VPWR VGND \$4968 sg13cmos5l_buf_1
* cell instance sg13cmos5l_buf_1_199 r0 *1 0,0
Xsg13cmos5l_buf_1_199 \$1086 VPWR VGND \$936 sg13cmos5l_buf_1
* cell instance sg13cmos5l_buf_1_200 r0 *1 0,0
Xsg13cmos5l_buf_1_200 \$4554 VPWR VGND \$5646 sg13cmos5l_buf_1
* cell instance sg13cmos5l_buf_1_201 r0 *1 0,0
Xsg13cmos5l_buf_1_201 \$2750 VPWR VGND \$1353 sg13cmos5l_buf_1
* cell instance sg13cmos5l_buf_1_202 r0 *1 0,0
Xsg13cmos5l_buf_1_202 \$1352 VPWR VGND \$681 sg13cmos5l_buf_1
* cell instance sg13cmos5l_buf_1_203 r0 *1 0,0
Xsg13cmos5l_buf_1_203 \$5889 VPWR VGND \$2750 sg13cmos5l_buf_1
* cell instance sg13cmos5l_buf_1_204 r0 *1 0,0
Xsg13cmos5l_buf_1_204 \$3958 VPWR VGND \$3973 sg13cmos5l_buf_1
* cell instance sg13cmos5l_buf_1_205 r0 *1 0,0
Xsg13cmos5l_buf_1_205 \$2886 VPWR VGND \$2146 sg13cmos5l_buf_1
* cell instance sg13cmos5l_buf_1_206 r0 *1 0,0
Xsg13cmos5l_buf_1_206 \$2750 VPWR VGND \$2733 sg13cmos5l_buf_1
* cell instance sg13cmos5l_buf_1_207 r0 *1 0,0
Xsg13cmos5l_buf_1_207 \$3062 VPWR VGND \$2153 sg13cmos5l_buf_1
* cell instance sg13cmos5l_buf_1_208 r0 *1 0,0
Xsg13cmos5l_buf_1_208 \$4423 VPWR VGND \$4424 sg13cmos5l_buf_1
* cell instance sg13cmos5l_buf_1_209 r0 *1 0,0
Xsg13cmos5l_buf_1_209 \$2219 VPWR VGND \$1929 sg13cmos5l_buf_1
* cell instance sg13cmos5l_buf_1_210 r0 *1 0,0
Xsg13cmos5l_buf_1_210 \$2076 VPWR VGND \$2434 sg13cmos5l_buf_1
* cell instance sg13cmos5l_buf_1_211 r0 *1 0,0
Xsg13cmos5l_buf_1_211 \$1353 VPWR VGND \$318 sg13cmos5l_buf_1
* cell instance sg13cmos5l_buf_1_212 r0 *1 0,0
Xsg13cmos5l_buf_1_212 \$2050 VPWR VGND \$2219 sg13cmos5l_buf_1
* cell instance sg13cmos5l_buf_1_213 r0 *1 0,0
Xsg13cmos5l_buf_1_213 \$2750 VPWR VGND \$3807 sg13cmos5l_buf_1
* cell instance sg13cmos5l_buf_1_214 r0 *1 0,0
Xsg13cmos5l_buf_1_214 \$446 VPWR VGND \$1073 sg13cmos5l_buf_1
* cell instance sg13cmos5l_buf_1_215 r0 *1 0,0
Xsg13cmos5l_buf_1_215 \$2219 VPWR VGND \$2754 sg13cmos5l_buf_1
* cell instance sg13cmos5l_buf_1_216 r0 *1 0,0
Xsg13cmos5l_buf_1_216 \$2047 VPWR VGND \$996 sg13cmos5l_buf_1
* cell instance sg13cmos5l_buf_1_217 r0 *1 0,0
Xsg13cmos5l_buf_1_217 \$2156 VPWR VGND \$973 sg13cmos5l_buf_1
* cell instance sg13cmos5l_buf_1_218 r0 *1 0,0
Xsg13cmos5l_buf_1_218 \$1272 VPWR VGND \$3976 sg13cmos5l_buf_1
* cell instance sg13cmos5l_buf_1_219 r0 *1 0,0
Xsg13cmos5l_buf_1_219 \$3052 VPWR VGND \$2156 sg13cmos5l_buf_1
* cell instance sg13cmos5l_buf_1_220 r0 *1 0,0
Xsg13cmos5l_buf_1_220 \$2159 VPWR VGND \$1424 sg13cmos5l_buf_1
* cell instance sg13cmos5l_buf_1_221 r0 *1 0,0
Xsg13cmos5l_buf_1_221 \$1583 VPWR VGND \$1584 sg13cmos5l_buf_1
* cell instance sg13cmos5l_buf_1_222 r0 *1 0,0
Xsg13cmos5l_buf_1_222 \$972 VPWR VGND \$1165 sg13cmos5l_buf_1
* cell instance sg13cmos5l_buf_1_223 r0 *1 0,0
Xsg13cmos5l_buf_1_223 \$2585 VPWR VGND \$1361 sg13cmos5l_buf_1
* cell instance sg13cmos5l_buf_1_224 r0 *1 0,0
Xsg13cmos5l_buf_1_224 \$1376 VPWR VGND \$64 sg13cmos5l_buf_1
* cell instance sg13cmos5l_buf_1_225 r0 *1 0,0
Xsg13cmos5l_buf_1_225 \$4809 VPWR VGND \$4425 sg13cmos5l_buf_1
* cell instance sg13cmos5l_buf_1_226 r0 *1 0,0
Xsg13cmos5l_buf_1_226 \$1818 VPWR VGND \$55 sg13cmos5l_buf_1
* cell instance sg13cmos5l_buf_1_227 r0 *1 0,0
Xsg13cmos5l_buf_1_227 \$4812 VPWR VGND \$4618 sg13cmos5l_buf_1
* cell instance sg13cmos5l_buf_1_228 r0 *1 0,0
Xsg13cmos5l_buf_1_228 \$691 VPWR VGND \$564 sg13cmos5l_buf_1
* cell instance sg13cmos5l_buf_1_229 r0 *1 0,0
Xsg13cmos5l_buf_1_229 \$4441 VPWR VGND \$4004 sg13cmos5l_buf_1
* cell instance sg13cmos5l_buf_1_230 r0 *1 0,0
Xsg13cmos5l_buf_1_230 \$456 VPWR VGND \$454 sg13cmos5l_buf_1
* cell instance sg13cmos5l_buf_1_231 r0 *1 0,0
Xsg13cmos5l_buf_1_231 \$2156 VPWR VGND \$850 sg13cmos5l_buf_1
* cell instance sg13cmos5l_buf_1_232 r0 *1 0,0
Xsg13cmos5l_buf_1_232 \$19099 VPWR VGND \$20216 sg13cmos5l_buf_1
* cell instance sg13cmos5l_buf_1_233 r0 *1 0,0
Xsg13cmos5l_buf_1_233 \$5889 VPWR VGND \$19099 sg13cmos5l_buf_1
* cell instance sg13cmos5l_buf_1_234 r0 *1 0,0
Xsg13cmos5l_buf_1_234 \$4940 VPWR VGND \$4127 sg13cmos5l_buf_1
* cell instance sg13cmos5l_buf_1_235 r0 *1 0,0
Xsg13cmos5l_buf_1_235 \$2892 VPWR VGND \$4129 sg13cmos5l_buf_1
* cell instance sg13cmos5l_buf_1_236 r0 *1 0,0
Xsg13cmos5l_buf_1_236 \$3818 VPWR VGND \$4287 sg13cmos5l_buf_1
* cell instance sg13cmos5l_buf_1_237 r0 *1 0,0
Xsg13cmos5l_buf_1_237 \$20006 VPWR VGND \$5889 sg13cmos5l_buf_1
* cell instance sg13cmos5l_buf_1_238 r0 *1 0,0
Xsg13cmos5l_buf_1_238 \$984 VPWR VGND \$988 sg13cmos5l_buf_1
* cell instance sg13cmos5l_buf_1_239 r0 *1 0,0
Xsg13cmos5l_buf_1_239 \$4287 VPWR VGND \$4288 sg13cmos5l_buf_1
* cell instance sg13cmos5l_buf_1_240 r0 *1 0,0
Xsg13cmos5l_buf_1_240 \$4451 VPWR VGND \$5039 sg13cmos5l_buf_1
* cell instance sg13cmos5l_buf_1_241 r0 *1 0,0
Xsg13cmos5l_buf_1_241 \$4289 VPWR VGND \$4304 sg13cmos5l_buf_1
* cell instance sg13cmos5l_buf_1_242 r0 *1 0,0
Xsg13cmos5l_buf_1_242 \$3522 VPWR VGND \$3715 sg13cmos5l_buf_1
* cell instance sg13cmos5l_buf_1_243 r0 *1 0,0
Xsg13cmos5l_buf_1_243 \$199 VPWR VGND \$340 sg13cmos5l_buf_1
* cell instance sg13cmos5l_buf_1_244 r0 *1 0,0
Xsg13cmos5l_buf_1_244 \$2299 VPWR VGND \$2150 sg13cmos5l_buf_1
* cell instance sg13cmos5l_buf_1_245 r0 *1 0,0
Xsg13cmos5l_buf_1_245 \$3653 VPWR VGND \$2985 sg13cmos5l_buf_1
* cell instance sg13cmos5l_buf_1_246 r0 *1 0,0
Xsg13cmos5l_buf_1_246 \$4287 VPWR VGND \$4139 sg13cmos5l_buf_1
* cell instance sg13cmos5l_buf_1_247 r0 *1 0,0
Xsg13cmos5l_buf_1_247 \$4914 VPWR VGND \$3990 sg13cmos5l_buf_1
* cell instance sg13cmos5l_buf_1_248 r0 *1 0,0
Xsg13cmos5l_buf_1_248 \$4129 VPWR VGND \$4815 sg13cmos5l_buf_1
* cell instance sg13cmos5l_buf_1_249 r0 *1 0,0
Xsg13cmos5l_buf_1_249 \$4424 VPWR VGND \$4466 sg13cmos5l_buf_1
* cell instance sg13cmos5l_buf_1_250 r0 *1 0,0
Xsg13cmos5l_buf_1_250 \$4425 VPWR VGND \$4685 sg13cmos5l_buf_1
* cell instance sg13cmos5l_buf_1_251 r0 *1 0,0
Xsg13cmos5l_buf_1_251 \$4111 VPWR VGND \$3653 sg13cmos5l_buf_1
* cell instance sg13cmos5l_buf_1_252 r0 *1 0,0
Xsg13cmos5l_buf_1_252 \$1249 VPWR VGND \$3502 sg13cmos5l_buf_1
* cell instance sg13cmos5l_buf_1_253 r0 *1 0,0
Xsg13cmos5l_buf_1_253 \$3522 VPWR VGND \$2654 sg13cmos5l_buf_1
* cell instance sg13cmos5l_buf_1_254 r0 *1 0,0
Xsg13cmos5l_buf_1_254 \$3653 VPWR VGND \$3661 sg13cmos5l_buf_1
* cell instance sg13cmos5l_buf_1_255 r0 *1 0,0
Xsg13cmos5l_buf_1_255 \$5889 VPWR VGND \$1249 sg13cmos5l_buf_1
* cell instance sg13cmos5l_buf_1_256 r0 *1 0,0
Xsg13cmos5l_buf_1_256 \$348 VPWR VGND \$201 sg13cmos5l_buf_1
* cell instance sg13cmos5l_buf_1_257 r0 *1 0,0
Xsg13cmos5l_buf_1_257 \$4291 VPWR VGND \$3496 sg13cmos5l_buf_1
* cell instance sg13cmos5l_buf_1_258 r0 *1 0,0
Xsg13cmos5l_buf_1_258 \$1113 VPWR VGND \$140 sg13cmos5l_buf_1
* cell instance sg13cmos5l_buf_1_259 r0 *1 0,0
Xsg13cmos5l_buf_1_259 \$3834 VPWR VGND \$3835 sg13cmos5l_buf_1
* cell instance sg13cmos5l_buf_1_260 r0 *1 0,0
Xsg13cmos5l_buf_1_260 \$1375 VPWR VGND \$1244 sg13cmos5l_buf_1
* cell instance sg13cmos5l_buf_1_261 r0 *1 0,0
Xsg13cmos5l_buf_1_261 \$1496 VPWR VGND \$1494 sg13cmos5l_buf_1
* cell instance sg13cmos5l_buf_1_262 r0 *1 0,0
Xsg13cmos5l_buf_1_262 \$1249 VPWR VGND \$206 sg13cmos5l_buf_1
* cell instance sg13cmos5l_buf_1_263 r0 *1 0,0
Xsg13cmos5l_buf_1_263 \$723 VPWR VGND \$1496 sg13cmos5l_buf_1
* cell instance sg13cmos5l_buf_1_264 r0 *1 0,0
Xsg13cmos5l_buf_1_264 \$2217 VPWR VGND \$3834 sg13cmos5l_buf_1
* cell instance sg13cmos5l_buf_1_265 r0 *1 0,0
Xsg13cmos5l_buf_1_265 \$584 VPWR VGND \$1247 sg13cmos5l_buf_1
* cell instance sg13cmos5l_buf_1_266 r0 *1 0,0
Xsg13cmos5l_buf_1_266 \$2625 VPWR VGND \$2606 sg13cmos5l_buf_1
* cell instance sg13cmos5l_buf_1_267 r0 *1 0,0
Xsg13cmos5l_buf_1_267 \$4454 VPWR VGND \$2625 sg13cmos5l_buf_1
* cell instance sg13cmos5l_buf_1_268 r0 *1 0,0
Xsg13cmos5l_buf_1_268 \$1256 VPWR VGND \$2073 sg13cmos5l_buf_1
* cell instance sg13cmos5l_buf_1_269 r0 *1 0,0
Xsg13cmos5l_buf_1_269 \$3496 VPWR VGND \$6039 sg13cmos5l_buf_1
* cell instance sg13cmos5l_buf_1_270 r0 *1 0,0
Xsg13cmos5l_buf_1_270 \$19099 VPWR VGND \$12998 sg13cmos5l_buf_1
* cell instance sg13cmos5l_buf_1_271 r0 *1 0,0
Xsg13cmos5l_buf_1_271 \$1605 VPWR VGND \$1477 sg13cmos5l_buf_1
* cell instance sg13cmos5l_buf_1_272 r0 *1 0,0
Xsg13cmos5l_buf_1_272 \$4127 VPWR VGND \$4060 sg13cmos5l_buf_1
* cell instance sg13cmos5l_buf_1_273 r0 *1 0,0
Xsg13cmos5l_buf_1_273 \$3990 VPWR VGND \$4147 sg13cmos5l_buf_1
* cell instance sg13cmos5l_buf_1_274 r0 *1 0,0
Xsg13cmos5l_buf_1_274 \$14498 VPWR VGND \$3235 sg13cmos5l_buf_1
* cell instance sg13cmos5l_buf_1_275 r0 *1 0,0
Xsg13cmos5l_buf_1_275 \$5035 VPWR VGND \$16322 sg13cmos5l_buf_1
* cell instance sg13cmos5l_buf_1_276 r0 *1 0,0
Xsg13cmos5l_buf_1_276 \$20002 VPWR VGND \$5035 sg13cmos5l_buf_1
* cell instance sg13cmos5l_buf_1_277 r0 *1 0,0
Xsg13cmos5l_buf_1_277 \$1285 VPWR VGND \$1605 sg13cmos5l_buf_1
* cell instance sg13cmos5l_buf_1_278 r0 *1 0,0
Xsg13cmos5l_buf_1_278 \$7190 VPWR VGND \$5891 sg13cmos5l_buf_1
* cell instance sg13cmos5l_buf_1_279 r0 *1 0,0
Xsg13cmos5l_buf_1_279 \$5840 VPWR VGND \$9009 sg13cmos5l_buf_1
* cell instance sg13cmos5l_buf_1_280 r0 *1 0,0
Xsg13cmos5l_buf_1_280 \$16322 VPWR VGND \$14831 sg13cmos5l_buf_1
* cell instance sg13cmos5l_buf_1_281 r0 *1 0,0
Xsg13cmos5l_buf_1_281 \$4003 VPWR VGND \$4011 sg13cmos5l_buf_1
* cell instance sg13cmos5l_buf_1_282 r0 *1 0,0
Xsg13cmos5l_buf_1_282 \$4421 VPWR VGND \$16365 sg13cmos5l_buf_1
* cell instance sg13cmos5l_buf_1_283 r0 *1 0,0
Xsg13cmos5l_buf_1_283 \$6043 VPWR VGND \$5470 sg13cmos5l_buf_1
* cell instance sg13cmos5l_buf_1_284 r0 *1 0,0
Xsg13cmos5l_buf_1_284 \$2308 VPWR VGND \$2180 sg13cmos5l_buf_1
* cell instance sg13cmos5l_buf_1_285 r0 *1 0,0
Xsg13cmos5l_buf_1_285 \$4011 VPWR VGND \$4007 sg13cmos5l_buf_1
* cell instance sg13cmos5l_buf_1_286 r0 *1 0,0
Xsg13cmos5l_buf_1_286 \$6041 VPWR VGND \$9183 sg13cmos5l_buf_1
* cell instance sg13cmos5l_buf_1_287 r0 *1 0,0
Xsg13cmos5l_buf_1_287 \$1240 VPWR VGND \$1469 sg13cmos5l_buf_1
* cell instance sg13cmos5l_buf_1_288 r0 *1 0,0
Xsg13cmos5l_buf_1_288 \$3653 VPWR VGND \$6043 sg13cmos5l_buf_1
* cell instance sg13cmos5l_buf_1_289 r0 *1 0,0
Xsg13cmos5l_buf_1_289 \$4009 VPWR VGND \$7957 sg13cmos5l_buf_1
* cell instance sg13cmos5l_buf_1_290 r0 *1 0,0
Xsg13cmos5l_buf_1_290 \$6348 VPWR VGND \$12050 sg13cmos5l_buf_1
* cell instance sg13cmos5l_buf_1_291 r0 *1 0,0
Xsg13cmos5l_buf_1_291 \$2078 VPWR VGND \$2308 sg13cmos5l_buf_1
* cell instance sg13cmos5l_buf_1_292 r0 *1 0,0
Xsg13cmos5l_buf_1_292 \$62 VPWR VGND \$3522 sg13cmos5l_buf_1
* cell instance sg13cmos5l_buf_1_293 r0 *1 0,0
Xsg13cmos5l_buf_1_293 \$19970 VPWR VGND \$15717 sg13cmos5l_buf_1
* cell instance sg13cmos5l_buf_1_294 r0 *1 0,0
Xsg13cmos5l_buf_1_294 \$1838 VPWR VGND \$1471 sg13cmos5l_buf_1
* cell instance sg13cmos5l_buf_1_295 r0 *1 0,0
Xsg13cmos5l_buf_1_295 \$4145 VPWR VGND \$4009 sg13cmos5l_buf_1
* cell instance sg13cmos5l_buf_1_296 r0 *1 0,0
Xsg13cmos5l_buf_1_296 \$4628 VPWR VGND \$5657 sg13cmos5l_buf_1
* cell instance sg13cmos5l_buf_1_297 r0 *1 0,0
Xsg13cmos5l_buf_1_297 \$6349 VPWR VGND \$13476 sg13cmos5l_buf_1
* cell instance sg13cmos5l_buf_1_298 r0 *1 0,0
Xsg13cmos5l_buf_1_298 \$3522 VPWR VGND \$7190 sg13cmos5l_buf_1
* cell instance sg13cmos5l_buf_1_299 r0 *1 0,0
Xsg13cmos5l_buf_1_299 \$5889 VPWR VGND \$7868 sg13cmos5l_buf_1
* cell instance sg13cmos5l_buf_1_300 r0 *1 0,0
Xsg13cmos5l_buf_1_300 \$7958 VPWR VGND \$7988 sg13cmos5l_buf_1
* cell instance sg13cmos5l_buf_1_301 r0 *1 0,0
Xsg13cmos5l_buf_1_301 \$1383 VPWR VGND \$233 sg13cmos5l_buf_1
* cell instance sg13cmos5l_buf_1_302 r0 *1 0,0
Xsg13cmos5l_buf_1_302 \$4815 VPWR VGND \$3868 sg13cmos5l_buf_1
* cell instance sg13cmos5l_buf_1_303 r0 *1 0,0
Xsg13cmos5l_buf_1_303 \$8225 VPWR VGND \$7958 sg13cmos5l_buf_1
* cell instance sg13cmos5l_buf_1_304 r0 *1 0,0
Xsg13cmos5l_buf_1_304 \$454 VPWR VGND \$740 sg13cmos5l_buf_1
* cell instance sg13cmos5l_buf_1_305 r0 *1 0,0
Xsg13cmos5l_buf_1_305 \$3548 VPWR VGND \$2618 sg13cmos5l_buf_1
* cell instance sg13cmos5l_buf_1_306 r0 *1 0,0
Xsg13cmos5l_buf_1_306 \$15213 VPWR VGND \$12418 sg13cmos5l_buf_1
* cell instance sg13cmos5l_buf_1_307 r0 *1 0,0
Xsg13cmos5l_buf_1_307 \$4158 VPWR VGND \$8225 sg13cmos5l_buf_1
* cell instance sg13cmos5l_buf_1_308 r0 *1 0,0
Xsg13cmos5l_buf_1_308 \$3834 VPWR VGND \$5428 sg13cmos5l_buf_1
* cell instance sg13cmos5l_buf_1_309 r0 *1 0,0
Xsg13cmos5l_buf_1_309 \$1249 VPWR VGND \$1383 sg13cmos5l_buf_1
* cell instance sg13cmos5l_buf_1_310 r0 *1 0,0
Xsg13cmos5l_buf_1_310 \$7868 VPWR VGND \$9244 sg13cmos5l_buf_1
* cell instance sg13cmos5l_buf_1_311 r0 *1 0,0
Xsg13cmos5l_buf_1_311 \$4304 VPWR VGND \$8781 sg13cmos5l_buf_1
* cell instance sg13cmos5l_buf_1_312 r0 *1 0,0
Xsg13cmos5l_buf_1_312 \$7190 VPWR VGND \$6590 sg13cmos5l_buf_1
* cell instance sg13cmos5l_buf_1_313 r0 *1 0,0
Xsg13cmos5l_buf_1_313 \$2076 VPWR VGND \$869 sg13cmos5l_buf_1
* cell instance sg13cmos5l_buf_1_314 r0 *1 0,0
Xsg13cmos5l_buf_1_314 \$1383 VPWR VGND \$1744 sg13cmos5l_buf_1
* cell instance sg13cmos5l_buf_1_315 r0 *1 0,0
Xsg13cmos5l_buf_1_315 \$16365 VPWR VGND \$14614 sg13cmos5l_buf_1
* cell instance sg13cmos5l_buf_1_316 r0 *1 0,0
Xsg13cmos5l_buf_1_316 \$3502 VPWR VGND \$2792 sg13cmos5l_buf_1
* cell instance sg13cmos5l_buf_1_317 r0 *1 0,0
Xsg13cmos5l_buf_1_317 \$1376 VPWR VGND \$2818 sg13cmos5l_buf_1
* cell instance sg13cmos5l_buf_1_318 r0 *1 0,0
Xsg13cmos5l_buf_1_318 \$564 VPWR VGND \$901 sg13cmos5l_buf_1
* cell instance sg13cmos5l_buf_1_319 r0 *1 0,0
Xsg13cmos5l_buf_1_319 \$7190 VPWR VGND \$5230 sg13cmos5l_buf_1
* cell instance sg13cmos5l_buf_1_320 r0 *1 0,0
Xsg13cmos5l_buf_1_320 \$6043 VPWR VGND \$5666 sg13cmos5l_buf_1
* cell instance sg13cmos5l_buf_1_321 r0 *1 0,0
Xsg13cmos5l_buf_1_321 \$3834 VPWR VGND \$3172 sg13cmos5l_buf_1
* cell instance sg13cmos5l_buf_1_322 r0 *1 0,0
Xsg13cmos5l_buf_1_322 \$3534 VPWR VGND \$2655 sg13cmos5l_buf_1
* cell instance sg13cmos5l_buf_1_323 r0 *1 0,0
Xsg13cmos5l_buf_1_323 \$7868 VPWR VGND \$6431 sg13cmos5l_buf_1
* cell instance sg13cmos5l_buf_1_324 r0 *1 0,0
Xsg13cmos5l_buf_1_324 \$5428 VPWR VGND \$6308 sg13cmos5l_buf_1
* cell instance sg13cmos5l_buf_1_325 r0 *1 0,0
Xsg13cmos5l_buf_1_325 \$6043 VPWR VGND \$7354 sg13cmos5l_buf_1
* cell instance sg13cmos5l_buf_1_326 r0 *1 0,0
Xsg13cmos5l_buf_1_326 \$3522 VPWR VGND \$3536 sg13cmos5l_buf_1
* cell instance sg13cmos5l_buf_1_327 r0 *1 0,0
Xsg13cmos5l_buf_1_327 \$5039 VPWR VGND \$4828 sg13cmos5l_buf_1
* cell instance sg13cmos5l_buf_1_328 r0 *1 0,0
Xsg13cmos5l_buf_1_328 \$4304 VPWR VGND \$4168 sg13cmos5l_buf_1
* cell instance sg13cmos5l_buf_1_329 r0 *1 0,0
Xsg13cmos5l_buf_1_329 \$3172 VPWR VGND \$2938 sg13cmos5l_buf_1
* cell instance sg13cmos5l_buf_1_330 r0 *1 0,0
Xsg13cmos5l_buf_1_330 \$3653 VPWR VGND \$3534 sg13cmos5l_buf_1
* cell instance sg13cmos5l_buf_1_331 r0 *1 0,0
Xsg13cmos5l_buf_1_331 \$5840 VPWR VGND \$9789 sg13cmos5l_buf_1
* cell instance sg13cmos5l_buf_1_332 r0 *1 0,0
Xsg13cmos5l_buf_1_332 \$3172 VPWR VGND \$4306 sg13cmos5l_buf_1
* cell instance sg13cmos5l_buf_1_333 r0 *1 0,0
Xsg13cmos5l_buf_1_333 \$19099 VPWR VGND \$15213 sg13cmos5l_buf_1
* cell instance sg13cmos5l_buf_1_334 r0 *1 0,0
Xsg13cmos5l_buf_1_334 \$3536 VPWR VGND \$2311 sg13cmos5l_buf_1
* cell instance sg13cmos5l_buf_1_335 r0 *1 0,0
Xsg13cmos5l_buf_1_335 \$12050 VPWR VGND \$11903 sg13cmos5l_buf_1
* cell instance sg13cmos5l_buf_1_336 r0 *1 0,0
Xsg13cmos5l_buf_1_336 \$9183 VPWR VGND \$9026 sg13cmos5l_buf_1
* cell instance sg13cmos5l_buf_1_337 r0 *1 0,0
Xsg13cmos5l_buf_1_337 \$4828 VPWR VGND \$6518 sg13cmos5l_buf_1
* cell instance sg13cmos5l_buf_1_338 r0 *1 0,0
Xsg13cmos5l_buf_1_338 \$1272 VPWR VGND \$3751 sg13cmos5l_buf_1
* cell instance sg13cmos5l_buf_1_339 r0 *1 0,0
Xsg13cmos5l_buf_1_339 \$13476 VPWR VGND \$13003 sg13cmos5l_buf_1
* cell instance sg13cmos5l_buf_1_340 r0 *1 0,0
Xsg13cmos5l_buf_1_340 \$2311 VPWR VGND \$3354 sg13cmos5l_buf_1
* cell instance sg13cmos5l_buf_1_341 r0 *1 0,0
Xsg13cmos5l_buf_1_341 \$7957 VPWR VGND \$6523 sg13cmos5l_buf_1
* cell instance sg13cmos5l_buf_1_342 r0 *1 0,0
Xsg13cmos5l_buf_1_342 \$8225 VPWR VGND \$8202 sg13cmos5l_buf_1
* cell instance sg13cmos5l_buf_1_343 r0 *1 0,0
Xsg13cmos5l_buf_1_343 \$2311 VPWR VGND \$2471 sg13cmos5l_buf_1
* cell instance sg13cmos5l_buf_1_344 r0 *1 0,0
Xsg13cmos5l_buf_1_344 \$740 VPWR VGND \$1020 sg13cmos5l_buf_1
* cell instance sg13cmos5l_buf_1_345 r0 *1 0,0
Xsg13cmos5l_buf_1_345 \$2612 VPWR VGND \$3865 sg13cmos5l_buf_1
* cell instance sg13cmos5l_buf_1_346 r0 *1 0,0
Xsg13cmos5l_buf_1_346 \$1367 VPWR VGND \$1356 sg13cmos5l_buf_1
* cell instance sg13cmos5l_buf_1_347 r0 *1 0,0
Xsg13cmos5l_buf_1_347 \$5657 VPWR VGND \$5868 sg13cmos5l_buf_1
* cell instance sg13cmos5l_buf_1_348 r0 *1 0,0
Xsg13cmos5l_buf_1_348 \$7190 VPWR VGND \$7200 sg13cmos5l_buf_1
* cell instance sg13cmos5l_buf_1_349 r0 *1 0,0
Xsg13cmos5l_buf_1_349 \$7868 VPWR VGND \$9253 sg13cmos5l_buf_1
* cell instance sg13cmos5l_buf_1_350 r0 *1 0,0
Xsg13cmos5l_buf_1_350 \$1383 VPWR VGND \$2202 sg13cmos5l_buf_1
* cell instance sg13cmos5l_buf_1_351 r0 *1 0,0
Xsg13cmos5l_buf_1_351 \$3534 VPWR VGND \$2628 sg13cmos5l_buf_1
* cell instance sg13cmos5l_buf_1_352 r0 *1 0,0
Xsg13cmos5l_buf_1_352 \$2199 VPWR VGND \$9622 sg13cmos5l_buf_1
* cell instance sg13cmos5l_buf_1_353 r0 *1 0,0
Xsg13cmos5l_buf_1_353 \$2612 VPWR VGND \$4026 sg13cmos5l_buf_1
* cell instance sg13cmos5l_buf_1_354 r0 *1 0,0
Xsg13cmos5l_buf_1_354 \$2618 VPWR VGND \$2482 sg13cmos5l_buf_1
* cell instance sg13cmos5l_buf_1_355 r0 *1 0,0
Xsg13cmos5l_buf_1_355 \$8202 VPWR VGND \$7997 sg13cmos5l_buf_1
* cell instance sg13cmos5l_buf_1_356 r0 *1 0,0
Xsg13cmos5l_buf_1_356 \$1383 VPWR VGND \$632 sg13cmos5l_buf_1
* cell instance sg13cmos5l_buf_1_357 r0 *1 0,0
Xsg13cmos5l_buf_1_357 \$12418 VPWR VGND \$13478 sg13cmos5l_buf_1
* cell instance sg13cmos5l_buf_1_358 r0 *1 0,0
Xsg13cmos5l_buf_1_358 \$2199 VPWR VGND \$5337 sg13cmos5l_buf_1
* cell instance sg13cmos5l_buf_1_359 r0 *1 0,0
Xsg13cmos5l_buf_1_359 \$5666 VPWR VGND \$6617 sg13cmos5l_buf_1
* cell instance sg13cmos5l_buf_1_360 r0 *1 0,0
Xsg13cmos5l_buf_1_360 \$1977 VPWR VGND \$2361 sg13cmos5l_buf_1
* cell instance sg13cmos5l_buf_4_0 r0 *1 0,0
Xsg13cmos5l_buf_4_0 \$7217 VPWR VGND \$6408 sg13cmos5l_buf_4
* cell instance sg13cmos5l_buf_4_1 r0 *1 0,0
Xsg13cmos5l_buf_4_1 \$7722 VPWR VGND \$6638 sg13cmos5l_buf_4
* cell instance sg13cmos5l_buf_4_2 r0 *1 0,0
Xsg13cmos5l_buf_4_2 \$7220 VPWR VGND \$6574 sg13cmos5l_buf_4
* cell instance sg13cmos5l_buf_4_3 r0 *1 0,0
Xsg13cmos5l_buf_4_3 \$7562 VPWR VGND \$6543 sg13cmos5l_buf_4
* cell instance sg13cmos5l_buf_4_4 r0 *1 0,0
Xsg13cmos5l_buf_4_4 \$7222 VPWR VGND \$6575 sg13cmos5l_buf_4
* cell instance sg13cmos5l_buf_4_5 r0 *1 0,0
Xsg13cmos5l_buf_4_5 \$7563 VPWR VGND \$6544 sg13cmos5l_buf_4
* cell instance sg13cmos5l_buf_4_6 r0 *1 0,0
Xsg13cmos5l_buf_4_6 \$11902 VPWR VGND \$6501 sg13cmos5l_buf_4
* cell instance sg13cmos5l_buf_4_7 r0 *1 0,0
Xsg13cmos5l_buf_4_7 \$6477 VPWR VGND \$6116 sg13cmos5l_buf_4
* cell instance sg13cmos5l_buf_4_8 r0 *1 0,0
Xsg13cmos5l_buf_4_8 \$6409 VPWR VGND \$5955 sg13cmos5l_buf_4
* cell instance sg13cmos5l_buf_4_9 r0 *1 0,0
Xsg13cmos5l_buf_4_9 \$5579 VPWR VGND \$5348 sg13cmos5l_buf_4
* cell instance sg13cmos5l_buf_4_10 r0 *1 0,0
Xsg13cmos5l_buf_4_10 \$5581 VPWR VGND \$5582 sg13cmos5l_buf_4
* cell instance sg13cmos5l_buf_4_11 r0 *1 0,0
Xsg13cmos5l_buf_4_11 \$5959 VPWR VGND \$5957 sg13cmos5l_buf_4
* cell instance sg13cmos5l_buf_4_12 r0 *1 0,0
Xsg13cmos5l_buf_4_12 \$5355 VPWR VGND \$5353 sg13cmos5l_buf_4
* cell instance sg13cmos5l_buf_4_13 r0 *1 0,0
Xsg13cmos5l_buf_4_13 \$5164 VPWR VGND \$5162 sg13cmos5l_buf_4
* cell instance sg13cmos5l_buf_4_14 r0 *1 0,0
Xsg13cmos5l_buf_4_14 \$5363 VPWR VGND \$5361 sg13cmos5l_buf_4
* cell instance sg13cmos5l_buf_4_15 r0 *1 0,0
Xsg13cmos5l_buf_4_15 \$5597 VPWR VGND \$5595 sg13cmos5l_buf_4
* cell instance sg13cmos5l_buf_4_16 r0 *1 0,0
Xsg13cmos5l_buf_4_16 \$4977 VPWR VGND \$5171 sg13cmos5l_buf_4
* cell instance sg13cmos5l_buf_4_17 r0 *1 0,0
Xsg13cmos5l_buf_4_17 \$5810 VPWR VGND \$5808 sg13cmos5l_buf_4
* cell instance sg13cmos5l_buf_4_18 r0 *1 0,0
Xsg13cmos5l_buf_4_18 \$5814 VPWR VGND \$5998 sg13cmos5l_buf_4
* cell instance sg13cmos5l_buf_4_19 r0 *1 0,0
Xsg13cmos5l_buf_4_19 \$6004 VPWR VGND \$6002 sg13cmos5l_buf_4
* cell instance sg13cmos5l_buf_4_20 r0 *1 0,0
Xsg13cmos5l_buf_4_20 \$5703 VPWR VGND \$6230 sg13cmos5l_buf_4
* cell instance sg13cmos5l_buf_4_21 r0 *1 0,0
Xsg13cmos5l_buf_4_21 \$20210 VPWR VGND \$20208 sg13cmos5l_buf_4
* cell instance sg13cmos5l_buf_4_22 r0 *1 0,0
Xsg13cmos5l_buf_4_22 \$10928 VPWR VGND \$8501 sg13cmos5l_buf_4
* cell instance sg13cmos5l_buf_4_23 r0 *1 0,0
Xsg13cmos5l_buf_4_23 \$13474 VPWR VGND \$9240 sg13cmos5l_buf_4
* cell instance sg13cmos5l_buf_4_24 r0 *1 0,0
Xsg13cmos5l_buf_4_24 \$10930 VPWR VGND \$8500 sg13cmos5l_buf_4
* cell instance sg13cmos5l_buf_4_25 r0 *1 0,0
Xsg13cmos5l_buf_4_25 \$9626 VPWR VGND \$7867 sg13cmos5l_buf_4
* cell instance sg13cmos5l_buf_4_26 r0 *1 0,0
Xsg13cmos5l_buf_4_26 \$9368 VPWR VGND \$8797 sg13cmos5l_buf_4
* cell instance sg13cmos5l_buf_8_0 r0 *1 0,0
Xsg13cmos5l_buf_8_0 \$9218 VPWR VGND \$8232 sg13cmos5l_buf_8
* cell instance sg13cmos5l_buf_8_1 r0 *1 0,0
Xsg13cmos5l_buf_8_1 \$8232 VPWR VGND \$9286 sg13cmos5l_buf_8
* cell instance sg13cmos5l_buf_8_2 r0 *1 0,0
Xsg13cmos5l_buf_8_2 \$2229 VPWR VGND \$4354 sg13cmos5l_buf_8
* cell instance sg13cmos5l_buf_8_3 r0 *1 0,0
Xsg13cmos5l_buf_8_3 \$9218 VPWR VGND \$11895 sg13cmos5l_buf_8
* cell instance sg13cmos5l_buf_8_4 r0 *1 0,0
Xsg13cmos5l_buf_8_4 \$9218 VPWR VGND \$6363 sg13cmos5l_buf_8
* cell instance sg13cmos5l_buf_8_5 r0 *1 0,0
Xsg13cmos5l_buf_8_5 \$2378 VPWR VGND \$3007 sg13cmos5l_buf_8
* cell instance sg13cmos5l_buf_8_6 r0 *1 0,0
Xsg13cmos5l_buf_8_6 \$2229 VPWR VGND \$2378 sg13cmos5l_buf_8
* cell instance sg13cmos5l_buf_8_7 r0 *1 0,0
Xsg13cmos5l_buf_8_7 \$9218 VPWR VGND \$16331 sg13cmos5l_buf_8
* cell instance sg13cmos5l_buf_8_8 r0 *1 0,0
Xsg13cmos5l_buf_8_8 \$3937 VPWR VGND \$9218 sg13cmos5l_buf_8
* cell instance sg13cmos5l_buf_8_9 r0 *1 0,0
Xsg13cmos5l_buf_8_9 \$9218 VPWR VGND \$9158 sg13cmos5l_buf_8
* cell instance sg13cmos5l_buf_8_10 r0 *1 0,0
Xsg13cmos5l_buf_8_10 \$9218 VPWR VGND \$17336 sg13cmos5l_buf_8
* cell instance sg13cmos5l_buf_8_11 r0 *1 0,0
Xsg13cmos5l_buf_8_11 \$3937 VPWR VGND \$2229 sg13cmos5l_buf_8
* cell instance sg13cmos5l_buf_8_12 r0 *1 0,0
Xsg13cmos5l_buf_8_12 \$2229 VPWR VGND \$2844 sg13cmos5l_buf_8
* cell instance sg13cmos5l_buf_8_13 r0 *1 0,0
Xsg13cmos5l_buf_8_13 \$2229 VPWR VGND \$5109 sg13cmos5l_buf_8
* cell instance sg13cmos5l_buf_8_14 r0 *1 0,0
Xsg13cmos5l_buf_8_14 \$2229 VPWR VGND \$2866 sg13cmos5l_buf_8
* cell instance sg13cmos5l_buf_8_15 r0 *1 0,0
Xsg13cmos5l_buf_8_15 \$6070 VPWR VGND \$6185 sg13cmos5l_buf_8
* cell instance sg13cmos5l_buf_8_16 r0 *1 0,0
Xsg13cmos5l_buf_8_16 clk VPWR VGND \$20202 sg13cmos5l_buf_8
* cell instance sg13cmos5l_buf_8_17 r0 *1 0,0
Xsg13cmos5l_buf_8_17 \$20202 VPWR VGND \$5966 sg13cmos5l_buf_8
* cell instance sg13cmos5l_buf_8_18 r0 *1 0,0
Xsg13cmos5l_buf_8_18 \$5966 VPWR VGND \$6191 sg13cmos5l_buf_8
* cell instance sg13cmos5l_buf_8_19 r0 *1 0,0
Xsg13cmos5l_buf_8_19 \$6191 VPWR VGND \$6070 sg13cmos5l_buf_8
* cell instance sg13cmos5l_buf_8_20 r0 *1 0,0
Xsg13cmos5l_buf_8_20 \$5973 VPWR VGND \$3937 sg13cmos5l_buf_8
* cell instance sg13cmos5l_buf_8_21 r0 *1 0,0
Xsg13cmos5l_buf_8_21 clk VPWR VGND \$5973 sg13cmos5l_buf_8
* cell instance sg13cmos5l_buf_8_22 r0 *1 0,0
Xsg13cmos5l_buf_8_22 \$860 VPWR VGND \$1299 sg13cmos5l_buf_8
* cell instance sg13cmos5l_buf_8_23 r0 *1 0,0
Xsg13cmos5l_buf_8_23 \$6288 VPWR VGND \$4783 sg13cmos5l_buf_8
* cell instance sg13cmos5l_buf_8_24 r0 *1 0,0
Xsg13cmos5l_buf_8_24 \$860 VPWR VGND \$322 sg13cmos5l_buf_8
* cell instance sg13cmos5l_buf_8_25 r0 *1 0,0
Xsg13cmos5l_buf_8_25 \$860 VPWR VGND \$3813 sg13cmos5l_buf_8
* cell instance sg13cmos5l_buf_8_26 r0 *1 0,0
Xsg13cmos5l_buf_8_26 \$322 VPWR VGND \$717 sg13cmos5l_buf_8
* cell instance sg13cmos5l_buf_8_27 r0 *1 0,0
Xsg13cmos5l_buf_8_27 \$3937 VPWR VGND \$860 sg13cmos5l_buf_8
* cell instance sg13cmos5l_buf_8_28 r0 *1 0,0
Xsg13cmos5l_buf_8_28 \$3937 VPWR VGND \$6288 sg13cmos5l_buf_8
* cell instance sg13cmos5l_buf_8_29 r0 *1 0,0
Xsg13cmos5l_buf_8_29 \$6288 VPWR VGND \$8192 sg13cmos5l_buf_8
* cell instance sg13cmos5l_buf_8_30 r0 *1 0,0
Xsg13cmos5l_buf_8_30 \$6288 VPWR VGND \$9016 sg13cmos5l_buf_8
* cell instance sg13cmos5l_buf_8_31 r0 *1 0,0
Xsg13cmos5l_buf_8_31 \$6288 VPWR VGND \$18784 sg13cmos5l_buf_8
* cell instance sg13cmos5l_buf_8_32 r0 *1 0,0
Xsg13cmos5l_buf_8_32 \$860 VPWR VGND \$519 sg13cmos5l_buf_8
* cell instance sg13cmos5l_buf_8_33 r0 *1 0,0
Xsg13cmos5l_buf_8_33 \$860 VPWR VGND \$1980 sg13cmos5l_buf_8
* cell instance sg13cmos5l_buf_8_34 r0 *1 0,0
Xsg13cmos5l_buf_8_34 \$3518 VPWR VGND \$3691 sg13cmos5l_buf_8
* cell instance sg13cmos5l_buf_8_35 r0 *1 0,0
Xsg13cmos5l_buf_8_35 \$860 VPWR VGND \$3518 sg13cmos5l_buf_8
* cell instance sg13cmos5l_buf_8_36 r0 *1 0,0
Xsg13cmos5l_buf_8_36 \$6288 VPWR VGND \$11905 sg13cmos5l_buf_8
* cell instance sg13cmos5l_buf_8_37 r0 *1 0,0
Xsg13cmos5l_buf_8_37 \$6288 VPWR VGND \$7090 sg13cmos5l_buf_8
* cell instance sg13cmos5l_decap_4_0 r0 *1 0,0
Xsg13cmos5l_decap_4_0 VPWR VGND sg13cmos5l_decap_4
* cell instance sg13cmos5l_decap_4_1 r0 *1 0,0
Xsg13cmos5l_decap_4_1 VPWR VGND sg13cmos5l_decap_4
* cell instance sg13cmos5l_decap_4_2 r0 *1 0,0
Xsg13cmos5l_decap_4_2 VPWR VGND sg13cmos5l_decap_4
* cell instance sg13cmos5l_decap_4_3 r0 *1 0,0
Xsg13cmos5l_decap_4_3 VPWR VGND sg13cmos5l_decap_4
* cell instance sg13cmos5l_decap_4_4 r0 *1 0,0
Xsg13cmos5l_decap_4_4 VPWR VGND sg13cmos5l_decap_4
* cell instance sg13cmos5l_decap_4_5 r0 *1 0,0
Xsg13cmos5l_decap_4_5 VPWR VGND sg13cmos5l_decap_4
* cell instance sg13cmos5l_decap_4_6 r0 *1 0,0
Xsg13cmos5l_decap_4_6 VPWR VGND sg13cmos5l_decap_4
* cell instance sg13cmos5l_decap_4_7 r0 *1 0,0
Xsg13cmos5l_decap_4_7 VPWR VGND sg13cmos5l_decap_4
* cell instance sg13cmos5l_decap_4_8 r0 *1 0,0
Xsg13cmos5l_decap_4_8 VPWR VGND sg13cmos5l_decap_4
* cell instance sg13cmos5l_decap_4_9 r0 *1 0,0
Xsg13cmos5l_decap_4_9 VPWR VGND sg13cmos5l_decap_4
* cell instance sg13cmos5l_decap_4_10 r0 *1 0,0
Xsg13cmos5l_decap_4_10 VPWR VGND sg13cmos5l_decap_4
* cell instance sg13cmos5l_decap_4_11 r0 *1 0,0
Xsg13cmos5l_decap_4_11 VPWR VGND sg13cmos5l_decap_4
* cell instance sg13cmos5l_decap_4_12 r0 *1 0,0
Xsg13cmos5l_decap_4_12 VPWR VGND sg13cmos5l_decap_4
* cell instance sg13cmos5l_decap_4_13 r0 *1 0,0
Xsg13cmos5l_decap_4_13 VPWR VGND sg13cmos5l_decap_4
* cell instance sg13cmos5l_decap_4_14 r0 *1 0,0
Xsg13cmos5l_decap_4_14 VPWR VGND sg13cmos5l_decap_4
* cell instance sg13cmos5l_decap_4_15 r0 *1 0,0
Xsg13cmos5l_decap_4_15 VPWR VGND sg13cmos5l_decap_4
* cell instance sg13cmos5l_decap_4_16 r0 *1 0,0
Xsg13cmos5l_decap_4_16 VPWR VGND sg13cmos5l_decap_4
* cell instance sg13cmos5l_decap_4_17 r0 *1 0,0
Xsg13cmos5l_decap_4_17 VPWR VGND sg13cmos5l_decap_4
* cell instance sg13cmos5l_decap_4_18 r0 *1 0,0
Xsg13cmos5l_decap_4_18 VPWR VGND sg13cmos5l_decap_4
* cell instance sg13cmos5l_decap_4_19 r0 *1 0,0
Xsg13cmos5l_decap_4_19 VPWR VGND sg13cmos5l_decap_4
* cell instance sg13cmos5l_decap_4_20 r0 *1 0,0
Xsg13cmos5l_decap_4_20 VPWR VGND sg13cmos5l_decap_4
* cell instance sg13cmos5l_decap_4_21 r0 *1 0,0
Xsg13cmos5l_decap_4_21 VPWR VGND sg13cmos5l_decap_4
* cell instance sg13cmos5l_decap_4_22 r0 *1 0,0
Xsg13cmos5l_decap_4_22 VPWR VGND sg13cmos5l_decap_4
* cell instance sg13cmos5l_decap_4_23 r0 *1 0,0
Xsg13cmos5l_decap_4_23 VPWR VGND sg13cmos5l_decap_4
* cell instance sg13cmos5l_decap_4_24 r0 *1 0,0
Xsg13cmos5l_decap_4_24 VPWR VGND sg13cmos5l_decap_4
* cell instance sg13cmos5l_decap_4_25 r0 *1 0,0
Xsg13cmos5l_decap_4_25 VPWR VGND sg13cmos5l_decap_4
* cell instance sg13cmos5l_decap_4_26 r0 *1 0,0
Xsg13cmos5l_decap_4_26 VPWR VGND sg13cmos5l_decap_4
* cell instance sg13cmos5l_decap_4_27 r0 *1 0,0
Xsg13cmos5l_decap_4_27 VPWR VGND sg13cmos5l_decap_4
* cell instance sg13cmos5l_decap_4_28 r0 *1 0,0
Xsg13cmos5l_decap_4_28 VPWR VGND sg13cmos5l_decap_4
* cell instance sg13cmos5l_decap_4_29 r0 *1 0,0
Xsg13cmos5l_decap_4_29 VPWR VGND sg13cmos5l_decap_4
* cell instance sg13cmos5l_decap_4_30 r0 *1 0,0
Xsg13cmos5l_decap_4_30 VPWR VGND sg13cmos5l_decap_4
* cell instance sg13cmos5l_decap_4_31 r0 *1 0,0
Xsg13cmos5l_decap_4_31 VPWR VGND sg13cmos5l_decap_4
* cell instance sg13cmos5l_decap_4_32 r0 *1 0,0
Xsg13cmos5l_decap_4_32 VPWR VGND sg13cmos5l_decap_4
* cell instance sg13cmos5l_decap_4_33 r0 *1 0,0
Xsg13cmos5l_decap_4_33 VPWR VGND sg13cmos5l_decap_4
* cell instance sg13cmos5l_decap_4_34 r0 *1 0,0
Xsg13cmos5l_decap_4_34 VPWR VGND sg13cmos5l_decap_4
* cell instance sg13cmos5l_decap_4_35 r0 *1 0,0
Xsg13cmos5l_decap_4_35 VPWR VGND sg13cmos5l_decap_4
* cell instance sg13cmos5l_decap_4_36 r0 *1 0,0
Xsg13cmos5l_decap_4_36 VPWR VGND sg13cmos5l_decap_4
* cell instance sg13cmos5l_decap_4_37 r0 *1 0,0
Xsg13cmos5l_decap_4_37 VPWR VGND sg13cmos5l_decap_4
* cell instance sg13cmos5l_decap_4_38 r0 *1 0,0
Xsg13cmos5l_decap_4_38 VPWR VGND sg13cmos5l_decap_4
* cell instance sg13cmos5l_decap_4_39 r0 *1 0,0
Xsg13cmos5l_decap_4_39 VPWR VGND sg13cmos5l_decap_4
* cell instance sg13cmos5l_decap_4_40 r0 *1 0,0
Xsg13cmos5l_decap_4_40 VPWR VGND sg13cmos5l_decap_4
* cell instance sg13cmos5l_decap_4_41 r0 *1 0,0
Xsg13cmos5l_decap_4_41 VPWR VGND sg13cmos5l_decap_4
* cell instance sg13cmos5l_decap_4_42 r0 *1 0,0
Xsg13cmos5l_decap_4_42 VPWR VGND sg13cmos5l_decap_4
* cell instance sg13cmos5l_decap_4_43 r0 *1 0,0
Xsg13cmos5l_decap_4_43 VPWR VGND sg13cmos5l_decap_4
* cell instance sg13cmos5l_decap_4_44 r0 *1 0,0
Xsg13cmos5l_decap_4_44 VPWR VGND sg13cmos5l_decap_4
* cell instance sg13cmos5l_decap_4_45 r0 *1 0,0
Xsg13cmos5l_decap_4_45 VPWR VGND sg13cmos5l_decap_4
* cell instance sg13cmos5l_decap_4_46 r0 *1 0,0
Xsg13cmos5l_decap_4_46 VPWR VGND sg13cmos5l_decap_4
* cell instance sg13cmos5l_decap_4_47 r0 *1 0,0
Xsg13cmos5l_decap_4_47 VPWR VGND sg13cmos5l_decap_4
* cell instance sg13cmos5l_decap_4_48 r0 *1 0,0
Xsg13cmos5l_decap_4_48 VPWR VGND sg13cmos5l_decap_4
* cell instance sg13cmos5l_decap_4_49 r0 *1 0,0
Xsg13cmos5l_decap_4_49 VPWR VGND sg13cmos5l_decap_4
* cell instance sg13cmos5l_decap_4_50 r0 *1 0,0
Xsg13cmos5l_decap_4_50 VPWR VGND sg13cmos5l_decap_4
* cell instance sg13cmos5l_decap_4_51 r0 *1 0,0
Xsg13cmos5l_decap_4_51 VPWR VGND sg13cmos5l_decap_4
* cell instance sg13cmos5l_decap_4_52 r0 *1 0,0
Xsg13cmos5l_decap_4_52 VPWR VGND sg13cmos5l_decap_4
* cell instance sg13cmos5l_decap_4_53 r0 *1 0,0
Xsg13cmos5l_decap_4_53 VPWR VGND sg13cmos5l_decap_4
* cell instance sg13cmos5l_decap_4_54 r0 *1 0,0
Xsg13cmos5l_decap_4_54 VPWR VGND sg13cmos5l_decap_4
* cell instance sg13cmos5l_decap_4_55 r0 *1 0,0
Xsg13cmos5l_decap_4_55 VPWR VGND sg13cmos5l_decap_4
* cell instance sg13cmos5l_decap_4_56 r0 *1 0,0
Xsg13cmos5l_decap_4_56 VPWR VGND sg13cmos5l_decap_4
* cell instance sg13cmos5l_decap_4_57 r0 *1 0,0
Xsg13cmos5l_decap_4_57 VPWR VGND sg13cmos5l_decap_4
* cell instance sg13cmos5l_decap_4_58 r0 *1 0,0
Xsg13cmos5l_decap_4_58 VPWR VGND sg13cmos5l_decap_4
* cell instance sg13cmos5l_decap_4_59 r0 *1 0,0
Xsg13cmos5l_decap_4_59 VPWR VGND sg13cmos5l_decap_4
* cell instance sg13cmos5l_decap_4_60 r0 *1 0,0
Xsg13cmos5l_decap_4_60 VPWR VGND sg13cmos5l_decap_4
* cell instance sg13cmos5l_decap_4_61 r0 *1 0,0
Xsg13cmos5l_decap_4_61 VPWR VGND sg13cmos5l_decap_4
* cell instance sg13cmos5l_decap_4_62 r0 *1 0,0
Xsg13cmos5l_decap_4_62 VPWR VGND sg13cmos5l_decap_4
* cell instance sg13cmos5l_decap_4_63 r0 *1 0,0
Xsg13cmos5l_decap_4_63 VPWR VGND sg13cmos5l_decap_4
* cell instance sg13cmos5l_decap_4_64 r0 *1 0,0
Xsg13cmos5l_decap_4_64 VPWR VGND sg13cmos5l_decap_4
* cell instance sg13cmos5l_decap_4_65 r0 *1 0,0
Xsg13cmos5l_decap_4_65 VPWR VGND sg13cmos5l_decap_4
* cell instance sg13cmos5l_decap_4_66 r0 *1 0,0
Xsg13cmos5l_decap_4_66 VPWR VGND sg13cmos5l_decap_4
* cell instance sg13cmos5l_decap_4_67 r0 *1 0,0
Xsg13cmos5l_decap_4_67 VPWR VGND sg13cmos5l_decap_4
* cell instance sg13cmos5l_decap_4_68 r0 *1 0,0
Xsg13cmos5l_decap_4_68 VPWR VGND sg13cmos5l_decap_4
* cell instance sg13cmos5l_decap_4_69 r0 *1 0,0
Xsg13cmos5l_decap_4_69 VPWR VGND sg13cmos5l_decap_4
* cell instance sg13cmos5l_decap_4_70 r0 *1 0,0
Xsg13cmos5l_decap_4_70 VPWR VGND sg13cmos5l_decap_4
* cell instance sg13cmos5l_decap_4_71 r0 *1 0,0
Xsg13cmos5l_decap_4_71 VPWR VGND sg13cmos5l_decap_4
* cell instance sg13cmos5l_decap_4_72 r0 *1 0,0
Xsg13cmos5l_decap_4_72 VPWR VGND sg13cmos5l_decap_4
* cell instance sg13cmos5l_decap_4_73 r0 *1 0,0
Xsg13cmos5l_decap_4_73 VPWR VGND sg13cmos5l_decap_4
* cell instance sg13cmos5l_decap_4_74 r0 *1 0,0
Xsg13cmos5l_decap_4_74 VPWR VGND sg13cmos5l_decap_4
* cell instance sg13cmos5l_decap_4_75 r0 *1 0,0
Xsg13cmos5l_decap_4_75 VPWR VGND sg13cmos5l_decap_4
* cell instance sg13cmos5l_decap_4_76 r0 *1 0,0
Xsg13cmos5l_decap_4_76 VPWR VGND sg13cmos5l_decap_4
* cell instance sg13cmos5l_decap_4_77 r0 *1 0,0
Xsg13cmos5l_decap_4_77 VPWR VGND sg13cmos5l_decap_4
* cell instance sg13cmos5l_decap_4_78 r0 *1 0,0
Xsg13cmos5l_decap_4_78 VPWR VGND sg13cmos5l_decap_4
* cell instance sg13cmos5l_decap_4_79 r0 *1 0,0
Xsg13cmos5l_decap_4_79 VPWR VGND sg13cmos5l_decap_4
* cell instance sg13cmos5l_decap_4_80 r0 *1 0,0
Xsg13cmos5l_decap_4_80 VPWR VGND sg13cmos5l_decap_4
* cell instance sg13cmos5l_decap_4_81 r0 *1 0,0
Xsg13cmos5l_decap_4_81 VPWR VGND sg13cmos5l_decap_4
* cell instance sg13cmos5l_decap_4_82 r0 *1 0,0
Xsg13cmos5l_decap_4_82 VPWR VGND sg13cmos5l_decap_4
* cell instance sg13cmos5l_decap_4_83 r0 *1 0,0
Xsg13cmos5l_decap_4_83 VPWR VGND sg13cmos5l_decap_4
* cell instance sg13cmos5l_decap_4_84 r0 *1 0,0
Xsg13cmos5l_decap_4_84 VPWR VGND sg13cmos5l_decap_4
* cell instance sg13cmos5l_decap_4_85 r0 *1 0,0
Xsg13cmos5l_decap_4_85 VPWR VGND sg13cmos5l_decap_4
* cell instance sg13cmos5l_decap_4_86 r0 *1 0,0
Xsg13cmos5l_decap_4_86 VPWR VGND sg13cmos5l_decap_4
* cell instance sg13cmos5l_decap_4_87 r0 *1 0,0
Xsg13cmos5l_decap_4_87 VPWR VGND sg13cmos5l_decap_4
* cell instance sg13cmos5l_decap_4_88 r0 *1 0,0
Xsg13cmos5l_decap_4_88 VPWR VGND sg13cmos5l_decap_4
* cell instance sg13cmos5l_decap_4_89 r0 *1 0,0
Xsg13cmos5l_decap_4_89 VPWR VGND sg13cmos5l_decap_4
* cell instance sg13cmos5l_decap_4_90 r0 *1 0,0
Xsg13cmos5l_decap_4_90 VPWR VGND sg13cmos5l_decap_4
* cell instance sg13cmos5l_decap_4_91 r0 *1 0,0
Xsg13cmos5l_decap_4_91 VPWR VGND sg13cmos5l_decap_4
* cell instance sg13cmos5l_decap_4_92 r0 *1 0,0
Xsg13cmos5l_decap_4_92 VPWR VGND sg13cmos5l_decap_4
* cell instance sg13cmos5l_decap_4_93 r0 *1 0,0
Xsg13cmos5l_decap_4_93 VPWR VGND sg13cmos5l_decap_4
* cell instance sg13cmos5l_decap_4_94 r0 *1 0,0
Xsg13cmos5l_decap_4_94 VPWR VGND sg13cmos5l_decap_4
* cell instance sg13cmos5l_decap_4_95 r0 *1 0,0
Xsg13cmos5l_decap_4_95 VPWR VGND sg13cmos5l_decap_4
* cell instance sg13cmos5l_decap_4_96 r0 *1 0,0
Xsg13cmos5l_decap_4_96 VPWR VGND sg13cmos5l_decap_4
* cell instance sg13cmos5l_decap_4_97 r0 *1 0,0
Xsg13cmos5l_decap_4_97 VPWR VGND sg13cmos5l_decap_4
* cell instance sg13cmos5l_decap_4_98 r0 *1 0,0
Xsg13cmos5l_decap_4_98 VPWR VGND sg13cmos5l_decap_4
* cell instance sg13cmos5l_decap_4_99 r0 *1 0,0
Xsg13cmos5l_decap_4_99 VPWR VGND sg13cmos5l_decap_4
* cell instance sg13cmos5l_decap_4_100 r0 *1 0,0
Xsg13cmos5l_decap_4_100 VPWR VGND sg13cmos5l_decap_4
* cell instance sg13cmos5l_decap_4_101 r0 *1 0,0
Xsg13cmos5l_decap_4_101 VPWR VGND sg13cmos5l_decap_4
* cell instance sg13cmos5l_decap_4_102 r0 *1 0,0
Xsg13cmos5l_decap_4_102 VPWR VGND sg13cmos5l_decap_4
* cell instance sg13cmos5l_decap_4_103 r0 *1 0,0
Xsg13cmos5l_decap_4_103 VPWR VGND sg13cmos5l_decap_4
* cell instance sg13cmos5l_decap_4_104 r0 *1 0,0
Xsg13cmos5l_decap_4_104 VPWR VGND sg13cmos5l_decap_4
* cell instance sg13cmos5l_decap_4_105 r0 *1 0,0
Xsg13cmos5l_decap_4_105 VPWR VGND sg13cmos5l_decap_4
* cell instance sg13cmos5l_decap_4_106 r0 *1 0,0
Xsg13cmos5l_decap_4_106 VPWR VGND sg13cmos5l_decap_4
* cell instance sg13cmos5l_decap_4_107 r0 *1 0,0
Xsg13cmos5l_decap_4_107 VPWR VGND sg13cmos5l_decap_4
* cell instance sg13cmos5l_decap_4_108 r0 *1 0,0
Xsg13cmos5l_decap_4_108 VPWR VGND sg13cmos5l_decap_4
* cell instance sg13cmos5l_decap_4_109 r0 *1 0,0
Xsg13cmos5l_decap_4_109 VPWR VGND sg13cmos5l_decap_4
* cell instance sg13cmos5l_decap_4_110 r0 *1 0,0
Xsg13cmos5l_decap_4_110 VPWR VGND sg13cmos5l_decap_4
* cell instance sg13cmos5l_decap_4_111 r0 *1 0,0
Xsg13cmos5l_decap_4_111 VPWR VGND sg13cmos5l_decap_4
* cell instance sg13cmos5l_decap_4_112 r0 *1 0,0
Xsg13cmos5l_decap_4_112 VPWR VGND sg13cmos5l_decap_4
* cell instance sg13cmos5l_decap_4_113 r0 *1 0,0
Xsg13cmos5l_decap_4_113 VPWR VGND sg13cmos5l_decap_4
* cell instance sg13cmos5l_decap_4_114 r0 *1 0,0
Xsg13cmos5l_decap_4_114 VPWR VGND sg13cmos5l_decap_4
* cell instance sg13cmos5l_decap_4_115 r0 *1 0,0
Xsg13cmos5l_decap_4_115 VPWR VGND sg13cmos5l_decap_4
* cell instance sg13cmos5l_decap_4_116 r0 *1 0,0
Xsg13cmos5l_decap_4_116 VPWR VGND sg13cmos5l_decap_4
* cell instance sg13cmos5l_decap_4_117 r0 *1 0,0
Xsg13cmos5l_decap_4_117 VPWR VGND sg13cmos5l_decap_4
* cell instance sg13cmos5l_decap_4_118 r0 *1 0,0
Xsg13cmos5l_decap_4_118 VPWR VGND sg13cmos5l_decap_4
* cell instance sg13cmos5l_decap_4_119 r0 *1 0,0
Xsg13cmos5l_decap_4_119 VPWR VGND sg13cmos5l_decap_4
* cell instance sg13cmos5l_decap_4_120 r0 *1 0,0
Xsg13cmos5l_decap_4_120 VPWR VGND sg13cmos5l_decap_4
* cell instance sg13cmos5l_decap_4_121 r0 *1 0,0
Xsg13cmos5l_decap_4_121 VPWR VGND sg13cmos5l_decap_4
* cell instance sg13cmos5l_decap_4_122 r0 *1 0,0
Xsg13cmos5l_decap_4_122 VPWR VGND sg13cmos5l_decap_4
* cell instance sg13cmos5l_decap_4_123 r0 *1 0,0
Xsg13cmos5l_decap_4_123 VPWR VGND sg13cmos5l_decap_4
* cell instance sg13cmos5l_decap_4_124 r0 *1 0,0
Xsg13cmos5l_decap_4_124 VPWR VGND sg13cmos5l_decap_4
* cell instance sg13cmos5l_decap_4_125 r0 *1 0,0
Xsg13cmos5l_decap_4_125 VPWR VGND sg13cmos5l_decap_4
* cell instance sg13cmos5l_decap_4_126 r0 *1 0,0
Xsg13cmos5l_decap_4_126 VPWR VGND sg13cmos5l_decap_4
* cell instance sg13cmos5l_decap_4_127 r0 *1 0,0
Xsg13cmos5l_decap_4_127 VPWR VGND sg13cmos5l_decap_4
* cell instance sg13cmos5l_decap_4_128 r0 *1 0,0
Xsg13cmos5l_decap_4_128 VPWR VGND sg13cmos5l_decap_4
* cell instance sg13cmos5l_decap_4_129 r0 *1 0,0
Xsg13cmos5l_decap_4_129 VPWR VGND sg13cmos5l_decap_4
* cell instance sg13cmos5l_decap_4_130 r0 *1 0,0
Xsg13cmos5l_decap_4_130 VPWR VGND sg13cmos5l_decap_4
* cell instance sg13cmos5l_decap_4_131 r0 *1 0,0
Xsg13cmos5l_decap_4_131 VPWR VGND sg13cmos5l_decap_4
* cell instance sg13cmos5l_decap_4_132 r0 *1 0,0
Xsg13cmos5l_decap_4_132 VPWR VGND sg13cmos5l_decap_4
* cell instance sg13cmos5l_decap_4_133 r0 *1 0,0
Xsg13cmos5l_decap_4_133 VPWR VGND sg13cmos5l_decap_4
* cell instance sg13cmos5l_decap_4_134 r0 *1 0,0
Xsg13cmos5l_decap_4_134 VPWR VGND sg13cmos5l_decap_4
* cell instance sg13cmos5l_decap_4_135 r0 *1 0,0
Xsg13cmos5l_decap_4_135 VPWR VGND sg13cmos5l_decap_4
* cell instance sg13cmos5l_decap_4_136 r0 *1 0,0
Xsg13cmos5l_decap_4_136 VPWR VGND sg13cmos5l_decap_4
* cell instance sg13cmos5l_decap_4_137 r0 *1 0,0
Xsg13cmos5l_decap_4_137 VPWR VGND sg13cmos5l_decap_4
* cell instance sg13cmos5l_decap_4_138 r0 *1 0,0
Xsg13cmos5l_decap_4_138 VPWR VGND sg13cmos5l_decap_4
* cell instance sg13cmos5l_decap_4_139 r0 *1 0,0
Xsg13cmos5l_decap_4_139 VPWR VGND sg13cmos5l_decap_4
* cell instance sg13cmos5l_decap_4_140 r0 *1 0,0
Xsg13cmos5l_decap_4_140 VPWR VGND sg13cmos5l_decap_4
* cell instance sg13cmos5l_decap_4_141 r0 *1 0,0
Xsg13cmos5l_decap_4_141 VPWR VGND sg13cmos5l_decap_4
* cell instance sg13cmos5l_decap_4_142 r0 *1 0,0
Xsg13cmos5l_decap_4_142 VPWR VGND sg13cmos5l_decap_4
* cell instance sg13cmos5l_decap_4_143 r0 *1 0,0
Xsg13cmos5l_decap_4_143 VPWR VGND sg13cmos5l_decap_4
* cell instance sg13cmos5l_decap_4_144 r0 *1 0,0
Xsg13cmos5l_decap_4_144 VPWR VGND sg13cmos5l_decap_4
* cell instance sg13cmos5l_decap_4_145 r0 *1 0,0
Xsg13cmos5l_decap_4_145 VPWR VGND sg13cmos5l_decap_4
* cell instance sg13cmos5l_decap_4_146 r0 *1 0,0
Xsg13cmos5l_decap_4_146 VPWR VGND sg13cmos5l_decap_4
* cell instance sg13cmos5l_decap_4_147 r0 *1 0,0
Xsg13cmos5l_decap_4_147 VPWR VGND sg13cmos5l_decap_4
* cell instance sg13cmos5l_decap_4_148 r0 *1 0,0
Xsg13cmos5l_decap_4_148 VPWR VGND sg13cmos5l_decap_4
* cell instance sg13cmos5l_decap_4_149 r0 *1 0,0
Xsg13cmos5l_decap_4_149 VPWR VGND sg13cmos5l_decap_4
* cell instance sg13cmos5l_decap_4_150 r0 *1 0,0
Xsg13cmos5l_decap_4_150 VPWR VGND sg13cmos5l_decap_4
* cell instance sg13cmos5l_decap_4_151 r0 *1 0,0
Xsg13cmos5l_decap_4_151 VPWR VGND sg13cmos5l_decap_4
* cell instance sg13cmos5l_decap_4_152 r0 *1 0,0
Xsg13cmos5l_decap_4_152 VPWR VGND sg13cmos5l_decap_4
* cell instance sg13cmos5l_decap_4_153 r0 *1 0,0
Xsg13cmos5l_decap_4_153 VPWR VGND sg13cmos5l_decap_4
* cell instance sg13cmos5l_decap_4_154 r0 *1 0,0
Xsg13cmos5l_decap_4_154 VPWR VGND sg13cmos5l_decap_4
* cell instance sg13cmos5l_decap_4_155 r0 *1 0,0
Xsg13cmos5l_decap_4_155 VPWR VGND sg13cmos5l_decap_4
* cell instance sg13cmos5l_decap_4_156 r0 *1 0,0
Xsg13cmos5l_decap_4_156 VPWR VGND sg13cmos5l_decap_4
* cell instance sg13cmos5l_decap_4_157 r0 *1 0,0
Xsg13cmos5l_decap_4_157 VPWR VGND sg13cmos5l_decap_4
* cell instance sg13cmos5l_decap_4_158 r0 *1 0,0
Xsg13cmos5l_decap_4_158 VPWR VGND sg13cmos5l_decap_4
* cell instance sg13cmos5l_decap_4_159 r0 *1 0,0
Xsg13cmos5l_decap_4_159 VPWR VGND sg13cmos5l_decap_4
* cell instance sg13cmos5l_decap_4_160 r0 *1 0,0
Xsg13cmos5l_decap_4_160 VPWR VGND sg13cmos5l_decap_4
* cell instance sg13cmos5l_decap_4_161 r0 *1 0,0
Xsg13cmos5l_decap_4_161 VPWR VGND sg13cmos5l_decap_4
* cell instance sg13cmos5l_decap_4_162 r0 *1 0,0
Xsg13cmos5l_decap_4_162 VPWR VGND sg13cmos5l_decap_4
* cell instance sg13cmos5l_decap_4_163 r0 *1 0,0
Xsg13cmos5l_decap_4_163 VPWR VGND sg13cmos5l_decap_4
* cell instance sg13cmos5l_decap_4_164 r0 *1 0,0
Xsg13cmos5l_decap_4_164 VPWR VGND sg13cmos5l_decap_4
* cell instance sg13cmos5l_decap_4_165 r0 *1 0,0
Xsg13cmos5l_decap_4_165 VPWR VGND sg13cmos5l_decap_4
* cell instance sg13cmos5l_decap_4_166 r0 *1 0,0
Xsg13cmos5l_decap_4_166 VPWR VGND sg13cmos5l_decap_4
* cell instance sg13cmos5l_decap_4_167 r0 *1 0,0
Xsg13cmos5l_decap_4_167 VPWR VGND sg13cmos5l_decap_4
* cell instance sg13cmos5l_decap_4_168 r0 *1 0,0
Xsg13cmos5l_decap_4_168 VPWR VGND sg13cmos5l_decap_4
* cell instance sg13cmos5l_decap_4_169 r0 *1 0,0
Xsg13cmos5l_decap_4_169 VPWR VGND sg13cmos5l_decap_4
* cell instance sg13cmos5l_decap_4_170 r0 *1 0,0
Xsg13cmos5l_decap_4_170 VPWR VGND sg13cmos5l_decap_4
* cell instance sg13cmos5l_decap_4_171 r0 *1 0,0
Xsg13cmos5l_decap_4_171 VPWR VGND sg13cmos5l_decap_4
* cell instance sg13cmos5l_decap_4_172 r0 *1 0,0
Xsg13cmos5l_decap_4_172 VPWR VGND sg13cmos5l_decap_4
* cell instance sg13cmos5l_decap_4_173 r0 *1 0,0
Xsg13cmos5l_decap_4_173 VPWR VGND sg13cmos5l_decap_4
* cell instance sg13cmos5l_decap_4_174 r0 *1 0,0
Xsg13cmos5l_decap_4_174 VPWR VGND sg13cmos5l_decap_4
* cell instance sg13cmos5l_decap_4_175 r0 *1 0,0
Xsg13cmos5l_decap_4_175 VPWR VGND sg13cmos5l_decap_4
* cell instance sg13cmos5l_decap_4_176 r0 *1 0,0
Xsg13cmos5l_decap_4_176 VPWR VGND sg13cmos5l_decap_4
* cell instance sg13cmos5l_decap_4_177 r0 *1 0,0
Xsg13cmos5l_decap_4_177 VPWR VGND sg13cmos5l_decap_4
* cell instance sg13cmos5l_decap_4_178 r0 *1 0,0
Xsg13cmos5l_decap_4_178 VPWR VGND sg13cmos5l_decap_4
* cell instance sg13cmos5l_decap_4_179 r0 *1 0,0
Xsg13cmos5l_decap_4_179 VPWR VGND sg13cmos5l_decap_4
* cell instance sg13cmos5l_decap_4_180 r0 *1 0,0
Xsg13cmos5l_decap_4_180 VPWR VGND sg13cmos5l_decap_4
* cell instance sg13cmos5l_decap_4_181 r0 *1 0,0
Xsg13cmos5l_decap_4_181 VPWR VGND sg13cmos5l_decap_4
* cell instance sg13cmos5l_decap_4_182 r0 *1 0,0
Xsg13cmos5l_decap_4_182 VPWR VGND sg13cmos5l_decap_4
* cell instance sg13cmos5l_decap_4_183 r0 *1 0,0
Xsg13cmos5l_decap_4_183 VPWR VGND sg13cmos5l_decap_4
* cell instance sg13cmos5l_decap_4_184 r0 *1 0,0
Xsg13cmos5l_decap_4_184 VPWR VGND sg13cmos5l_decap_4
* cell instance sg13cmos5l_decap_4_185 r0 *1 0,0
Xsg13cmos5l_decap_4_185 VPWR VGND sg13cmos5l_decap_4
* cell instance sg13cmos5l_decap_4_186 r0 *1 0,0
Xsg13cmos5l_decap_4_186 VPWR VGND sg13cmos5l_decap_4
* cell instance sg13cmos5l_decap_4_187 r0 *1 0,0
Xsg13cmos5l_decap_4_187 VPWR VGND sg13cmos5l_decap_4
* cell instance sg13cmos5l_decap_4_188 r0 *1 0,0
Xsg13cmos5l_decap_4_188 VPWR VGND sg13cmos5l_decap_4
* cell instance sg13cmos5l_decap_4_189 r0 *1 0,0
Xsg13cmos5l_decap_4_189 VPWR VGND sg13cmos5l_decap_4
* cell instance sg13cmos5l_decap_4_190 r0 *1 0,0
Xsg13cmos5l_decap_4_190 VPWR VGND sg13cmos5l_decap_4
* cell instance sg13cmos5l_decap_4_191 r0 *1 0,0
Xsg13cmos5l_decap_4_191 VPWR VGND sg13cmos5l_decap_4
* cell instance sg13cmos5l_decap_4_192 r0 *1 0,0
Xsg13cmos5l_decap_4_192 VPWR VGND sg13cmos5l_decap_4
* cell instance sg13cmos5l_decap_4_193 r0 *1 0,0
Xsg13cmos5l_decap_4_193 VPWR VGND sg13cmos5l_decap_4
* cell instance sg13cmos5l_decap_4_194 r0 *1 0,0
Xsg13cmos5l_decap_4_194 VPWR VGND sg13cmos5l_decap_4
* cell instance sg13cmos5l_decap_4_195 r0 *1 0,0
Xsg13cmos5l_decap_4_195 VPWR VGND sg13cmos5l_decap_4
* cell instance sg13cmos5l_decap_4_196 r0 *1 0,0
Xsg13cmos5l_decap_4_196 VPWR VGND sg13cmos5l_decap_4
* cell instance sg13cmos5l_decap_4_197 r0 *1 0,0
Xsg13cmos5l_decap_4_197 VPWR VGND sg13cmos5l_decap_4
* cell instance sg13cmos5l_decap_4_198 r0 *1 0,0
Xsg13cmos5l_decap_4_198 VPWR VGND sg13cmos5l_decap_4
* cell instance sg13cmos5l_decap_4_199 r0 *1 0,0
Xsg13cmos5l_decap_4_199 VPWR VGND sg13cmos5l_decap_4
* cell instance sg13cmos5l_decap_4_200 r0 *1 0,0
Xsg13cmos5l_decap_4_200 VPWR VGND sg13cmos5l_decap_4
* cell instance sg13cmos5l_decap_4_201 r0 *1 0,0
Xsg13cmos5l_decap_4_201 VPWR VGND sg13cmos5l_decap_4
* cell instance sg13cmos5l_decap_4_202 r0 *1 0,0
Xsg13cmos5l_decap_4_202 VPWR VGND sg13cmos5l_decap_4
* cell instance sg13cmos5l_decap_4_203 r0 *1 0,0
Xsg13cmos5l_decap_4_203 VPWR VGND sg13cmos5l_decap_4
* cell instance sg13cmos5l_decap_4_204 r0 *1 0,0
Xsg13cmos5l_decap_4_204 VPWR VGND sg13cmos5l_decap_4
* cell instance sg13cmos5l_decap_4_205 r0 *1 0,0
Xsg13cmos5l_decap_4_205 VPWR VGND sg13cmos5l_decap_4
* cell instance sg13cmos5l_decap_4_206 r0 *1 0,0
Xsg13cmos5l_decap_4_206 VPWR VGND sg13cmos5l_decap_4
* cell instance sg13cmos5l_decap_4_207 r0 *1 0,0
Xsg13cmos5l_decap_4_207 VPWR VGND sg13cmos5l_decap_4
* cell instance sg13cmos5l_decap_4_208 r0 *1 0,0
Xsg13cmos5l_decap_4_208 VPWR VGND sg13cmos5l_decap_4
* cell instance sg13cmos5l_decap_4_209 r0 *1 0,0
Xsg13cmos5l_decap_4_209 VPWR VGND sg13cmos5l_decap_4
* cell instance sg13cmos5l_decap_4_210 r0 *1 0,0
Xsg13cmos5l_decap_4_210 VPWR VGND sg13cmos5l_decap_4
* cell instance sg13cmos5l_decap_4_211 r0 *1 0,0
Xsg13cmos5l_decap_4_211 VPWR VGND sg13cmos5l_decap_4
* cell instance sg13cmos5l_decap_4_212 r0 *1 0,0
Xsg13cmos5l_decap_4_212 VPWR VGND sg13cmos5l_decap_4
* cell instance sg13cmos5l_decap_4_213 r0 *1 0,0
Xsg13cmos5l_decap_4_213 VPWR VGND sg13cmos5l_decap_4
* cell instance sg13cmos5l_decap_4_214 r0 *1 0,0
Xsg13cmos5l_decap_4_214 VPWR VGND sg13cmos5l_decap_4
* cell instance sg13cmos5l_decap_4_215 r0 *1 0,0
Xsg13cmos5l_decap_4_215 VPWR VGND sg13cmos5l_decap_4
* cell instance sg13cmos5l_decap_4_216 r0 *1 0,0
Xsg13cmos5l_decap_4_216 VPWR VGND sg13cmos5l_decap_4
* cell instance sg13cmos5l_decap_4_217 r0 *1 0,0
Xsg13cmos5l_decap_4_217 VPWR VGND sg13cmos5l_decap_4
* cell instance sg13cmos5l_decap_4_218 r0 *1 0,0
Xsg13cmos5l_decap_4_218 VPWR VGND sg13cmos5l_decap_4
* cell instance sg13cmos5l_decap_4_219 r0 *1 0,0
Xsg13cmos5l_decap_4_219 VPWR VGND sg13cmos5l_decap_4
* cell instance sg13cmos5l_decap_4_220 r0 *1 0,0
Xsg13cmos5l_decap_4_220 VPWR VGND sg13cmos5l_decap_4
* cell instance sg13cmos5l_decap_4_221 r0 *1 0,0
Xsg13cmos5l_decap_4_221 VPWR VGND sg13cmos5l_decap_4
* cell instance sg13cmos5l_decap_4_222 r0 *1 0,0
Xsg13cmos5l_decap_4_222 VPWR VGND sg13cmos5l_decap_4
* cell instance sg13cmos5l_decap_4_223 r0 *1 0,0
Xsg13cmos5l_decap_4_223 VPWR VGND sg13cmos5l_decap_4
* cell instance sg13cmos5l_decap_4_224 r0 *1 0,0
Xsg13cmos5l_decap_4_224 VPWR VGND sg13cmos5l_decap_4
* cell instance sg13cmos5l_decap_4_225 r0 *1 0,0
Xsg13cmos5l_decap_4_225 VPWR VGND sg13cmos5l_decap_4
* cell instance sg13cmos5l_decap_4_226 r0 *1 0,0
Xsg13cmos5l_decap_4_226 VPWR VGND sg13cmos5l_decap_4
* cell instance sg13cmos5l_decap_4_227 r0 *1 0,0
Xsg13cmos5l_decap_4_227 VPWR VGND sg13cmos5l_decap_4
* cell instance sg13cmos5l_decap_4_228 r0 *1 0,0
Xsg13cmos5l_decap_4_228 VPWR VGND sg13cmos5l_decap_4
* cell instance sg13cmos5l_decap_4_229 r0 *1 0,0
Xsg13cmos5l_decap_4_229 VPWR VGND sg13cmos5l_decap_4
* cell instance sg13cmos5l_decap_4_230 r0 *1 0,0
Xsg13cmos5l_decap_4_230 VPWR VGND sg13cmos5l_decap_4
* cell instance sg13cmos5l_decap_4_231 r0 *1 0,0
Xsg13cmos5l_decap_4_231 VPWR VGND sg13cmos5l_decap_4
* cell instance sg13cmos5l_decap_4_232 r0 *1 0,0
Xsg13cmos5l_decap_4_232 VPWR VGND sg13cmos5l_decap_4
* cell instance sg13cmos5l_decap_4_233 r0 *1 0,0
Xsg13cmos5l_decap_4_233 VPWR VGND sg13cmos5l_decap_4
* cell instance sg13cmos5l_decap_4_234 r0 *1 0,0
Xsg13cmos5l_decap_4_234 VPWR VGND sg13cmos5l_decap_4
* cell instance sg13cmos5l_decap_4_235 r0 *1 0,0
Xsg13cmos5l_decap_4_235 VPWR VGND sg13cmos5l_decap_4
* cell instance sg13cmos5l_decap_4_236 r0 *1 0,0
Xsg13cmos5l_decap_4_236 VPWR VGND sg13cmos5l_decap_4
* cell instance sg13cmos5l_decap_4_237 r0 *1 0,0
Xsg13cmos5l_decap_4_237 VPWR VGND sg13cmos5l_decap_4
* cell instance sg13cmos5l_decap_4_238 r0 *1 0,0
Xsg13cmos5l_decap_4_238 VPWR VGND sg13cmos5l_decap_4
* cell instance sg13cmos5l_decap_4_239 r0 *1 0,0
Xsg13cmos5l_decap_4_239 VPWR VGND sg13cmos5l_decap_4
* cell instance sg13cmos5l_decap_4_240 r0 *1 0,0
Xsg13cmos5l_decap_4_240 VPWR VGND sg13cmos5l_decap_4
* cell instance sg13cmos5l_decap_4_241 r0 *1 0,0
Xsg13cmos5l_decap_4_241 VPWR VGND sg13cmos5l_decap_4
* cell instance sg13cmos5l_decap_4_242 r0 *1 0,0
Xsg13cmos5l_decap_4_242 VPWR VGND sg13cmos5l_decap_4
* cell instance sg13cmos5l_decap_4_243 r0 *1 0,0
Xsg13cmos5l_decap_4_243 VPWR VGND sg13cmos5l_decap_4
* cell instance sg13cmos5l_decap_4_244 r0 *1 0,0
Xsg13cmos5l_decap_4_244 VPWR VGND sg13cmos5l_decap_4
* cell instance sg13cmos5l_decap_4_245 r0 *1 0,0
Xsg13cmos5l_decap_4_245 VPWR VGND sg13cmos5l_decap_4
* cell instance sg13cmos5l_decap_4_246 r0 *1 0,0
Xsg13cmos5l_decap_4_246 VPWR VGND sg13cmos5l_decap_4
* cell instance sg13cmos5l_decap_4_247 r0 *1 0,0
Xsg13cmos5l_decap_4_247 VPWR VGND sg13cmos5l_decap_4
* cell instance sg13cmos5l_decap_4_248 r0 *1 0,0
Xsg13cmos5l_decap_4_248 VPWR VGND sg13cmos5l_decap_4
* cell instance sg13cmos5l_decap_4_249 r0 *1 0,0
Xsg13cmos5l_decap_4_249 VPWR VGND sg13cmos5l_decap_4
* cell instance sg13cmos5l_decap_4_250 r0 *1 0,0
Xsg13cmos5l_decap_4_250 VPWR VGND sg13cmos5l_decap_4
* cell instance sg13cmos5l_decap_4_251 r0 *1 0,0
Xsg13cmos5l_decap_4_251 VPWR VGND sg13cmos5l_decap_4
* cell instance sg13cmos5l_decap_4_252 r0 *1 0,0
Xsg13cmos5l_decap_4_252 VPWR VGND sg13cmos5l_decap_4
* cell instance sg13cmos5l_decap_4_253 r0 *1 0,0
Xsg13cmos5l_decap_4_253 VPWR VGND sg13cmos5l_decap_4
* cell instance sg13cmos5l_decap_4_254 r0 *1 0,0
Xsg13cmos5l_decap_4_254 VPWR VGND sg13cmos5l_decap_4
* cell instance sg13cmos5l_decap_4_255 r0 *1 0,0
Xsg13cmos5l_decap_4_255 VPWR VGND sg13cmos5l_decap_4
* cell instance sg13cmos5l_decap_4_256 r0 *1 0,0
Xsg13cmos5l_decap_4_256 VPWR VGND sg13cmos5l_decap_4
* cell instance sg13cmos5l_decap_4_257 r0 *1 0,0
Xsg13cmos5l_decap_4_257 VPWR VGND sg13cmos5l_decap_4
* cell instance sg13cmos5l_decap_4_258 r0 *1 0,0
Xsg13cmos5l_decap_4_258 VPWR VGND sg13cmos5l_decap_4
* cell instance sg13cmos5l_decap_4_259 r0 *1 0,0
Xsg13cmos5l_decap_4_259 VPWR VGND sg13cmos5l_decap_4
* cell instance sg13cmos5l_decap_4_260 r0 *1 0,0
Xsg13cmos5l_decap_4_260 VPWR VGND sg13cmos5l_decap_4
* cell instance sg13cmos5l_decap_4_261 r0 *1 0,0
Xsg13cmos5l_decap_4_261 VPWR VGND sg13cmos5l_decap_4
* cell instance sg13cmos5l_decap_4_262 r0 *1 0,0
Xsg13cmos5l_decap_4_262 VPWR VGND sg13cmos5l_decap_4
* cell instance sg13cmos5l_decap_4_263 r0 *1 0,0
Xsg13cmos5l_decap_4_263 VPWR VGND sg13cmos5l_decap_4
* cell instance sg13cmos5l_decap_4_264 r0 *1 0,0
Xsg13cmos5l_decap_4_264 VPWR VGND sg13cmos5l_decap_4
* cell instance sg13cmos5l_decap_4_265 r0 *1 0,0
Xsg13cmos5l_decap_4_265 VPWR VGND sg13cmos5l_decap_4
* cell instance sg13cmos5l_decap_4_266 r0 *1 0,0
Xsg13cmos5l_decap_4_266 VPWR VGND sg13cmos5l_decap_4
* cell instance sg13cmos5l_decap_4_267 r0 *1 0,0
Xsg13cmos5l_decap_4_267 VPWR VGND sg13cmos5l_decap_4
* cell instance sg13cmos5l_decap_4_268 r0 *1 0,0
Xsg13cmos5l_decap_4_268 VPWR VGND sg13cmos5l_decap_4
* cell instance sg13cmos5l_decap_4_269 r0 *1 0,0
Xsg13cmos5l_decap_4_269 VPWR VGND sg13cmos5l_decap_4
* cell instance sg13cmos5l_decap_4_270 r0 *1 0,0
Xsg13cmos5l_decap_4_270 VPWR VGND sg13cmos5l_decap_4
* cell instance sg13cmos5l_decap_4_271 r0 *1 0,0
Xsg13cmos5l_decap_4_271 VPWR VGND sg13cmos5l_decap_4
* cell instance sg13cmos5l_decap_4_272 r0 *1 0,0
Xsg13cmos5l_decap_4_272 VPWR VGND sg13cmos5l_decap_4
* cell instance sg13cmos5l_decap_4_273 r0 *1 0,0
Xsg13cmos5l_decap_4_273 VPWR VGND sg13cmos5l_decap_4
* cell instance sg13cmos5l_decap_4_274 r0 *1 0,0
Xsg13cmos5l_decap_4_274 VPWR VGND sg13cmos5l_decap_4
* cell instance sg13cmos5l_decap_4_275 r0 *1 0,0
Xsg13cmos5l_decap_4_275 VPWR VGND sg13cmos5l_decap_4
* cell instance sg13cmos5l_decap_4_276 r0 *1 0,0
Xsg13cmos5l_decap_4_276 VPWR VGND sg13cmos5l_decap_4
* cell instance sg13cmos5l_decap_4_277 r0 *1 0,0
Xsg13cmos5l_decap_4_277 VPWR VGND sg13cmos5l_decap_4
* cell instance sg13cmos5l_decap_4_278 r0 *1 0,0
Xsg13cmos5l_decap_4_278 VPWR VGND sg13cmos5l_decap_4
* cell instance sg13cmos5l_decap_4_279 r0 *1 0,0
Xsg13cmos5l_decap_4_279 VPWR VGND sg13cmos5l_decap_4
* cell instance sg13cmos5l_decap_4_280 r0 *1 0,0
Xsg13cmos5l_decap_4_280 VPWR VGND sg13cmos5l_decap_4
* cell instance sg13cmos5l_decap_4_281 r0 *1 0,0
Xsg13cmos5l_decap_4_281 VPWR VGND sg13cmos5l_decap_4
* cell instance sg13cmos5l_decap_4_282 r0 *1 0,0
Xsg13cmos5l_decap_4_282 VPWR VGND sg13cmos5l_decap_4
* cell instance sg13cmos5l_decap_4_283 r0 *1 0,0
Xsg13cmos5l_decap_4_283 VPWR VGND sg13cmos5l_decap_4
* cell instance sg13cmos5l_decap_4_284 r0 *1 0,0
Xsg13cmos5l_decap_4_284 VPWR VGND sg13cmos5l_decap_4
* cell instance sg13cmos5l_decap_4_285 r0 *1 0,0
Xsg13cmos5l_decap_4_285 VPWR VGND sg13cmos5l_decap_4
* cell instance sg13cmos5l_decap_4_286 r0 *1 0,0
Xsg13cmos5l_decap_4_286 VPWR VGND sg13cmos5l_decap_4
* cell instance sg13cmos5l_decap_4_287 r0 *1 0,0
Xsg13cmos5l_decap_4_287 VPWR VGND sg13cmos5l_decap_4
* cell instance sg13cmos5l_decap_4_288 r0 *1 0,0
Xsg13cmos5l_decap_4_288 VPWR VGND sg13cmos5l_decap_4
* cell instance sg13cmos5l_decap_4_289 r0 *1 0,0
Xsg13cmos5l_decap_4_289 VPWR VGND sg13cmos5l_decap_4
* cell instance sg13cmos5l_decap_4_290 r0 *1 0,0
Xsg13cmos5l_decap_4_290 VPWR VGND sg13cmos5l_decap_4
* cell instance sg13cmos5l_decap_4_291 r0 *1 0,0
Xsg13cmos5l_decap_4_291 VPWR VGND sg13cmos5l_decap_4
* cell instance sg13cmos5l_decap_4_292 r0 *1 0,0
Xsg13cmos5l_decap_4_292 VPWR VGND sg13cmos5l_decap_4
* cell instance sg13cmos5l_decap_4_293 r0 *1 0,0
Xsg13cmos5l_decap_4_293 VPWR VGND sg13cmos5l_decap_4
* cell instance sg13cmos5l_decap_4_294 r0 *1 0,0
Xsg13cmos5l_decap_4_294 VPWR VGND sg13cmos5l_decap_4
* cell instance sg13cmos5l_decap_4_295 r0 *1 0,0
Xsg13cmos5l_decap_4_295 VPWR VGND sg13cmos5l_decap_4
* cell instance sg13cmos5l_decap_4_296 r0 *1 0,0
Xsg13cmos5l_decap_4_296 VPWR VGND sg13cmos5l_decap_4
* cell instance sg13cmos5l_decap_4_297 r0 *1 0,0
Xsg13cmos5l_decap_4_297 VPWR VGND sg13cmos5l_decap_4
* cell instance sg13cmos5l_decap_4_298 r0 *1 0,0
Xsg13cmos5l_decap_4_298 VPWR VGND sg13cmos5l_decap_4
* cell instance sg13cmos5l_decap_4_299 r0 *1 0,0
Xsg13cmos5l_decap_4_299 VPWR VGND sg13cmos5l_decap_4
* cell instance sg13cmos5l_decap_4_300 r0 *1 0,0
Xsg13cmos5l_decap_4_300 VPWR VGND sg13cmos5l_decap_4
* cell instance sg13cmos5l_decap_4_301 r0 *1 0,0
Xsg13cmos5l_decap_4_301 VPWR VGND sg13cmos5l_decap_4
* cell instance sg13cmos5l_decap_4_302 r0 *1 0,0
Xsg13cmos5l_decap_4_302 VPWR VGND sg13cmos5l_decap_4
* cell instance sg13cmos5l_decap_4_303 r0 *1 0,0
Xsg13cmos5l_decap_4_303 VPWR VGND sg13cmos5l_decap_4
* cell instance sg13cmos5l_decap_4_304 r0 *1 0,0
Xsg13cmos5l_decap_4_304 VPWR VGND sg13cmos5l_decap_4
* cell instance sg13cmos5l_decap_4_305 r0 *1 0,0
Xsg13cmos5l_decap_4_305 VPWR VGND sg13cmos5l_decap_4
* cell instance sg13cmos5l_decap_4_306 r0 *1 0,0
Xsg13cmos5l_decap_4_306 VPWR VGND sg13cmos5l_decap_4
* cell instance sg13cmos5l_decap_4_307 r0 *1 0,0
Xsg13cmos5l_decap_4_307 VPWR VGND sg13cmos5l_decap_4
* cell instance sg13cmos5l_decap_4_308 r0 *1 0,0
Xsg13cmos5l_decap_4_308 VPWR VGND sg13cmos5l_decap_4
* cell instance sg13cmos5l_decap_4_309 r0 *1 0,0
Xsg13cmos5l_decap_4_309 VPWR VGND sg13cmos5l_decap_4
* cell instance sg13cmos5l_decap_4_310 r0 *1 0,0
Xsg13cmos5l_decap_4_310 VPWR VGND sg13cmos5l_decap_4
* cell instance sg13cmos5l_decap_4_311 r0 *1 0,0
Xsg13cmos5l_decap_4_311 VPWR VGND sg13cmos5l_decap_4
* cell instance sg13cmos5l_decap_4_312 r0 *1 0,0
Xsg13cmos5l_decap_4_312 VPWR VGND sg13cmos5l_decap_4
* cell instance sg13cmos5l_decap_4_313 r0 *1 0,0
Xsg13cmos5l_decap_4_313 VPWR VGND sg13cmos5l_decap_4
* cell instance sg13cmos5l_decap_4_314 r0 *1 0,0
Xsg13cmos5l_decap_4_314 VPWR VGND sg13cmos5l_decap_4
* cell instance sg13cmos5l_decap_4_315 r0 *1 0,0
Xsg13cmos5l_decap_4_315 VPWR VGND sg13cmos5l_decap_4
* cell instance sg13cmos5l_decap_4_316 r0 *1 0,0
Xsg13cmos5l_decap_4_316 VPWR VGND sg13cmos5l_decap_4
* cell instance sg13cmos5l_decap_4_317 r0 *1 0,0
Xsg13cmos5l_decap_4_317 VPWR VGND sg13cmos5l_decap_4
* cell instance sg13cmos5l_decap_4_318 r0 *1 0,0
Xsg13cmos5l_decap_4_318 VPWR VGND sg13cmos5l_decap_4
* cell instance sg13cmos5l_decap_4_319 r0 *1 0,0
Xsg13cmos5l_decap_4_319 VPWR VGND sg13cmos5l_decap_4
* cell instance sg13cmos5l_decap_4_320 r0 *1 0,0
Xsg13cmos5l_decap_4_320 VPWR VGND sg13cmos5l_decap_4
* cell instance sg13cmos5l_decap_4_321 r0 *1 0,0
Xsg13cmos5l_decap_4_321 VPWR VGND sg13cmos5l_decap_4
* cell instance sg13cmos5l_decap_4_322 r0 *1 0,0
Xsg13cmos5l_decap_4_322 VPWR VGND sg13cmos5l_decap_4
* cell instance sg13cmos5l_decap_4_323 r0 *1 0,0
Xsg13cmos5l_decap_4_323 VPWR VGND sg13cmos5l_decap_4
* cell instance sg13cmos5l_decap_4_324 r0 *1 0,0
Xsg13cmos5l_decap_4_324 VPWR VGND sg13cmos5l_decap_4
* cell instance sg13cmos5l_decap_4_325 r0 *1 0,0
Xsg13cmos5l_decap_4_325 VPWR VGND sg13cmos5l_decap_4
* cell instance sg13cmos5l_decap_4_326 r0 *1 0,0
Xsg13cmos5l_decap_4_326 VPWR VGND sg13cmos5l_decap_4
* cell instance sg13cmos5l_decap_4_327 r0 *1 0,0
Xsg13cmos5l_decap_4_327 VPWR VGND sg13cmos5l_decap_4
* cell instance sg13cmos5l_decap_4_328 r0 *1 0,0
Xsg13cmos5l_decap_4_328 VPWR VGND sg13cmos5l_decap_4
* cell instance sg13cmos5l_decap_4_329 r0 *1 0,0
Xsg13cmos5l_decap_4_329 VPWR VGND sg13cmos5l_decap_4
* cell instance sg13cmos5l_decap_4_330 r0 *1 0,0
Xsg13cmos5l_decap_4_330 VPWR VGND sg13cmos5l_decap_4
* cell instance sg13cmos5l_decap_4_331 r0 *1 0,0
Xsg13cmos5l_decap_4_331 VPWR VGND sg13cmos5l_decap_4
* cell instance sg13cmos5l_decap_4_332 r0 *1 0,0
Xsg13cmos5l_decap_4_332 VPWR VGND sg13cmos5l_decap_4
* cell instance sg13cmos5l_decap_4_333 r0 *1 0,0
Xsg13cmos5l_decap_4_333 VPWR VGND sg13cmos5l_decap_4
* cell instance sg13cmos5l_decap_4_334 r0 *1 0,0
Xsg13cmos5l_decap_4_334 VPWR VGND sg13cmos5l_decap_4
* cell instance sg13cmos5l_decap_4_335 r0 *1 0,0
Xsg13cmos5l_decap_4_335 VPWR VGND sg13cmos5l_decap_4
* cell instance sg13cmos5l_decap_4_336 r0 *1 0,0
Xsg13cmos5l_decap_4_336 VPWR VGND sg13cmos5l_decap_4
* cell instance sg13cmos5l_decap_4_337 r0 *1 0,0
Xsg13cmos5l_decap_4_337 VPWR VGND sg13cmos5l_decap_4
* cell instance sg13cmos5l_decap_4_338 r0 *1 0,0
Xsg13cmos5l_decap_4_338 VPWR VGND sg13cmos5l_decap_4
* cell instance sg13cmos5l_decap_4_339 r0 *1 0,0
Xsg13cmos5l_decap_4_339 VPWR VGND sg13cmos5l_decap_4
* cell instance sg13cmos5l_decap_4_340 r0 *1 0,0
Xsg13cmos5l_decap_4_340 VPWR VGND sg13cmos5l_decap_4
* cell instance sg13cmos5l_decap_4_341 r0 *1 0,0
Xsg13cmos5l_decap_4_341 VPWR VGND sg13cmos5l_decap_4
* cell instance sg13cmos5l_decap_4_342 r0 *1 0,0
Xsg13cmos5l_decap_4_342 VPWR VGND sg13cmos5l_decap_4
* cell instance sg13cmos5l_decap_4_343 r0 *1 0,0
Xsg13cmos5l_decap_4_343 VPWR VGND sg13cmos5l_decap_4
* cell instance sg13cmos5l_decap_4_344 r0 *1 0,0
Xsg13cmos5l_decap_4_344 VPWR VGND sg13cmos5l_decap_4
* cell instance sg13cmos5l_decap_4_345 r0 *1 0,0
Xsg13cmos5l_decap_4_345 VPWR VGND sg13cmos5l_decap_4
* cell instance sg13cmos5l_decap_4_346 r0 *1 0,0
Xsg13cmos5l_decap_4_346 VPWR VGND sg13cmos5l_decap_4
* cell instance sg13cmos5l_decap_4_347 r0 *1 0,0
Xsg13cmos5l_decap_4_347 VPWR VGND sg13cmos5l_decap_4
* cell instance sg13cmos5l_decap_4_348 r0 *1 0,0
Xsg13cmos5l_decap_4_348 VPWR VGND sg13cmos5l_decap_4
* cell instance sg13cmos5l_decap_4_349 r0 *1 0,0
Xsg13cmos5l_decap_4_349 VPWR VGND sg13cmos5l_decap_4
* cell instance sg13cmos5l_decap_4_350 r0 *1 0,0
Xsg13cmos5l_decap_4_350 VPWR VGND sg13cmos5l_decap_4
* cell instance sg13cmos5l_decap_4_351 r0 *1 0,0
Xsg13cmos5l_decap_4_351 VPWR VGND sg13cmos5l_decap_4
* cell instance sg13cmos5l_decap_4_352 r0 *1 0,0
Xsg13cmos5l_decap_4_352 VPWR VGND sg13cmos5l_decap_4
* cell instance sg13cmos5l_decap_4_353 r0 *1 0,0
Xsg13cmos5l_decap_4_353 VPWR VGND sg13cmos5l_decap_4
* cell instance sg13cmos5l_decap_4_354 r0 *1 0,0
Xsg13cmos5l_decap_4_354 VPWR VGND sg13cmos5l_decap_4
* cell instance sg13cmos5l_decap_4_355 r0 *1 0,0
Xsg13cmos5l_decap_4_355 VPWR VGND sg13cmos5l_decap_4
* cell instance sg13cmos5l_decap_4_356 r0 *1 0,0
Xsg13cmos5l_decap_4_356 VPWR VGND sg13cmos5l_decap_4
* cell instance sg13cmos5l_decap_4_357 r0 *1 0,0
Xsg13cmos5l_decap_4_357 VPWR VGND sg13cmos5l_decap_4
* cell instance sg13cmos5l_decap_4_358 r0 *1 0,0
Xsg13cmos5l_decap_4_358 VPWR VGND sg13cmos5l_decap_4
* cell instance sg13cmos5l_decap_4_359 r0 *1 0,0
Xsg13cmos5l_decap_4_359 VPWR VGND sg13cmos5l_decap_4
* cell instance sg13cmos5l_decap_4_360 r0 *1 0,0
Xsg13cmos5l_decap_4_360 VPWR VGND sg13cmos5l_decap_4
* cell instance sg13cmos5l_decap_4_361 r0 *1 0,0
Xsg13cmos5l_decap_4_361 VPWR VGND sg13cmos5l_decap_4
* cell instance sg13cmos5l_decap_4_362 r0 *1 0,0
Xsg13cmos5l_decap_4_362 VPWR VGND sg13cmos5l_decap_4
* cell instance sg13cmos5l_decap_4_363 r0 *1 0,0
Xsg13cmos5l_decap_4_363 VPWR VGND sg13cmos5l_decap_4
* cell instance sg13cmos5l_decap_4_364 r0 *1 0,0
Xsg13cmos5l_decap_4_364 VPWR VGND sg13cmos5l_decap_4
* cell instance sg13cmos5l_decap_4_365 r0 *1 0,0
Xsg13cmos5l_decap_4_365 VPWR VGND sg13cmos5l_decap_4
* cell instance sg13cmos5l_decap_4_366 r0 *1 0,0
Xsg13cmos5l_decap_4_366 VPWR VGND sg13cmos5l_decap_4
* cell instance sg13cmos5l_decap_4_367 r0 *1 0,0
Xsg13cmos5l_decap_4_367 VPWR VGND sg13cmos5l_decap_4
* cell instance sg13cmos5l_decap_4_368 r0 *1 0,0
Xsg13cmos5l_decap_4_368 VPWR VGND sg13cmos5l_decap_4
* cell instance sg13cmos5l_decap_4_369 r0 *1 0,0
Xsg13cmos5l_decap_4_369 VPWR VGND sg13cmos5l_decap_4
* cell instance sg13cmos5l_decap_4_370 r0 *1 0,0
Xsg13cmos5l_decap_4_370 VPWR VGND sg13cmos5l_decap_4
* cell instance sg13cmos5l_decap_4_371 r0 *1 0,0
Xsg13cmos5l_decap_4_371 VPWR VGND sg13cmos5l_decap_4
* cell instance sg13cmos5l_decap_4_372 r0 *1 0,0
Xsg13cmos5l_decap_4_372 VPWR VGND sg13cmos5l_decap_4
* cell instance sg13cmos5l_decap_4_373 r0 *1 0,0
Xsg13cmos5l_decap_4_373 VPWR VGND sg13cmos5l_decap_4
* cell instance sg13cmos5l_decap_4_374 r0 *1 0,0
Xsg13cmos5l_decap_4_374 VPWR VGND sg13cmos5l_decap_4
* cell instance sg13cmos5l_decap_4_375 r0 *1 0,0
Xsg13cmos5l_decap_4_375 VPWR VGND sg13cmos5l_decap_4
* cell instance sg13cmos5l_decap_4_376 r0 *1 0,0
Xsg13cmos5l_decap_4_376 VPWR VGND sg13cmos5l_decap_4
* cell instance sg13cmos5l_decap_4_377 r0 *1 0,0
Xsg13cmos5l_decap_4_377 VPWR VGND sg13cmos5l_decap_4
* cell instance sg13cmos5l_decap_4_378 r0 *1 0,0
Xsg13cmos5l_decap_4_378 VPWR VGND sg13cmos5l_decap_4
* cell instance sg13cmos5l_decap_4_379 r0 *1 0,0
Xsg13cmos5l_decap_4_379 VPWR VGND sg13cmos5l_decap_4
* cell instance sg13cmos5l_decap_4_380 r0 *1 0,0
Xsg13cmos5l_decap_4_380 VPWR VGND sg13cmos5l_decap_4
* cell instance sg13cmos5l_decap_4_381 r0 *1 0,0
Xsg13cmos5l_decap_4_381 VPWR VGND sg13cmos5l_decap_4
* cell instance sg13cmos5l_decap_4_382 r0 *1 0,0
Xsg13cmos5l_decap_4_382 VPWR VGND sg13cmos5l_decap_4
* cell instance sg13cmos5l_decap_4_383 r0 *1 0,0
Xsg13cmos5l_decap_4_383 VPWR VGND sg13cmos5l_decap_4
* cell instance sg13cmos5l_decap_4_384 r0 *1 0,0
Xsg13cmos5l_decap_4_384 VPWR VGND sg13cmos5l_decap_4
* cell instance sg13cmos5l_decap_4_385 r0 *1 0,0
Xsg13cmos5l_decap_4_385 VPWR VGND sg13cmos5l_decap_4
* cell instance sg13cmos5l_decap_4_386 r0 *1 0,0
Xsg13cmos5l_decap_4_386 VPWR VGND sg13cmos5l_decap_4
* cell instance sg13cmos5l_decap_4_387 r0 *1 0,0
Xsg13cmos5l_decap_4_387 VPWR VGND sg13cmos5l_decap_4
* cell instance sg13cmos5l_decap_4_388 r0 *1 0,0
Xsg13cmos5l_decap_4_388 VPWR VGND sg13cmos5l_decap_4
* cell instance sg13cmos5l_decap_4_389 r0 *1 0,0
Xsg13cmos5l_decap_4_389 VPWR VGND sg13cmos5l_decap_4
* cell instance sg13cmos5l_decap_4_390 r0 *1 0,0
Xsg13cmos5l_decap_4_390 VPWR VGND sg13cmos5l_decap_4
* cell instance sg13cmos5l_decap_4_391 r0 *1 0,0
Xsg13cmos5l_decap_4_391 VPWR VGND sg13cmos5l_decap_4
* cell instance sg13cmos5l_decap_4_392 r0 *1 0,0
Xsg13cmos5l_decap_4_392 VPWR VGND sg13cmos5l_decap_4
* cell instance sg13cmos5l_decap_4_393 r0 *1 0,0
Xsg13cmos5l_decap_4_393 VPWR VGND sg13cmos5l_decap_4
* cell instance sg13cmos5l_decap_4_394 r0 *1 0,0
Xsg13cmos5l_decap_4_394 VPWR VGND sg13cmos5l_decap_4
* cell instance sg13cmos5l_decap_4_395 r0 *1 0,0
Xsg13cmos5l_decap_4_395 VPWR VGND sg13cmos5l_decap_4
* cell instance sg13cmos5l_decap_4_396 r0 *1 0,0
Xsg13cmos5l_decap_4_396 VPWR VGND sg13cmos5l_decap_4
* cell instance sg13cmos5l_decap_4_397 r0 *1 0,0
Xsg13cmos5l_decap_4_397 VPWR VGND sg13cmos5l_decap_4
* cell instance sg13cmos5l_decap_4_398 r0 *1 0,0
Xsg13cmos5l_decap_4_398 VPWR VGND sg13cmos5l_decap_4
* cell instance sg13cmos5l_decap_4_399 r0 *1 0,0
Xsg13cmos5l_decap_4_399 VPWR VGND sg13cmos5l_decap_4
* cell instance sg13cmos5l_decap_4_400 r0 *1 0,0
Xsg13cmos5l_decap_4_400 VPWR VGND sg13cmos5l_decap_4
* cell instance sg13cmos5l_decap_4_401 r0 *1 0,0
Xsg13cmos5l_decap_4_401 VPWR VGND sg13cmos5l_decap_4
* cell instance sg13cmos5l_decap_4_402 r0 *1 0,0
Xsg13cmos5l_decap_4_402 VPWR VGND sg13cmos5l_decap_4
* cell instance sg13cmos5l_decap_4_403 r0 *1 0,0
Xsg13cmos5l_decap_4_403 VPWR VGND sg13cmos5l_decap_4
* cell instance sg13cmos5l_decap_4_404 r0 *1 0,0
Xsg13cmos5l_decap_4_404 VPWR VGND sg13cmos5l_decap_4
* cell instance sg13cmos5l_decap_4_405 r0 *1 0,0
Xsg13cmos5l_decap_4_405 VPWR VGND sg13cmos5l_decap_4
* cell instance sg13cmos5l_decap_4_406 r0 *1 0,0
Xsg13cmos5l_decap_4_406 VPWR VGND sg13cmos5l_decap_4
* cell instance sg13cmos5l_decap_4_407 r0 *1 0,0
Xsg13cmos5l_decap_4_407 VPWR VGND sg13cmos5l_decap_4
* cell instance sg13cmos5l_decap_4_408 r0 *1 0,0
Xsg13cmos5l_decap_4_408 VPWR VGND sg13cmos5l_decap_4
* cell instance sg13cmos5l_decap_4_409 r0 *1 0,0
Xsg13cmos5l_decap_4_409 VPWR VGND sg13cmos5l_decap_4
* cell instance sg13cmos5l_decap_4_410 r0 *1 0,0
Xsg13cmos5l_decap_4_410 VPWR VGND sg13cmos5l_decap_4
* cell instance sg13cmos5l_decap_4_411 r0 *1 0,0
Xsg13cmos5l_decap_4_411 VPWR VGND sg13cmos5l_decap_4
* cell instance sg13cmos5l_decap_4_412 r0 *1 0,0
Xsg13cmos5l_decap_4_412 VPWR VGND sg13cmos5l_decap_4
* cell instance sg13cmos5l_decap_4_413 r0 *1 0,0
Xsg13cmos5l_decap_4_413 VPWR VGND sg13cmos5l_decap_4
* cell instance sg13cmos5l_decap_4_414 r0 *1 0,0
Xsg13cmos5l_decap_4_414 VPWR VGND sg13cmos5l_decap_4
* cell instance sg13cmos5l_decap_4_415 r0 *1 0,0
Xsg13cmos5l_decap_4_415 VPWR VGND sg13cmos5l_decap_4
* cell instance sg13cmos5l_decap_4_416 r0 *1 0,0
Xsg13cmos5l_decap_4_416 VPWR VGND sg13cmos5l_decap_4
* cell instance sg13cmos5l_decap_4_417 r0 *1 0,0
Xsg13cmos5l_decap_4_417 VPWR VGND sg13cmos5l_decap_4
* cell instance sg13cmos5l_decap_4_418 r0 *1 0,0
Xsg13cmos5l_decap_4_418 VPWR VGND sg13cmos5l_decap_4
* cell instance sg13cmos5l_decap_4_419 r0 *1 0,0
Xsg13cmos5l_decap_4_419 VPWR VGND sg13cmos5l_decap_4
* cell instance sg13cmos5l_decap_4_420 r0 *1 0,0
Xsg13cmos5l_decap_4_420 VPWR VGND sg13cmos5l_decap_4
* cell instance sg13cmos5l_decap_4_421 r0 *1 0,0
Xsg13cmos5l_decap_4_421 VPWR VGND sg13cmos5l_decap_4
* cell instance sg13cmos5l_decap_4_422 r0 *1 0,0
Xsg13cmos5l_decap_4_422 VPWR VGND sg13cmos5l_decap_4
* cell instance sg13cmos5l_decap_4_423 r0 *1 0,0
Xsg13cmos5l_decap_4_423 VPWR VGND sg13cmos5l_decap_4
* cell instance sg13cmos5l_decap_4_424 r0 *1 0,0
Xsg13cmos5l_decap_4_424 VPWR VGND sg13cmos5l_decap_4
* cell instance sg13cmos5l_decap_4_425 r0 *1 0,0
Xsg13cmos5l_decap_4_425 VPWR VGND sg13cmos5l_decap_4
* cell instance sg13cmos5l_decap_4_426 r0 *1 0,0
Xsg13cmos5l_decap_4_426 VPWR VGND sg13cmos5l_decap_4
* cell instance sg13cmos5l_decap_4_427 r0 *1 0,0
Xsg13cmos5l_decap_4_427 VPWR VGND sg13cmos5l_decap_4
* cell instance sg13cmos5l_decap_4_428 r0 *1 0,0
Xsg13cmos5l_decap_4_428 VPWR VGND sg13cmos5l_decap_4
* cell instance sg13cmos5l_decap_4_429 r0 *1 0,0
Xsg13cmos5l_decap_4_429 VPWR VGND sg13cmos5l_decap_4
* cell instance sg13cmos5l_decap_4_430 r0 *1 0,0
Xsg13cmos5l_decap_4_430 VPWR VGND sg13cmos5l_decap_4
* cell instance sg13cmos5l_decap_4_431 r0 *1 0,0
Xsg13cmos5l_decap_4_431 VPWR VGND sg13cmos5l_decap_4
* cell instance sg13cmos5l_decap_4_432 r0 *1 0,0
Xsg13cmos5l_decap_4_432 VPWR VGND sg13cmos5l_decap_4
* cell instance sg13cmos5l_decap_4_433 r0 *1 0,0
Xsg13cmos5l_decap_4_433 VPWR VGND sg13cmos5l_decap_4
* cell instance sg13cmos5l_decap_4_434 r0 *1 0,0
Xsg13cmos5l_decap_4_434 VPWR VGND sg13cmos5l_decap_4
* cell instance sg13cmos5l_decap_4_435 r0 *1 0,0
Xsg13cmos5l_decap_4_435 VPWR VGND sg13cmos5l_decap_4
* cell instance sg13cmos5l_decap_4_436 r0 *1 0,0
Xsg13cmos5l_decap_4_436 VPWR VGND sg13cmos5l_decap_4
* cell instance sg13cmos5l_decap_4_437 r0 *1 0,0
Xsg13cmos5l_decap_4_437 VPWR VGND sg13cmos5l_decap_4
* cell instance sg13cmos5l_decap_4_438 r0 *1 0,0
Xsg13cmos5l_decap_4_438 VPWR VGND sg13cmos5l_decap_4
* cell instance sg13cmos5l_decap_4_439 r0 *1 0,0
Xsg13cmos5l_decap_4_439 VPWR VGND sg13cmos5l_decap_4
* cell instance sg13cmos5l_decap_4_440 r0 *1 0,0
Xsg13cmos5l_decap_4_440 VPWR VGND sg13cmos5l_decap_4
* cell instance sg13cmos5l_decap_4_441 r0 *1 0,0
Xsg13cmos5l_decap_4_441 VPWR VGND sg13cmos5l_decap_4
* cell instance sg13cmos5l_decap_4_442 r0 *1 0,0
Xsg13cmos5l_decap_4_442 VPWR VGND sg13cmos5l_decap_4
* cell instance sg13cmos5l_decap_4_443 r0 *1 0,0
Xsg13cmos5l_decap_4_443 VPWR VGND sg13cmos5l_decap_4
* cell instance sg13cmos5l_decap_4_444 r0 *1 0,0
Xsg13cmos5l_decap_4_444 VPWR VGND sg13cmos5l_decap_4
* cell instance sg13cmos5l_decap_4_445 r0 *1 0,0
Xsg13cmos5l_decap_4_445 VPWR VGND sg13cmos5l_decap_4
* cell instance sg13cmos5l_decap_4_446 r0 *1 0,0
Xsg13cmos5l_decap_4_446 VPWR VGND sg13cmos5l_decap_4
* cell instance sg13cmos5l_decap_4_447 r0 *1 0,0
Xsg13cmos5l_decap_4_447 VPWR VGND sg13cmos5l_decap_4
* cell instance sg13cmos5l_decap_4_448 r0 *1 0,0
Xsg13cmos5l_decap_4_448 VPWR VGND sg13cmos5l_decap_4
* cell instance sg13cmos5l_decap_4_449 r0 *1 0,0
Xsg13cmos5l_decap_4_449 VPWR VGND sg13cmos5l_decap_4
* cell instance sg13cmos5l_decap_4_450 r0 *1 0,0
Xsg13cmos5l_decap_4_450 VPWR VGND sg13cmos5l_decap_4
* cell instance sg13cmos5l_decap_4_451 r0 *1 0,0
Xsg13cmos5l_decap_4_451 VPWR VGND sg13cmos5l_decap_4
* cell instance sg13cmos5l_decap_4_452 r0 *1 0,0
Xsg13cmos5l_decap_4_452 VPWR VGND sg13cmos5l_decap_4
* cell instance sg13cmos5l_decap_4_453 r0 *1 0,0
Xsg13cmos5l_decap_4_453 VPWR VGND sg13cmos5l_decap_4
* cell instance sg13cmos5l_decap_4_454 r0 *1 0,0
Xsg13cmos5l_decap_4_454 VPWR VGND sg13cmos5l_decap_4
* cell instance sg13cmos5l_decap_4_455 r0 *1 0,0
Xsg13cmos5l_decap_4_455 VPWR VGND sg13cmos5l_decap_4
* cell instance sg13cmos5l_decap_4_456 r0 *1 0,0
Xsg13cmos5l_decap_4_456 VPWR VGND sg13cmos5l_decap_4
* cell instance sg13cmos5l_decap_4_457 r0 *1 0,0
Xsg13cmos5l_decap_4_457 VPWR VGND sg13cmos5l_decap_4
* cell instance sg13cmos5l_decap_4_458 r0 *1 0,0
Xsg13cmos5l_decap_4_458 VPWR VGND sg13cmos5l_decap_4
* cell instance sg13cmos5l_decap_4_459 r0 *1 0,0
Xsg13cmos5l_decap_4_459 VPWR VGND sg13cmos5l_decap_4
* cell instance sg13cmos5l_decap_4_460 r0 *1 0,0
Xsg13cmos5l_decap_4_460 VPWR VGND sg13cmos5l_decap_4
* cell instance sg13cmos5l_decap_4_461 r0 *1 0,0
Xsg13cmos5l_decap_4_461 VPWR VGND sg13cmos5l_decap_4
* cell instance sg13cmos5l_decap_4_462 r0 *1 0,0
Xsg13cmos5l_decap_4_462 VPWR VGND sg13cmos5l_decap_4
* cell instance sg13cmos5l_decap_4_463 r0 *1 0,0
Xsg13cmos5l_decap_4_463 VPWR VGND sg13cmos5l_decap_4
* cell instance sg13cmos5l_decap_4_464 r0 *1 0,0
Xsg13cmos5l_decap_4_464 VPWR VGND sg13cmos5l_decap_4
* cell instance sg13cmos5l_decap_4_465 r0 *1 0,0
Xsg13cmos5l_decap_4_465 VPWR VGND sg13cmos5l_decap_4
* cell instance sg13cmos5l_decap_4_466 r0 *1 0,0
Xsg13cmos5l_decap_4_466 VPWR VGND sg13cmos5l_decap_4
* cell instance sg13cmos5l_decap_4_467 r0 *1 0,0
Xsg13cmos5l_decap_4_467 VPWR VGND sg13cmos5l_decap_4
* cell instance sg13cmos5l_decap_4_468 r0 *1 0,0
Xsg13cmos5l_decap_4_468 VPWR VGND sg13cmos5l_decap_4
* cell instance sg13cmos5l_decap_4_469 r0 *1 0,0
Xsg13cmos5l_decap_4_469 VPWR VGND sg13cmos5l_decap_4
* cell instance sg13cmos5l_decap_4_470 r0 *1 0,0
Xsg13cmos5l_decap_4_470 VPWR VGND sg13cmos5l_decap_4
* cell instance sg13cmos5l_decap_4_471 r0 *1 0,0
Xsg13cmos5l_decap_4_471 VPWR VGND sg13cmos5l_decap_4
* cell instance sg13cmos5l_decap_4_472 r0 *1 0,0
Xsg13cmos5l_decap_4_472 VPWR VGND sg13cmos5l_decap_4
* cell instance sg13cmos5l_decap_4_473 r0 *1 0,0
Xsg13cmos5l_decap_4_473 VPWR VGND sg13cmos5l_decap_4
* cell instance sg13cmos5l_decap_4_474 r0 *1 0,0
Xsg13cmos5l_decap_4_474 VPWR VGND sg13cmos5l_decap_4
* cell instance sg13cmos5l_decap_4_475 r0 *1 0,0
Xsg13cmos5l_decap_4_475 VPWR VGND sg13cmos5l_decap_4
* cell instance sg13cmos5l_decap_4_476 r0 *1 0,0
Xsg13cmos5l_decap_4_476 VPWR VGND sg13cmos5l_decap_4
* cell instance sg13cmos5l_decap_4_477 r0 *1 0,0
Xsg13cmos5l_decap_4_477 VPWR VGND sg13cmos5l_decap_4
* cell instance sg13cmos5l_decap_4_478 r0 *1 0,0
Xsg13cmos5l_decap_4_478 VPWR VGND sg13cmos5l_decap_4
* cell instance sg13cmos5l_decap_4_479 r0 *1 0,0
Xsg13cmos5l_decap_4_479 VPWR VGND sg13cmos5l_decap_4
* cell instance sg13cmos5l_decap_4_480 r0 *1 0,0
Xsg13cmos5l_decap_4_480 VPWR VGND sg13cmos5l_decap_4
* cell instance sg13cmos5l_decap_4_481 r0 *1 0,0
Xsg13cmos5l_decap_4_481 VPWR VGND sg13cmos5l_decap_4
* cell instance sg13cmos5l_decap_4_482 r0 *1 0,0
Xsg13cmos5l_decap_4_482 VPWR VGND sg13cmos5l_decap_4
* cell instance sg13cmos5l_decap_4_483 r0 *1 0,0
Xsg13cmos5l_decap_4_483 VPWR VGND sg13cmos5l_decap_4
* cell instance sg13cmos5l_decap_4_484 r0 *1 0,0
Xsg13cmos5l_decap_4_484 VPWR VGND sg13cmos5l_decap_4
* cell instance sg13cmos5l_decap_4_485 r0 *1 0,0
Xsg13cmos5l_decap_4_485 VPWR VGND sg13cmos5l_decap_4
* cell instance sg13cmos5l_decap_4_486 r0 *1 0,0
Xsg13cmos5l_decap_4_486 VPWR VGND sg13cmos5l_decap_4
* cell instance sg13cmos5l_decap_4_487 r0 *1 0,0
Xsg13cmos5l_decap_4_487 VPWR VGND sg13cmos5l_decap_4
* cell instance sg13cmos5l_decap_4_488 r0 *1 0,0
Xsg13cmos5l_decap_4_488 VPWR VGND sg13cmos5l_decap_4
* cell instance sg13cmos5l_decap_4_489 r0 *1 0,0
Xsg13cmos5l_decap_4_489 VPWR VGND sg13cmos5l_decap_4
* cell instance sg13cmos5l_decap_4_490 r0 *1 0,0
Xsg13cmos5l_decap_4_490 VPWR VGND sg13cmos5l_decap_4
* cell instance sg13cmos5l_decap_4_491 r0 *1 0,0
Xsg13cmos5l_decap_4_491 VPWR VGND sg13cmos5l_decap_4
* cell instance sg13cmos5l_decap_4_492 r0 *1 0,0
Xsg13cmos5l_decap_4_492 VPWR VGND sg13cmos5l_decap_4
* cell instance sg13cmos5l_decap_4_493 r0 *1 0,0
Xsg13cmos5l_decap_4_493 VPWR VGND sg13cmos5l_decap_4
* cell instance sg13cmos5l_decap_4_494 r0 *1 0,0
Xsg13cmos5l_decap_4_494 VPWR VGND sg13cmos5l_decap_4
* cell instance sg13cmos5l_decap_4_495 r0 *1 0,0
Xsg13cmos5l_decap_4_495 VPWR VGND sg13cmos5l_decap_4
* cell instance sg13cmos5l_decap_4_496 r0 *1 0,0
Xsg13cmos5l_decap_4_496 VPWR VGND sg13cmos5l_decap_4
* cell instance sg13cmos5l_decap_4_497 r0 *1 0,0
Xsg13cmos5l_decap_4_497 VPWR VGND sg13cmos5l_decap_4
* cell instance sg13cmos5l_decap_4_498 r0 *1 0,0
Xsg13cmos5l_decap_4_498 VPWR VGND sg13cmos5l_decap_4
* cell instance sg13cmos5l_decap_4_499 r0 *1 0,0
Xsg13cmos5l_decap_4_499 VPWR VGND sg13cmos5l_decap_4
* cell instance sg13cmos5l_decap_4_500 r0 *1 0,0
Xsg13cmos5l_decap_4_500 VPWR VGND sg13cmos5l_decap_4
* cell instance sg13cmos5l_decap_4_501 r0 *1 0,0
Xsg13cmos5l_decap_4_501 VPWR VGND sg13cmos5l_decap_4
* cell instance sg13cmos5l_decap_4_502 r0 *1 0,0
Xsg13cmos5l_decap_4_502 VPWR VGND sg13cmos5l_decap_4
* cell instance sg13cmos5l_decap_4_503 r0 *1 0,0
Xsg13cmos5l_decap_4_503 VPWR VGND sg13cmos5l_decap_4
* cell instance sg13cmos5l_decap_4_504 r0 *1 0,0
Xsg13cmos5l_decap_4_504 VPWR VGND sg13cmos5l_decap_4
* cell instance sg13cmos5l_decap_4_505 r0 *1 0,0
Xsg13cmos5l_decap_4_505 VPWR VGND sg13cmos5l_decap_4
* cell instance sg13cmos5l_decap_4_506 r0 *1 0,0
Xsg13cmos5l_decap_4_506 VPWR VGND sg13cmos5l_decap_4
* cell instance sg13cmos5l_decap_4_507 r0 *1 0,0
Xsg13cmos5l_decap_4_507 VPWR VGND sg13cmos5l_decap_4
* cell instance sg13cmos5l_decap_4_508 r0 *1 0,0
Xsg13cmos5l_decap_4_508 VPWR VGND sg13cmos5l_decap_4
* cell instance sg13cmos5l_decap_4_509 r0 *1 0,0
Xsg13cmos5l_decap_4_509 VPWR VGND sg13cmos5l_decap_4
* cell instance sg13cmos5l_decap_4_510 r0 *1 0,0
Xsg13cmos5l_decap_4_510 VPWR VGND sg13cmos5l_decap_4
* cell instance sg13cmos5l_decap_4_511 r0 *1 0,0
Xsg13cmos5l_decap_4_511 VPWR VGND sg13cmos5l_decap_4
* cell instance sg13cmos5l_decap_4_512 r0 *1 0,0
Xsg13cmos5l_decap_4_512 VPWR VGND sg13cmos5l_decap_4
* cell instance sg13cmos5l_decap_4_513 r0 *1 0,0
Xsg13cmos5l_decap_4_513 VPWR VGND sg13cmos5l_decap_4
* cell instance sg13cmos5l_decap_4_514 r0 *1 0,0
Xsg13cmos5l_decap_4_514 VPWR VGND sg13cmos5l_decap_4
* cell instance sg13cmos5l_decap_4_515 r0 *1 0,0
Xsg13cmos5l_decap_4_515 VPWR VGND sg13cmos5l_decap_4
* cell instance sg13cmos5l_decap_4_516 r0 *1 0,0
Xsg13cmos5l_decap_4_516 VPWR VGND sg13cmos5l_decap_4
* cell instance sg13cmos5l_decap_4_517 r0 *1 0,0
Xsg13cmos5l_decap_4_517 VPWR VGND sg13cmos5l_decap_4
* cell instance sg13cmos5l_decap_4_518 r0 *1 0,0
Xsg13cmos5l_decap_4_518 VPWR VGND sg13cmos5l_decap_4
* cell instance sg13cmos5l_decap_4_519 r0 *1 0,0
Xsg13cmos5l_decap_4_519 VPWR VGND sg13cmos5l_decap_4
* cell instance sg13cmos5l_decap_4_520 r0 *1 0,0
Xsg13cmos5l_decap_4_520 VPWR VGND sg13cmos5l_decap_4
* cell instance sg13cmos5l_decap_4_521 r0 *1 0,0
Xsg13cmos5l_decap_4_521 VPWR VGND sg13cmos5l_decap_4
* cell instance sg13cmos5l_decap_4_522 r0 *1 0,0
Xsg13cmos5l_decap_4_522 VPWR VGND sg13cmos5l_decap_4
* cell instance sg13cmos5l_decap_4_523 r0 *1 0,0
Xsg13cmos5l_decap_4_523 VPWR VGND sg13cmos5l_decap_4
* cell instance sg13cmos5l_decap_4_524 r0 *1 0,0
Xsg13cmos5l_decap_4_524 VPWR VGND sg13cmos5l_decap_4
* cell instance sg13cmos5l_decap_4_525 r0 *1 0,0
Xsg13cmos5l_decap_4_525 VPWR VGND sg13cmos5l_decap_4
* cell instance sg13cmos5l_decap_4_526 r0 *1 0,0
Xsg13cmos5l_decap_4_526 VPWR VGND sg13cmos5l_decap_4
* cell instance sg13cmos5l_decap_4_527 r0 *1 0,0
Xsg13cmos5l_decap_4_527 VPWR VGND sg13cmos5l_decap_4
* cell instance sg13cmos5l_decap_4_528 r0 *1 0,0
Xsg13cmos5l_decap_4_528 VPWR VGND sg13cmos5l_decap_4
* cell instance sg13cmos5l_decap_4_529 r0 *1 0,0
Xsg13cmos5l_decap_4_529 VPWR VGND sg13cmos5l_decap_4
* cell instance sg13cmos5l_decap_4_530 r0 *1 0,0
Xsg13cmos5l_decap_4_530 VPWR VGND sg13cmos5l_decap_4
* cell instance sg13cmos5l_decap_4_531 r0 *1 0,0
Xsg13cmos5l_decap_4_531 VPWR VGND sg13cmos5l_decap_4
* cell instance sg13cmos5l_decap_4_532 r0 *1 0,0
Xsg13cmos5l_decap_4_532 VPWR VGND sg13cmos5l_decap_4
* cell instance sg13cmos5l_decap_4_533 r0 *1 0,0
Xsg13cmos5l_decap_4_533 VPWR VGND sg13cmos5l_decap_4
* cell instance sg13cmos5l_decap_4_534 r0 *1 0,0
Xsg13cmos5l_decap_4_534 VPWR VGND sg13cmos5l_decap_4
* cell instance sg13cmos5l_decap_4_535 r0 *1 0,0
Xsg13cmos5l_decap_4_535 VPWR VGND sg13cmos5l_decap_4
* cell instance sg13cmos5l_decap_4_536 r0 *1 0,0
Xsg13cmos5l_decap_4_536 VPWR VGND sg13cmos5l_decap_4
* cell instance sg13cmos5l_decap_4_537 r0 *1 0,0
Xsg13cmos5l_decap_4_537 VPWR VGND sg13cmos5l_decap_4
* cell instance sg13cmos5l_decap_4_538 r0 *1 0,0
Xsg13cmos5l_decap_4_538 VPWR VGND sg13cmos5l_decap_4
* cell instance sg13cmos5l_decap_4_539 r0 *1 0,0
Xsg13cmos5l_decap_4_539 VPWR VGND sg13cmos5l_decap_4
* cell instance sg13cmos5l_decap_4_540 r0 *1 0,0
Xsg13cmos5l_decap_4_540 VPWR VGND sg13cmos5l_decap_4
* cell instance sg13cmos5l_decap_4_541 r0 *1 0,0
Xsg13cmos5l_decap_4_541 VPWR VGND sg13cmos5l_decap_4
* cell instance sg13cmos5l_decap_4_542 r0 *1 0,0
Xsg13cmos5l_decap_4_542 VPWR VGND sg13cmos5l_decap_4
* cell instance sg13cmos5l_decap_4_543 r0 *1 0,0
Xsg13cmos5l_decap_4_543 VPWR VGND sg13cmos5l_decap_4
* cell instance sg13cmos5l_decap_4_544 r0 *1 0,0
Xsg13cmos5l_decap_4_544 VPWR VGND sg13cmos5l_decap_4
* cell instance sg13cmos5l_decap_4_545 r0 *1 0,0
Xsg13cmos5l_decap_4_545 VPWR VGND sg13cmos5l_decap_4
* cell instance sg13cmos5l_decap_4_546 r0 *1 0,0
Xsg13cmos5l_decap_4_546 VPWR VGND sg13cmos5l_decap_4
* cell instance sg13cmos5l_decap_4_547 r0 *1 0,0
Xsg13cmos5l_decap_4_547 VPWR VGND sg13cmos5l_decap_4
* cell instance sg13cmos5l_decap_4_548 r0 *1 0,0
Xsg13cmos5l_decap_4_548 VPWR VGND sg13cmos5l_decap_4
* cell instance sg13cmos5l_decap_4_549 r0 *1 0,0
Xsg13cmos5l_decap_4_549 VPWR VGND sg13cmos5l_decap_4
* cell instance sg13cmos5l_decap_4_550 r0 *1 0,0
Xsg13cmos5l_decap_4_550 VPWR VGND sg13cmos5l_decap_4
* cell instance sg13cmos5l_decap_4_551 r0 *1 0,0
Xsg13cmos5l_decap_4_551 VPWR VGND sg13cmos5l_decap_4
* cell instance sg13cmos5l_decap_4_552 r0 *1 0,0
Xsg13cmos5l_decap_4_552 VPWR VGND sg13cmos5l_decap_4
* cell instance sg13cmos5l_decap_4_553 r0 *1 0,0
Xsg13cmos5l_decap_4_553 VPWR VGND sg13cmos5l_decap_4
* cell instance sg13cmos5l_decap_4_554 r0 *1 0,0
Xsg13cmos5l_decap_4_554 VPWR VGND sg13cmos5l_decap_4
* cell instance sg13cmos5l_decap_4_555 r0 *1 0,0
Xsg13cmos5l_decap_4_555 VPWR VGND sg13cmos5l_decap_4
* cell instance sg13cmos5l_decap_4_556 r0 *1 0,0
Xsg13cmos5l_decap_4_556 VPWR VGND sg13cmos5l_decap_4
* cell instance sg13cmos5l_decap_4_557 r0 *1 0,0
Xsg13cmos5l_decap_4_557 VPWR VGND sg13cmos5l_decap_4
* cell instance sg13cmos5l_decap_4_558 r0 *1 0,0
Xsg13cmos5l_decap_4_558 VPWR VGND sg13cmos5l_decap_4
* cell instance sg13cmos5l_decap_4_559 r0 *1 0,0
Xsg13cmos5l_decap_4_559 VPWR VGND sg13cmos5l_decap_4
* cell instance sg13cmos5l_decap_4_560 r0 *1 0,0
Xsg13cmos5l_decap_4_560 VPWR VGND sg13cmos5l_decap_4
* cell instance sg13cmos5l_decap_4_561 r0 *1 0,0
Xsg13cmos5l_decap_4_561 VPWR VGND sg13cmos5l_decap_4
* cell instance sg13cmos5l_decap_4_562 r0 *1 0,0
Xsg13cmos5l_decap_4_562 VPWR VGND sg13cmos5l_decap_4
* cell instance sg13cmos5l_decap_4_563 r0 *1 0,0
Xsg13cmos5l_decap_4_563 VPWR VGND sg13cmos5l_decap_4
* cell instance sg13cmos5l_decap_4_564 r0 *1 0,0
Xsg13cmos5l_decap_4_564 VPWR VGND sg13cmos5l_decap_4
* cell instance sg13cmos5l_decap_4_565 r0 *1 0,0
Xsg13cmos5l_decap_4_565 VPWR VGND sg13cmos5l_decap_4
* cell instance sg13cmos5l_decap_4_566 r0 *1 0,0
Xsg13cmos5l_decap_4_566 VPWR VGND sg13cmos5l_decap_4
* cell instance sg13cmos5l_decap_4_567 r0 *1 0,0
Xsg13cmos5l_decap_4_567 VPWR VGND sg13cmos5l_decap_4
* cell instance sg13cmos5l_decap_4_568 r0 *1 0,0
Xsg13cmos5l_decap_4_568 VPWR VGND sg13cmos5l_decap_4
* cell instance sg13cmos5l_decap_4_569 r0 *1 0,0
Xsg13cmos5l_decap_4_569 VPWR VGND sg13cmos5l_decap_4
* cell instance sg13cmos5l_decap_4_570 r0 *1 0,0
Xsg13cmos5l_decap_4_570 VPWR VGND sg13cmos5l_decap_4
* cell instance sg13cmos5l_decap_4_571 r0 *1 0,0
Xsg13cmos5l_decap_4_571 VPWR VGND sg13cmos5l_decap_4
* cell instance sg13cmos5l_decap_4_572 r0 *1 0,0
Xsg13cmos5l_decap_4_572 VPWR VGND sg13cmos5l_decap_4
* cell instance sg13cmos5l_decap_4_573 r0 *1 0,0
Xsg13cmos5l_decap_4_573 VPWR VGND sg13cmos5l_decap_4
* cell instance sg13cmos5l_decap_4_574 r0 *1 0,0
Xsg13cmos5l_decap_4_574 VPWR VGND sg13cmos5l_decap_4
* cell instance sg13cmos5l_decap_4_575 r0 *1 0,0
Xsg13cmos5l_decap_4_575 VPWR VGND sg13cmos5l_decap_4
* cell instance sg13cmos5l_decap_4_576 r0 *1 0,0
Xsg13cmos5l_decap_4_576 VPWR VGND sg13cmos5l_decap_4
* cell instance sg13cmos5l_decap_4_577 r0 *1 0,0
Xsg13cmos5l_decap_4_577 VPWR VGND sg13cmos5l_decap_4
* cell instance sg13cmos5l_decap_4_578 r0 *1 0,0
Xsg13cmos5l_decap_4_578 VPWR VGND sg13cmos5l_decap_4
* cell instance sg13cmos5l_decap_4_579 r0 *1 0,0
Xsg13cmos5l_decap_4_579 VPWR VGND sg13cmos5l_decap_4
* cell instance sg13cmos5l_decap_4_580 r0 *1 0,0
Xsg13cmos5l_decap_4_580 VPWR VGND sg13cmos5l_decap_4
* cell instance sg13cmos5l_decap_4_581 r0 *1 0,0
Xsg13cmos5l_decap_4_581 VPWR VGND sg13cmos5l_decap_4
* cell instance sg13cmos5l_decap_4_582 r0 *1 0,0
Xsg13cmos5l_decap_4_582 VPWR VGND sg13cmos5l_decap_4
* cell instance sg13cmos5l_decap_4_583 r0 *1 0,0
Xsg13cmos5l_decap_4_583 VPWR VGND sg13cmos5l_decap_4
* cell instance sg13cmos5l_decap_4_584 r0 *1 0,0
Xsg13cmos5l_decap_4_584 VPWR VGND sg13cmos5l_decap_4
* cell instance sg13cmos5l_decap_4_585 r0 *1 0,0
Xsg13cmos5l_decap_4_585 VPWR VGND sg13cmos5l_decap_4
* cell instance sg13cmos5l_decap_4_586 r0 *1 0,0
Xsg13cmos5l_decap_4_586 VPWR VGND sg13cmos5l_decap_4
* cell instance sg13cmos5l_decap_4_587 r0 *1 0,0
Xsg13cmos5l_decap_4_587 VPWR VGND sg13cmos5l_decap_4
* cell instance sg13cmos5l_decap_4_588 r0 *1 0,0
Xsg13cmos5l_decap_4_588 VPWR VGND sg13cmos5l_decap_4
* cell instance sg13cmos5l_decap_4_589 r0 *1 0,0
Xsg13cmos5l_decap_4_589 VPWR VGND sg13cmos5l_decap_4
* cell instance sg13cmos5l_decap_4_590 r0 *1 0,0
Xsg13cmos5l_decap_4_590 VPWR VGND sg13cmos5l_decap_4
* cell instance sg13cmos5l_decap_4_591 r0 *1 0,0
Xsg13cmos5l_decap_4_591 VPWR VGND sg13cmos5l_decap_4
* cell instance sg13cmos5l_decap_4_592 r0 *1 0,0
Xsg13cmos5l_decap_4_592 VPWR VGND sg13cmos5l_decap_4
* cell instance sg13cmos5l_decap_4_593 r0 *1 0,0
Xsg13cmos5l_decap_4_593 VPWR VGND sg13cmos5l_decap_4
* cell instance sg13cmos5l_decap_4_594 r0 *1 0,0
Xsg13cmos5l_decap_4_594 VPWR VGND sg13cmos5l_decap_4
* cell instance sg13cmos5l_decap_4_595 r0 *1 0,0
Xsg13cmos5l_decap_4_595 VPWR VGND sg13cmos5l_decap_4
* cell instance sg13cmos5l_decap_4_596 r0 *1 0,0
Xsg13cmos5l_decap_4_596 VPWR VGND sg13cmos5l_decap_4
* cell instance sg13cmos5l_decap_4_597 r0 *1 0,0
Xsg13cmos5l_decap_4_597 VPWR VGND sg13cmos5l_decap_4
* cell instance sg13cmos5l_decap_4_598 r0 *1 0,0
Xsg13cmos5l_decap_4_598 VPWR VGND sg13cmos5l_decap_4
* cell instance sg13cmos5l_decap_4_599 r0 *1 0,0
Xsg13cmos5l_decap_4_599 VPWR VGND sg13cmos5l_decap_4
* cell instance sg13cmos5l_decap_4_600 r0 *1 0,0
Xsg13cmos5l_decap_4_600 VPWR VGND sg13cmos5l_decap_4
* cell instance sg13cmos5l_decap_4_601 r0 *1 0,0
Xsg13cmos5l_decap_4_601 VPWR VGND sg13cmos5l_decap_4
* cell instance sg13cmos5l_decap_4_602 r0 *1 0,0
Xsg13cmos5l_decap_4_602 VPWR VGND sg13cmos5l_decap_4
* cell instance sg13cmos5l_decap_4_603 r0 *1 0,0
Xsg13cmos5l_decap_4_603 VPWR VGND sg13cmos5l_decap_4
* cell instance sg13cmos5l_decap_4_604 r0 *1 0,0
Xsg13cmos5l_decap_4_604 VPWR VGND sg13cmos5l_decap_4
* cell instance sg13cmos5l_decap_4_605 r0 *1 0,0
Xsg13cmos5l_decap_4_605 VPWR VGND sg13cmos5l_decap_4
* cell instance sg13cmos5l_decap_4_606 r0 *1 0,0
Xsg13cmos5l_decap_4_606 VPWR VGND sg13cmos5l_decap_4
* cell instance sg13cmos5l_decap_4_607 r0 *1 0,0
Xsg13cmos5l_decap_4_607 VPWR VGND sg13cmos5l_decap_4
* cell instance sg13cmos5l_decap_4_608 r0 *1 0,0
Xsg13cmos5l_decap_4_608 VPWR VGND sg13cmos5l_decap_4
* cell instance sg13cmos5l_decap_4_609 r0 *1 0,0
Xsg13cmos5l_decap_4_609 VPWR VGND sg13cmos5l_decap_4
* cell instance sg13cmos5l_decap_4_610 r0 *1 0,0
Xsg13cmos5l_decap_4_610 VPWR VGND sg13cmos5l_decap_4
* cell instance sg13cmos5l_decap_4_611 r0 *1 0,0
Xsg13cmos5l_decap_4_611 VPWR VGND sg13cmos5l_decap_4
* cell instance sg13cmos5l_decap_4_612 r0 *1 0,0
Xsg13cmos5l_decap_4_612 VPWR VGND sg13cmos5l_decap_4
* cell instance sg13cmos5l_decap_4_613 r0 *1 0,0
Xsg13cmos5l_decap_4_613 VPWR VGND sg13cmos5l_decap_4
* cell instance sg13cmos5l_decap_4_614 r0 *1 0,0
Xsg13cmos5l_decap_4_614 VPWR VGND sg13cmos5l_decap_4
* cell instance sg13cmos5l_decap_4_615 r0 *1 0,0
Xsg13cmos5l_decap_4_615 VPWR VGND sg13cmos5l_decap_4
* cell instance sg13cmos5l_decap_4_616 r0 *1 0,0
Xsg13cmos5l_decap_4_616 VPWR VGND sg13cmos5l_decap_4
* cell instance sg13cmos5l_decap_4_617 r0 *1 0,0
Xsg13cmos5l_decap_4_617 VPWR VGND sg13cmos5l_decap_4
* cell instance sg13cmos5l_decap_4_618 r0 *1 0,0
Xsg13cmos5l_decap_4_618 VPWR VGND sg13cmos5l_decap_4
* cell instance sg13cmos5l_decap_4_619 r0 *1 0,0
Xsg13cmos5l_decap_4_619 VPWR VGND sg13cmos5l_decap_4
* cell instance sg13cmos5l_decap_4_620 r0 *1 0,0
Xsg13cmos5l_decap_4_620 VPWR VGND sg13cmos5l_decap_4
* cell instance sg13cmos5l_decap_4_621 r0 *1 0,0
Xsg13cmos5l_decap_4_621 VPWR VGND sg13cmos5l_decap_4
* cell instance sg13cmos5l_decap_4_622 r0 *1 0,0
Xsg13cmos5l_decap_4_622 VPWR VGND sg13cmos5l_decap_4
* cell instance sg13cmos5l_decap_4_623 r0 *1 0,0
Xsg13cmos5l_decap_4_623 VPWR VGND sg13cmos5l_decap_4
* cell instance sg13cmos5l_decap_4_624 r0 *1 0,0
Xsg13cmos5l_decap_4_624 VPWR VGND sg13cmos5l_decap_4
* cell instance sg13cmos5l_decap_4_625 r0 *1 0,0
Xsg13cmos5l_decap_4_625 VPWR VGND sg13cmos5l_decap_4
* cell instance sg13cmos5l_decap_4_626 r0 *1 0,0
Xsg13cmos5l_decap_4_626 VPWR VGND sg13cmos5l_decap_4
* cell instance sg13cmos5l_decap_4_627 r0 *1 0,0
Xsg13cmos5l_decap_4_627 VPWR VGND sg13cmos5l_decap_4
* cell instance sg13cmos5l_decap_4_628 r0 *1 0,0
Xsg13cmos5l_decap_4_628 VPWR VGND sg13cmos5l_decap_4
* cell instance sg13cmos5l_decap_4_629 r0 *1 0,0
Xsg13cmos5l_decap_4_629 VPWR VGND sg13cmos5l_decap_4
* cell instance sg13cmos5l_decap_4_630 r0 *1 0,0
Xsg13cmos5l_decap_4_630 VPWR VGND sg13cmos5l_decap_4
* cell instance sg13cmos5l_decap_4_631 r0 *1 0,0
Xsg13cmos5l_decap_4_631 VPWR VGND sg13cmos5l_decap_4
* cell instance sg13cmos5l_decap_4_632 r0 *1 0,0
Xsg13cmos5l_decap_4_632 VPWR VGND sg13cmos5l_decap_4
* cell instance sg13cmos5l_decap_4_633 r0 *1 0,0
Xsg13cmos5l_decap_4_633 VPWR VGND sg13cmos5l_decap_4
* cell instance sg13cmos5l_decap_4_634 r0 *1 0,0
Xsg13cmos5l_decap_4_634 VPWR VGND sg13cmos5l_decap_4
* cell instance sg13cmos5l_decap_4_635 r0 *1 0,0
Xsg13cmos5l_decap_4_635 VPWR VGND sg13cmos5l_decap_4
* cell instance sg13cmos5l_decap_4_636 r0 *1 0,0
Xsg13cmos5l_decap_4_636 VPWR VGND sg13cmos5l_decap_4
* cell instance sg13cmos5l_decap_4_637 r0 *1 0,0
Xsg13cmos5l_decap_4_637 VPWR VGND sg13cmos5l_decap_4
* cell instance sg13cmos5l_decap_4_638 r0 *1 0,0
Xsg13cmos5l_decap_4_638 VPWR VGND sg13cmos5l_decap_4
* cell instance sg13cmos5l_decap_4_639 r0 *1 0,0
Xsg13cmos5l_decap_4_639 VPWR VGND sg13cmos5l_decap_4
* cell instance sg13cmos5l_decap_4_640 r0 *1 0,0
Xsg13cmos5l_decap_4_640 VPWR VGND sg13cmos5l_decap_4
* cell instance sg13cmos5l_decap_4_641 r0 *1 0,0
Xsg13cmos5l_decap_4_641 VPWR VGND sg13cmos5l_decap_4
* cell instance sg13cmos5l_decap_4_642 r0 *1 0,0
Xsg13cmos5l_decap_4_642 VPWR VGND sg13cmos5l_decap_4
* cell instance sg13cmos5l_decap_4_643 r0 *1 0,0
Xsg13cmos5l_decap_4_643 VPWR VGND sg13cmos5l_decap_4
* cell instance sg13cmos5l_decap_4_644 r0 *1 0,0
Xsg13cmos5l_decap_4_644 VPWR VGND sg13cmos5l_decap_4
* cell instance sg13cmos5l_decap_4_645 r0 *1 0,0
Xsg13cmos5l_decap_4_645 VPWR VGND sg13cmos5l_decap_4
* cell instance sg13cmos5l_decap_4_646 r0 *1 0,0
Xsg13cmos5l_decap_4_646 VPWR VGND sg13cmos5l_decap_4
* cell instance sg13cmos5l_decap_4_647 r0 *1 0,0
Xsg13cmos5l_decap_4_647 VPWR VGND sg13cmos5l_decap_4
* cell instance sg13cmos5l_decap_4_648 r0 *1 0,0
Xsg13cmos5l_decap_4_648 VPWR VGND sg13cmos5l_decap_4
* cell instance sg13cmos5l_decap_4_649 r0 *1 0,0
Xsg13cmos5l_decap_4_649 VPWR VGND sg13cmos5l_decap_4
* cell instance sg13cmos5l_decap_4_650 r0 *1 0,0
Xsg13cmos5l_decap_4_650 VPWR VGND sg13cmos5l_decap_4
* cell instance sg13cmos5l_decap_4_651 r0 *1 0,0
Xsg13cmos5l_decap_4_651 VPWR VGND sg13cmos5l_decap_4
* cell instance sg13cmos5l_decap_4_652 r0 *1 0,0
Xsg13cmos5l_decap_4_652 VPWR VGND sg13cmos5l_decap_4
* cell instance sg13cmos5l_decap_4_653 r0 *1 0,0
Xsg13cmos5l_decap_4_653 VPWR VGND sg13cmos5l_decap_4
* cell instance sg13cmos5l_decap_4_654 r0 *1 0,0
Xsg13cmos5l_decap_4_654 VPWR VGND sg13cmos5l_decap_4
* cell instance sg13cmos5l_decap_4_655 r0 *1 0,0
Xsg13cmos5l_decap_4_655 VPWR VGND sg13cmos5l_decap_4
* cell instance sg13cmos5l_decap_4_656 r0 *1 0,0
Xsg13cmos5l_decap_4_656 VPWR VGND sg13cmos5l_decap_4
* cell instance sg13cmos5l_decap_4_657 r0 *1 0,0
Xsg13cmos5l_decap_4_657 VPWR VGND sg13cmos5l_decap_4
* cell instance sg13cmos5l_decap_4_658 r0 *1 0,0
Xsg13cmos5l_decap_4_658 VPWR VGND sg13cmos5l_decap_4
* cell instance sg13cmos5l_decap_4_659 r0 *1 0,0
Xsg13cmos5l_decap_4_659 VPWR VGND sg13cmos5l_decap_4
* cell instance sg13cmos5l_decap_4_660 r0 *1 0,0
Xsg13cmos5l_decap_4_660 VPWR VGND sg13cmos5l_decap_4
* cell instance sg13cmos5l_decap_4_661 r0 *1 0,0
Xsg13cmos5l_decap_4_661 VPWR VGND sg13cmos5l_decap_4
* cell instance sg13cmos5l_decap_4_662 r0 *1 0,0
Xsg13cmos5l_decap_4_662 VPWR VGND sg13cmos5l_decap_4
* cell instance sg13cmos5l_decap_4_663 r0 *1 0,0
Xsg13cmos5l_decap_4_663 VPWR VGND sg13cmos5l_decap_4
* cell instance sg13cmos5l_decap_4_664 r0 *1 0,0
Xsg13cmos5l_decap_4_664 VPWR VGND sg13cmos5l_decap_4
* cell instance sg13cmos5l_decap_4_665 r0 *1 0,0
Xsg13cmos5l_decap_4_665 VPWR VGND sg13cmos5l_decap_4
* cell instance sg13cmos5l_decap_4_666 r0 *1 0,0
Xsg13cmos5l_decap_4_666 VPWR VGND sg13cmos5l_decap_4
* cell instance sg13cmos5l_decap_4_667 r0 *1 0,0
Xsg13cmos5l_decap_4_667 VPWR VGND sg13cmos5l_decap_4
* cell instance sg13cmos5l_decap_4_668 r0 *1 0,0
Xsg13cmos5l_decap_4_668 VPWR VGND sg13cmos5l_decap_4
* cell instance sg13cmos5l_decap_4_669 r0 *1 0,0
Xsg13cmos5l_decap_4_669 VPWR VGND sg13cmos5l_decap_4
* cell instance sg13cmos5l_decap_4_670 r0 *1 0,0
Xsg13cmos5l_decap_4_670 VPWR VGND sg13cmos5l_decap_4
* cell instance sg13cmos5l_decap_4_671 r0 *1 0,0
Xsg13cmos5l_decap_4_671 VPWR VGND sg13cmos5l_decap_4
* cell instance sg13cmos5l_decap_4_672 r0 *1 0,0
Xsg13cmos5l_decap_4_672 VPWR VGND sg13cmos5l_decap_4
* cell instance sg13cmos5l_decap_4_673 r0 *1 0,0
Xsg13cmos5l_decap_4_673 VPWR VGND sg13cmos5l_decap_4
* cell instance sg13cmos5l_decap_4_674 r0 *1 0,0
Xsg13cmos5l_decap_4_674 VPWR VGND sg13cmos5l_decap_4
* cell instance sg13cmos5l_decap_4_675 r0 *1 0,0
Xsg13cmos5l_decap_4_675 VPWR VGND sg13cmos5l_decap_4
* cell instance sg13cmos5l_decap_4_676 r0 *1 0,0
Xsg13cmos5l_decap_4_676 VPWR VGND sg13cmos5l_decap_4
* cell instance sg13cmos5l_decap_4_677 r0 *1 0,0
Xsg13cmos5l_decap_4_677 VPWR VGND sg13cmos5l_decap_4
* cell instance sg13cmos5l_decap_4_678 r0 *1 0,0
Xsg13cmos5l_decap_4_678 VPWR VGND sg13cmos5l_decap_4
* cell instance sg13cmos5l_decap_4_679 r0 *1 0,0
Xsg13cmos5l_decap_4_679 VPWR VGND sg13cmos5l_decap_4
* cell instance sg13cmos5l_decap_4_680 r0 *1 0,0
Xsg13cmos5l_decap_4_680 VPWR VGND sg13cmos5l_decap_4
* cell instance sg13cmos5l_decap_4_681 r0 *1 0,0
Xsg13cmos5l_decap_4_681 VPWR VGND sg13cmos5l_decap_4
* cell instance sg13cmos5l_decap_4_682 r0 *1 0,0
Xsg13cmos5l_decap_4_682 VPWR VGND sg13cmos5l_decap_4
* cell instance sg13cmos5l_decap_4_683 r0 *1 0,0
Xsg13cmos5l_decap_4_683 VPWR VGND sg13cmos5l_decap_4
* cell instance sg13cmos5l_decap_4_684 r0 *1 0,0
Xsg13cmos5l_decap_4_684 VPWR VGND sg13cmos5l_decap_4
* cell instance sg13cmos5l_decap_4_685 r0 *1 0,0
Xsg13cmos5l_decap_4_685 VPWR VGND sg13cmos5l_decap_4
* cell instance sg13cmos5l_decap_4_686 r0 *1 0,0
Xsg13cmos5l_decap_4_686 VPWR VGND sg13cmos5l_decap_4
* cell instance sg13cmos5l_decap_4_687 r0 *1 0,0
Xsg13cmos5l_decap_4_687 VPWR VGND sg13cmos5l_decap_4
* cell instance sg13cmos5l_decap_4_688 r0 *1 0,0
Xsg13cmos5l_decap_4_688 VPWR VGND sg13cmos5l_decap_4
* cell instance sg13cmos5l_decap_4_689 r0 *1 0,0
Xsg13cmos5l_decap_4_689 VPWR VGND sg13cmos5l_decap_4
* cell instance sg13cmos5l_decap_4_690 r0 *1 0,0
Xsg13cmos5l_decap_4_690 VPWR VGND sg13cmos5l_decap_4
* cell instance sg13cmos5l_decap_4_691 r0 *1 0,0
Xsg13cmos5l_decap_4_691 VPWR VGND sg13cmos5l_decap_4
* cell instance sg13cmos5l_decap_4_692 r0 *1 0,0
Xsg13cmos5l_decap_4_692 VPWR VGND sg13cmos5l_decap_4
* cell instance sg13cmos5l_decap_4_693 r0 *1 0,0
Xsg13cmos5l_decap_4_693 VPWR VGND sg13cmos5l_decap_4
* cell instance sg13cmos5l_decap_4_694 r0 *1 0,0
Xsg13cmos5l_decap_4_694 VPWR VGND sg13cmos5l_decap_4
* cell instance sg13cmos5l_decap_4_695 r0 *1 0,0
Xsg13cmos5l_decap_4_695 VPWR VGND sg13cmos5l_decap_4
* cell instance sg13cmos5l_decap_4_696 r0 *1 0,0
Xsg13cmos5l_decap_4_696 VPWR VGND sg13cmos5l_decap_4
* cell instance sg13cmos5l_decap_4_697 r0 *1 0,0
Xsg13cmos5l_decap_4_697 VPWR VGND sg13cmos5l_decap_4
* cell instance sg13cmos5l_decap_4_698 r0 *1 0,0
Xsg13cmos5l_decap_4_698 VPWR VGND sg13cmos5l_decap_4
* cell instance sg13cmos5l_decap_4_699 r0 *1 0,0
Xsg13cmos5l_decap_4_699 VPWR VGND sg13cmos5l_decap_4
* cell instance sg13cmos5l_decap_4_700 r0 *1 0,0
Xsg13cmos5l_decap_4_700 VPWR VGND sg13cmos5l_decap_4
* cell instance sg13cmos5l_decap_4_701 r0 *1 0,0
Xsg13cmos5l_decap_4_701 VPWR VGND sg13cmos5l_decap_4
* cell instance sg13cmos5l_decap_4_702 r0 *1 0,0
Xsg13cmos5l_decap_4_702 VPWR VGND sg13cmos5l_decap_4
* cell instance sg13cmos5l_decap_4_703 r0 *1 0,0
Xsg13cmos5l_decap_4_703 VPWR VGND sg13cmos5l_decap_4
* cell instance sg13cmos5l_decap_4_704 r0 *1 0,0
Xsg13cmos5l_decap_4_704 VPWR VGND sg13cmos5l_decap_4
* cell instance sg13cmos5l_decap_4_705 r0 *1 0,0
Xsg13cmos5l_decap_4_705 VPWR VGND sg13cmos5l_decap_4
* cell instance sg13cmos5l_decap_4_706 r0 *1 0,0
Xsg13cmos5l_decap_4_706 VPWR VGND sg13cmos5l_decap_4
* cell instance sg13cmos5l_decap_4_707 r0 *1 0,0
Xsg13cmos5l_decap_4_707 VPWR VGND sg13cmos5l_decap_4
* cell instance sg13cmos5l_decap_4_708 r0 *1 0,0
Xsg13cmos5l_decap_4_708 VPWR VGND sg13cmos5l_decap_4
* cell instance sg13cmos5l_decap_4_709 r0 *1 0,0
Xsg13cmos5l_decap_4_709 VPWR VGND sg13cmos5l_decap_4
* cell instance sg13cmos5l_decap_4_710 r0 *1 0,0
Xsg13cmos5l_decap_4_710 VPWR VGND sg13cmos5l_decap_4
* cell instance sg13cmos5l_decap_4_711 r0 *1 0,0
Xsg13cmos5l_decap_4_711 VPWR VGND sg13cmos5l_decap_4
* cell instance sg13cmos5l_decap_4_712 r0 *1 0,0
Xsg13cmos5l_decap_4_712 VPWR VGND sg13cmos5l_decap_4
* cell instance sg13cmos5l_decap_4_713 r0 *1 0,0
Xsg13cmos5l_decap_4_713 VPWR VGND sg13cmos5l_decap_4
* cell instance sg13cmos5l_decap_4_714 r0 *1 0,0
Xsg13cmos5l_decap_4_714 VPWR VGND sg13cmos5l_decap_4
* cell instance sg13cmos5l_decap_4_715 r0 *1 0,0
Xsg13cmos5l_decap_4_715 VPWR VGND sg13cmos5l_decap_4
* cell instance sg13cmos5l_decap_4_716 r0 *1 0,0
Xsg13cmos5l_decap_4_716 VPWR VGND sg13cmos5l_decap_4
* cell instance sg13cmos5l_decap_4_717 r0 *1 0,0
Xsg13cmos5l_decap_4_717 VPWR VGND sg13cmos5l_decap_4
* cell instance sg13cmos5l_decap_4_718 r0 *1 0,0
Xsg13cmos5l_decap_4_718 VPWR VGND sg13cmos5l_decap_4
* cell instance sg13cmos5l_decap_4_719 r0 *1 0,0
Xsg13cmos5l_decap_4_719 VPWR VGND sg13cmos5l_decap_4
* cell instance sg13cmos5l_decap_4_720 r0 *1 0,0
Xsg13cmos5l_decap_4_720 VPWR VGND sg13cmos5l_decap_4
* cell instance sg13cmos5l_decap_4_721 r0 *1 0,0
Xsg13cmos5l_decap_4_721 VPWR VGND sg13cmos5l_decap_4
* cell instance sg13cmos5l_decap_4_722 r0 *1 0,0
Xsg13cmos5l_decap_4_722 VPWR VGND sg13cmos5l_decap_4
* cell instance sg13cmos5l_decap_4_723 r0 *1 0,0
Xsg13cmos5l_decap_4_723 VPWR VGND sg13cmos5l_decap_4
* cell instance sg13cmos5l_decap_4_724 r0 *1 0,0
Xsg13cmos5l_decap_4_724 VPWR VGND sg13cmos5l_decap_4
* cell instance sg13cmos5l_decap_4_725 r0 *1 0,0
Xsg13cmos5l_decap_4_725 VPWR VGND sg13cmos5l_decap_4
* cell instance sg13cmos5l_decap_4_726 r0 *1 0,0
Xsg13cmos5l_decap_4_726 VPWR VGND sg13cmos5l_decap_4
* cell instance sg13cmos5l_decap_4_727 r0 *1 0,0
Xsg13cmos5l_decap_4_727 VPWR VGND sg13cmos5l_decap_4
* cell instance sg13cmos5l_decap_8_0 r0 *1 0,0
Xsg13cmos5l_decap_8_0 VPWR VGND sg13cmos5l_decap_8
* cell instance sg13cmos5l_decap_8_1 r0 *1 0,0
Xsg13cmos5l_decap_8_1 VPWR VGND sg13cmos5l_decap_8
* cell instance sg13cmos5l_decap_8_2 r0 *1 0,0
Xsg13cmos5l_decap_8_2 VPWR VGND sg13cmos5l_decap_8
* cell instance sg13cmos5l_decap_8_3 r0 *1 0,0
Xsg13cmos5l_decap_8_3 VPWR VGND sg13cmos5l_decap_8
* cell instance sg13cmos5l_decap_8_4 r0 *1 0,0
Xsg13cmos5l_decap_8_4 VPWR VGND sg13cmos5l_decap_8
* cell instance sg13cmos5l_decap_8_5 r0 *1 0,0
Xsg13cmos5l_decap_8_5 VPWR VGND sg13cmos5l_decap_8
* cell instance sg13cmos5l_decap_8_6 r0 *1 0,0
Xsg13cmos5l_decap_8_6 VPWR VGND sg13cmos5l_decap_8
* cell instance sg13cmos5l_decap_8_7 r0 *1 0,0
Xsg13cmos5l_decap_8_7 VPWR VGND sg13cmos5l_decap_8
* cell instance sg13cmos5l_decap_8_8 r0 *1 0,0
Xsg13cmos5l_decap_8_8 VPWR VGND sg13cmos5l_decap_8
* cell instance sg13cmos5l_decap_8_9 r0 *1 0,0
Xsg13cmos5l_decap_8_9 VPWR VGND sg13cmos5l_decap_8
* cell instance sg13cmos5l_decap_8_10 r0 *1 0,0
Xsg13cmos5l_decap_8_10 VPWR VGND sg13cmos5l_decap_8
* cell instance sg13cmos5l_decap_8_11 r0 *1 0,0
Xsg13cmos5l_decap_8_11 VPWR VGND sg13cmos5l_decap_8
* cell instance sg13cmos5l_decap_8_12 r0 *1 0,0
Xsg13cmos5l_decap_8_12 VPWR VGND sg13cmos5l_decap_8
* cell instance sg13cmos5l_decap_8_13 r0 *1 0,0
Xsg13cmos5l_decap_8_13 VPWR VGND sg13cmos5l_decap_8
* cell instance sg13cmos5l_decap_8_14 r0 *1 0,0
Xsg13cmos5l_decap_8_14 VPWR VGND sg13cmos5l_decap_8
* cell instance sg13cmos5l_decap_8_15 r0 *1 0,0
Xsg13cmos5l_decap_8_15 VPWR VGND sg13cmos5l_decap_8
* cell instance sg13cmos5l_decap_8_16 r0 *1 0,0
Xsg13cmos5l_decap_8_16 VPWR VGND sg13cmos5l_decap_8
* cell instance sg13cmos5l_decap_8_17 r0 *1 0,0
Xsg13cmos5l_decap_8_17 VPWR VGND sg13cmos5l_decap_8
* cell instance sg13cmos5l_decap_8_18 r0 *1 0,0
Xsg13cmos5l_decap_8_18 VPWR VGND sg13cmos5l_decap_8
* cell instance sg13cmos5l_decap_8_19 r0 *1 0,0
Xsg13cmos5l_decap_8_19 VPWR VGND sg13cmos5l_decap_8
* cell instance sg13cmos5l_decap_8_20 r0 *1 0,0
Xsg13cmos5l_decap_8_20 VPWR VGND sg13cmos5l_decap_8
* cell instance sg13cmos5l_decap_8_21 r0 *1 0,0
Xsg13cmos5l_decap_8_21 VPWR VGND sg13cmos5l_decap_8
* cell instance sg13cmos5l_decap_8_22 r0 *1 0,0
Xsg13cmos5l_decap_8_22 VPWR VGND sg13cmos5l_decap_8
* cell instance sg13cmos5l_decap_8_23 r0 *1 0,0
Xsg13cmos5l_decap_8_23 VPWR VGND sg13cmos5l_decap_8
* cell instance sg13cmos5l_decap_8_24 r0 *1 0,0
Xsg13cmos5l_decap_8_24 VPWR VGND sg13cmos5l_decap_8
* cell instance sg13cmos5l_decap_8_25 r0 *1 0,0
Xsg13cmos5l_decap_8_25 VPWR VGND sg13cmos5l_decap_8
* cell instance sg13cmos5l_decap_8_26 r0 *1 0,0
Xsg13cmos5l_decap_8_26 VPWR VGND sg13cmos5l_decap_8
* cell instance sg13cmos5l_decap_8_27 r0 *1 0,0
Xsg13cmos5l_decap_8_27 VPWR VGND sg13cmos5l_decap_8
* cell instance sg13cmos5l_decap_8_28 r0 *1 0,0
Xsg13cmos5l_decap_8_28 VPWR VGND sg13cmos5l_decap_8
* cell instance sg13cmos5l_decap_8_29 r0 *1 0,0
Xsg13cmos5l_decap_8_29 VPWR VGND sg13cmos5l_decap_8
* cell instance sg13cmos5l_decap_8_30 r0 *1 0,0
Xsg13cmos5l_decap_8_30 VPWR VGND sg13cmos5l_decap_8
* cell instance sg13cmos5l_decap_8_31 r0 *1 0,0
Xsg13cmos5l_decap_8_31 VPWR VGND sg13cmos5l_decap_8
* cell instance sg13cmos5l_decap_8_32 r0 *1 0,0
Xsg13cmos5l_decap_8_32 VPWR VGND sg13cmos5l_decap_8
* cell instance sg13cmos5l_decap_8_33 r0 *1 0,0
Xsg13cmos5l_decap_8_33 VPWR VGND sg13cmos5l_decap_8
* cell instance sg13cmos5l_decap_8_34 r0 *1 0,0
Xsg13cmos5l_decap_8_34 VPWR VGND sg13cmos5l_decap_8
* cell instance sg13cmos5l_decap_8_35 r0 *1 0,0
Xsg13cmos5l_decap_8_35 VPWR VGND sg13cmos5l_decap_8
* cell instance sg13cmos5l_decap_8_36 r0 *1 0,0
Xsg13cmos5l_decap_8_36 VPWR VGND sg13cmos5l_decap_8
* cell instance sg13cmos5l_decap_8_37 r0 *1 0,0
Xsg13cmos5l_decap_8_37 VPWR VGND sg13cmos5l_decap_8
* cell instance sg13cmos5l_decap_8_38 r0 *1 0,0
Xsg13cmos5l_decap_8_38 VPWR VGND sg13cmos5l_decap_8
* cell instance sg13cmos5l_decap_8_39 r0 *1 0,0
Xsg13cmos5l_decap_8_39 VPWR VGND sg13cmos5l_decap_8
* cell instance sg13cmos5l_decap_8_40 r0 *1 0,0
Xsg13cmos5l_decap_8_40 VPWR VGND sg13cmos5l_decap_8
* cell instance sg13cmos5l_decap_8_41 r0 *1 0,0
Xsg13cmos5l_decap_8_41 VPWR VGND sg13cmos5l_decap_8
* cell instance sg13cmos5l_decap_8_42 r0 *1 0,0
Xsg13cmos5l_decap_8_42 VPWR VGND sg13cmos5l_decap_8
* cell instance sg13cmos5l_decap_8_43 r0 *1 0,0
Xsg13cmos5l_decap_8_43 VPWR VGND sg13cmos5l_decap_8
* cell instance sg13cmos5l_decap_8_44 r0 *1 0,0
Xsg13cmos5l_decap_8_44 VPWR VGND sg13cmos5l_decap_8
* cell instance sg13cmos5l_decap_8_45 r0 *1 0,0
Xsg13cmos5l_decap_8_45 VPWR VGND sg13cmos5l_decap_8
* cell instance sg13cmos5l_decap_8_46 r0 *1 0,0
Xsg13cmos5l_decap_8_46 VPWR VGND sg13cmos5l_decap_8
* cell instance sg13cmos5l_decap_8_47 r0 *1 0,0
Xsg13cmos5l_decap_8_47 VPWR VGND sg13cmos5l_decap_8
* cell instance sg13cmos5l_decap_8_48 r0 *1 0,0
Xsg13cmos5l_decap_8_48 VPWR VGND sg13cmos5l_decap_8
* cell instance sg13cmos5l_decap_8_49 r0 *1 0,0
Xsg13cmos5l_decap_8_49 VPWR VGND sg13cmos5l_decap_8
* cell instance sg13cmos5l_decap_8_50 r0 *1 0,0
Xsg13cmos5l_decap_8_50 VPWR VGND sg13cmos5l_decap_8
* cell instance sg13cmos5l_decap_8_51 r0 *1 0,0
Xsg13cmos5l_decap_8_51 VPWR VGND sg13cmos5l_decap_8
* cell instance sg13cmos5l_decap_8_52 r0 *1 0,0
Xsg13cmos5l_decap_8_52 VPWR VGND sg13cmos5l_decap_8
* cell instance sg13cmos5l_decap_8_53 r0 *1 0,0
Xsg13cmos5l_decap_8_53 VPWR VGND sg13cmos5l_decap_8
* cell instance sg13cmos5l_decap_8_54 r0 *1 0,0
Xsg13cmos5l_decap_8_54 VPWR VGND sg13cmos5l_decap_8
* cell instance sg13cmos5l_decap_8_55 r0 *1 0,0
Xsg13cmos5l_decap_8_55 VPWR VGND sg13cmos5l_decap_8
* cell instance sg13cmos5l_decap_8_56 r0 *1 0,0
Xsg13cmos5l_decap_8_56 VPWR VGND sg13cmos5l_decap_8
* cell instance sg13cmos5l_decap_8_57 r0 *1 0,0
Xsg13cmos5l_decap_8_57 VPWR VGND sg13cmos5l_decap_8
* cell instance sg13cmos5l_decap_8_58 r0 *1 0,0
Xsg13cmos5l_decap_8_58 VPWR VGND sg13cmos5l_decap_8
* cell instance sg13cmos5l_decap_8_59 r0 *1 0,0
Xsg13cmos5l_decap_8_59 VPWR VGND sg13cmos5l_decap_8
* cell instance sg13cmos5l_decap_8_60 r0 *1 0,0
Xsg13cmos5l_decap_8_60 VPWR VGND sg13cmos5l_decap_8
* cell instance sg13cmos5l_decap_8_61 r0 *1 0,0
Xsg13cmos5l_decap_8_61 VPWR VGND sg13cmos5l_decap_8
* cell instance sg13cmos5l_decap_8_62 r0 *1 0,0
Xsg13cmos5l_decap_8_62 VPWR VGND sg13cmos5l_decap_8
* cell instance sg13cmos5l_decap_8_63 r0 *1 0,0
Xsg13cmos5l_decap_8_63 VPWR VGND sg13cmos5l_decap_8
* cell instance sg13cmos5l_decap_8_64 r0 *1 0,0
Xsg13cmos5l_decap_8_64 VPWR VGND sg13cmos5l_decap_8
* cell instance sg13cmos5l_decap_8_65 r0 *1 0,0
Xsg13cmos5l_decap_8_65 VPWR VGND sg13cmos5l_decap_8
* cell instance sg13cmos5l_decap_8_66 r0 *1 0,0
Xsg13cmos5l_decap_8_66 VPWR VGND sg13cmos5l_decap_8
* cell instance sg13cmos5l_decap_8_67 r0 *1 0,0
Xsg13cmos5l_decap_8_67 VPWR VGND sg13cmos5l_decap_8
* cell instance sg13cmos5l_decap_8_68 r0 *1 0,0
Xsg13cmos5l_decap_8_68 VPWR VGND sg13cmos5l_decap_8
* cell instance sg13cmos5l_decap_8_69 r0 *1 0,0
Xsg13cmos5l_decap_8_69 VPWR VGND sg13cmos5l_decap_8
* cell instance sg13cmos5l_decap_8_70 r0 *1 0,0
Xsg13cmos5l_decap_8_70 VPWR VGND sg13cmos5l_decap_8
* cell instance sg13cmos5l_decap_8_71 r0 *1 0,0
Xsg13cmos5l_decap_8_71 VPWR VGND sg13cmos5l_decap_8
* cell instance sg13cmos5l_decap_8_72 r0 *1 0,0
Xsg13cmos5l_decap_8_72 VPWR VGND sg13cmos5l_decap_8
* cell instance sg13cmos5l_decap_8_73 r0 *1 0,0
Xsg13cmos5l_decap_8_73 VPWR VGND sg13cmos5l_decap_8
* cell instance sg13cmos5l_decap_8_74 r0 *1 0,0
Xsg13cmos5l_decap_8_74 VPWR VGND sg13cmos5l_decap_8
* cell instance sg13cmos5l_decap_8_75 r0 *1 0,0
Xsg13cmos5l_decap_8_75 VPWR VGND sg13cmos5l_decap_8
* cell instance sg13cmos5l_decap_8_76 r0 *1 0,0
Xsg13cmos5l_decap_8_76 VPWR VGND sg13cmos5l_decap_8
* cell instance sg13cmos5l_decap_8_77 r0 *1 0,0
Xsg13cmos5l_decap_8_77 VPWR VGND sg13cmos5l_decap_8
* cell instance sg13cmos5l_decap_8_78 r0 *1 0,0
Xsg13cmos5l_decap_8_78 VPWR VGND sg13cmos5l_decap_8
* cell instance sg13cmos5l_decap_8_79 r0 *1 0,0
Xsg13cmos5l_decap_8_79 VPWR VGND sg13cmos5l_decap_8
* cell instance sg13cmos5l_decap_8_80 r0 *1 0,0
Xsg13cmos5l_decap_8_80 VPWR VGND sg13cmos5l_decap_8
* cell instance sg13cmos5l_decap_8_81 r0 *1 0,0
Xsg13cmos5l_decap_8_81 VPWR VGND sg13cmos5l_decap_8
* cell instance sg13cmos5l_decap_8_82 r0 *1 0,0
Xsg13cmos5l_decap_8_82 VPWR VGND sg13cmos5l_decap_8
* cell instance sg13cmos5l_decap_8_83 r0 *1 0,0
Xsg13cmos5l_decap_8_83 VPWR VGND sg13cmos5l_decap_8
* cell instance sg13cmos5l_decap_8_84 r0 *1 0,0
Xsg13cmos5l_decap_8_84 VPWR VGND sg13cmos5l_decap_8
* cell instance sg13cmos5l_decap_8_85 r0 *1 0,0
Xsg13cmos5l_decap_8_85 VPWR VGND sg13cmos5l_decap_8
* cell instance sg13cmos5l_decap_8_86 r0 *1 0,0
Xsg13cmos5l_decap_8_86 VPWR VGND sg13cmos5l_decap_8
* cell instance sg13cmos5l_decap_8_87 r0 *1 0,0
Xsg13cmos5l_decap_8_87 VPWR VGND sg13cmos5l_decap_8
* cell instance sg13cmos5l_decap_8_88 r0 *1 0,0
Xsg13cmos5l_decap_8_88 VPWR VGND sg13cmos5l_decap_8
* cell instance sg13cmos5l_decap_8_89 r0 *1 0,0
Xsg13cmos5l_decap_8_89 VPWR VGND sg13cmos5l_decap_8
* cell instance sg13cmos5l_decap_8_90 r0 *1 0,0
Xsg13cmos5l_decap_8_90 VPWR VGND sg13cmos5l_decap_8
* cell instance sg13cmos5l_decap_8_91 r0 *1 0,0
Xsg13cmos5l_decap_8_91 VPWR VGND sg13cmos5l_decap_8
* cell instance sg13cmos5l_decap_8_92 r0 *1 0,0
Xsg13cmos5l_decap_8_92 VPWR VGND sg13cmos5l_decap_8
* cell instance sg13cmos5l_decap_8_93 r0 *1 0,0
Xsg13cmos5l_decap_8_93 VPWR VGND sg13cmos5l_decap_8
* cell instance sg13cmos5l_decap_8_94 r0 *1 0,0
Xsg13cmos5l_decap_8_94 VPWR VGND sg13cmos5l_decap_8
* cell instance sg13cmos5l_decap_8_95 r0 *1 0,0
Xsg13cmos5l_decap_8_95 VPWR VGND sg13cmos5l_decap_8
* cell instance sg13cmos5l_decap_8_96 r0 *1 0,0
Xsg13cmos5l_decap_8_96 VPWR VGND sg13cmos5l_decap_8
* cell instance sg13cmos5l_decap_8_97 r0 *1 0,0
Xsg13cmos5l_decap_8_97 VPWR VGND sg13cmos5l_decap_8
* cell instance sg13cmos5l_decap_8_98 r0 *1 0,0
Xsg13cmos5l_decap_8_98 VPWR VGND sg13cmos5l_decap_8
* cell instance sg13cmos5l_decap_8_99 r0 *1 0,0
Xsg13cmos5l_decap_8_99 VPWR VGND sg13cmos5l_decap_8
* cell instance sg13cmos5l_decap_8_100 r0 *1 0,0
Xsg13cmos5l_decap_8_100 VPWR VGND sg13cmos5l_decap_8
* cell instance sg13cmos5l_decap_8_101 r0 *1 0,0
Xsg13cmos5l_decap_8_101 VPWR VGND sg13cmos5l_decap_8
* cell instance sg13cmos5l_decap_8_102 r0 *1 0,0
Xsg13cmos5l_decap_8_102 VPWR VGND sg13cmos5l_decap_8
* cell instance sg13cmos5l_decap_8_103 r0 *1 0,0
Xsg13cmos5l_decap_8_103 VPWR VGND sg13cmos5l_decap_8
* cell instance sg13cmos5l_decap_8_104 r0 *1 0,0
Xsg13cmos5l_decap_8_104 VPWR VGND sg13cmos5l_decap_8
* cell instance sg13cmos5l_decap_8_105 r0 *1 0,0
Xsg13cmos5l_decap_8_105 VPWR VGND sg13cmos5l_decap_8
* cell instance sg13cmos5l_decap_8_106 r0 *1 0,0
Xsg13cmos5l_decap_8_106 VPWR VGND sg13cmos5l_decap_8
* cell instance sg13cmos5l_decap_8_107 r0 *1 0,0
Xsg13cmos5l_decap_8_107 VPWR VGND sg13cmos5l_decap_8
* cell instance sg13cmos5l_decap_8_108 r0 *1 0,0
Xsg13cmos5l_decap_8_108 VPWR VGND sg13cmos5l_decap_8
* cell instance sg13cmos5l_decap_8_109 r0 *1 0,0
Xsg13cmos5l_decap_8_109 VPWR VGND sg13cmos5l_decap_8
* cell instance sg13cmos5l_decap_8_110 r0 *1 0,0
Xsg13cmos5l_decap_8_110 VPWR VGND sg13cmos5l_decap_8
* cell instance sg13cmos5l_decap_8_111 r0 *1 0,0
Xsg13cmos5l_decap_8_111 VPWR VGND sg13cmos5l_decap_8
* cell instance sg13cmos5l_decap_8_112 r0 *1 0,0
Xsg13cmos5l_decap_8_112 VPWR VGND sg13cmos5l_decap_8
* cell instance sg13cmos5l_decap_8_113 r0 *1 0,0
Xsg13cmos5l_decap_8_113 VPWR VGND sg13cmos5l_decap_8
* cell instance sg13cmos5l_decap_8_114 r0 *1 0,0
Xsg13cmos5l_decap_8_114 VPWR VGND sg13cmos5l_decap_8
* cell instance sg13cmos5l_decap_8_115 r0 *1 0,0
Xsg13cmos5l_decap_8_115 VPWR VGND sg13cmos5l_decap_8
* cell instance sg13cmos5l_decap_8_116 r0 *1 0,0
Xsg13cmos5l_decap_8_116 VPWR VGND sg13cmos5l_decap_8
* cell instance sg13cmos5l_decap_8_117 r0 *1 0,0
Xsg13cmos5l_decap_8_117 VPWR VGND sg13cmos5l_decap_8
* cell instance sg13cmos5l_decap_8_118 r0 *1 0,0
Xsg13cmos5l_decap_8_118 VPWR VGND sg13cmos5l_decap_8
* cell instance sg13cmos5l_decap_8_119 r0 *1 0,0
Xsg13cmos5l_decap_8_119 VPWR VGND sg13cmos5l_decap_8
* cell instance sg13cmos5l_decap_8_120 r0 *1 0,0
Xsg13cmos5l_decap_8_120 VPWR VGND sg13cmos5l_decap_8
* cell instance sg13cmos5l_decap_8_121 r0 *1 0,0
Xsg13cmos5l_decap_8_121 VPWR VGND sg13cmos5l_decap_8
* cell instance sg13cmos5l_decap_8_122 r0 *1 0,0
Xsg13cmos5l_decap_8_122 VPWR VGND sg13cmos5l_decap_8
* cell instance sg13cmos5l_decap_8_123 r0 *1 0,0
Xsg13cmos5l_decap_8_123 VPWR VGND sg13cmos5l_decap_8
* cell instance sg13cmos5l_decap_8_124 r0 *1 0,0
Xsg13cmos5l_decap_8_124 VPWR VGND sg13cmos5l_decap_8
* cell instance sg13cmos5l_decap_8_125 r0 *1 0,0
Xsg13cmos5l_decap_8_125 VPWR VGND sg13cmos5l_decap_8
* cell instance sg13cmos5l_decap_8_126 r0 *1 0,0
Xsg13cmos5l_decap_8_126 VPWR VGND sg13cmos5l_decap_8
* cell instance sg13cmos5l_decap_8_127 r0 *1 0,0
Xsg13cmos5l_decap_8_127 VPWR VGND sg13cmos5l_decap_8
* cell instance sg13cmos5l_decap_8_128 r0 *1 0,0
Xsg13cmos5l_decap_8_128 VPWR VGND sg13cmos5l_decap_8
* cell instance sg13cmos5l_decap_8_129 r0 *1 0,0
Xsg13cmos5l_decap_8_129 VPWR VGND sg13cmos5l_decap_8
* cell instance sg13cmos5l_decap_8_130 r0 *1 0,0
Xsg13cmos5l_decap_8_130 VPWR VGND sg13cmos5l_decap_8
* cell instance sg13cmos5l_decap_8_131 r0 *1 0,0
Xsg13cmos5l_decap_8_131 VPWR VGND sg13cmos5l_decap_8
* cell instance sg13cmos5l_decap_8_132 r0 *1 0,0
Xsg13cmos5l_decap_8_132 VPWR VGND sg13cmos5l_decap_8
* cell instance sg13cmos5l_decap_8_133 r0 *1 0,0
Xsg13cmos5l_decap_8_133 VPWR VGND sg13cmos5l_decap_8
* cell instance sg13cmos5l_decap_8_134 r0 *1 0,0
Xsg13cmos5l_decap_8_134 VPWR VGND sg13cmos5l_decap_8
* cell instance sg13cmos5l_decap_8_135 r0 *1 0,0
Xsg13cmos5l_decap_8_135 VPWR VGND sg13cmos5l_decap_8
* cell instance sg13cmos5l_decap_8_136 r0 *1 0,0
Xsg13cmos5l_decap_8_136 VPWR VGND sg13cmos5l_decap_8
* cell instance sg13cmos5l_decap_8_137 r0 *1 0,0
Xsg13cmos5l_decap_8_137 VPWR VGND sg13cmos5l_decap_8
* cell instance sg13cmos5l_decap_8_138 r0 *1 0,0
Xsg13cmos5l_decap_8_138 VPWR VGND sg13cmos5l_decap_8
* cell instance sg13cmos5l_decap_8_139 r0 *1 0,0
Xsg13cmos5l_decap_8_139 VPWR VGND sg13cmos5l_decap_8
* cell instance sg13cmos5l_decap_8_140 r0 *1 0,0
Xsg13cmos5l_decap_8_140 VPWR VGND sg13cmos5l_decap_8
* cell instance sg13cmos5l_decap_8_141 r0 *1 0,0
Xsg13cmos5l_decap_8_141 VPWR VGND sg13cmos5l_decap_8
* cell instance sg13cmos5l_decap_8_142 r0 *1 0,0
Xsg13cmos5l_decap_8_142 VPWR VGND sg13cmos5l_decap_8
* cell instance sg13cmos5l_decap_8_143 r0 *1 0,0
Xsg13cmos5l_decap_8_143 VPWR VGND sg13cmos5l_decap_8
* cell instance sg13cmos5l_decap_8_144 r0 *1 0,0
Xsg13cmos5l_decap_8_144 VPWR VGND sg13cmos5l_decap_8
* cell instance sg13cmos5l_decap_8_145 r0 *1 0,0
Xsg13cmos5l_decap_8_145 VPWR VGND sg13cmos5l_decap_8
* cell instance sg13cmos5l_decap_8_146 r0 *1 0,0
Xsg13cmos5l_decap_8_146 VPWR VGND sg13cmos5l_decap_8
* cell instance sg13cmos5l_decap_8_147 r0 *1 0,0
Xsg13cmos5l_decap_8_147 VPWR VGND sg13cmos5l_decap_8
* cell instance sg13cmos5l_decap_8_148 r0 *1 0,0
Xsg13cmos5l_decap_8_148 VPWR VGND sg13cmos5l_decap_8
* cell instance sg13cmos5l_decap_8_149 r0 *1 0,0
Xsg13cmos5l_decap_8_149 VPWR VGND sg13cmos5l_decap_8
* cell instance sg13cmos5l_decap_8_150 r0 *1 0,0
Xsg13cmos5l_decap_8_150 VPWR VGND sg13cmos5l_decap_8
* cell instance sg13cmos5l_decap_8_151 r0 *1 0,0
Xsg13cmos5l_decap_8_151 VPWR VGND sg13cmos5l_decap_8
* cell instance sg13cmos5l_decap_8_152 r0 *1 0,0
Xsg13cmos5l_decap_8_152 VPWR VGND sg13cmos5l_decap_8
* cell instance sg13cmos5l_decap_8_153 r0 *1 0,0
Xsg13cmos5l_decap_8_153 VPWR VGND sg13cmos5l_decap_8
* cell instance sg13cmos5l_decap_8_154 r0 *1 0,0
Xsg13cmos5l_decap_8_154 VPWR VGND sg13cmos5l_decap_8
* cell instance sg13cmos5l_decap_8_155 r0 *1 0,0
Xsg13cmos5l_decap_8_155 VPWR VGND sg13cmos5l_decap_8
* cell instance sg13cmos5l_decap_8_156 r0 *1 0,0
Xsg13cmos5l_decap_8_156 VPWR VGND sg13cmos5l_decap_8
* cell instance sg13cmos5l_decap_8_157 r0 *1 0,0
Xsg13cmos5l_decap_8_157 VPWR VGND sg13cmos5l_decap_8
* cell instance sg13cmos5l_decap_8_158 r0 *1 0,0
Xsg13cmos5l_decap_8_158 VPWR VGND sg13cmos5l_decap_8
* cell instance sg13cmos5l_decap_8_159 r0 *1 0,0
Xsg13cmos5l_decap_8_159 VPWR VGND sg13cmos5l_decap_8
* cell instance sg13cmos5l_decap_8_160 r0 *1 0,0
Xsg13cmos5l_decap_8_160 VPWR VGND sg13cmos5l_decap_8
* cell instance sg13cmos5l_decap_8_161 r0 *1 0,0
Xsg13cmos5l_decap_8_161 VPWR VGND sg13cmos5l_decap_8
* cell instance sg13cmos5l_decap_8_162 r0 *1 0,0
Xsg13cmos5l_decap_8_162 VPWR VGND sg13cmos5l_decap_8
* cell instance sg13cmos5l_decap_8_163 r0 *1 0,0
Xsg13cmos5l_decap_8_163 VPWR VGND sg13cmos5l_decap_8
* cell instance sg13cmos5l_decap_8_164 r0 *1 0,0
Xsg13cmos5l_decap_8_164 VPWR VGND sg13cmos5l_decap_8
* cell instance sg13cmos5l_decap_8_165 r0 *1 0,0
Xsg13cmos5l_decap_8_165 VPWR VGND sg13cmos5l_decap_8
* cell instance sg13cmos5l_decap_8_166 r0 *1 0,0
Xsg13cmos5l_decap_8_166 VPWR VGND sg13cmos5l_decap_8
* cell instance sg13cmos5l_decap_8_167 r0 *1 0,0
Xsg13cmos5l_decap_8_167 VPWR VGND sg13cmos5l_decap_8
* cell instance sg13cmos5l_decap_8_168 r0 *1 0,0
Xsg13cmos5l_decap_8_168 VPWR VGND sg13cmos5l_decap_8
* cell instance sg13cmos5l_decap_8_169 r0 *1 0,0
Xsg13cmos5l_decap_8_169 VPWR VGND sg13cmos5l_decap_8
* cell instance sg13cmos5l_decap_8_170 r0 *1 0,0
Xsg13cmos5l_decap_8_170 VPWR VGND sg13cmos5l_decap_8
* cell instance sg13cmos5l_decap_8_171 r0 *1 0,0
Xsg13cmos5l_decap_8_171 VPWR VGND sg13cmos5l_decap_8
* cell instance sg13cmos5l_decap_8_172 r0 *1 0,0
Xsg13cmos5l_decap_8_172 VPWR VGND sg13cmos5l_decap_8
* cell instance sg13cmos5l_decap_8_173 r0 *1 0,0
Xsg13cmos5l_decap_8_173 VPWR VGND sg13cmos5l_decap_8
* cell instance sg13cmos5l_decap_8_174 r0 *1 0,0
Xsg13cmos5l_decap_8_174 VPWR VGND sg13cmos5l_decap_8
* cell instance sg13cmos5l_decap_8_175 r0 *1 0,0
Xsg13cmos5l_decap_8_175 VPWR VGND sg13cmos5l_decap_8
* cell instance sg13cmos5l_decap_8_176 r0 *1 0,0
Xsg13cmos5l_decap_8_176 VPWR VGND sg13cmos5l_decap_8
* cell instance sg13cmos5l_decap_8_177 r0 *1 0,0
Xsg13cmos5l_decap_8_177 VPWR VGND sg13cmos5l_decap_8
* cell instance sg13cmos5l_decap_8_178 r0 *1 0,0
Xsg13cmos5l_decap_8_178 VPWR VGND sg13cmos5l_decap_8
* cell instance sg13cmos5l_decap_8_179 r0 *1 0,0
Xsg13cmos5l_decap_8_179 VPWR VGND sg13cmos5l_decap_8
* cell instance sg13cmos5l_decap_8_180 r0 *1 0,0
Xsg13cmos5l_decap_8_180 VPWR VGND sg13cmos5l_decap_8
* cell instance sg13cmos5l_decap_8_181 r0 *1 0,0
Xsg13cmos5l_decap_8_181 VPWR VGND sg13cmos5l_decap_8
* cell instance sg13cmos5l_decap_8_182 r0 *1 0,0
Xsg13cmos5l_decap_8_182 VPWR VGND sg13cmos5l_decap_8
* cell instance sg13cmos5l_decap_8_183 r0 *1 0,0
Xsg13cmos5l_decap_8_183 VPWR VGND sg13cmos5l_decap_8
* cell instance sg13cmos5l_decap_8_184 r0 *1 0,0
Xsg13cmos5l_decap_8_184 VPWR VGND sg13cmos5l_decap_8
* cell instance sg13cmos5l_decap_8_185 r0 *1 0,0
Xsg13cmos5l_decap_8_185 VPWR VGND sg13cmos5l_decap_8
* cell instance sg13cmos5l_decap_8_186 r0 *1 0,0
Xsg13cmos5l_decap_8_186 VPWR VGND sg13cmos5l_decap_8
* cell instance sg13cmos5l_decap_8_187 r0 *1 0,0
Xsg13cmos5l_decap_8_187 VPWR VGND sg13cmos5l_decap_8
* cell instance sg13cmos5l_decap_8_188 r0 *1 0,0
Xsg13cmos5l_decap_8_188 VPWR VGND sg13cmos5l_decap_8
* cell instance sg13cmos5l_decap_8_189 r0 *1 0,0
Xsg13cmos5l_decap_8_189 VPWR VGND sg13cmos5l_decap_8
* cell instance sg13cmos5l_decap_8_190 r0 *1 0,0
Xsg13cmos5l_decap_8_190 VPWR VGND sg13cmos5l_decap_8
* cell instance sg13cmos5l_decap_8_191 r0 *1 0,0
Xsg13cmos5l_decap_8_191 VPWR VGND sg13cmos5l_decap_8
* cell instance sg13cmos5l_decap_8_192 r0 *1 0,0
Xsg13cmos5l_decap_8_192 VPWR VGND sg13cmos5l_decap_8
* cell instance sg13cmos5l_decap_8_193 r0 *1 0,0
Xsg13cmos5l_decap_8_193 VPWR VGND sg13cmos5l_decap_8
* cell instance sg13cmos5l_decap_8_194 r0 *1 0,0
Xsg13cmos5l_decap_8_194 VPWR VGND sg13cmos5l_decap_8
* cell instance sg13cmos5l_decap_8_195 r0 *1 0,0
Xsg13cmos5l_decap_8_195 VPWR VGND sg13cmos5l_decap_8
* cell instance sg13cmos5l_decap_8_196 r0 *1 0,0
Xsg13cmos5l_decap_8_196 VPWR VGND sg13cmos5l_decap_8
* cell instance sg13cmos5l_decap_8_197 r0 *1 0,0
Xsg13cmos5l_decap_8_197 VPWR VGND sg13cmos5l_decap_8
* cell instance sg13cmos5l_decap_8_198 r0 *1 0,0
Xsg13cmos5l_decap_8_198 VPWR VGND sg13cmos5l_decap_8
* cell instance sg13cmos5l_decap_8_199 r0 *1 0,0
Xsg13cmos5l_decap_8_199 VPWR VGND sg13cmos5l_decap_8
* cell instance sg13cmos5l_decap_8_200 r0 *1 0,0
Xsg13cmos5l_decap_8_200 VPWR VGND sg13cmos5l_decap_8
* cell instance sg13cmos5l_decap_8_201 r0 *1 0,0
Xsg13cmos5l_decap_8_201 VPWR VGND sg13cmos5l_decap_8
* cell instance sg13cmos5l_decap_8_202 r0 *1 0,0
Xsg13cmos5l_decap_8_202 VPWR VGND sg13cmos5l_decap_8
* cell instance sg13cmos5l_decap_8_203 r0 *1 0,0
Xsg13cmos5l_decap_8_203 VPWR VGND sg13cmos5l_decap_8
* cell instance sg13cmos5l_decap_8_204 r0 *1 0,0
Xsg13cmos5l_decap_8_204 VPWR VGND sg13cmos5l_decap_8
* cell instance sg13cmos5l_decap_8_205 r0 *1 0,0
Xsg13cmos5l_decap_8_205 VPWR VGND sg13cmos5l_decap_8
* cell instance sg13cmos5l_decap_8_206 r0 *1 0,0
Xsg13cmos5l_decap_8_206 VPWR VGND sg13cmos5l_decap_8
* cell instance sg13cmos5l_decap_8_207 r0 *1 0,0
Xsg13cmos5l_decap_8_207 VPWR VGND sg13cmos5l_decap_8
* cell instance sg13cmos5l_decap_8_208 r0 *1 0,0
Xsg13cmos5l_decap_8_208 VPWR VGND sg13cmos5l_decap_8
* cell instance sg13cmos5l_decap_8_209 r0 *1 0,0
Xsg13cmos5l_decap_8_209 VPWR VGND sg13cmos5l_decap_8
* cell instance sg13cmos5l_decap_8_210 r0 *1 0,0
Xsg13cmos5l_decap_8_210 VPWR VGND sg13cmos5l_decap_8
* cell instance sg13cmos5l_decap_8_211 r0 *1 0,0
Xsg13cmos5l_decap_8_211 VPWR VGND sg13cmos5l_decap_8
* cell instance sg13cmos5l_decap_8_212 r0 *1 0,0
Xsg13cmos5l_decap_8_212 VPWR VGND sg13cmos5l_decap_8
* cell instance sg13cmos5l_decap_8_213 r0 *1 0,0
Xsg13cmos5l_decap_8_213 VPWR VGND sg13cmos5l_decap_8
* cell instance sg13cmos5l_decap_8_214 r0 *1 0,0
Xsg13cmos5l_decap_8_214 VPWR VGND sg13cmos5l_decap_8
* cell instance sg13cmos5l_decap_8_215 r0 *1 0,0
Xsg13cmos5l_decap_8_215 VPWR VGND sg13cmos5l_decap_8
* cell instance sg13cmos5l_decap_8_216 r0 *1 0,0
Xsg13cmos5l_decap_8_216 VPWR VGND sg13cmos5l_decap_8
* cell instance sg13cmos5l_decap_8_217 r0 *1 0,0
Xsg13cmos5l_decap_8_217 VPWR VGND sg13cmos5l_decap_8
* cell instance sg13cmos5l_decap_8_218 r0 *1 0,0
Xsg13cmos5l_decap_8_218 VPWR VGND sg13cmos5l_decap_8
* cell instance sg13cmos5l_decap_8_219 r0 *1 0,0
Xsg13cmos5l_decap_8_219 VPWR VGND sg13cmos5l_decap_8
* cell instance sg13cmos5l_decap_8_220 r0 *1 0,0
Xsg13cmos5l_decap_8_220 VPWR VGND sg13cmos5l_decap_8
* cell instance sg13cmos5l_decap_8_221 r0 *1 0,0
Xsg13cmos5l_decap_8_221 VPWR VGND sg13cmos5l_decap_8
* cell instance sg13cmos5l_decap_8_222 r0 *1 0,0
Xsg13cmos5l_decap_8_222 VPWR VGND sg13cmos5l_decap_8
* cell instance sg13cmos5l_decap_8_223 r0 *1 0,0
Xsg13cmos5l_decap_8_223 VPWR VGND sg13cmos5l_decap_8
* cell instance sg13cmos5l_decap_8_224 r0 *1 0,0
Xsg13cmos5l_decap_8_224 VPWR VGND sg13cmos5l_decap_8
* cell instance sg13cmos5l_decap_8_225 r0 *1 0,0
Xsg13cmos5l_decap_8_225 VPWR VGND sg13cmos5l_decap_8
* cell instance sg13cmos5l_decap_8_226 r0 *1 0,0
Xsg13cmos5l_decap_8_226 VPWR VGND sg13cmos5l_decap_8
* cell instance sg13cmos5l_decap_8_227 r0 *1 0,0
Xsg13cmos5l_decap_8_227 VPWR VGND sg13cmos5l_decap_8
* cell instance sg13cmos5l_decap_8_228 r0 *1 0,0
Xsg13cmos5l_decap_8_228 VPWR VGND sg13cmos5l_decap_8
* cell instance sg13cmos5l_decap_8_229 r0 *1 0,0
Xsg13cmos5l_decap_8_229 VPWR VGND sg13cmos5l_decap_8
* cell instance sg13cmos5l_decap_8_230 r0 *1 0,0
Xsg13cmos5l_decap_8_230 VPWR VGND sg13cmos5l_decap_8
* cell instance sg13cmos5l_decap_8_231 r0 *1 0,0
Xsg13cmos5l_decap_8_231 VPWR VGND sg13cmos5l_decap_8
* cell instance sg13cmos5l_decap_8_232 r0 *1 0,0
Xsg13cmos5l_decap_8_232 VPWR VGND sg13cmos5l_decap_8
* cell instance sg13cmos5l_decap_8_233 r0 *1 0,0
Xsg13cmos5l_decap_8_233 VPWR VGND sg13cmos5l_decap_8
* cell instance sg13cmos5l_decap_8_234 r0 *1 0,0
Xsg13cmos5l_decap_8_234 VPWR VGND sg13cmos5l_decap_8
* cell instance sg13cmos5l_decap_8_235 r0 *1 0,0
Xsg13cmos5l_decap_8_235 VPWR VGND sg13cmos5l_decap_8
* cell instance sg13cmos5l_decap_8_236 r0 *1 0,0
Xsg13cmos5l_decap_8_236 VPWR VGND sg13cmos5l_decap_8
* cell instance sg13cmos5l_decap_8_237 r0 *1 0,0
Xsg13cmos5l_decap_8_237 VPWR VGND sg13cmos5l_decap_8
* cell instance sg13cmos5l_decap_8_238 r0 *1 0,0
Xsg13cmos5l_decap_8_238 VPWR VGND sg13cmos5l_decap_8
* cell instance sg13cmos5l_decap_8_239 r0 *1 0,0
Xsg13cmos5l_decap_8_239 VPWR VGND sg13cmos5l_decap_8
* cell instance sg13cmos5l_decap_8_240 r0 *1 0,0
Xsg13cmos5l_decap_8_240 VPWR VGND sg13cmos5l_decap_8
* cell instance sg13cmos5l_decap_8_241 r0 *1 0,0
Xsg13cmos5l_decap_8_241 VPWR VGND sg13cmos5l_decap_8
* cell instance sg13cmos5l_decap_8_242 r0 *1 0,0
Xsg13cmos5l_decap_8_242 VPWR VGND sg13cmos5l_decap_8
* cell instance sg13cmos5l_decap_8_243 r0 *1 0,0
Xsg13cmos5l_decap_8_243 VPWR VGND sg13cmos5l_decap_8
* cell instance sg13cmos5l_decap_8_244 r0 *1 0,0
Xsg13cmos5l_decap_8_244 VPWR VGND sg13cmos5l_decap_8
* cell instance sg13cmos5l_decap_8_245 r0 *1 0,0
Xsg13cmos5l_decap_8_245 VPWR VGND sg13cmos5l_decap_8
* cell instance sg13cmos5l_decap_8_246 r0 *1 0,0
Xsg13cmos5l_decap_8_246 VPWR VGND sg13cmos5l_decap_8
* cell instance sg13cmos5l_decap_8_247 r0 *1 0,0
Xsg13cmos5l_decap_8_247 VPWR VGND sg13cmos5l_decap_8
* cell instance sg13cmos5l_decap_8_248 r0 *1 0,0
Xsg13cmos5l_decap_8_248 VPWR VGND sg13cmos5l_decap_8
* cell instance sg13cmos5l_decap_8_249 r0 *1 0,0
Xsg13cmos5l_decap_8_249 VPWR VGND sg13cmos5l_decap_8
* cell instance sg13cmos5l_decap_8_250 r0 *1 0,0
Xsg13cmos5l_decap_8_250 VPWR VGND sg13cmos5l_decap_8
* cell instance sg13cmos5l_decap_8_251 r0 *1 0,0
Xsg13cmos5l_decap_8_251 VPWR VGND sg13cmos5l_decap_8
* cell instance sg13cmos5l_decap_8_252 r0 *1 0,0
Xsg13cmos5l_decap_8_252 VPWR VGND sg13cmos5l_decap_8
* cell instance sg13cmos5l_decap_8_253 r0 *1 0,0
Xsg13cmos5l_decap_8_253 VPWR VGND sg13cmos5l_decap_8
* cell instance sg13cmos5l_decap_8_254 r0 *1 0,0
Xsg13cmos5l_decap_8_254 VPWR VGND sg13cmos5l_decap_8
* cell instance sg13cmos5l_decap_8_255 r0 *1 0,0
Xsg13cmos5l_decap_8_255 VPWR VGND sg13cmos5l_decap_8
* cell instance sg13cmos5l_decap_8_256 r0 *1 0,0
Xsg13cmos5l_decap_8_256 VPWR VGND sg13cmos5l_decap_8
* cell instance sg13cmos5l_decap_8_257 r0 *1 0,0
Xsg13cmos5l_decap_8_257 VPWR VGND sg13cmos5l_decap_8
* cell instance sg13cmos5l_decap_8_258 r0 *1 0,0
Xsg13cmos5l_decap_8_258 VPWR VGND sg13cmos5l_decap_8
* cell instance sg13cmos5l_decap_8_259 r0 *1 0,0
Xsg13cmos5l_decap_8_259 VPWR VGND sg13cmos5l_decap_8
* cell instance sg13cmos5l_decap_8_260 r0 *1 0,0
Xsg13cmos5l_decap_8_260 VPWR VGND sg13cmos5l_decap_8
* cell instance sg13cmos5l_decap_8_261 r0 *1 0,0
Xsg13cmos5l_decap_8_261 VPWR VGND sg13cmos5l_decap_8
* cell instance sg13cmos5l_decap_8_262 r0 *1 0,0
Xsg13cmos5l_decap_8_262 VPWR VGND sg13cmos5l_decap_8
* cell instance sg13cmos5l_decap_8_263 r0 *1 0,0
Xsg13cmos5l_decap_8_263 VPWR VGND sg13cmos5l_decap_8
* cell instance sg13cmos5l_decap_8_264 r0 *1 0,0
Xsg13cmos5l_decap_8_264 VPWR VGND sg13cmos5l_decap_8
* cell instance sg13cmos5l_decap_8_265 r0 *1 0,0
Xsg13cmos5l_decap_8_265 VPWR VGND sg13cmos5l_decap_8
* cell instance sg13cmos5l_decap_8_266 r0 *1 0,0
Xsg13cmos5l_decap_8_266 VPWR VGND sg13cmos5l_decap_8
* cell instance sg13cmos5l_decap_8_267 r0 *1 0,0
Xsg13cmos5l_decap_8_267 VPWR VGND sg13cmos5l_decap_8
* cell instance sg13cmos5l_decap_8_268 r0 *1 0,0
Xsg13cmos5l_decap_8_268 VPWR VGND sg13cmos5l_decap_8
* cell instance sg13cmos5l_decap_8_269 r0 *1 0,0
Xsg13cmos5l_decap_8_269 VPWR VGND sg13cmos5l_decap_8
* cell instance sg13cmos5l_decap_8_270 r0 *1 0,0
Xsg13cmos5l_decap_8_270 VPWR VGND sg13cmos5l_decap_8
* cell instance sg13cmos5l_decap_8_271 r0 *1 0,0
Xsg13cmos5l_decap_8_271 VPWR VGND sg13cmos5l_decap_8
* cell instance sg13cmos5l_decap_8_272 r0 *1 0,0
Xsg13cmos5l_decap_8_272 VPWR VGND sg13cmos5l_decap_8
* cell instance sg13cmos5l_decap_8_273 r0 *1 0,0
Xsg13cmos5l_decap_8_273 VPWR VGND sg13cmos5l_decap_8
* cell instance sg13cmos5l_decap_8_274 r0 *1 0,0
Xsg13cmos5l_decap_8_274 VPWR VGND sg13cmos5l_decap_8
* cell instance sg13cmos5l_decap_8_275 r0 *1 0,0
Xsg13cmos5l_decap_8_275 VPWR VGND sg13cmos5l_decap_8
* cell instance sg13cmos5l_decap_8_276 r0 *1 0,0
Xsg13cmos5l_decap_8_276 VPWR VGND sg13cmos5l_decap_8
* cell instance sg13cmos5l_decap_8_277 r0 *1 0,0
Xsg13cmos5l_decap_8_277 VPWR VGND sg13cmos5l_decap_8
* cell instance sg13cmos5l_decap_8_278 r0 *1 0,0
Xsg13cmos5l_decap_8_278 VPWR VGND sg13cmos5l_decap_8
* cell instance sg13cmos5l_decap_8_279 r0 *1 0,0
Xsg13cmos5l_decap_8_279 VPWR VGND sg13cmos5l_decap_8
* cell instance sg13cmos5l_decap_8_280 r0 *1 0,0
Xsg13cmos5l_decap_8_280 VPWR VGND sg13cmos5l_decap_8
* cell instance sg13cmos5l_decap_8_281 r0 *1 0,0
Xsg13cmos5l_decap_8_281 VPWR VGND sg13cmos5l_decap_8
* cell instance sg13cmos5l_decap_8_282 r0 *1 0,0
Xsg13cmos5l_decap_8_282 VPWR VGND sg13cmos5l_decap_8
* cell instance sg13cmos5l_decap_8_283 r0 *1 0,0
Xsg13cmos5l_decap_8_283 VPWR VGND sg13cmos5l_decap_8
* cell instance sg13cmos5l_decap_8_284 r0 *1 0,0
Xsg13cmos5l_decap_8_284 VPWR VGND sg13cmos5l_decap_8
* cell instance sg13cmos5l_decap_8_285 r0 *1 0,0
Xsg13cmos5l_decap_8_285 VPWR VGND sg13cmos5l_decap_8
* cell instance sg13cmos5l_decap_8_286 r0 *1 0,0
Xsg13cmos5l_decap_8_286 VPWR VGND sg13cmos5l_decap_8
* cell instance sg13cmos5l_decap_8_287 r0 *1 0,0
Xsg13cmos5l_decap_8_287 VPWR VGND sg13cmos5l_decap_8
* cell instance sg13cmos5l_decap_8_288 r0 *1 0,0
Xsg13cmos5l_decap_8_288 VPWR VGND sg13cmos5l_decap_8
* cell instance sg13cmos5l_decap_8_289 r0 *1 0,0
Xsg13cmos5l_decap_8_289 VPWR VGND sg13cmos5l_decap_8
* cell instance sg13cmos5l_decap_8_290 r0 *1 0,0
Xsg13cmos5l_decap_8_290 VPWR VGND sg13cmos5l_decap_8
* cell instance sg13cmos5l_decap_8_291 r0 *1 0,0
Xsg13cmos5l_decap_8_291 VPWR VGND sg13cmos5l_decap_8
* cell instance sg13cmos5l_decap_8_292 r0 *1 0,0
Xsg13cmos5l_decap_8_292 VPWR VGND sg13cmos5l_decap_8
* cell instance sg13cmos5l_decap_8_293 r0 *1 0,0
Xsg13cmos5l_decap_8_293 VPWR VGND sg13cmos5l_decap_8
* cell instance sg13cmos5l_decap_8_294 r0 *1 0,0
Xsg13cmos5l_decap_8_294 VPWR VGND sg13cmos5l_decap_8
* cell instance sg13cmos5l_decap_8_295 r0 *1 0,0
Xsg13cmos5l_decap_8_295 VPWR VGND sg13cmos5l_decap_8
* cell instance sg13cmos5l_decap_8_296 r0 *1 0,0
Xsg13cmos5l_decap_8_296 VPWR VGND sg13cmos5l_decap_8
* cell instance sg13cmos5l_decap_8_297 r0 *1 0,0
Xsg13cmos5l_decap_8_297 VPWR VGND sg13cmos5l_decap_8
* cell instance sg13cmos5l_decap_8_298 r0 *1 0,0
Xsg13cmos5l_decap_8_298 VPWR VGND sg13cmos5l_decap_8
* cell instance sg13cmos5l_decap_8_299 r0 *1 0,0
Xsg13cmos5l_decap_8_299 VPWR VGND sg13cmos5l_decap_8
* cell instance sg13cmos5l_decap_8_300 r0 *1 0,0
Xsg13cmos5l_decap_8_300 VPWR VGND sg13cmos5l_decap_8
* cell instance sg13cmos5l_decap_8_301 r0 *1 0,0
Xsg13cmos5l_decap_8_301 VPWR VGND sg13cmos5l_decap_8
* cell instance sg13cmos5l_decap_8_302 r0 *1 0,0
Xsg13cmos5l_decap_8_302 VPWR VGND sg13cmos5l_decap_8
* cell instance sg13cmos5l_decap_8_303 r0 *1 0,0
Xsg13cmos5l_decap_8_303 VPWR VGND sg13cmos5l_decap_8
* cell instance sg13cmos5l_decap_8_304 r0 *1 0,0
Xsg13cmos5l_decap_8_304 VPWR VGND sg13cmos5l_decap_8
* cell instance sg13cmos5l_decap_8_305 r0 *1 0,0
Xsg13cmos5l_decap_8_305 VPWR VGND sg13cmos5l_decap_8
* cell instance sg13cmos5l_decap_8_306 r0 *1 0,0
Xsg13cmos5l_decap_8_306 VPWR VGND sg13cmos5l_decap_8
* cell instance sg13cmos5l_decap_8_307 r0 *1 0,0
Xsg13cmos5l_decap_8_307 VPWR VGND sg13cmos5l_decap_8
* cell instance sg13cmos5l_decap_8_308 r0 *1 0,0
Xsg13cmos5l_decap_8_308 VPWR VGND sg13cmos5l_decap_8
* cell instance sg13cmos5l_decap_8_309 r0 *1 0,0
Xsg13cmos5l_decap_8_309 VPWR VGND sg13cmos5l_decap_8
* cell instance sg13cmos5l_decap_8_310 r0 *1 0,0
Xsg13cmos5l_decap_8_310 VPWR VGND sg13cmos5l_decap_8
* cell instance sg13cmos5l_decap_8_311 r0 *1 0,0
Xsg13cmos5l_decap_8_311 VPWR VGND sg13cmos5l_decap_8
* cell instance sg13cmos5l_decap_8_312 r0 *1 0,0
Xsg13cmos5l_decap_8_312 VPWR VGND sg13cmos5l_decap_8
* cell instance sg13cmos5l_decap_8_313 r0 *1 0,0
Xsg13cmos5l_decap_8_313 VPWR VGND sg13cmos5l_decap_8
* cell instance sg13cmos5l_decap_8_314 r0 *1 0,0
Xsg13cmos5l_decap_8_314 VPWR VGND sg13cmos5l_decap_8
* cell instance sg13cmos5l_decap_8_315 r0 *1 0,0
Xsg13cmos5l_decap_8_315 VPWR VGND sg13cmos5l_decap_8
* cell instance sg13cmos5l_decap_8_316 r0 *1 0,0
Xsg13cmos5l_decap_8_316 VPWR VGND sg13cmos5l_decap_8
* cell instance sg13cmos5l_decap_8_317 r0 *1 0,0
Xsg13cmos5l_decap_8_317 VPWR VGND sg13cmos5l_decap_8
* cell instance sg13cmos5l_decap_8_318 r0 *1 0,0
Xsg13cmos5l_decap_8_318 VPWR VGND sg13cmos5l_decap_8
* cell instance sg13cmos5l_decap_8_319 r0 *1 0,0
Xsg13cmos5l_decap_8_319 VPWR VGND sg13cmos5l_decap_8
* cell instance sg13cmos5l_decap_8_320 r0 *1 0,0
Xsg13cmos5l_decap_8_320 VPWR VGND sg13cmos5l_decap_8
* cell instance sg13cmos5l_decap_8_321 r0 *1 0,0
Xsg13cmos5l_decap_8_321 VPWR VGND sg13cmos5l_decap_8
* cell instance sg13cmos5l_decap_8_322 r0 *1 0,0
Xsg13cmos5l_decap_8_322 VPWR VGND sg13cmos5l_decap_8
* cell instance sg13cmos5l_decap_8_323 r0 *1 0,0
Xsg13cmos5l_decap_8_323 VPWR VGND sg13cmos5l_decap_8
* cell instance sg13cmos5l_decap_8_324 r0 *1 0,0
Xsg13cmos5l_decap_8_324 VPWR VGND sg13cmos5l_decap_8
* cell instance sg13cmos5l_decap_8_325 r0 *1 0,0
Xsg13cmos5l_decap_8_325 VPWR VGND sg13cmos5l_decap_8
* cell instance sg13cmos5l_decap_8_326 r0 *1 0,0
Xsg13cmos5l_decap_8_326 VPWR VGND sg13cmos5l_decap_8
* cell instance sg13cmos5l_decap_8_327 r0 *1 0,0
Xsg13cmos5l_decap_8_327 VPWR VGND sg13cmos5l_decap_8
* cell instance sg13cmos5l_decap_8_328 r0 *1 0,0
Xsg13cmos5l_decap_8_328 VPWR VGND sg13cmos5l_decap_8
* cell instance sg13cmos5l_decap_8_329 r0 *1 0,0
Xsg13cmos5l_decap_8_329 VPWR VGND sg13cmos5l_decap_8
* cell instance sg13cmos5l_decap_8_330 r0 *1 0,0
Xsg13cmos5l_decap_8_330 VPWR VGND sg13cmos5l_decap_8
* cell instance sg13cmos5l_decap_8_331 r0 *1 0,0
Xsg13cmos5l_decap_8_331 VPWR VGND sg13cmos5l_decap_8
* cell instance sg13cmos5l_decap_8_332 r0 *1 0,0
Xsg13cmos5l_decap_8_332 VPWR VGND sg13cmos5l_decap_8
* cell instance sg13cmos5l_decap_8_333 r0 *1 0,0
Xsg13cmos5l_decap_8_333 VPWR VGND sg13cmos5l_decap_8
* cell instance sg13cmos5l_decap_8_334 r0 *1 0,0
Xsg13cmos5l_decap_8_334 VPWR VGND sg13cmos5l_decap_8
* cell instance sg13cmos5l_decap_8_335 r0 *1 0,0
Xsg13cmos5l_decap_8_335 VPWR VGND sg13cmos5l_decap_8
* cell instance sg13cmos5l_decap_8_336 r0 *1 0,0
Xsg13cmos5l_decap_8_336 VPWR VGND sg13cmos5l_decap_8
* cell instance sg13cmos5l_decap_8_337 r0 *1 0,0
Xsg13cmos5l_decap_8_337 VPWR VGND sg13cmos5l_decap_8
* cell instance sg13cmos5l_decap_8_338 r0 *1 0,0
Xsg13cmos5l_decap_8_338 VPWR VGND sg13cmos5l_decap_8
* cell instance sg13cmos5l_decap_8_339 r0 *1 0,0
Xsg13cmos5l_decap_8_339 VPWR VGND sg13cmos5l_decap_8
* cell instance sg13cmos5l_decap_8_340 r0 *1 0,0
Xsg13cmos5l_decap_8_340 VPWR VGND sg13cmos5l_decap_8
* cell instance sg13cmos5l_decap_8_341 r0 *1 0,0
Xsg13cmos5l_decap_8_341 VPWR VGND sg13cmos5l_decap_8
* cell instance sg13cmos5l_decap_8_342 r0 *1 0,0
Xsg13cmos5l_decap_8_342 VPWR VGND sg13cmos5l_decap_8
* cell instance sg13cmos5l_decap_8_343 r0 *1 0,0
Xsg13cmos5l_decap_8_343 VPWR VGND sg13cmos5l_decap_8
* cell instance sg13cmos5l_decap_8_344 r0 *1 0,0
Xsg13cmos5l_decap_8_344 VPWR VGND sg13cmos5l_decap_8
* cell instance sg13cmos5l_decap_8_345 r0 *1 0,0
Xsg13cmos5l_decap_8_345 VPWR VGND sg13cmos5l_decap_8
* cell instance sg13cmos5l_decap_8_346 r0 *1 0,0
Xsg13cmos5l_decap_8_346 VPWR VGND sg13cmos5l_decap_8
* cell instance sg13cmos5l_decap_8_347 r0 *1 0,0
Xsg13cmos5l_decap_8_347 VPWR VGND sg13cmos5l_decap_8
* cell instance sg13cmos5l_decap_8_348 r0 *1 0,0
Xsg13cmos5l_decap_8_348 VPWR VGND sg13cmos5l_decap_8
* cell instance sg13cmos5l_decap_8_349 r0 *1 0,0
Xsg13cmos5l_decap_8_349 VPWR VGND sg13cmos5l_decap_8
* cell instance sg13cmos5l_decap_8_350 r0 *1 0,0
Xsg13cmos5l_decap_8_350 VPWR VGND sg13cmos5l_decap_8
* cell instance sg13cmos5l_decap_8_351 r0 *1 0,0
Xsg13cmos5l_decap_8_351 VPWR VGND sg13cmos5l_decap_8
* cell instance sg13cmos5l_decap_8_352 r0 *1 0,0
Xsg13cmos5l_decap_8_352 VPWR VGND sg13cmos5l_decap_8
* cell instance sg13cmos5l_decap_8_353 r0 *1 0,0
Xsg13cmos5l_decap_8_353 VPWR VGND sg13cmos5l_decap_8
* cell instance sg13cmos5l_decap_8_354 r0 *1 0,0
Xsg13cmos5l_decap_8_354 VPWR VGND sg13cmos5l_decap_8
* cell instance sg13cmos5l_decap_8_355 r0 *1 0,0
Xsg13cmos5l_decap_8_355 VPWR VGND sg13cmos5l_decap_8
* cell instance sg13cmos5l_decap_8_356 r0 *1 0,0
Xsg13cmos5l_decap_8_356 VPWR VGND sg13cmos5l_decap_8
* cell instance sg13cmos5l_decap_8_357 r0 *1 0,0
Xsg13cmos5l_decap_8_357 VPWR VGND sg13cmos5l_decap_8
* cell instance sg13cmos5l_decap_8_358 r0 *1 0,0
Xsg13cmos5l_decap_8_358 VPWR VGND sg13cmos5l_decap_8
* cell instance sg13cmos5l_decap_8_359 r0 *1 0,0
Xsg13cmos5l_decap_8_359 VPWR VGND sg13cmos5l_decap_8
* cell instance sg13cmos5l_decap_8_360 r0 *1 0,0
Xsg13cmos5l_decap_8_360 VPWR VGND sg13cmos5l_decap_8
* cell instance sg13cmos5l_decap_8_361 r0 *1 0,0
Xsg13cmos5l_decap_8_361 VPWR VGND sg13cmos5l_decap_8
* cell instance sg13cmos5l_decap_8_362 r0 *1 0,0
Xsg13cmos5l_decap_8_362 VPWR VGND sg13cmos5l_decap_8
* cell instance sg13cmos5l_decap_8_363 r0 *1 0,0
Xsg13cmos5l_decap_8_363 VPWR VGND sg13cmos5l_decap_8
* cell instance sg13cmos5l_decap_8_364 r0 *1 0,0
Xsg13cmos5l_decap_8_364 VPWR VGND sg13cmos5l_decap_8
* cell instance sg13cmos5l_decap_8_365 r0 *1 0,0
Xsg13cmos5l_decap_8_365 VPWR VGND sg13cmos5l_decap_8
* cell instance sg13cmos5l_decap_8_366 r0 *1 0,0
Xsg13cmos5l_decap_8_366 VPWR VGND sg13cmos5l_decap_8
* cell instance sg13cmos5l_decap_8_367 r0 *1 0,0
Xsg13cmos5l_decap_8_367 VPWR VGND sg13cmos5l_decap_8
* cell instance sg13cmos5l_decap_8_368 r0 *1 0,0
Xsg13cmos5l_decap_8_368 VPWR VGND sg13cmos5l_decap_8
* cell instance sg13cmos5l_decap_8_369 r0 *1 0,0
Xsg13cmos5l_decap_8_369 VPWR VGND sg13cmos5l_decap_8
* cell instance sg13cmos5l_decap_8_370 r0 *1 0,0
Xsg13cmos5l_decap_8_370 VPWR VGND sg13cmos5l_decap_8
* cell instance sg13cmos5l_decap_8_371 r0 *1 0,0
Xsg13cmos5l_decap_8_371 VPWR VGND sg13cmos5l_decap_8
* cell instance sg13cmos5l_decap_8_372 r0 *1 0,0
Xsg13cmos5l_decap_8_372 VPWR VGND sg13cmos5l_decap_8
* cell instance sg13cmos5l_decap_8_373 r0 *1 0,0
Xsg13cmos5l_decap_8_373 VPWR VGND sg13cmos5l_decap_8
* cell instance sg13cmos5l_decap_8_374 r0 *1 0,0
Xsg13cmos5l_decap_8_374 VPWR VGND sg13cmos5l_decap_8
* cell instance sg13cmos5l_decap_8_375 r0 *1 0,0
Xsg13cmos5l_decap_8_375 VPWR VGND sg13cmos5l_decap_8
* cell instance sg13cmos5l_decap_8_376 r0 *1 0,0
Xsg13cmos5l_decap_8_376 VPWR VGND sg13cmos5l_decap_8
* cell instance sg13cmos5l_decap_8_377 r0 *1 0,0
Xsg13cmos5l_decap_8_377 VPWR VGND sg13cmos5l_decap_8
* cell instance sg13cmos5l_decap_8_378 r0 *1 0,0
Xsg13cmos5l_decap_8_378 VPWR VGND sg13cmos5l_decap_8
* cell instance sg13cmos5l_decap_8_379 r0 *1 0,0
Xsg13cmos5l_decap_8_379 VPWR VGND sg13cmos5l_decap_8
* cell instance sg13cmos5l_decap_8_380 r0 *1 0,0
Xsg13cmos5l_decap_8_380 VPWR VGND sg13cmos5l_decap_8
* cell instance sg13cmos5l_decap_8_381 r0 *1 0,0
Xsg13cmos5l_decap_8_381 VPWR VGND sg13cmos5l_decap_8
* cell instance sg13cmos5l_decap_8_382 r0 *1 0,0
Xsg13cmos5l_decap_8_382 VPWR VGND sg13cmos5l_decap_8
* cell instance sg13cmos5l_decap_8_383 r0 *1 0,0
Xsg13cmos5l_decap_8_383 VPWR VGND sg13cmos5l_decap_8
* cell instance sg13cmos5l_decap_8_384 r0 *1 0,0
Xsg13cmos5l_decap_8_384 VPWR VGND sg13cmos5l_decap_8
* cell instance sg13cmos5l_decap_8_385 r0 *1 0,0
Xsg13cmos5l_decap_8_385 VPWR VGND sg13cmos5l_decap_8
* cell instance sg13cmos5l_decap_8_386 r0 *1 0,0
Xsg13cmos5l_decap_8_386 VPWR VGND sg13cmos5l_decap_8
* cell instance sg13cmos5l_decap_8_387 r0 *1 0,0
Xsg13cmos5l_decap_8_387 VPWR VGND sg13cmos5l_decap_8
* cell instance sg13cmos5l_decap_8_388 r0 *1 0,0
Xsg13cmos5l_decap_8_388 VPWR VGND sg13cmos5l_decap_8
* cell instance sg13cmos5l_decap_8_389 r0 *1 0,0
Xsg13cmos5l_decap_8_389 VPWR VGND sg13cmos5l_decap_8
* cell instance sg13cmos5l_decap_8_390 r0 *1 0,0
Xsg13cmos5l_decap_8_390 VPWR VGND sg13cmos5l_decap_8
* cell instance sg13cmos5l_decap_8_391 r0 *1 0,0
Xsg13cmos5l_decap_8_391 VPWR VGND sg13cmos5l_decap_8
* cell instance sg13cmos5l_decap_8_392 r0 *1 0,0
Xsg13cmos5l_decap_8_392 VPWR VGND sg13cmos5l_decap_8
* cell instance sg13cmos5l_decap_8_393 r0 *1 0,0
Xsg13cmos5l_decap_8_393 VPWR VGND sg13cmos5l_decap_8
* cell instance sg13cmos5l_decap_8_394 r0 *1 0,0
Xsg13cmos5l_decap_8_394 VPWR VGND sg13cmos5l_decap_8
* cell instance sg13cmos5l_decap_8_395 r0 *1 0,0
Xsg13cmos5l_decap_8_395 VPWR VGND sg13cmos5l_decap_8
* cell instance sg13cmos5l_decap_8_396 r0 *1 0,0
Xsg13cmos5l_decap_8_396 VPWR VGND sg13cmos5l_decap_8
* cell instance sg13cmos5l_decap_8_397 r0 *1 0,0
Xsg13cmos5l_decap_8_397 VPWR VGND sg13cmos5l_decap_8
* cell instance sg13cmos5l_decap_8_398 r0 *1 0,0
Xsg13cmos5l_decap_8_398 VPWR VGND sg13cmos5l_decap_8
* cell instance sg13cmos5l_decap_8_399 r0 *1 0,0
Xsg13cmos5l_decap_8_399 VPWR VGND sg13cmos5l_decap_8
* cell instance sg13cmos5l_decap_8_400 r0 *1 0,0
Xsg13cmos5l_decap_8_400 VPWR VGND sg13cmos5l_decap_8
* cell instance sg13cmos5l_decap_8_401 r0 *1 0,0
Xsg13cmos5l_decap_8_401 VPWR VGND sg13cmos5l_decap_8
* cell instance sg13cmos5l_decap_8_402 r0 *1 0,0
Xsg13cmos5l_decap_8_402 VPWR VGND sg13cmos5l_decap_8
* cell instance sg13cmos5l_decap_8_403 r0 *1 0,0
Xsg13cmos5l_decap_8_403 VPWR VGND sg13cmos5l_decap_8
* cell instance sg13cmos5l_decap_8_404 r0 *1 0,0
Xsg13cmos5l_decap_8_404 VPWR VGND sg13cmos5l_decap_8
* cell instance sg13cmos5l_decap_8_405 r0 *1 0,0
Xsg13cmos5l_decap_8_405 VPWR VGND sg13cmos5l_decap_8
* cell instance sg13cmos5l_decap_8_406 r0 *1 0,0
Xsg13cmos5l_decap_8_406 VPWR VGND sg13cmos5l_decap_8
* cell instance sg13cmos5l_decap_8_407 r0 *1 0,0
Xsg13cmos5l_decap_8_407 VPWR VGND sg13cmos5l_decap_8
* cell instance sg13cmos5l_decap_8_408 r0 *1 0,0
Xsg13cmos5l_decap_8_408 VPWR VGND sg13cmos5l_decap_8
* cell instance sg13cmos5l_decap_8_409 r0 *1 0,0
Xsg13cmos5l_decap_8_409 VPWR VGND sg13cmos5l_decap_8
* cell instance sg13cmos5l_decap_8_410 r0 *1 0,0
Xsg13cmos5l_decap_8_410 VPWR VGND sg13cmos5l_decap_8
* cell instance sg13cmos5l_decap_8_411 r0 *1 0,0
Xsg13cmos5l_decap_8_411 VPWR VGND sg13cmos5l_decap_8
* cell instance sg13cmos5l_decap_8_412 r0 *1 0,0
Xsg13cmos5l_decap_8_412 VPWR VGND sg13cmos5l_decap_8
* cell instance sg13cmos5l_decap_8_413 r0 *1 0,0
Xsg13cmos5l_decap_8_413 VPWR VGND sg13cmos5l_decap_8
* cell instance sg13cmos5l_decap_8_414 r0 *1 0,0
Xsg13cmos5l_decap_8_414 VPWR VGND sg13cmos5l_decap_8
* cell instance sg13cmos5l_decap_8_415 r0 *1 0,0
Xsg13cmos5l_decap_8_415 VPWR VGND sg13cmos5l_decap_8
* cell instance sg13cmos5l_decap_8_416 r0 *1 0,0
Xsg13cmos5l_decap_8_416 VPWR VGND sg13cmos5l_decap_8
* cell instance sg13cmos5l_decap_8_417 r0 *1 0,0
Xsg13cmos5l_decap_8_417 VPWR VGND sg13cmos5l_decap_8
* cell instance sg13cmos5l_decap_8_418 r0 *1 0,0
Xsg13cmos5l_decap_8_418 VPWR VGND sg13cmos5l_decap_8
* cell instance sg13cmos5l_decap_8_419 r0 *1 0,0
Xsg13cmos5l_decap_8_419 VPWR VGND sg13cmos5l_decap_8
* cell instance sg13cmos5l_decap_8_420 r0 *1 0,0
Xsg13cmos5l_decap_8_420 VPWR VGND sg13cmos5l_decap_8
* cell instance sg13cmos5l_decap_8_421 r0 *1 0,0
Xsg13cmos5l_decap_8_421 VPWR VGND sg13cmos5l_decap_8
* cell instance sg13cmos5l_decap_8_422 r0 *1 0,0
Xsg13cmos5l_decap_8_422 VPWR VGND sg13cmos5l_decap_8
* cell instance sg13cmos5l_decap_8_423 r0 *1 0,0
Xsg13cmos5l_decap_8_423 VPWR VGND sg13cmos5l_decap_8
* cell instance sg13cmos5l_decap_8_424 r0 *1 0,0
Xsg13cmos5l_decap_8_424 VPWR VGND sg13cmos5l_decap_8
* cell instance sg13cmos5l_decap_8_425 r0 *1 0,0
Xsg13cmos5l_decap_8_425 VPWR VGND sg13cmos5l_decap_8
* cell instance sg13cmos5l_decap_8_426 r0 *1 0,0
Xsg13cmos5l_decap_8_426 VPWR VGND sg13cmos5l_decap_8
* cell instance sg13cmos5l_decap_8_427 r0 *1 0,0
Xsg13cmos5l_decap_8_427 VPWR VGND sg13cmos5l_decap_8
* cell instance sg13cmos5l_decap_8_428 r0 *1 0,0
Xsg13cmos5l_decap_8_428 VPWR VGND sg13cmos5l_decap_8
* cell instance sg13cmos5l_decap_8_429 r0 *1 0,0
Xsg13cmos5l_decap_8_429 VPWR VGND sg13cmos5l_decap_8
* cell instance sg13cmos5l_decap_8_430 r0 *1 0,0
Xsg13cmos5l_decap_8_430 VPWR VGND sg13cmos5l_decap_8
* cell instance sg13cmos5l_decap_8_431 r0 *1 0,0
Xsg13cmos5l_decap_8_431 VPWR VGND sg13cmos5l_decap_8
* cell instance sg13cmos5l_decap_8_432 r0 *1 0,0
Xsg13cmos5l_decap_8_432 VPWR VGND sg13cmos5l_decap_8
* cell instance sg13cmos5l_decap_8_433 r0 *1 0,0
Xsg13cmos5l_decap_8_433 VPWR VGND sg13cmos5l_decap_8
* cell instance sg13cmos5l_decap_8_434 r0 *1 0,0
Xsg13cmos5l_decap_8_434 VPWR VGND sg13cmos5l_decap_8
* cell instance sg13cmos5l_decap_8_435 r0 *1 0,0
Xsg13cmos5l_decap_8_435 VPWR VGND sg13cmos5l_decap_8
* cell instance sg13cmos5l_decap_8_436 r0 *1 0,0
Xsg13cmos5l_decap_8_436 VPWR VGND sg13cmos5l_decap_8
* cell instance sg13cmos5l_decap_8_437 r0 *1 0,0
Xsg13cmos5l_decap_8_437 VPWR VGND sg13cmos5l_decap_8
* cell instance sg13cmos5l_decap_8_438 r0 *1 0,0
Xsg13cmos5l_decap_8_438 VPWR VGND sg13cmos5l_decap_8
* cell instance sg13cmos5l_decap_8_439 r0 *1 0,0
Xsg13cmos5l_decap_8_439 VPWR VGND sg13cmos5l_decap_8
* cell instance sg13cmos5l_decap_8_440 r0 *1 0,0
Xsg13cmos5l_decap_8_440 VPWR VGND sg13cmos5l_decap_8
* cell instance sg13cmos5l_decap_8_441 r0 *1 0,0
Xsg13cmos5l_decap_8_441 VPWR VGND sg13cmos5l_decap_8
* cell instance sg13cmos5l_decap_8_442 r0 *1 0,0
Xsg13cmos5l_decap_8_442 VPWR VGND sg13cmos5l_decap_8
* cell instance sg13cmos5l_decap_8_443 r0 *1 0,0
Xsg13cmos5l_decap_8_443 VPWR VGND sg13cmos5l_decap_8
* cell instance sg13cmos5l_decap_8_444 r0 *1 0,0
Xsg13cmos5l_decap_8_444 VPWR VGND sg13cmos5l_decap_8
* cell instance sg13cmos5l_decap_8_445 r0 *1 0,0
Xsg13cmos5l_decap_8_445 VPWR VGND sg13cmos5l_decap_8
* cell instance sg13cmos5l_decap_8_446 r0 *1 0,0
Xsg13cmos5l_decap_8_446 VPWR VGND sg13cmos5l_decap_8
* cell instance sg13cmos5l_decap_8_447 r0 *1 0,0
Xsg13cmos5l_decap_8_447 VPWR VGND sg13cmos5l_decap_8
* cell instance sg13cmos5l_decap_8_448 r0 *1 0,0
Xsg13cmos5l_decap_8_448 VPWR VGND sg13cmos5l_decap_8
* cell instance sg13cmos5l_decap_8_449 r0 *1 0,0
Xsg13cmos5l_decap_8_449 VPWR VGND sg13cmos5l_decap_8
* cell instance sg13cmos5l_decap_8_450 r0 *1 0,0
Xsg13cmos5l_decap_8_450 VPWR VGND sg13cmos5l_decap_8
* cell instance sg13cmos5l_decap_8_451 r0 *1 0,0
Xsg13cmos5l_decap_8_451 VPWR VGND sg13cmos5l_decap_8
* cell instance sg13cmos5l_decap_8_452 r0 *1 0,0
Xsg13cmos5l_decap_8_452 VPWR VGND sg13cmos5l_decap_8
* cell instance sg13cmos5l_decap_8_453 r0 *1 0,0
Xsg13cmos5l_decap_8_453 VPWR VGND sg13cmos5l_decap_8
* cell instance sg13cmos5l_decap_8_454 r0 *1 0,0
Xsg13cmos5l_decap_8_454 VPWR VGND sg13cmos5l_decap_8
* cell instance sg13cmos5l_decap_8_455 r0 *1 0,0
Xsg13cmos5l_decap_8_455 VPWR VGND sg13cmos5l_decap_8
* cell instance sg13cmos5l_decap_8_456 r0 *1 0,0
Xsg13cmos5l_decap_8_456 VPWR VGND sg13cmos5l_decap_8
* cell instance sg13cmos5l_decap_8_457 r0 *1 0,0
Xsg13cmos5l_decap_8_457 VPWR VGND sg13cmos5l_decap_8
* cell instance sg13cmos5l_decap_8_458 r0 *1 0,0
Xsg13cmos5l_decap_8_458 VPWR VGND sg13cmos5l_decap_8
* cell instance sg13cmos5l_decap_8_459 r0 *1 0,0
Xsg13cmos5l_decap_8_459 VPWR VGND sg13cmos5l_decap_8
* cell instance sg13cmos5l_decap_8_460 r0 *1 0,0
Xsg13cmos5l_decap_8_460 VPWR VGND sg13cmos5l_decap_8
* cell instance sg13cmos5l_decap_8_461 r0 *1 0,0
Xsg13cmos5l_decap_8_461 VPWR VGND sg13cmos5l_decap_8
* cell instance sg13cmos5l_decap_8_462 r0 *1 0,0
Xsg13cmos5l_decap_8_462 VPWR VGND sg13cmos5l_decap_8
* cell instance sg13cmos5l_decap_8_463 r0 *1 0,0
Xsg13cmos5l_decap_8_463 VPWR VGND sg13cmos5l_decap_8
* cell instance sg13cmos5l_decap_8_464 r0 *1 0,0
Xsg13cmos5l_decap_8_464 VPWR VGND sg13cmos5l_decap_8
* cell instance sg13cmos5l_decap_8_465 r0 *1 0,0
Xsg13cmos5l_decap_8_465 VPWR VGND sg13cmos5l_decap_8
* cell instance sg13cmos5l_decap_8_466 r0 *1 0,0
Xsg13cmos5l_decap_8_466 VPWR VGND sg13cmos5l_decap_8
* cell instance sg13cmos5l_decap_8_467 r0 *1 0,0
Xsg13cmos5l_decap_8_467 VPWR VGND sg13cmos5l_decap_8
* cell instance sg13cmos5l_decap_8_468 r0 *1 0,0
Xsg13cmos5l_decap_8_468 VPWR VGND sg13cmos5l_decap_8
* cell instance sg13cmos5l_decap_8_469 r0 *1 0,0
Xsg13cmos5l_decap_8_469 VPWR VGND sg13cmos5l_decap_8
* cell instance sg13cmos5l_decap_8_470 r0 *1 0,0
Xsg13cmos5l_decap_8_470 VPWR VGND sg13cmos5l_decap_8
* cell instance sg13cmos5l_decap_8_471 r0 *1 0,0
Xsg13cmos5l_decap_8_471 VPWR VGND sg13cmos5l_decap_8
* cell instance sg13cmos5l_decap_8_472 r0 *1 0,0
Xsg13cmos5l_decap_8_472 VPWR VGND sg13cmos5l_decap_8
* cell instance sg13cmos5l_decap_8_473 r0 *1 0,0
Xsg13cmos5l_decap_8_473 VPWR VGND sg13cmos5l_decap_8
* cell instance sg13cmos5l_decap_8_474 r0 *1 0,0
Xsg13cmos5l_decap_8_474 VPWR VGND sg13cmos5l_decap_8
* cell instance sg13cmos5l_decap_8_475 r0 *1 0,0
Xsg13cmos5l_decap_8_475 VPWR VGND sg13cmos5l_decap_8
* cell instance sg13cmos5l_decap_8_476 r0 *1 0,0
Xsg13cmos5l_decap_8_476 VPWR VGND sg13cmos5l_decap_8
* cell instance sg13cmos5l_decap_8_477 r0 *1 0,0
Xsg13cmos5l_decap_8_477 VPWR VGND sg13cmos5l_decap_8
* cell instance sg13cmos5l_decap_8_478 r0 *1 0,0
Xsg13cmos5l_decap_8_478 VPWR VGND sg13cmos5l_decap_8
* cell instance sg13cmos5l_decap_8_479 r0 *1 0,0
Xsg13cmos5l_decap_8_479 VPWR VGND sg13cmos5l_decap_8
* cell instance sg13cmos5l_decap_8_480 r0 *1 0,0
Xsg13cmos5l_decap_8_480 VPWR VGND sg13cmos5l_decap_8
* cell instance sg13cmos5l_decap_8_481 r0 *1 0,0
Xsg13cmos5l_decap_8_481 VPWR VGND sg13cmos5l_decap_8
* cell instance sg13cmos5l_decap_8_482 r0 *1 0,0
Xsg13cmos5l_decap_8_482 VPWR VGND sg13cmos5l_decap_8
* cell instance sg13cmos5l_decap_8_483 r0 *1 0,0
Xsg13cmos5l_decap_8_483 VPWR VGND sg13cmos5l_decap_8
* cell instance sg13cmos5l_decap_8_484 r0 *1 0,0
Xsg13cmos5l_decap_8_484 VPWR VGND sg13cmos5l_decap_8
* cell instance sg13cmos5l_decap_8_485 r0 *1 0,0
Xsg13cmos5l_decap_8_485 VPWR VGND sg13cmos5l_decap_8
* cell instance sg13cmos5l_decap_8_486 r0 *1 0,0
Xsg13cmos5l_decap_8_486 VPWR VGND sg13cmos5l_decap_8
* cell instance sg13cmos5l_decap_8_487 r0 *1 0,0
Xsg13cmos5l_decap_8_487 VPWR VGND sg13cmos5l_decap_8
* cell instance sg13cmos5l_decap_8_488 r0 *1 0,0
Xsg13cmos5l_decap_8_488 VPWR VGND sg13cmos5l_decap_8
* cell instance sg13cmos5l_decap_8_489 r0 *1 0,0
Xsg13cmos5l_decap_8_489 VPWR VGND sg13cmos5l_decap_8
* cell instance sg13cmos5l_decap_8_490 r0 *1 0,0
Xsg13cmos5l_decap_8_490 VPWR VGND sg13cmos5l_decap_8
* cell instance sg13cmos5l_decap_8_491 r0 *1 0,0
Xsg13cmos5l_decap_8_491 VPWR VGND sg13cmos5l_decap_8
* cell instance sg13cmos5l_decap_8_492 r0 *1 0,0
Xsg13cmos5l_decap_8_492 VPWR VGND sg13cmos5l_decap_8
* cell instance sg13cmos5l_decap_8_493 r0 *1 0,0
Xsg13cmos5l_decap_8_493 VPWR VGND sg13cmos5l_decap_8
* cell instance sg13cmos5l_decap_8_494 r0 *1 0,0
Xsg13cmos5l_decap_8_494 VPWR VGND sg13cmos5l_decap_8
* cell instance sg13cmos5l_decap_8_495 r0 *1 0,0
Xsg13cmos5l_decap_8_495 VPWR VGND sg13cmos5l_decap_8
* cell instance sg13cmos5l_decap_8_496 r0 *1 0,0
Xsg13cmos5l_decap_8_496 VPWR VGND sg13cmos5l_decap_8
* cell instance sg13cmos5l_decap_8_497 r0 *1 0,0
Xsg13cmos5l_decap_8_497 VPWR VGND sg13cmos5l_decap_8
* cell instance sg13cmos5l_decap_8_498 r0 *1 0,0
Xsg13cmos5l_decap_8_498 VPWR VGND sg13cmos5l_decap_8
* cell instance sg13cmos5l_decap_8_499 r0 *1 0,0
Xsg13cmos5l_decap_8_499 VPWR VGND sg13cmos5l_decap_8
* cell instance sg13cmos5l_decap_8_500 r0 *1 0,0
Xsg13cmos5l_decap_8_500 VPWR VGND sg13cmos5l_decap_8
* cell instance sg13cmos5l_decap_8_501 r0 *1 0,0
Xsg13cmos5l_decap_8_501 VPWR VGND sg13cmos5l_decap_8
* cell instance sg13cmos5l_decap_8_502 r0 *1 0,0
Xsg13cmos5l_decap_8_502 VPWR VGND sg13cmos5l_decap_8
* cell instance sg13cmos5l_decap_8_503 r0 *1 0,0
Xsg13cmos5l_decap_8_503 VPWR VGND sg13cmos5l_decap_8
* cell instance sg13cmos5l_decap_8_504 r0 *1 0,0
Xsg13cmos5l_decap_8_504 VPWR VGND sg13cmos5l_decap_8
* cell instance sg13cmos5l_decap_8_505 r0 *1 0,0
Xsg13cmos5l_decap_8_505 VPWR VGND sg13cmos5l_decap_8
* cell instance sg13cmos5l_decap_8_506 r0 *1 0,0
Xsg13cmos5l_decap_8_506 VPWR VGND sg13cmos5l_decap_8
* cell instance sg13cmos5l_decap_8_507 r0 *1 0,0
Xsg13cmos5l_decap_8_507 VPWR VGND sg13cmos5l_decap_8
* cell instance sg13cmos5l_decap_8_508 r0 *1 0,0
Xsg13cmos5l_decap_8_508 VPWR VGND sg13cmos5l_decap_8
* cell instance sg13cmos5l_decap_8_509 r0 *1 0,0
Xsg13cmos5l_decap_8_509 VPWR VGND sg13cmos5l_decap_8
* cell instance sg13cmos5l_decap_8_510 r0 *1 0,0
Xsg13cmos5l_decap_8_510 VPWR VGND sg13cmos5l_decap_8
* cell instance sg13cmos5l_decap_8_511 r0 *1 0,0
Xsg13cmos5l_decap_8_511 VPWR VGND sg13cmos5l_decap_8
* cell instance sg13cmos5l_decap_8_512 r0 *1 0,0
Xsg13cmos5l_decap_8_512 VPWR VGND sg13cmos5l_decap_8
* cell instance sg13cmos5l_decap_8_513 r0 *1 0,0
Xsg13cmos5l_decap_8_513 VPWR VGND sg13cmos5l_decap_8
* cell instance sg13cmos5l_decap_8_514 r0 *1 0,0
Xsg13cmos5l_decap_8_514 VPWR VGND sg13cmos5l_decap_8
* cell instance sg13cmos5l_decap_8_515 r0 *1 0,0
Xsg13cmos5l_decap_8_515 VPWR VGND sg13cmos5l_decap_8
* cell instance sg13cmos5l_decap_8_516 r0 *1 0,0
Xsg13cmos5l_decap_8_516 VPWR VGND sg13cmos5l_decap_8
* cell instance sg13cmos5l_decap_8_517 r0 *1 0,0
Xsg13cmos5l_decap_8_517 VPWR VGND sg13cmos5l_decap_8
* cell instance sg13cmos5l_decap_8_518 r0 *1 0,0
Xsg13cmos5l_decap_8_518 VPWR VGND sg13cmos5l_decap_8
* cell instance sg13cmos5l_decap_8_519 r0 *1 0,0
Xsg13cmos5l_decap_8_519 VPWR VGND sg13cmos5l_decap_8
* cell instance sg13cmos5l_decap_8_520 r0 *1 0,0
Xsg13cmos5l_decap_8_520 VPWR VGND sg13cmos5l_decap_8
* cell instance sg13cmos5l_decap_8_521 r0 *1 0,0
Xsg13cmos5l_decap_8_521 VPWR VGND sg13cmos5l_decap_8
* cell instance sg13cmos5l_decap_8_522 r0 *1 0,0
Xsg13cmos5l_decap_8_522 VPWR VGND sg13cmos5l_decap_8
* cell instance sg13cmos5l_decap_8_523 r0 *1 0,0
Xsg13cmos5l_decap_8_523 VPWR VGND sg13cmos5l_decap_8
* cell instance sg13cmos5l_decap_8_524 r0 *1 0,0
Xsg13cmos5l_decap_8_524 VPWR VGND sg13cmos5l_decap_8
* cell instance sg13cmos5l_decap_8_525 r0 *1 0,0
Xsg13cmos5l_decap_8_525 VPWR VGND sg13cmos5l_decap_8
* cell instance sg13cmos5l_decap_8_526 r0 *1 0,0
Xsg13cmos5l_decap_8_526 VPWR VGND sg13cmos5l_decap_8
* cell instance sg13cmos5l_decap_8_527 r0 *1 0,0
Xsg13cmos5l_decap_8_527 VPWR VGND sg13cmos5l_decap_8
* cell instance sg13cmos5l_decap_8_528 r0 *1 0,0
Xsg13cmos5l_decap_8_528 VPWR VGND sg13cmos5l_decap_8
* cell instance sg13cmos5l_decap_8_529 r0 *1 0,0
Xsg13cmos5l_decap_8_529 VPWR VGND sg13cmos5l_decap_8
* cell instance sg13cmos5l_decap_8_530 r0 *1 0,0
Xsg13cmos5l_decap_8_530 VPWR VGND sg13cmos5l_decap_8
* cell instance sg13cmos5l_decap_8_531 r0 *1 0,0
Xsg13cmos5l_decap_8_531 VPWR VGND sg13cmos5l_decap_8
* cell instance sg13cmos5l_decap_8_532 r0 *1 0,0
Xsg13cmos5l_decap_8_532 VPWR VGND sg13cmos5l_decap_8
* cell instance sg13cmos5l_decap_8_533 r0 *1 0,0
Xsg13cmos5l_decap_8_533 VPWR VGND sg13cmos5l_decap_8
* cell instance sg13cmos5l_decap_8_534 r0 *1 0,0
Xsg13cmos5l_decap_8_534 VPWR VGND sg13cmos5l_decap_8
* cell instance sg13cmos5l_decap_8_535 r0 *1 0,0
Xsg13cmos5l_decap_8_535 VPWR VGND sg13cmos5l_decap_8
* cell instance sg13cmos5l_decap_8_536 r0 *1 0,0
Xsg13cmos5l_decap_8_536 VPWR VGND sg13cmos5l_decap_8
* cell instance sg13cmos5l_decap_8_537 r0 *1 0,0
Xsg13cmos5l_decap_8_537 VPWR VGND sg13cmos5l_decap_8
* cell instance sg13cmos5l_decap_8_538 r0 *1 0,0
Xsg13cmos5l_decap_8_538 VPWR VGND sg13cmos5l_decap_8
* cell instance sg13cmos5l_decap_8_539 r0 *1 0,0
Xsg13cmos5l_decap_8_539 VPWR VGND sg13cmos5l_decap_8
* cell instance sg13cmos5l_decap_8_540 r0 *1 0,0
Xsg13cmos5l_decap_8_540 VPWR VGND sg13cmos5l_decap_8
* cell instance sg13cmos5l_decap_8_541 r0 *1 0,0
Xsg13cmos5l_decap_8_541 VPWR VGND sg13cmos5l_decap_8
* cell instance sg13cmos5l_decap_8_542 r0 *1 0,0
Xsg13cmos5l_decap_8_542 VPWR VGND sg13cmos5l_decap_8
* cell instance sg13cmos5l_decap_8_543 r0 *1 0,0
Xsg13cmos5l_decap_8_543 VPWR VGND sg13cmos5l_decap_8
* cell instance sg13cmos5l_decap_8_544 r0 *1 0,0
Xsg13cmos5l_decap_8_544 VPWR VGND sg13cmos5l_decap_8
* cell instance sg13cmos5l_decap_8_545 r0 *1 0,0
Xsg13cmos5l_decap_8_545 VPWR VGND sg13cmos5l_decap_8
* cell instance sg13cmos5l_decap_8_546 r0 *1 0,0
Xsg13cmos5l_decap_8_546 VPWR VGND sg13cmos5l_decap_8
* cell instance sg13cmos5l_decap_8_547 r0 *1 0,0
Xsg13cmos5l_decap_8_547 VPWR VGND sg13cmos5l_decap_8
* cell instance sg13cmos5l_decap_8_548 r0 *1 0,0
Xsg13cmos5l_decap_8_548 VPWR VGND sg13cmos5l_decap_8
* cell instance sg13cmos5l_decap_8_549 r0 *1 0,0
Xsg13cmos5l_decap_8_549 VPWR VGND sg13cmos5l_decap_8
* cell instance sg13cmos5l_decap_8_550 r0 *1 0,0
Xsg13cmos5l_decap_8_550 VPWR VGND sg13cmos5l_decap_8
* cell instance sg13cmos5l_decap_8_551 r0 *1 0,0
Xsg13cmos5l_decap_8_551 VPWR VGND sg13cmos5l_decap_8
* cell instance sg13cmos5l_decap_8_552 r0 *1 0,0
Xsg13cmos5l_decap_8_552 VPWR VGND sg13cmos5l_decap_8
* cell instance sg13cmos5l_decap_8_553 r0 *1 0,0
Xsg13cmos5l_decap_8_553 VPWR VGND sg13cmos5l_decap_8
* cell instance sg13cmos5l_decap_8_554 r0 *1 0,0
Xsg13cmos5l_decap_8_554 VPWR VGND sg13cmos5l_decap_8
* cell instance sg13cmos5l_decap_8_555 r0 *1 0,0
Xsg13cmos5l_decap_8_555 VPWR VGND sg13cmos5l_decap_8
* cell instance sg13cmos5l_decap_8_556 r0 *1 0,0
Xsg13cmos5l_decap_8_556 VPWR VGND sg13cmos5l_decap_8
* cell instance sg13cmos5l_decap_8_557 r0 *1 0,0
Xsg13cmos5l_decap_8_557 VPWR VGND sg13cmos5l_decap_8
* cell instance sg13cmos5l_decap_8_558 r0 *1 0,0
Xsg13cmos5l_decap_8_558 VPWR VGND sg13cmos5l_decap_8
* cell instance sg13cmos5l_decap_8_559 r0 *1 0,0
Xsg13cmos5l_decap_8_559 VPWR VGND sg13cmos5l_decap_8
* cell instance sg13cmos5l_decap_8_560 r0 *1 0,0
Xsg13cmos5l_decap_8_560 VPWR VGND sg13cmos5l_decap_8
* cell instance sg13cmos5l_decap_8_561 r0 *1 0,0
Xsg13cmos5l_decap_8_561 VPWR VGND sg13cmos5l_decap_8
* cell instance sg13cmos5l_decap_8_562 r0 *1 0,0
Xsg13cmos5l_decap_8_562 VPWR VGND sg13cmos5l_decap_8
* cell instance sg13cmos5l_decap_8_563 r0 *1 0,0
Xsg13cmos5l_decap_8_563 VPWR VGND sg13cmos5l_decap_8
* cell instance sg13cmos5l_decap_8_564 r0 *1 0,0
Xsg13cmos5l_decap_8_564 VPWR VGND sg13cmos5l_decap_8
* cell instance sg13cmos5l_decap_8_565 r0 *1 0,0
Xsg13cmos5l_decap_8_565 VPWR VGND sg13cmos5l_decap_8
* cell instance sg13cmos5l_decap_8_566 r0 *1 0,0
Xsg13cmos5l_decap_8_566 VPWR VGND sg13cmos5l_decap_8
* cell instance sg13cmos5l_decap_8_567 r0 *1 0,0
Xsg13cmos5l_decap_8_567 VPWR VGND sg13cmos5l_decap_8
* cell instance sg13cmos5l_decap_8_568 r0 *1 0,0
Xsg13cmos5l_decap_8_568 VPWR VGND sg13cmos5l_decap_8
* cell instance sg13cmos5l_decap_8_569 r0 *1 0,0
Xsg13cmos5l_decap_8_569 VPWR VGND sg13cmos5l_decap_8
* cell instance sg13cmos5l_decap_8_570 r0 *1 0,0
Xsg13cmos5l_decap_8_570 VPWR VGND sg13cmos5l_decap_8
* cell instance sg13cmos5l_decap_8_571 r0 *1 0,0
Xsg13cmos5l_decap_8_571 VPWR VGND sg13cmos5l_decap_8
* cell instance sg13cmos5l_decap_8_572 r0 *1 0,0
Xsg13cmos5l_decap_8_572 VPWR VGND sg13cmos5l_decap_8
* cell instance sg13cmos5l_decap_8_573 r0 *1 0,0
Xsg13cmos5l_decap_8_573 VPWR VGND sg13cmos5l_decap_8
* cell instance sg13cmos5l_decap_8_574 r0 *1 0,0
Xsg13cmos5l_decap_8_574 VPWR VGND sg13cmos5l_decap_8
* cell instance sg13cmos5l_decap_8_575 r0 *1 0,0
Xsg13cmos5l_decap_8_575 VPWR VGND sg13cmos5l_decap_8
* cell instance sg13cmos5l_decap_8_576 r0 *1 0,0
Xsg13cmos5l_decap_8_576 VPWR VGND sg13cmos5l_decap_8
* cell instance sg13cmos5l_decap_8_577 r0 *1 0,0
Xsg13cmos5l_decap_8_577 VPWR VGND sg13cmos5l_decap_8
* cell instance sg13cmos5l_decap_8_578 r0 *1 0,0
Xsg13cmos5l_decap_8_578 VPWR VGND sg13cmos5l_decap_8
* cell instance sg13cmos5l_decap_8_579 r0 *1 0,0
Xsg13cmos5l_decap_8_579 VPWR VGND sg13cmos5l_decap_8
* cell instance sg13cmos5l_decap_8_580 r0 *1 0,0
Xsg13cmos5l_decap_8_580 VPWR VGND sg13cmos5l_decap_8
* cell instance sg13cmos5l_decap_8_581 r0 *1 0,0
Xsg13cmos5l_decap_8_581 VPWR VGND sg13cmos5l_decap_8
* cell instance sg13cmos5l_decap_8_582 r0 *1 0,0
Xsg13cmos5l_decap_8_582 VPWR VGND sg13cmos5l_decap_8
* cell instance sg13cmos5l_decap_8_583 r0 *1 0,0
Xsg13cmos5l_decap_8_583 VPWR VGND sg13cmos5l_decap_8
* cell instance sg13cmos5l_decap_8_584 r0 *1 0,0
Xsg13cmos5l_decap_8_584 VPWR VGND sg13cmos5l_decap_8
* cell instance sg13cmos5l_decap_8_585 r0 *1 0,0
Xsg13cmos5l_decap_8_585 VPWR VGND sg13cmos5l_decap_8
* cell instance sg13cmos5l_decap_8_586 r0 *1 0,0
Xsg13cmos5l_decap_8_586 VPWR VGND sg13cmos5l_decap_8
* cell instance sg13cmos5l_decap_8_587 r0 *1 0,0
Xsg13cmos5l_decap_8_587 VPWR VGND sg13cmos5l_decap_8
* cell instance sg13cmos5l_decap_8_588 r0 *1 0,0
Xsg13cmos5l_decap_8_588 VPWR VGND sg13cmos5l_decap_8
* cell instance sg13cmos5l_decap_8_589 r0 *1 0,0
Xsg13cmos5l_decap_8_589 VPWR VGND sg13cmos5l_decap_8
* cell instance sg13cmos5l_decap_8_590 r0 *1 0,0
Xsg13cmos5l_decap_8_590 VPWR VGND sg13cmos5l_decap_8
* cell instance sg13cmos5l_decap_8_591 r0 *1 0,0
Xsg13cmos5l_decap_8_591 VPWR VGND sg13cmos5l_decap_8
* cell instance sg13cmos5l_decap_8_592 r0 *1 0,0
Xsg13cmos5l_decap_8_592 VPWR VGND sg13cmos5l_decap_8
* cell instance sg13cmos5l_decap_8_593 r0 *1 0,0
Xsg13cmos5l_decap_8_593 VPWR VGND sg13cmos5l_decap_8
* cell instance sg13cmos5l_decap_8_594 r0 *1 0,0
Xsg13cmos5l_decap_8_594 VPWR VGND sg13cmos5l_decap_8
* cell instance sg13cmos5l_decap_8_595 r0 *1 0,0
Xsg13cmos5l_decap_8_595 VPWR VGND sg13cmos5l_decap_8
* cell instance sg13cmos5l_decap_8_596 r0 *1 0,0
Xsg13cmos5l_decap_8_596 VPWR VGND sg13cmos5l_decap_8
* cell instance sg13cmos5l_decap_8_597 r0 *1 0,0
Xsg13cmos5l_decap_8_597 VPWR VGND sg13cmos5l_decap_8
* cell instance sg13cmos5l_decap_8_598 r0 *1 0,0
Xsg13cmos5l_decap_8_598 VPWR VGND sg13cmos5l_decap_8
* cell instance sg13cmos5l_decap_8_599 r0 *1 0,0
Xsg13cmos5l_decap_8_599 VPWR VGND sg13cmos5l_decap_8
* cell instance sg13cmos5l_decap_8_600 r0 *1 0,0
Xsg13cmos5l_decap_8_600 VPWR VGND sg13cmos5l_decap_8
* cell instance sg13cmos5l_decap_8_601 r0 *1 0,0
Xsg13cmos5l_decap_8_601 VPWR VGND sg13cmos5l_decap_8
* cell instance sg13cmos5l_decap_8_602 r0 *1 0,0
Xsg13cmos5l_decap_8_602 VPWR VGND sg13cmos5l_decap_8
* cell instance sg13cmos5l_decap_8_603 r0 *1 0,0
Xsg13cmos5l_decap_8_603 VPWR VGND sg13cmos5l_decap_8
* cell instance sg13cmos5l_decap_8_604 r0 *1 0,0
Xsg13cmos5l_decap_8_604 VPWR VGND sg13cmos5l_decap_8
* cell instance sg13cmos5l_decap_8_605 r0 *1 0,0
Xsg13cmos5l_decap_8_605 VPWR VGND sg13cmos5l_decap_8
* cell instance sg13cmos5l_decap_8_606 r0 *1 0,0
Xsg13cmos5l_decap_8_606 VPWR VGND sg13cmos5l_decap_8
* cell instance sg13cmos5l_decap_8_607 r0 *1 0,0
Xsg13cmos5l_decap_8_607 VPWR VGND sg13cmos5l_decap_8
* cell instance sg13cmos5l_decap_8_608 r0 *1 0,0
Xsg13cmos5l_decap_8_608 VPWR VGND sg13cmos5l_decap_8
* cell instance sg13cmos5l_decap_8_609 r0 *1 0,0
Xsg13cmos5l_decap_8_609 VPWR VGND sg13cmos5l_decap_8
* cell instance sg13cmos5l_decap_8_610 r0 *1 0,0
Xsg13cmos5l_decap_8_610 VPWR VGND sg13cmos5l_decap_8
* cell instance sg13cmos5l_decap_8_611 r0 *1 0,0
Xsg13cmos5l_decap_8_611 VPWR VGND sg13cmos5l_decap_8
* cell instance sg13cmos5l_decap_8_612 r0 *1 0,0
Xsg13cmos5l_decap_8_612 VPWR VGND sg13cmos5l_decap_8
* cell instance sg13cmos5l_decap_8_613 r0 *1 0,0
Xsg13cmos5l_decap_8_613 VPWR VGND sg13cmos5l_decap_8
* cell instance sg13cmos5l_decap_8_614 r0 *1 0,0
Xsg13cmos5l_decap_8_614 VPWR VGND sg13cmos5l_decap_8
* cell instance sg13cmos5l_decap_8_615 r0 *1 0,0
Xsg13cmos5l_decap_8_615 VPWR VGND sg13cmos5l_decap_8
* cell instance sg13cmos5l_decap_8_616 r0 *1 0,0
Xsg13cmos5l_decap_8_616 VPWR VGND sg13cmos5l_decap_8
* cell instance sg13cmos5l_decap_8_617 r0 *1 0,0
Xsg13cmos5l_decap_8_617 VPWR VGND sg13cmos5l_decap_8
* cell instance sg13cmos5l_decap_8_618 r0 *1 0,0
Xsg13cmos5l_decap_8_618 VPWR VGND sg13cmos5l_decap_8
* cell instance sg13cmos5l_decap_8_619 r0 *1 0,0
Xsg13cmos5l_decap_8_619 VPWR VGND sg13cmos5l_decap_8
* cell instance sg13cmos5l_decap_8_620 r0 *1 0,0
Xsg13cmos5l_decap_8_620 VPWR VGND sg13cmos5l_decap_8
* cell instance sg13cmos5l_decap_8_621 r0 *1 0,0
Xsg13cmos5l_decap_8_621 VPWR VGND sg13cmos5l_decap_8
* cell instance sg13cmos5l_decap_8_622 r0 *1 0,0
Xsg13cmos5l_decap_8_622 VPWR VGND sg13cmos5l_decap_8
* cell instance sg13cmos5l_decap_8_623 r0 *1 0,0
Xsg13cmos5l_decap_8_623 VPWR VGND sg13cmos5l_decap_8
* cell instance sg13cmos5l_decap_8_624 r0 *1 0,0
Xsg13cmos5l_decap_8_624 VPWR VGND sg13cmos5l_decap_8
* cell instance sg13cmos5l_decap_8_625 r0 *1 0,0
Xsg13cmos5l_decap_8_625 VPWR VGND sg13cmos5l_decap_8
* cell instance sg13cmos5l_decap_8_626 r0 *1 0,0
Xsg13cmos5l_decap_8_626 VPWR VGND sg13cmos5l_decap_8
* cell instance sg13cmos5l_decap_8_627 r0 *1 0,0
Xsg13cmos5l_decap_8_627 VPWR VGND sg13cmos5l_decap_8
* cell instance sg13cmos5l_decap_8_628 r0 *1 0,0
Xsg13cmos5l_decap_8_628 VPWR VGND sg13cmos5l_decap_8
* cell instance sg13cmos5l_decap_8_629 r0 *1 0,0
Xsg13cmos5l_decap_8_629 VPWR VGND sg13cmos5l_decap_8
* cell instance sg13cmos5l_decap_8_630 r0 *1 0,0
Xsg13cmos5l_decap_8_630 VPWR VGND sg13cmos5l_decap_8
* cell instance sg13cmos5l_decap_8_631 r0 *1 0,0
Xsg13cmos5l_decap_8_631 VPWR VGND sg13cmos5l_decap_8
* cell instance sg13cmos5l_decap_8_632 r0 *1 0,0
Xsg13cmos5l_decap_8_632 VPWR VGND sg13cmos5l_decap_8
* cell instance sg13cmos5l_decap_8_633 r0 *1 0,0
Xsg13cmos5l_decap_8_633 VPWR VGND sg13cmos5l_decap_8
* cell instance sg13cmos5l_decap_8_634 r0 *1 0,0
Xsg13cmos5l_decap_8_634 VPWR VGND sg13cmos5l_decap_8
* cell instance sg13cmos5l_decap_8_635 r0 *1 0,0
Xsg13cmos5l_decap_8_635 VPWR VGND sg13cmos5l_decap_8
* cell instance sg13cmos5l_decap_8_636 r0 *1 0,0
Xsg13cmos5l_decap_8_636 VPWR VGND sg13cmos5l_decap_8
* cell instance sg13cmos5l_decap_8_637 r0 *1 0,0
Xsg13cmos5l_decap_8_637 VPWR VGND sg13cmos5l_decap_8
* cell instance sg13cmos5l_decap_8_638 r0 *1 0,0
Xsg13cmos5l_decap_8_638 VPWR VGND sg13cmos5l_decap_8
* cell instance sg13cmos5l_decap_8_639 r0 *1 0,0
Xsg13cmos5l_decap_8_639 VPWR VGND sg13cmos5l_decap_8
* cell instance sg13cmos5l_decap_8_640 r0 *1 0,0
Xsg13cmos5l_decap_8_640 VPWR VGND sg13cmos5l_decap_8
* cell instance sg13cmos5l_decap_8_641 r0 *1 0,0
Xsg13cmos5l_decap_8_641 VPWR VGND sg13cmos5l_decap_8
* cell instance sg13cmos5l_decap_8_642 r0 *1 0,0
Xsg13cmos5l_decap_8_642 VPWR VGND sg13cmos5l_decap_8
* cell instance sg13cmos5l_decap_8_643 r0 *1 0,0
Xsg13cmos5l_decap_8_643 VPWR VGND sg13cmos5l_decap_8
* cell instance sg13cmos5l_decap_8_644 r0 *1 0,0
Xsg13cmos5l_decap_8_644 VPWR VGND sg13cmos5l_decap_8
* cell instance sg13cmos5l_decap_8_645 r0 *1 0,0
Xsg13cmos5l_decap_8_645 VPWR VGND sg13cmos5l_decap_8
* cell instance sg13cmos5l_decap_8_646 r0 *1 0,0
Xsg13cmos5l_decap_8_646 VPWR VGND sg13cmos5l_decap_8
* cell instance sg13cmos5l_decap_8_647 r0 *1 0,0
Xsg13cmos5l_decap_8_647 VPWR VGND sg13cmos5l_decap_8
* cell instance sg13cmos5l_decap_8_648 r0 *1 0,0
Xsg13cmos5l_decap_8_648 VPWR VGND sg13cmos5l_decap_8
* cell instance sg13cmos5l_decap_8_649 r0 *1 0,0
Xsg13cmos5l_decap_8_649 VPWR VGND sg13cmos5l_decap_8
* cell instance sg13cmos5l_decap_8_650 r0 *1 0,0
Xsg13cmos5l_decap_8_650 VPWR VGND sg13cmos5l_decap_8
* cell instance sg13cmos5l_decap_8_651 r0 *1 0,0
Xsg13cmos5l_decap_8_651 VPWR VGND sg13cmos5l_decap_8
* cell instance sg13cmos5l_decap_8_652 r0 *1 0,0
Xsg13cmos5l_decap_8_652 VPWR VGND sg13cmos5l_decap_8
* cell instance sg13cmos5l_decap_8_653 r0 *1 0,0
Xsg13cmos5l_decap_8_653 VPWR VGND sg13cmos5l_decap_8
* cell instance sg13cmos5l_decap_8_654 r0 *1 0,0
Xsg13cmos5l_decap_8_654 VPWR VGND sg13cmos5l_decap_8
* cell instance sg13cmos5l_decap_8_655 r0 *1 0,0
Xsg13cmos5l_decap_8_655 VPWR VGND sg13cmos5l_decap_8
* cell instance sg13cmos5l_decap_8_656 r0 *1 0,0
Xsg13cmos5l_decap_8_656 VPWR VGND sg13cmos5l_decap_8
* cell instance sg13cmos5l_decap_8_657 r0 *1 0,0
Xsg13cmos5l_decap_8_657 VPWR VGND sg13cmos5l_decap_8
* cell instance sg13cmos5l_decap_8_658 r0 *1 0,0
Xsg13cmos5l_decap_8_658 VPWR VGND sg13cmos5l_decap_8
* cell instance sg13cmos5l_decap_8_659 r0 *1 0,0
Xsg13cmos5l_decap_8_659 VPWR VGND sg13cmos5l_decap_8
* cell instance sg13cmos5l_decap_8_660 r0 *1 0,0
Xsg13cmos5l_decap_8_660 VPWR VGND sg13cmos5l_decap_8
* cell instance sg13cmos5l_decap_8_661 r0 *1 0,0
Xsg13cmos5l_decap_8_661 VPWR VGND sg13cmos5l_decap_8
* cell instance sg13cmos5l_decap_8_662 r0 *1 0,0
Xsg13cmos5l_decap_8_662 VPWR VGND sg13cmos5l_decap_8
* cell instance sg13cmos5l_decap_8_663 r0 *1 0,0
Xsg13cmos5l_decap_8_663 VPWR VGND sg13cmos5l_decap_8
* cell instance sg13cmos5l_decap_8_664 r0 *1 0,0
Xsg13cmos5l_decap_8_664 VPWR VGND sg13cmos5l_decap_8
* cell instance sg13cmos5l_decap_8_665 r0 *1 0,0
Xsg13cmos5l_decap_8_665 VPWR VGND sg13cmos5l_decap_8
* cell instance sg13cmos5l_decap_8_666 r0 *1 0,0
Xsg13cmos5l_decap_8_666 VPWR VGND sg13cmos5l_decap_8
* cell instance sg13cmos5l_decap_8_667 r0 *1 0,0
Xsg13cmos5l_decap_8_667 VPWR VGND sg13cmos5l_decap_8
* cell instance sg13cmos5l_decap_8_668 r0 *1 0,0
Xsg13cmos5l_decap_8_668 VPWR VGND sg13cmos5l_decap_8
* cell instance sg13cmos5l_decap_8_669 r0 *1 0,0
Xsg13cmos5l_decap_8_669 VPWR VGND sg13cmos5l_decap_8
* cell instance sg13cmos5l_decap_8_670 r0 *1 0,0
Xsg13cmos5l_decap_8_670 VPWR VGND sg13cmos5l_decap_8
* cell instance sg13cmos5l_decap_8_671 r0 *1 0,0
Xsg13cmos5l_decap_8_671 VPWR VGND sg13cmos5l_decap_8
* cell instance sg13cmos5l_decap_8_672 r0 *1 0,0
Xsg13cmos5l_decap_8_672 VPWR VGND sg13cmos5l_decap_8
* cell instance sg13cmos5l_decap_8_673 r0 *1 0,0
Xsg13cmos5l_decap_8_673 VPWR VGND sg13cmos5l_decap_8
* cell instance sg13cmos5l_decap_8_674 r0 *1 0,0
Xsg13cmos5l_decap_8_674 VPWR VGND sg13cmos5l_decap_8
* cell instance sg13cmos5l_decap_8_675 r0 *1 0,0
Xsg13cmos5l_decap_8_675 VPWR VGND sg13cmos5l_decap_8
* cell instance sg13cmos5l_decap_8_676 r0 *1 0,0
Xsg13cmos5l_decap_8_676 VPWR VGND sg13cmos5l_decap_8
* cell instance sg13cmos5l_decap_8_677 r0 *1 0,0
Xsg13cmos5l_decap_8_677 VPWR VGND sg13cmos5l_decap_8
* cell instance sg13cmos5l_decap_8_678 r0 *1 0,0
Xsg13cmos5l_decap_8_678 VPWR VGND sg13cmos5l_decap_8
* cell instance sg13cmos5l_decap_8_679 r0 *1 0,0
Xsg13cmos5l_decap_8_679 VPWR VGND sg13cmos5l_decap_8
* cell instance sg13cmos5l_decap_8_680 r0 *1 0,0
Xsg13cmos5l_decap_8_680 VPWR VGND sg13cmos5l_decap_8
* cell instance sg13cmos5l_decap_8_681 r0 *1 0,0
Xsg13cmos5l_decap_8_681 VPWR VGND sg13cmos5l_decap_8
* cell instance sg13cmos5l_decap_8_682 r0 *1 0,0
Xsg13cmos5l_decap_8_682 VPWR VGND sg13cmos5l_decap_8
* cell instance sg13cmos5l_decap_8_683 r0 *1 0,0
Xsg13cmos5l_decap_8_683 VPWR VGND sg13cmos5l_decap_8
* cell instance sg13cmos5l_decap_8_684 r0 *1 0,0
Xsg13cmos5l_decap_8_684 VPWR VGND sg13cmos5l_decap_8
* cell instance sg13cmos5l_decap_8_685 r0 *1 0,0
Xsg13cmos5l_decap_8_685 VPWR VGND sg13cmos5l_decap_8
* cell instance sg13cmos5l_decap_8_686 r0 *1 0,0
Xsg13cmos5l_decap_8_686 VPWR VGND sg13cmos5l_decap_8
* cell instance sg13cmos5l_decap_8_687 r0 *1 0,0
Xsg13cmos5l_decap_8_687 VPWR VGND sg13cmos5l_decap_8
* cell instance sg13cmos5l_decap_8_688 r0 *1 0,0
Xsg13cmos5l_decap_8_688 VPWR VGND sg13cmos5l_decap_8
* cell instance sg13cmos5l_decap_8_689 r0 *1 0,0
Xsg13cmos5l_decap_8_689 VPWR VGND sg13cmos5l_decap_8
* cell instance sg13cmos5l_decap_8_690 r0 *1 0,0
Xsg13cmos5l_decap_8_690 VPWR VGND sg13cmos5l_decap_8
* cell instance sg13cmos5l_decap_8_691 r0 *1 0,0
Xsg13cmos5l_decap_8_691 VPWR VGND sg13cmos5l_decap_8
* cell instance sg13cmos5l_decap_8_692 r0 *1 0,0
Xsg13cmos5l_decap_8_692 VPWR VGND sg13cmos5l_decap_8
* cell instance sg13cmos5l_decap_8_693 r0 *1 0,0
Xsg13cmos5l_decap_8_693 VPWR VGND sg13cmos5l_decap_8
* cell instance sg13cmos5l_decap_8_694 r0 *1 0,0
Xsg13cmos5l_decap_8_694 VPWR VGND sg13cmos5l_decap_8
* cell instance sg13cmos5l_decap_8_695 r0 *1 0,0
Xsg13cmos5l_decap_8_695 VPWR VGND sg13cmos5l_decap_8
* cell instance sg13cmos5l_decap_8_696 r0 *1 0,0
Xsg13cmos5l_decap_8_696 VPWR VGND sg13cmos5l_decap_8
* cell instance sg13cmos5l_decap_8_697 r0 *1 0,0
Xsg13cmos5l_decap_8_697 VPWR VGND sg13cmos5l_decap_8
* cell instance sg13cmos5l_decap_8_698 r0 *1 0,0
Xsg13cmos5l_decap_8_698 VPWR VGND sg13cmos5l_decap_8
* cell instance sg13cmos5l_decap_8_699 r0 *1 0,0
Xsg13cmos5l_decap_8_699 VPWR VGND sg13cmos5l_decap_8
* cell instance sg13cmos5l_decap_8_700 r0 *1 0,0
Xsg13cmos5l_decap_8_700 VPWR VGND sg13cmos5l_decap_8
* cell instance sg13cmos5l_decap_8_701 r0 *1 0,0
Xsg13cmos5l_decap_8_701 VPWR VGND sg13cmos5l_decap_8
* cell instance sg13cmos5l_decap_8_702 r0 *1 0,0
Xsg13cmos5l_decap_8_702 VPWR VGND sg13cmos5l_decap_8
* cell instance sg13cmos5l_decap_8_703 r0 *1 0,0
Xsg13cmos5l_decap_8_703 VPWR VGND sg13cmos5l_decap_8
* cell instance sg13cmos5l_decap_8_704 r0 *1 0,0
Xsg13cmos5l_decap_8_704 VPWR VGND sg13cmos5l_decap_8
* cell instance sg13cmos5l_decap_8_705 r0 *1 0,0
Xsg13cmos5l_decap_8_705 VPWR VGND sg13cmos5l_decap_8
* cell instance sg13cmos5l_decap_8_706 r0 *1 0,0
Xsg13cmos5l_decap_8_706 VPWR VGND sg13cmos5l_decap_8
* cell instance sg13cmos5l_decap_8_707 r0 *1 0,0
Xsg13cmos5l_decap_8_707 VPWR VGND sg13cmos5l_decap_8
* cell instance sg13cmos5l_decap_8_708 r0 *1 0,0
Xsg13cmos5l_decap_8_708 VPWR VGND sg13cmos5l_decap_8
* cell instance sg13cmos5l_decap_8_709 r0 *1 0,0
Xsg13cmos5l_decap_8_709 VPWR VGND sg13cmos5l_decap_8
* cell instance sg13cmos5l_decap_8_710 r0 *1 0,0
Xsg13cmos5l_decap_8_710 VPWR VGND sg13cmos5l_decap_8
* cell instance sg13cmos5l_decap_8_711 r0 *1 0,0
Xsg13cmos5l_decap_8_711 VPWR VGND sg13cmos5l_decap_8
* cell instance sg13cmos5l_decap_8_712 r0 *1 0,0
Xsg13cmos5l_decap_8_712 VPWR VGND sg13cmos5l_decap_8
* cell instance sg13cmos5l_decap_8_713 r0 *1 0,0
Xsg13cmos5l_decap_8_713 VPWR VGND sg13cmos5l_decap_8
* cell instance sg13cmos5l_decap_8_714 r0 *1 0,0
Xsg13cmos5l_decap_8_714 VPWR VGND sg13cmos5l_decap_8
* cell instance sg13cmos5l_decap_8_715 r0 *1 0,0
Xsg13cmos5l_decap_8_715 VPWR VGND sg13cmos5l_decap_8
* cell instance sg13cmos5l_decap_8_716 r0 *1 0,0
Xsg13cmos5l_decap_8_716 VPWR VGND sg13cmos5l_decap_8
* cell instance sg13cmos5l_decap_8_717 r0 *1 0,0
Xsg13cmos5l_decap_8_717 VPWR VGND sg13cmos5l_decap_8
* cell instance sg13cmos5l_decap_8_718 r0 *1 0,0
Xsg13cmos5l_decap_8_718 VPWR VGND sg13cmos5l_decap_8
* cell instance sg13cmos5l_decap_8_719 r0 *1 0,0
Xsg13cmos5l_decap_8_719 VPWR VGND sg13cmos5l_decap_8
* cell instance sg13cmos5l_decap_8_720 r0 *1 0,0
Xsg13cmos5l_decap_8_720 VPWR VGND sg13cmos5l_decap_8
* cell instance sg13cmos5l_decap_8_721 r0 *1 0,0
Xsg13cmos5l_decap_8_721 VPWR VGND sg13cmos5l_decap_8
* cell instance sg13cmos5l_decap_8_722 r0 *1 0,0
Xsg13cmos5l_decap_8_722 VPWR VGND sg13cmos5l_decap_8
* cell instance sg13cmos5l_decap_8_723 r0 *1 0,0
Xsg13cmos5l_decap_8_723 VPWR VGND sg13cmos5l_decap_8
* cell instance sg13cmos5l_decap_8_724 r0 *1 0,0
Xsg13cmos5l_decap_8_724 VPWR VGND sg13cmos5l_decap_8
* cell instance sg13cmos5l_decap_8_725 r0 *1 0,0
Xsg13cmos5l_decap_8_725 VPWR VGND sg13cmos5l_decap_8
* cell instance sg13cmos5l_decap_8_726 r0 *1 0,0
Xsg13cmos5l_decap_8_726 VPWR VGND sg13cmos5l_decap_8
* cell instance sg13cmos5l_decap_8_727 r0 *1 0,0
Xsg13cmos5l_decap_8_727 VPWR VGND sg13cmos5l_decap_8
* cell instance sg13cmos5l_decap_8_728 r0 *1 0,0
Xsg13cmos5l_decap_8_728 VPWR VGND sg13cmos5l_decap_8
* cell instance sg13cmos5l_decap_8_729 r0 *1 0,0
Xsg13cmos5l_decap_8_729 VPWR VGND sg13cmos5l_decap_8
* cell instance sg13cmos5l_decap_8_730 r0 *1 0,0
Xsg13cmos5l_decap_8_730 VPWR VGND sg13cmos5l_decap_8
* cell instance sg13cmos5l_decap_8_731 r0 *1 0,0
Xsg13cmos5l_decap_8_731 VPWR VGND sg13cmos5l_decap_8
* cell instance sg13cmos5l_decap_8_732 r0 *1 0,0
Xsg13cmos5l_decap_8_732 VPWR VGND sg13cmos5l_decap_8
* cell instance sg13cmos5l_decap_8_733 r0 *1 0,0
Xsg13cmos5l_decap_8_733 VPWR VGND sg13cmos5l_decap_8
* cell instance sg13cmos5l_decap_8_734 r0 *1 0,0
Xsg13cmos5l_decap_8_734 VPWR VGND sg13cmos5l_decap_8
* cell instance sg13cmos5l_decap_8_735 r0 *1 0,0
Xsg13cmos5l_decap_8_735 VPWR VGND sg13cmos5l_decap_8
* cell instance sg13cmos5l_decap_8_736 r0 *1 0,0
Xsg13cmos5l_decap_8_736 VPWR VGND sg13cmos5l_decap_8
* cell instance sg13cmos5l_decap_8_737 r0 *1 0,0
Xsg13cmos5l_decap_8_737 VPWR VGND sg13cmos5l_decap_8
* cell instance sg13cmos5l_decap_8_738 r0 *1 0,0
Xsg13cmos5l_decap_8_738 VPWR VGND sg13cmos5l_decap_8
* cell instance sg13cmos5l_decap_8_739 r0 *1 0,0
Xsg13cmos5l_decap_8_739 VPWR VGND sg13cmos5l_decap_8
* cell instance sg13cmos5l_decap_8_740 r0 *1 0,0
Xsg13cmos5l_decap_8_740 VPWR VGND sg13cmos5l_decap_8
* cell instance sg13cmos5l_decap_8_741 r0 *1 0,0
Xsg13cmos5l_decap_8_741 VPWR VGND sg13cmos5l_decap_8
* cell instance sg13cmos5l_decap_8_742 r0 *1 0,0
Xsg13cmos5l_decap_8_742 VPWR VGND sg13cmos5l_decap_8
* cell instance sg13cmos5l_decap_8_743 r0 *1 0,0
Xsg13cmos5l_decap_8_743 VPWR VGND sg13cmos5l_decap_8
* cell instance sg13cmos5l_decap_8_744 r0 *1 0,0
Xsg13cmos5l_decap_8_744 VPWR VGND sg13cmos5l_decap_8
* cell instance sg13cmos5l_decap_8_745 r0 *1 0,0
Xsg13cmos5l_decap_8_745 VPWR VGND sg13cmos5l_decap_8
* cell instance sg13cmos5l_decap_8_746 r0 *1 0,0
Xsg13cmos5l_decap_8_746 VPWR VGND sg13cmos5l_decap_8
* cell instance sg13cmos5l_decap_8_747 r0 *1 0,0
Xsg13cmos5l_decap_8_747 VPWR VGND sg13cmos5l_decap_8
* cell instance sg13cmos5l_decap_8_748 r0 *1 0,0
Xsg13cmos5l_decap_8_748 VPWR VGND sg13cmos5l_decap_8
* cell instance sg13cmos5l_decap_8_749 r0 *1 0,0
Xsg13cmos5l_decap_8_749 VPWR VGND sg13cmos5l_decap_8
* cell instance sg13cmos5l_decap_8_750 r0 *1 0,0
Xsg13cmos5l_decap_8_750 VPWR VGND sg13cmos5l_decap_8
* cell instance sg13cmos5l_decap_8_751 r0 *1 0,0
Xsg13cmos5l_decap_8_751 VPWR VGND sg13cmos5l_decap_8
* cell instance sg13cmos5l_decap_8_752 r0 *1 0,0
Xsg13cmos5l_decap_8_752 VPWR VGND sg13cmos5l_decap_8
* cell instance sg13cmos5l_decap_8_753 r0 *1 0,0
Xsg13cmos5l_decap_8_753 VPWR VGND sg13cmos5l_decap_8
* cell instance sg13cmos5l_decap_8_754 r0 *1 0,0
Xsg13cmos5l_decap_8_754 VPWR VGND sg13cmos5l_decap_8
* cell instance sg13cmos5l_decap_8_755 r0 *1 0,0
Xsg13cmos5l_decap_8_755 VPWR VGND sg13cmos5l_decap_8
* cell instance sg13cmos5l_decap_8_756 r0 *1 0,0
Xsg13cmos5l_decap_8_756 VPWR VGND sg13cmos5l_decap_8
* cell instance sg13cmos5l_decap_8_757 r0 *1 0,0
Xsg13cmos5l_decap_8_757 VPWR VGND sg13cmos5l_decap_8
* cell instance sg13cmos5l_decap_8_758 r0 *1 0,0
Xsg13cmos5l_decap_8_758 VPWR VGND sg13cmos5l_decap_8
* cell instance sg13cmos5l_decap_8_759 r0 *1 0,0
Xsg13cmos5l_decap_8_759 VPWR VGND sg13cmos5l_decap_8
* cell instance sg13cmos5l_decap_8_760 r0 *1 0,0
Xsg13cmos5l_decap_8_760 VPWR VGND sg13cmos5l_decap_8
* cell instance sg13cmos5l_decap_8_761 r0 *1 0,0
Xsg13cmos5l_decap_8_761 VPWR VGND sg13cmos5l_decap_8
* cell instance sg13cmos5l_decap_8_762 r0 *1 0,0
Xsg13cmos5l_decap_8_762 VPWR VGND sg13cmos5l_decap_8
* cell instance sg13cmos5l_decap_8_763 r0 *1 0,0
Xsg13cmos5l_decap_8_763 VPWR VGND sg13cmos5l_decap_8
* cell instance sg13cmos5l_decap_8_764 r0 *1 0,0
Xsg13cmos5l_decap_8_764 VPWR VGND sg13cmos5l_decap_8
* cell instance sg13cmos5l_decap_8_765 r0 *1 0,0
Xsg13cmos5l_decap_8_765 VPWR VGND sg13cmos5l_decap_8
* cell instance sg13cmos5l_decap_8_766 r0 *1 0,0
Xsg13cmos5l_decap_8_766 VPWR VGND sg13cmos5l_decap_8
* cell instance sg13cmos5l_decap_8_767 r0 *1 0,0
Xsg13cmos5l_decap_8_767 VPWR VGND sg13cmos5l_decap_8
* cell instance sg13cmos5l_decap_8_768 r0 *1 0,0
Xsg13cmos5l_decap_8_768 VPWR VGND sg13cmos5l_decap_8
* cell instance sg13cmos5l_decap_8_769 r0 *1 0,0
Xsg13cmos5l_decap_8_769 VPWR VGND sg13cmos5l_decap_8
* cell instance sg13cmos5l_decap_8_770 r0 *1 0,0
Xsg13cmos5l_decap_8_770 VPWR VGND sg13cmos5l_decap_8
* cell instance sg13cmos5l_decap_8_771 r0 *1 0,0
Xsg13cmos5l_decap_8_771 VPWR VGND sg13cmos5l_decap_8
* cell instance sg13cmos5l_decap_8_772 r0 *1 0,0
Xsg13cmos5l_decap_8_772 VPWR VGND sg13cmos5l_decap_8
* cell instance sg13cmos5l_decap_8_773 r0 *1 0,0
Xsg13cmos5l_decap_8_773 VPWR VGND sg13cmos5l_decap_8
* cell instance sg13cmos5l_decap_8_774 r0 *1 0,0
Xsg13cmos5l_decap_8_774 VPWR VGND sg13cmos5l_decap_8
* cell instance sg13cmos5l_decap_8_775 r0 *1 0,0
Xsg13cmos5l_decap_8_775 VPWR VGND sg13cmos5l_decap_8
* cell instance sg13cmos5l_decap_8_776 r0 *1 0,0
Xsg13cmos5l_decap_8_776 VPWR VGND sg13cmos5l_decap_8
* cell instance sg13cmos5l_decap_8_777 r0 *1 0,0
Xsg13cmos5l_decap_8_777 VPWR VGND sg13cmos5l_decap_8
* cell instance sg13cmos5l_decap_8_778 r0 *1 0,0
Xsg13cmos5l_decap_8_778 VPWR VGND sg13cmos5l_decap_8
* cell instance sg13cmos5l_decap_8_779 r0 *1 0,0
Xsg13cmos5l_decap_8_779 VPWR VGND sg13cmos5l_decap_8
* cell instance sg13cmos5l_decap_8_780 r0 *1 0,0
Xsg13cmos5l_decap_8_780 VPWR VGND sg13cmos5l_decap_8
* cell instance sg13cmos5l_decap_8_781 r0 *1 0,0
Xsg13cmos5l_decap_8_781 VPWR VGND sg13cmos5l_decap_8
* cell instance sg13cmos5l_decap_8_782 r0 *1 0,0
Xsg13cmos5l_decap_8_782 VPWR VGND sg13cmos5l_decap_8
* cell instance sg13cmos5l_decap_8_783 r0 *1 0,0
Xsg13cmos5l_decap_8_783 VPWR VGND sg13cmos5l_decap_8
* cell instance sg13cmos5l_decap_8_784 r0 *1 0,0
Xsg13cmos5l_decap_8_784 VPWR VGND sg13cmos5l_decap_8
* cell instance sg13cmos5l_decap_8_785 r0 *1 0,0
Xsg13cmos5l_decap_8_785 VPWR VGND sg13cmos5l_decap_8
* cell instance sg13cmos5l_decap_8_786 r0 *1 0,0
Xsg13cmos5l_decap_8_786 VPWR VGND sg13cmos5l_decap_8
* cell instance sg13cmos5l_decap_8_787 r0 *1 0,0
Xsg13cmos5l_decap_8_787 VPWR VGND sg13cmos5l_decap_8
* cell instance sg13cmos5l_decap_8_788 r0 *1 0,0
Xsg13cmos5l_decap_8_788 VPWR VGND sg13cmos5l_decap_8
* cell instance sg13cmos5l_decap_8_789 r0 *1 0,0
Xsg13cmos5l_decap_8_789 VPWR VGND sg13cmos5l_decap_8
* cell instance sg13cmos5l_decap_8_790 r0 *1 0,0
Xsg13cmos5l_decap_8_790 VPWR VGND sg13cmos5l_decap_8
* cell instance sg13cmos5l_decap_8_791 r0 *1 0,0
Xsg13cmos5l_decap_8_791 VPWR VGND sg13cmos5l_decap_8
* cell instance sg13cmos5l_decap_8_792 r0 *1 0,0
Xsg13cmos5l_decap_8_792 VPWR VGND sg13cmos5l_decap_8
* cell instance sg13cmos5l_decap_8_793 r0 *1 0,0
Xsg13cmos5l_decap_8_793 VPWR VGND sg13cmos5l_decap_8
* cell instance sg13cmos5l_decap_8_794 r0 *1 0,0
Xsg13cmos5l_decap_8_794 VPWR VGND sg13cmos5l_decap_8
* cell instance sg13cmos5l_decap_8_795 r0 *1 0,0
Xsg13cmos5l_decap_8_795 VPWR VGND sg13cmos5l_decap_8
* cell instance sg13cmos5l_decap_8_796 r0 *1 0,0
Xsg13cmos5l_decap_8_796 VPWR VGND sg13cmos5l_decap_8
* cell instance sg13cmos5l_decap_8_797 r0 *1 0,0
Xsg13cmos5l_decap_8_797 VPWR VGND sg13cmos5l_decap_8
* cell instance sg13cmos5l_decap_8_798 r0 *1 0,0
Xsg13cmos5l_decap_8_798 VPWR VGND sg13cmos5l_decap_8
* cell instance sg13cmos5l_decap_8_799 r0 *1 0,0
Xsg13cmos5l_decap_8_799 VPWR VGND sg13cmos5l_decap_8
* cell instance sg13cmos5l_decap_8_800 r0 *1 0,0
Xsg13cmos5l_decap_8_800 VPWR VGND sg13cmos5l_decap_8
* cell instance sg13cmos5l_decap_8_801 r0 *1 0,0
Xsg13cmos5l_decap_8_801 VPWR VGND sg13cmos5l_decap_8
* cell instance sg13cmos5l_decap_8_802 r0 *1 0,0
Xsg13cmos5l_decap_8_802 VPWR VGND sg13cmos5l_decap_8
* cell instance sg13cmos5l_decap_8_803 r0 *1 0,0
Xsg13cmos5l_decap_8_803 VPWR VGND sg13cmos5l_decap_8
* cell instance sg13cmos5l_decap_8_804 r0 *1 0,0
Xsg13cmos5l_decap_8_804 VPWR VGND sg13cmos5l_decap_8
* cell instance sg13cmos5l_decap_8_805 r0 *1 0,0
Xsg13cmos5l_decap_8_805 VPWR VGND sg13cmos5l_decap_8
* cell instance sg13cmos5l_decap_8_806 r0 *1 0,0
Xsg13cmos5l_decap_8_806 VPWR VGND sg13cmos5l_decap_8
* cell instance sg13cmos5l_decap_8_807 r0 *1 0,0
Xsg13cmos5l_decap_8_807 VPWR VGND sg13cmos5l_decap_8
* cell instance sg13cmos5l_decap_8_808 r0 *1 0,0
Xsg13cmos5l_decap_8_808 VPWR VGND sg13cmos5l_decap_8
* cell instance sg13cmos5l_decap_8_809 r0 *1 0,0
Xsg13cmos5l_decap_8_809 VPWR VGND sg13cmos5l_decap_8
* cell instance sg13cmos5l_decap_8_810 r0 *1 0,0
Xsg13cmos5l_decap_8_810 VPWR VGND sg13cmos5l_decap_8
* cell instance sg13cmos5l_decap_8_811 r0 *1 0,0
Xsg13cmos5l_decap_8_811 VPWR VGND sg13cmos5l_decap_8
* cell instance sg13cmos5l_decap_8_812 r0 *1 0,0
Xsg13cmos5l_decap_8_812 VPWR VGND sg13cmos5l_decap_8
* cell instance sg13cmos5l_decap_8_813 r0 *1 0,0
Xsg13cmos5l_decap_8_813 VPWR VGND sg13cmos5l_decap_8
* cell instance sg13cmos5l_decap_8_814 r0 *1 0,0
Xsg13cmos5l_decap_8_814 VPWR VGND sg13cmos5l_decap_8
* cell instance sg13cmos5l_decap_8_815 r0 *1 0,0
Xsg13cmos5l_decap_8_815 VPWR VGND sg13cmos5l_decap_8
* cell instance sg13cmos5l_decap_8_816 r0 *1 0,0
Xsg13cmos5l_decap_8_816 VPWR VGND sg13cmos5l_decap_8
* cell instance sg13cmos5l_decap_8_817 r0 *1 0,0
Xsg13cmos5l_decap_8_817 VPWR VGND sg13cmos5l_decap_8
* cell instance sg13cmos5l_decap_8_818 r0 *1 0,0
Xsg13cmos5l_decap_8_818 VPWR VGND sg13cmos5l_decap_8
* cell instance sg13cmos5l_decap_8_819 r0 *1 0,0
Xsg13cmos5l_decap_8_819 VPWR VGND sg13cmos5l_decap_8
* cell instance sg13cmos5l_decap_8_820 r0 *1 0,0
Xsg13cmos5l_decap_8_820 VPWR VGND sg13cmos5l_decap_8
* cell instance sg13cmos5l_decap_8_821 r0 *1 0,0
Xsg13cmos5l_decap_8_821 VPWR VGND sg13cmos5l_decap_8
* cell instance sg13cmos5l_decap_8_822 r0 *1 0,0
Xsg13cmos5l_decap_8_822 VPWR VGND sg13cmos5l_decap_8
* cell instance sg13cmos5l_decap_8_823 r0 *1 0,0
Xsg13cmos5l_decap_8_823 VPWR VGND sg13cmos5l_decap_8
* cell instance sg13cmos5l_decap_8_824 r0 *1 0,0
Xsg13cmos5l_decap_8_824 VPWR VGND sg13cmos5l_decap_8
* cell instance sg13cmos5l_decap_8_825 r0 *1 0,0
Xsg13cmos5l_decap_8_825 VPWR VGND sg13cmos5l_decap_8
* cell instance sg13cmos5l_decap_8_826 r0 *1 0,0
Xsg13cmos5l_decap_8_826 VPWR VGND sg13cmos5l_decap_8
* cell instance sg13cmos5l_decap_8_827 r0 *1 0,0
Xsg13cmos5l_decap_8_827 VPWR VGND sg13cmos5l_decap_8
* cell instance sg13cmos5l_decap_8_828 r0 *1 0,0
Xsg13cmos5l_decap_8_828 VPWR VGND sg13cmos5l_decap_8
* cell instance sg13cmos5l_decap_8_829 r0 *1 0,0
Xsg13cmos5l_decap_8_829 VPWR VGND sg13cmos5l_decap_8
* cell instance sg13cmos5l_decap_8_830 r0 *1 0,0
Xsg13cmos5l_decap_8_830 VPWR VGND sg13cmos5l_decap_8
* cell instance sg13cmos5l_decap_8_831 r0 *1 0,0
Xsg13cmos5l_decap_8_831 VPWR VGND sg13cmos5l_decap_8
* cell instance sg13cmos5l_decap_8_832 r0 *1 0,0
Xsg13cmos5l_decap_8_832 VPWR VGND sg13cmos5l_decap_8
* cell instance sg13cmos5l_decap_8_833 r0 *1 0,0
Xsg13cmos5l_decap_8_833 VPWR VGND sg13cmos5l_decap_8
* cell instance sg13cmos5l_decap_8_834 r0 *1 0,0
Xsg13cmos5l_decap_8_834 VPWR VGND sg13cmos5l_decap_8
* cell instance sg13cmos5l_decap_8_835 r0 *1 0,0
Xsg13cmos5l_decap_8_835 VPWR VGND sg13cmos5l_decap_8
* cell instance sg13cmos5l_decap_8_836 r0 *1 0,0
Xsg13cmos5l_decap_8_836 VPWR VGND sg13cmos5l_decap_8
* cell instance sg13cmos5l_decap_8_837 r0 *1 0,0
Xsg13cmos5l_decap_8_837 VPWR VGND sg13cmos5l_decap_8
* cell instance sg13cmos5l_decap_8_838 r0 *1 0,0
Xsg13cmos5l_decap_8_838 VPWR VGND sg13cmos5l_decap_8
* cell instance sg13cmos5l_decap_8_839 r0 *1 0,0
Xsg13cmos5l_decap_8_839 VPWR VGND sg13cmos5l_decap_8
* cell instance sg13cmos5l_decap_8_840 r0 *1 0,0
Xsg13cmos5l_decap_8_840 VPWR VGND sg13cmos5l_decap_8
* cell instance sg13cmos5l_decap_8_841 r0 *1 0,0
Xsg13cmos5l_decap_8_841 VPWR VGND sg13cmos5l_decap_8
* cell instance sg13cmos5l_decap_8_842 r0 *1 0,0
Xsg13cmos5l_decap_8_842 VPWR VGND sg13cmos5l_decap_8
* cell instance sg13cmos5l_decap_8_843 r0 *1 0,0
Xsg13cmos5l_decap_8_843 VPWR VGND sg13cmos5l_decap_8
* cell instance sg13cmos5l_decap_8_844 r0 *1 0,0
Xsg13cmos5l_decap_8_844 VPWR VGND sg13cmos5l_decap_8
* cell instance sg13cmos5l_decap_8_845 r0 *1 0,0
Xsg13cmos5l_decap_8_845 VPWR VGND sg13cmos5l_decap_8
* cell instance sg13cmos5l_decap_8_846 r0 *1 0,0
Xsg13cmos5l_decap_8_846 VPWR VGND sg13cmos5l_decap_8
* cell instance sg13cmos5l_decap_8_847 r0 *1 0,0
Xsg13cmos5l_decap_8_847 VPWR VGND sg13cmos5l_decap_8
* cell instance sg13cmos5l_decap_8_848 r0 *1 0,0
Xsg13cmos5l_decap_8_848 VPWR VGND sg13cmos5l_decap_8
* cell instance sg13cmos5l_decap_8_849 r0 *1 0,0
Xsg13cmos5l_decap_8_849 VPWR VGND sg13cmos5l_decap_8
* cell instance sg13cmos5l_decap_8_850 r0 *1 0,0
Xsg13cmos5l_decap_8_850 VPWR VGND sg13cmos5l_decap_8
* cell instance sg13cmos5l_decap_8_851 r0 *1 0,0
Xsg13cmos5l_decap_8_851 VPWR VGND sg13cmos5l_decap_8
* cell instance sg13cmos5l_decap_8_852 r0 *1 0,0
Xsg13cmos5l_decap_8_852 VPWR VGND sg13cmos5l_decap_8
* cell instance sg13cmos5l_decap_8_853 r0 *1 0,0
Xsg13cmos5l_decap_8_853 VPWR VGND sg13cmos5l_decap_8
* cell instance sg13cmos5l_decap_8_854 r0 *1 0,0
Xsg13cmos5l_decap_8_854 VPWR VGND sg13cmos5l_decap_8
* cell instance sg13cmos5l_decap_8_855 r0 *1 0,0
Xsg13cmos5l_decap_8_855 VPWR VGND sg13cmos5l_decap_8
* cell instance sg13cmos5l_decap_8_856 r0 *1 0,0
Xsg13cmos5l_decap_8_856 VPWR VGND sg13cmos5l_decap_8
* cell instance sg13cmos5l_decap_8_857 r0 *1 0,0
Xsg13cmos5l_decap_8_857 VPWR VGND sg13cmos5l_decap_8
* cell instance sg13cmos5l_decap_8_858 r0 *1 0,0
Xsg13cmos5l_decap_8_858 VPWR VGND sg13cmos5l_decap_8
* cell instance sg13cmos5l_decap_8_859 r0 *1 0,0
Xsg13cmos5l_decap_8_859 VPWR VGND sg13cmos5l_decap_8
* cell instance sg13cmos5l_decap_8_860 r0 *1 0,0
Xsg13cmos5l_decap_8_860 VPWR VGND sg13cmos5l_decap_8
* cell instance sg13cmos5l_decap_8_861 r0 *1 0,0
Xsg13cmos5l_decap_8_861 VPWR VGND sg13cmos5l_decap_8
* cell instance sg13cmos5l_decap_8_862 r0 *1 0,0
Xsg13cmos5l_decap_8_862 VPWR VGND sg13cmos5l_decap_8
* cell instance sg13cmos5l_decap_8_863 r0 *1 0,0
Xsg13cmos5l_decap_8_863 VPWR VGND sg13cmos5l_decap_8
* cell instance sg13cmos5l_decap_8_864 r0 *1 0,0
Xsg13cmos5l_decap_8_864 VPWR VGND sg13cmos5l_decap_8
* cell instance sg13cmos5l_decap_8_865 r0 *1 0,0
Xsg13cmos5l_decap_8_865 VPWR VGND sg13cmos5l_decap_8
* cell instance sg13cmos5l_decap_8_866 r0 *1 0,0
Xsg13cmos5l_decap_8_866 VPWR VGND sg13cmos5l_decap_8
* cell instance sg13cmos5l_decap_8_867 r0 *1 0,0
Xsg13cmos5l_decap_8_867 VPWR VGND sg13cmos5l_decap_8
* cell instance sg13cmos5l_decap_8_868 r0 *1 0,0
Xsg13cmos5l_decap_8_868 VPWR VGND sg13cmos5l_decap_8
* cell instance sg13cmos5l_decap_8_869 r0 *1 0,0
Xsg13cmos5l_decap_8_869 VPWR VGND sg13cmos5l_decap_8
* cell instance sg13cmos5l_decap_8_870 r0 *1 0,0
Xsg13cmos5l_decap_8_870 VPWR VGND sg13cmos5l_decap_8
* cell instance sg13cmos5l_decap_8_871 r0 *1 0,0
Xsg13cmos5l_decap_8_871 VPWR VGND sg13cmos5l_decap_8
* cell instance sg13cmos5l_decap_8_872 r0 *1 0,0
Xsg13cmos5l_decap_8_872 VPWR VGND sg13cmos5l_decap_8
* cell instance sg13cmos5l_decap_8_873 r0 *1 0,0
Xsg13cmos5l_decap_8_873 VPWR VGND sg13cmos5l_decap_8
* cell instance sg13cmos5l_decap_8_874 r0 *1 0,0
Xsg13cmos5l_decap_8_874 VPWR VGND sg13cmos5l_decap_8
* cell instance sg13cmos5l_decap_8_875 r0 *1 0,0
Xsg13cmos5l_decap_8_875 VPWR VGND sg13cmos5l_decap_8
* cell instance sg13cmos5l_decap_8_876 r0 *1 0,0
Xsg13cmos5l_decap_8_876 VPWR VGND sg13cmos5l_decap_8
* cell instance sg13cmos5l_decap_8_877 r0 *1 0,0
Xsg13cmos5l_decap_8_877 VPWR VGND sg13cmos5l_decap_8
* cell instance sg13cmos5l_decap_8_878 r0 *1 0,0
Xsg13cmos5l_decap_8_878 VPWR VGND sg13cmos5l_decap_8
* cell instance sg13cmos5l_decap_8_879 r0 *1 0,0
Xsg13cmos5l_decap_8_879 VPWR VGND sg13cmos5l_decap_8
* cell instance sg13cmos5l_decap_8_880 r0 *1 0,0
Xsg13cmos5l_decap_8_880 VPWR VGND sg13cmos5l_decap_8
* cell instance sg13cmos5l_decap_8_881 r0 *1 0,0
Xsg13cmos5l_decap_8_881 VPWR VGND sg13cmos5l_decap_8
* cell instance sg13cmos5l_decap_8_882 r0 *1 0,0
Xsg13cmos5l_decap_8_882 VPWR VGND sg13cmos5l_decap_8
* cell instance sg13cmos5l_decap_8_883 r0 *1 0,0
Xsg13cmos5l_decap_8_883 VPWR VGND sg13cmos5l_decap_8
* cell instance sg13cmos5l_decap_8_884 r0 *1 0,0
Xsg13cmos5l_decap_8_884 VPWR VGND sg13cmos5l_decap_8
* cell instance sg13cmos5l_decap_8_885 r0 *1 0,0
Xsg13cmos5l_decap_8_885 VPWR VGND sg13cmos5l_decap_8
* cell instance sg13cmos5l_decap_8_886 r0 *1 0,0
Xsg13cmos5l_decap_8_886 VPWR VGND sg13cmos5l_decap_8
* cell instance sg13cmos5l_decap_8_887 r0 *1 0,0
Xsg13cmos5l_decap_8_887 VPWR VGND sg13cmos5l_decap_8
* cell instance sg13cmos5l_decap_8_888 r0 *1 0,0
Xsg13cmos5l_decap_8_888 VPWR VGND sg13cmos5l_decap_8
* cell instance sg13cmos5l_decap_8_889 r0 *1 0,0
Xsg13cmos5l_decap_8_889 VPWR VGND sg13cmos5l_decap_8
* cell instance sg13cmos5l_decap_8_890 r0 *1 0,0
Xsg13cmos5l_decap_8_890 VPWR VGND sg13cmos5l_decap_8
* cell instance sg13cmos5l_decap_8_891 r0 *1 0,0
Xsg13cmos5l_decap_8_891 VPWR VGND sg13cmos5l_decap_8
* cell instance sg13cmos5l_decap_8_892 r0 *1 0,0
Xsg13cmos5l_decap_8_892 VPWR VGND sg13cmos5l_decap_8
* cell instance sg13cmos5l_decap_8_893 r0 *1 0,0
Xsg13cmos5l_decap_8_893 VPWR VGND sg13cmos5l_decap_8
* cell instance sg13cmos5l_decap_8_894 r0 *1 0,0
Xsg13cmos5l_decap_8_894 VPWR VGND sg13cmos5l_decap_8
* cell instance sg13cmos5l_decap_8_895 r0 *1 0,0
Xsg13cmos5l_decap_8_895 VPWR VGND sg13cmos5l_decap_8
* cell instance sg13cmos5l_decap_8_896 r0 *1 0,0
Xsg13cmos5l_decap_8_896 VPWR VGND sg13cmos5l_decap_8
* cell instance sg13cmos5l_decap_8_897 r0 *1 0,0
Xsg13cmos5l_decap_8_897 VPWR VGND sg13cmos5l_decap_8
* cell instance sg13cmos5l_decap_8_898 r0 *1 0,0
Xsg13cmos5l_decap_8_898 VPWR VGND sg13cmos5l_decap_8
* cell instance sg13cmos5l_decap_8_899 r0 *1 0,0
Xsg13cmos5l_decap_8_899 VPWR VGND sg13cmos5l_decap_8
* cell instance sg13cmos5l_decap_8_900 r0 *1 0,0
Xsg13cmos5l_decap_8_900 VPWR VGND sg13cmos5l_decap_8
* cell instance sg13cmos5l_decap_8_901 r0 *1 0,0
Xsg13cmos5l_decap_8_901 VPWR VGND sg13cmos5l_decap_8
* cell instance sg13cmos5l_decap_8_902 r0 *1 0,0
Xsg13cmos5l_decap_8_902 VPWR VGND sg13cmos5l_decap_8
* cell instance sg13cmos5l_decap_8_903 r0 *1 0,0
Xsg13cmos5l_decap_8_903 VPWR VGND sg13cmos5l_decap_8
* cell instance sg13cmos5l_decap_8_904 r0 *1 0,0
Xsg13cmos5l_decap_8_904 VPWR VGND sg13cmos5l_decap_8
* cell instance sg13cmos5l_decap_8_905 r0 *1 0,0
Xsg13cmos5l_decap_8_905 VPWR VGND sg13cmos5l_decap_8
* cell instance sg13cmos5l_decap_8_906 r0 *1 0,0
Xsg13cmos5l_decap_8_906 VPWR VGND sg13cmos5l_decap_8
* cell instance sg13cmos5l_decap_8_907 r0 *1 0,0
Xsg13cmos5l_decap_8_907 VPWR VGND sg13cmos5l_decap_8
* cell instance sg13cmos5l_decap_8_908 r0 *1 0,0
Xsg13cmos5l_decap_8_908 VPWR VGND sg13cmos5l_decap_8
* cell instance sg13cmos5l_decap_8_909 r0 *1 0,0
Xsg13cmos5l_decap_8_909 VPWR VGND sg13cmos5l_decap_8
* cell instance sg13cmos5l_decap_8_910 r0 *1 0,0
Xsg13cmos5l_decap_8_910 VPWR VGND sg13cmos5l_decap_8
* cell instance sg13cmos5l_decap_8_911 r0 *1 0,0
Xsg13cmos5l_decap_8_911 VPWR VGND sg13cmos5l_decap_8
* cell instance sg13cmos5l_decap_8_912 r0 *1 0,0
Xsg13cmos5l_decap_8_912 VPWR VGND sg13cmos5l_decap_8
* cell instance sg13cmos5l_decap_8_913 r0 *1 0,0
Xsg13cmos5l_decap_8_913 VPWR VGND sg13cmos5l_decap_8
* cell instance sg13cmos5l_decap_8_914 r0 *1 0,0
Xsg13cmos5l_decap_8_914 VPWR VGND sg13cmos5l_decap_8
* cell instance sg13cmos5l_decap_8_915 r0 *1 0,0
Xsg13cmos5l_decap_8_915 VPWR VGND sg13cmos5l_decap_8
* cell instance sg13cmos5l_decap_8_916 r0 *1 0,0
Xsg13cmos5l_decap_8_916 VPWR VGND sg13cmos5l_decap_8
* cell instance sg13cmos5l_decap_8_917 r0 *1 0,0
Xsg13cmos5l_decap_8_917 VPWR VGND sg13cmos5l_decap_8
* cell instance sg13cmos5l_decap_8_918 r0 *1 0,0
Xsg13cmos5l_decap_8_918 VPWR VGND sg13cmos5l_decap_8
* cell instance sg13cmos5l_decap_8_919 r0 *1 0,0
Xsg13cmos5l_decap_8_919 VPWR VGND sg13cmos5l_decap_8
* cell instance sg13cmos5l_decap_8_920 r0 *1 0,0
Xsg13cmos5l_decap_8_920 VPWR VGND sg13cmos5l_decap_8
* cell instance sg13cmos5l_decap_8_921 r0 *1 0,0
Xsg13cmos5l_decap_8_921 VPWR VGND sg13cmos5l_decap_8
* cell instance sg13cmos5l_decap_8_922 r0 *1 0,0
Xsg13cmos5l_decap_8_922 VPWR VGND sg13cmos5l_decap_8
* cell instance sg13cmos5l_decap_8_923 r0 *1 0,0
Xsg13cmos5l_decap_8_923 VPWR VGND sg13cmos5l_decap_8
* cell instance sg13cmos5l_decap_8_924 r0 *1 0,0
Xsg13cmos5l_decap_8_924 VPWR VGND sg13cmos5l_decap_8
* cell instance sg13cmos5l_decap_8_925 r0 *1 0,0
Xsg13cmos5l_decap_8_925 VPWR VGND sg13cmos5l_decap_8
* cell instance sg13cmos5l_decap_8_926 r0 *1 0,0
Xsg13cmos5l_decap_8_926 VPWR VGND sg13cmos5l_decap_8
* cell instance sg13cmos5l_decap_8_927 r0 *1 0,0
Xsg13cmos5l_decap_8_927 VPWR VGND sg13cmos5l_decap_8
* cell instance sg13cmos5l_decap_8_928 r0 *1 0,0
Xsg13cmos5l_decap_8_928 VPWR VGND sg13cmos5l_decap_8
* cell instance sg13cmos5l_decap_8_929 r0 *1 0,0
Xsg13cmos5l_decap_8_929 VPWR VGND sg13cmos5l_decap_8
* cell instance sg13cmos5l_decap_8_930 r0 *1 0,0
Xsg13cmos5l_decap_8_930 VPWR VGND sg13cmos5l_decap_8
* cell instance sg13cmos5l_decap_8_931 r0 *1 0,0
Xsg13cmos5l_decap_8_931 VPWR VGND sg13cmos5l_decap_8
* cell instance sg13cmos5l_decap_8_932 r0 *1 0,0
Xsg13cmos5l_decap_8_932 VPWR VGND sg13cmos5l_decap_8
* cell instance sg13cmos5l_decap_8_933 r0 *1 0,0
Xsg13cmos5l_decap_8_933 VPWR VGND sg13cmos5l_decap_8
* cell instance sg13cmos5l_decap_8_934 r0 *1 0,0
Xsg13cmos5l_decap_8_934 VPWR VGND sg13cmos5l_decap_8
* cell instance sg13cmos5l_decap_8_935 r0 *1 0,0
Xsg13cmos5l_decap_8_935 VPWR VGND sg13cmos5l_decap_8
* cell instance sg13cmos5l_decap_8_936 r0 *1 0,0
Xsg13cmos5l_decap_8_936 VPWR VGND sg13cmos5l_decap_8
* cell instance sg13cmos5l_decap_8_937 r0 *1 0,0
Xsg13cmos5l_decap_8_937 VPWR VGND sg13cmos5l_decap_8
* cell instance sg13cmos5l_decap_8_938 r0 *1 0,0
Xsg13cmos5l_decap_8_938 VPWR VGND sg13cmos5l_decap_8
* cell instance sg13cmos5l_decap_8_939 r0 *1 0,0
Xsg13cmos5l_decap_8_939 VPWR VGND sg13cmos5l_decap_8
* cell instance sg13cmos5l_decap_8_940 r0 *1 0,0
Xsg13cmos5l_decap_8_940 VPWR VGND sg13cmos5l_decap_8
* cell instance sg13cmos5l_decap_8_941 r0 *1 0,0
Xsg13cmos5l_decap_8_941 VPWR VGND sg13cmos5l_decap_8
* cell instance sg13cmos5l_decap_8_942 r0 *1 0,0
Xsg13cmos5l_decap_8_942 VPWR VGND sg13cmos5l_decap_8
* cell instance sg13cmos5l_decap_8_943 r0 *1 0,0
Xsg13cmos5l_decap_8_943 VPWR VGND sg13cmos5l_decap_8
* cell instance sg13cmos5l_decap_8_944 r0 *1 0,0
Xsg13cmos5l_decap_8_944 VPWR VGND sg13cmos5l_decap_8
* cell instance sg13cmos5l_decap_8_945 r0 *1 0,0
Xsg13cmos5l_decap_8_945 VPWR VGND sg13cmos5l_decap_8
* cell instance sg13cmos5l_decap_8_946 r0 *1 0,0
Xsg13cmos5l_decap_8_946 VPWR VGND sg13cmos5l_decap_8
* cell instance sg13cmos5l_decap_8_947 r0 *1 0,0
Xsg13cmos5l_decap_8_947 VPWR VGND sg13cmos5l_decap_8
* cell instance sg13cmos5l_decap_8_948 r0 *1 0,0
Xsg13cmos5l_decap_8_948 VPWR VGND sg13cmos5l_decap_8
* cell instance sg13cmos5l_decap_8_949 r0 *1 0,0
Xsg13cmos5l_decap_8_949 VPWR VGND sg13cmos5l_decap_8
* cell instance sg13cmos5l_decap_8_950 r0 *1 0,0
Xsg13cmos5l_decap_8_950 VPWR VGND sg13cmos5l_decap_8
* cell instance sg13cmos5l_decap_8_951 r0 *1 0,0
Xsg13cmos5l_decap_8_951 VPWR VGND sg13cmos5l_decap_8
* cell instance sg13cmos5l_decap_8_952 r0 *1 0,0
Xsg13cmos5l_decap_8_952 VPWR VGND sg13cmos5l_decap_8
* cell instance sg13cmos5l_decap_8_953 r0 *1 0,0
Xsg13cmos5l_decap_8_953 VPWR VGND sg13cmos5l_decap_8
* cell instance sg13cmos5l_decap_8_954 r0 *1 0,0
Xsg13cmos5l_decap_8_954 VPWR VGND sg13cmos5l_decap_8
* cell instance sg13cmos5l_decap_8_955 r0 *1 0,0
Xsg13cmos5l_decap_8_955 VPWR VGND sg13cmos5l_decap_8
* cell instance sg13cmos5l_decap_8_956 r0 *1 0,0
Xsg13cmos5l_decap_8_956 VPWR VGND sg13cmos5l_decap_8
* cell instance sg13cmos5l_decap_8_957 r0 *1 0,0
Xsg13cmos5l_decap_8_957 VPWR VGND sg13cmos5l_decap_8
* cell instance sg13cmos5l_decap_8_958 r0 *1 0,0
Xsg13cmos5l_decap_8_958 VPWR VGND sg13cmos5l_decap_8
* cell instance sg13cmos5l_decap_8_959 r0 *1 0,0
Xsg13cmos5l_decap_8_959 VPWR VGND sg13cmos5l_decap_8
* cell instance sg13cmos5l_decap_8_960 r0 *1 0,0
Xsg13cmos5l_decap_8_960 VPWR VGND sg13cmos5l_decap_8
* cell instance sg13cmos5l_decap_8_961 r0 *1 0,0
Xsg13cmos5l_decap_8_961 VPWR VGND sg13cmos5l_decap_8
* cell instance sg13cmos5l_decap_8_962 r0 *1 0,0
Xsg13cmos5l_decap_8_962 VPWR VGND sg13cmos5l_decap_8
* cell instance sg13cmos5l_decap_8_963 r0 *1 0,0
Xsg13cmos5l_decap_8_963 VPWR VGND sg13cmos5l_decap_8
* cell instance sg13cmos5l_decap_8_964 r0 *1 0,0
Xsg13cmos5l_decap_8_964 VPWR VGND sg13cmos5l_decap_8
* cell instance sg13cmos5l_decap_8_965 r0 *1 0,0
Xsg13cmos5l_decap_8_965 VPWR VGND sg13cmos5l_decap_8
* cell instance sg13cmos5l_decap_8_966 r0 *1 0,0
Xsg13cmos5l_decap_8_966 VPWR VGND sg13cmos5l_decap_8
* cell instance sg13cmos5l_decap_8_967 r0 *1 0,0
Xsg13cmos5l_decap_8_967 VPWR VGND sg13cmos5l_decap_8
* cell instance sg13cmos5l_decap_8_968 r0 *1 0,0
Xsg13cmos5l_decap_8_968 VPWR VGND sg13cmos5l_decap_8
* cell instance sg13cmos5l_decap_8_969 r0 *1 0,0
Xsg13cmos5l_decap_8_969 VPWR VGND sg13cmos5l_decap_8
* cell instance sg13cmos5l_decap_8_970 r0 *1 0,0
Xsg13cmos5l_decap_8_970 VPWR VGND sg13cmos5l_decap_8
* cell instance sg13cmos5l_decap_8_971 r0 *1 0,0
Xsg13cmos5l_decap_8_971 VPWR VGND sg13cmos5l_decap_8
* cell instance sg13cmos5l_decap_8_972 r0 *1 0,0
Xsg13cmos5l_decap_8_972 VPWR VGND sg13cmos5l_decap_8
* cell instance sg13cmos5l_decap_8_973 r0 *1 0,0
Xsg13cmos5l_decap_8_973 VPWR VGND sg13cmos5l_decap_8
* cell instance sg13cmos5l_decap_8_974 r0 *1 0,0
Xsg13cmos5l_decap_8_974 VPWR VGND sg13cmos5l_decap_8
* cell instance sg13cmos5l_decap_8_975 r0 *1 0,0
Xsg13cmos5l_decap_8_975 VPWR VGND sg13cmos5l_decap_8
* cell instance sg13cmos5l_decap_8_976 r0 *1 0,0
Xsg13cmos5l_decap_8_976 VPWR VGND sg13cmos5l_decap_8
* cell instance sg13cmos5l_decap_8_977 r0 *1 0,0
Xsg13cmos5l_decap_8_977 VPWR VGND sg13cmos5l_decap_8
* cell instance sg13cmos5l_decap_8_978 r0 *1 0,0
Xsg13cmos5l_decap_8_978 VPWR VGND sg13cmos5l_decap_8
* cell instance sg13cmos5l_decap_8_979 r0 *1 0,0
Xsg13cmos5l_decap_8_979 VPWR VGND sg13cmos5l_decap_8
* cell instance sg13cmos5l_decap_8_980 r0 *1 0,0
Xsg13cmos5l_decap_8_980 VPWR VGND sg13cmos5l_decap_8
* cell instance sg13cmos5l_decap_8_981 r0 *1 0,0
Xsg13cmos5l_decap_8_981 VPWR VGND sg13cmos5l_decap_8
* cell instance sg13cmos5l_decap_8_982 r0 *1 0,0
Xsg13cmos5l_decap_8_982 VPWR VGND sg13cmos5l_decap_8
* cell instance sg13cmos5l_decap_8_983 r0 *1 0,0
Xsg13cmos5l_decap_8_983 VPWR VGND sg13cmos5l_decap_8
* cell instance sg13cmos5l_decap_8_984 r0 *1 0,0
Xsg13cmos5l_decap_8_984 VPWR VGND sg13cmos5l_decap_8
* cell instance sg13cmos5l_decap_8_985 r0 *1 0,0
Xsg13cmos5l_decap_8_985 VPWR VGND sg13cmos5l_decap_8
* cell instance sg13cmos5l_decap_8_986 r0 *1 0,0
Xsg13cmos5l_decap_8_986 VPWR VGND sg13cmos5l_decap_8
* cell instance sg13cmos5l_decap_8_987 r0 *1 0,0
Xsg13cmos5l_decap_8_987 VPWR VGND sg13cmos5l_decap_8
* cell instance sg13cmos5l_decap_8_988 r0 *1 0,0
Xsg13cmos5l_decap_8_988 VPWR VGND sg13cmos5l_decap_8
* cell instance sg13cmos5l_decap_8_989 r0 *1 0,0
Xsg13cmos5l_decap_8_989 VPWR VGND sg13cmos5l_decap_8
* cell instance sg13cmos5l_decap_8_990 r0 *1 0,0
Xsg13cmos5l_decap_8_990 VPWR VGND sg13cmos5l_decap_8
* cell instance sg13cmos5l_decap_8_991 r0 *1 0,0
Xsg13cmos5l_decap_8_991 VPWR VGND sg13cmos5l_decap_8
* cell instance sg13cmos5l_decap_8_992 r0 *1 0,0
Xsg13cmos5l_decap_8_992 VPWR VGND sg13cmos5l_decap_8
* cell instance sg13cmos5l_decap_8_993 r0 *1 0,0
Xsg13cmos5l_decap_8_993 VPWR VGND sg13cmos5l_decap_8
* cell instance sg13cmos5l_decap_8_994 r0 *1 0,0
Xsg13cmos5l_decap_8_994 VPWR VGND sg13cmos5l_decap_8
* cell instance sg13cmos5l_decap_8_995 r0 *1 0,0
Xsg13cmos5l_decap_8_995 VPWR VGND sg13cmos5l_decap_8
* cell instance sg13cmos5l_decap_8_996 r0 *1 0,0
Xsg13cmos5l_decap_8_996 VPWR VGND sg13cmos5l_decap_8
* cell instance sg13cmos5l_decap_8_997 r0 *1 0,0
Xsg13cmos5l_decap_8_997 VPWR VGND sg13cmos5l_decap_8
* cell instance sg13cmos5l_decap_8_998 r0 *1 0,0
Xsg13cmos5l_decap_8_998 VPWR VGND sg13cmos5l_decap_8
* cell instance sg13cmos5l_decap_8_999 r0 *1 0,0
Xsg13cmos5l_decap_8_999 VPWR VGND sg13cmos5l_decap_8
* cell instance sg13cmos5l_decap_8_1000 r0 *1 0,0
Xsg13cmos5l_decap_8_1000 VPWR VGND sg13cmos5l_decap_8
* cell instance sg13cmos5l_decap_8_1001 r0 *1 0,0
Xsg13cmos5l_decap_8_1001 VPWR VGND sg13cmos5l_decap_8
* cell instance sg13cmos5l_decap_8_1002 r0 *1 0,0
Xsg13cmos5l_decap_8_1002 VPWR VGND sg13cmos5l_decap_8
* cell instance sg13cmos5l_decap_8_1003 r0 *1 0,0
Xsg13cmos5l_decap_8_1003 VPWR VGND sg13cmos5l_decap_8
* cell instance sg13cmos5l_decap_8_1004 r0 *1 0,0
Xsg13cmos5l_decap_8_1004 VPWR VGND sg13cmos5l_decap_8
* cell instance sg13cmos5l_decap_8_1005 r0 *1 0,0
Xsg13cmos5l_decap_8_1005 VPWR VGND sg13cmos5l_decap_8
* cell instance sg13cmos5l_decap_8_1006 r0 *1 0,0
Xsg13cmos5l_decap_8_1006 VPWR VGND sg13cmos5l_decap_8
* cell instance sg13cmos5l_decap_8_1007 r0 *1 0,0
Xsg13cmos5l_decap_8_1007 VPWR VGND sg13cmos5l_decap_8
* cell instance sg13cmos5l_decap_8_1008 r0 *1 0,0
Xsg13cmos5l_decap_8_1008 VPWR VGND sg13cmos5l_decap_8
* cell instance sg13cmos5l_decap_8_1009 r0 *1 0,0
Xsg13cmos5l_decap_8_1009 VPWR VGND sg13cmos5l_decap_8
* cell instance sg13cmos5l_decap_8_1010 r0 *1 0,0
Xsg13cmos5l_decap_8_1010 VPWR VGND sg13cmos5l_decap_8
* cell instance sg13cmos5l_decap_8_1011 r0 *1 0,0
Xsg13cmos5l_decap_8_1011 VPWR VGND sg13cmos5l_decap_8
* cell instance sg13cmos5l_decap_8_1012 r0 *1 0,0
Xsg13cmos5l_decap_8_1012 VPWR VGND sg13cmos5l_decap_8
* cell instance sg13cmos5l_decap_8_1013 r0 *1 0,0
Xsg13cmos5l_decap_8_1013 VPWR VGND sg13cmos5l_decap_8
* cell instance sg13cmos5l_decap_8_1014 r0 *1 0,0
Xsg13cmos5l_decap_8_1014 VPWR VGND sg13cmos5l_decap_8
* cell instance sg13cmos5l_decap_8_1015 r0 *1 0,0
Xsg13cmos5l_decap_8_1015 VPWR VGND sg13cmos5l_decap_8
* cell instance sg13cmos5l_decap_8_1016 r0 *1 0,0
Xsg13cmos5l_decap_8_1016 VPWR VGND sg13cmos5l_decap_8
* cell instance sg13cmos5l_decap_8_1017 r0 *1 0,0
Xsg13cmos5l_decap_8_1017 VPWR VGND sg13cmos5l_decap_8
* cell instance sg13cmos5l_decap_8_1018 r0 *1 0,0
Xsg13cmos5l_decap_8_1018 VPWR VGND sg13cmos5l_decap_8
* cell instance sg13cmos5l_decap_8_1019 r0 *1 0,0
Xsg13cmos5l_decap_8_1019 VPWR VGND sg13cmos5l_decap_8
* cell instance sg13cmos5l_decap_8_1020 r0 *1 0,0
Xsg13cmos5l_decap_8_1020 VPWR VGND sg13cmos5l_decap_8
* cell instance sg13cmos5l_decap_8_1021 r0 *1 0,0
Xsg13cmos5l_decap_8_1021 VPWR VGND sg13cmos5l_decap_8
* cell instance sg13cmos5l_decap_8_1022 r0 *1 0,0
Xsg13cmos5l_decap_8_1022 VPWR VGND sg13cmos5l_decap_8
* cell instance sg13cmos5l_decap_8_1023 r0 *1 0,0
Xsg13cmos5l_decap_8_1023 VPWR VGND sg13cmos5l_decap_8
* cell instance sg13cmos5l_decap_8_1024 r0 *1 0,0
Xsg13cmos5l_decap_8_1024 VPWR VGND sg13cmos5l_decap_8
* cell instance sg13cmos5l_decap_8_1025 r0 *1 0,0
Xsg13cmos5l_decap_8_1025 VPWR VGND sg13cmos5l_decap_8
* cell instance sg13cmos5l_decap_8_1026 r0 *1 0,0
Xsg13cmos5l_decap_8_1026 VPWR VGND sg13cmos5l_decap_8
* cell instance sg13cmos5l_decap_8_1027 r0 *1 0,0
Xsg13cmos5l_decap_8_1027 VPWR VGND sg13cmos5l_decap_8
* cell instance sg13cmos5l_decap_8_1028 r0 *1 0,0
Xsg13cmos5l_decap_8_1028 VPWR VGND sg13cmos5l_decap_8
* cell instance sg13cmos5l_decap_8_1029 r0 *1 0,0
Xsg13cmos5l_decap_8_1029 VPWR VGND sg13cmos5l_decap_8
* cell instance sg13cmos5l_decap_8_1030 r0 *1 0,0
Xsg13cmos5l_decap_8_1030 VPWR VGND sg13cmos5l_decap_8
* cell instance sg13cmos5l_decap_8_1031 r0 *1 0,0
Xsg13cmos5l_decap_8_1031 VPWR VGND sg13cmos5l_decap_8
* cell instance sg13cmos5l_decap_8_1032 r0 *1 0,0
Xsg13cmos5l_decap_8_1032 VPWR VGND sg13cmos5l_decap_8
* cell instance sg13cmos5l_decap_8_1033 r0 *1 0,0
Xsg13cmos5l_decap_8_1033 VPWR VGND sg13cmos5l_decap_8
* cell instance sg13cmos5l_decap_8_1034 r0 *1 0,0
Xsg13cmos5l_decap_8_1034 VPWR VGND sg13cmos5l_decap_8
* cell instance sg13cmos5l_decap_8_1035 r0 *1 0,0
Xsg13cmos5l_decap_8_1035 VPWR VGND sg13cmos5l_decap_8
* cell instance sg13cmos5l_decap_8_1036 r0 *1 0,0
Xsg13cmos5l_decap_8_1036 VPWR VGND sg13cmos5l_decap_8
* cell instance sg13cmos5l_decap_8_1037 r0 *1 0,0
Xsg13cmos5l_decap_8_1037 VPWR VGND sg13cmos5l_decap_8
* cell instance sg13cmos5l_decap_8_1038 r0 *1 0,0
Xsg13cmos5l_decap_8_1038 VPWR VGND sg13cmos5l_decap_8
* cell instance sg13cmos5l_decap_8_1039 r0 *1 0,0
Xsg13cmos5l_decap_8_1039 VPWR VGND sg13cmos5l_decap_8
* cell instance sg13cmos5l_decap_8_1040 r0 *1 0,0
Xsg13cmos5l_decap_8_1040 VPWR VGND sg13cmos5l_decap_8
* cell instance sg13cmos5l_decap_8_1041 r0 *1 0,0
Xsg13cmos5l_decap_8_1041 VPWR VGND sg13cmos5l_decap_8
* cell instance sg13cmos5l_decap_8_1042 r0 *1 0,0
Xsg13cmos5l_decap_8_1042 VPWR VGND sg13cmos5l_decap_8
* cell instance sg13cmos5l_decap_8_1043 r0 *1 0,0
Xsg13cmos5l_decap_8_1043 VPWR VGND sg13cmos5l_decap_8
* cell instance sg13cmos5l_decap_8_1044 r0 *1 0,0
Xsg13cmos5l_decap_8_1044 VPWR VGND sg13cmos5l_decap_8
* cell instance sg13cmos5l_decap_8_1045 r0 *1 0,0
Xsg13cmos5l_decap_8_1045 VPWR VGND sg13cmos5l_decap_8
* cell instance sg13cmos5l_decap_8_1046 r0 *1 0,0
Xsg13cmos5l_decap_8_1046 VPWR VGND sg13cmos5l_decap_8
* cell instance sg13cmos5l_decap_8_1047 r0 *1 0,0
Xsg13cmos5l_decap_8_1047 VPWR VGND sg13cmos5l_decap_8
* cell instance sg13cmos5l_decap_8_1048 r0 *1 0,0
Xsg13cmos5l_decap_8_1048 VPWR VGND sg13cmos5l_decap_8
* cell instance sg13cmos5l_decap_8_1049 r0 *1 0,0
Xsg13cmos5l_decap_8_1049 VPWR VGND sg13cmos5l_decap_8
* cell instance sg13cmos5l_decap_8_1050 r0 *1 0,0
Xsg13cmos5l_decap_8_1050 VPWR VGND sg13cmos5l_decap_8
* cell instance sg13cmos5l_decap_8_1051 r0 *1 0,0
Xsg13cmos5l_decap_8_1051 VPWR VGND sg13cmos5l_decap_8
* cell instance sg13cmos5l_decap_8_1052 r0 *1 0,0
Xsg13cmos5l_decap_8_1052 VPWR VGND sg13cmos5l_decap_8
* cell instance sg13cmos5l_decap_8_1053 r0 *1 0,0
Xsg13cmos5l_decap_8_1053 VPWR VGND sg13cmos5l_decap_8
* cell instance sg13cmos5l_decap_8_1054 r0 *1 0,0
Xsg13cmos5l_decap_8_1054 VPWR VGND sg13cmos5l_decap_8
* cell instance sg13cmos5l_decap_8_1055 r0 *1 0,0
Xsg13cmos5l_decap_8_1055 VPWR VGND sg13cmos5l_decap_8
* cell instance sg13cmos5l_decap_8_1056 r0 *1 0,0
Xsg13cmos5l_decap_8_1056 VPWR VGND sg13cmos5l_decap_8
* cell instance sg13cmos5l_decap_8_1057 r0 *1 0,0
Xsg13cmos5l_decap_8_1057 VPWR VGND sg13cmos5l_decap_8
* cell instance sg13cmos5l_decap_8_1058 r0 *1 0,0
Xsg13cmos5l_decap_8_1058 VPWR VGND sg13cmos5l_decap_8
* cell instance sg13cmos5l_decap_8_1059 r0 *1 0,0
Xsg13cmos5l_decap_8_1059 VPWR VGND sg13cmos5l_decap_8
* cell instance sg13cmos5l_decap_8_1060 r0 *1 0,0
Xsg13cmos5l_decap_8_1060 VPWR VGND sg13cmos5l_decap_8
* cell instance sg13cmos5l_decap_8_1061 r0 *1 0,0
Xsg13cmos5l_decap_8_1061 VPWR VGND sg13cmos5l_decap_8
* cell instance sg13cmos5l_decap_8_1062 r0 *1 0,0
Xsg13cmos5l_decap_8_1062 VPWR VGND sg13cmos5l_decap_8
* cell instance sg13cmos5l_decap_8_1063 r0 *1 0,0
Xsg13cmos5l_decap_8_1063 VPWR VGND sg13cmos5l_decap_8
* cell instance sg13cmos5l_decap_8_1064 r0 *1 0,0
Xsg13cmos5l_decap_8_1064 VPWR VGND sg13cmos5l_decap_8
* cell instance sg13cmos5l_decap_8_1065 r0 *1 0,0
Xsg13cmos5l_decap_8_1065 VPWR VGND sg13cmos5l_decap_8
* cell instance sg13cmos5l_decap_8_1066 r0 *1 0,0
Xsg13cmos5l_decap_8_1066 VPWR VGND sg13cmos5l_decap_8
* cell instance sg13cmos5l_decap_8_1067 r0 *1 0,0
Xsg13cmos5l_decap_8_1067 VPWR VGND sg13cmos5l_decap_8
* cell instance sg13cmos5l_decap_8_1068 r0 *1 0,0
Xsg13cmos5l_decap_8_1068 VPWR VGND sg13cmos5l_decap_8
* cell instance sg13cmos5l_decap_8_1069 r0 *1 0,0
Xsg13cmos5l_decap_8_1069 VPWR VGND sg13cmos5l_decap_8
* cell instance sg13cmos5l_decap_8_1070 r0 *1 0,0
Xsg13cmos5l_decap_8_1070 VPWR VGND sg13cmos5l_decap_8
* cell instance sg13cmos5l_decap_8_1071 r0 *1 0,0
Xsg13cmos5l_decap_8_1071 VPWR VGND sg13cmos5l_decap_8
* cell instance sg13cmos5l_decap_8_1072 r0 *1 0,0
Xsg13cmos5l_decap_8_1072 VPWR VGND sg13cmos5l_decap_8
* cell instance sg13cmos5l_decap_8_1073 r0 *1 0,0
Xsg13cmos5l_decap_8_1073 VPWR VGND sg13cmos5l_decap_8
* cell instance sg13cmos5l_decap_8_1074 r0 *1 0,0
Xsg13cmos5l_decap_8_1074 VPWR VGND sg13cmos5l_decap_8
* cell instance sg13cmos5l_decap_8_1075 r0 *1 0,0
Xsg13cmos5l_decap_8_1075 VPWR VGND sg13cmos5l_decap_8
* cell instance sg13cmos5l_decap_8_1076 r0 *1 0,0
Xsg13cmos5l_decap_8_1076 VPWR VGND sg13cmos5l_decap_8
* cell instance sg13cmos5l_decap_8_1077 r0 *1 0,0
Xsg13cmos5l_decap_8_1077 VPWR VGND sg13cmos5l_decap_8
* cell instance sg13cmos5l_decap_8_1078 r0 *1 0,0
Xsg13cmos5l_decap_8_1078 VPWR VGND sg13cmos5l_decap_8
* cell instance sg13cmos5l_decap_8_1079 r0 *1 0,0
Xsg13cmos5l_decap_8_1079 VPWR VGND sg13cmos5l_decap_8
* cell instance sg13cmos5l_decap_8_1080 r0 *1 0,0
Xsg13cmos5l_decap_8_1080 VPWR VGND sg13cmos5l_decap_8
* cell instance sg13cmos5l_decap_8_1081 r0 *1 0,0
Xsg13cmos5l_decap_8_1081 VPWR VGND sg13cmos5l_decap_8
* cell instance sg13cmos5l_decap_8_1082 r0 *1 0,0
Xsg13cmos5l_decap_8_1082 VPWR VGND sg13cmos5l_decap_8
* cell instance sg13cmos5l_decap_8_1083 r0 *1 0,0
Xsg13cmos5l_decap_8_1083 VPWR VGND sg13cmos5l_decap_8
* cell instance sg13cmos5l_decap_8_1084 r0 *1 0,0
Xsg13cmos5l_decap_8_1084 VPWR VGND sg13cmos5l_decap_8
* cell instance sg13cmos5l_decap_8_1085 r0 *1 0,0
Xsg13cmos5l_decap_8_1085 VPWR VGND sg13cmos5l_decap_8
* cell instance sg13cmos5l_decap_8_1086 r0 *1 0,0
Xsg13cmos5l_decap_8_1086 VPWR VGND sg13cmos5l_decap_8
* cell instance sg13cmos5l_decap_8_1087 r0 *1 0,0
Xsg13cmos5l_decap_8_1087 VPWR VGND sg13cmos5l_decap_8
* cell instance sg13cmos5l_decap_8_1088 r0 *1 0,0
Xsg13cmos5l_decap_8_1088 VPWR VGND sg13cmos5l_decap_8
* cell instance sg13cmos5l_decap_8_1089 r0 *1 0,0
Xsg13cmos5l_decap_8_1089 VPWR VGND sg13cmos5l_decap_8
* cell instance sg13cmos5l_decap_8_1090 r0 *1 0,0
Xsg13cmos5l_decap_8_1090 VPWR VGND sg13cmos5l_decap_8
* cell instance sg13cmos5l_decap_8_1091 r0 *1 0,0
Xsg13cmos5l_decap_8_1091 VPWR VGND sg13cmos5l_decap_8
* cell instance sg13cmos5l_decap_8_1092 r0 *1 0,0
Xsg13cmos5l_decap_8_1092 VPWR VGND sg13cmos5l_decap_8
* cell instance sg13cmos5l_decap_8_1093 r0 *1 0,0
Xsg13cmos5l_decap_8_1093 VPWR VGND sg13cmos5l_decap_8
* cell instance sg13cmos5l_decap_8_1094 r0 *1 0,0
Xsg13cmos5l_decap_8_1094 VPWR VGND sg13cmos5l_decap_8
* cell instance sg13cmos5l_decap_8_1095 r0 *1 0,0
Xsg13cmos5l_decap_8_1095 VPWR VGND sg13cmos5l_decap_8
* cell instance sg13cmos5l_decap_8_1096 r0 *1 0,0
Xsg13cmos5l_decap_8_1096 VPWR VGND sg13cmos5l_decap_8
* cell instance sg13cmos5l_decap_8_1097 r0 *1 0,0
Xsg13cmos5l_decap_8_1097 VPWR VGND sg13cmos5l_decap_8
* cell instance sg13cmos5l_decap_8_1098 r0 *1 0,0
Xsg13cmos5l_decap_8_1098 VPWR VGND sg13cmos5l_decap_8
* cell instance sg13cmos5l_decap_8_1099 r0 *1 0,0
Xsg13cmos5l_decap_8_1099 VPWR VGND sg13cmos5l_decap_8
* cell instance sg13cmos5l_decap_8_1100 r0 *1 0,0
Xsg13cmos5l_decap_8_1100 VPWR VGND sg13cmos5l_decap_8
* cell instance sg13cmos5l_decap_8_1101 r0 *1 0,0
Xsg13cmos5l_decap_8_1101 VPWR VGND sg13cmos5l_decap_8
* cell instance sg13cmos5l_decap_8_1102 r0 *1 0,0
Xsg13cmos5l_decap_8_1102 VPWR VGND sg13cmos5l_decap_8
* cell instance sg13cmos5l_decap_8_1103 r0 *1 0,0
Xsg13cmos5l_decap_8_1103 VPWR VGND sg13cmos5l_decap_8
* cell instance sg13cmos5l_decap_8_1104 r0 *1 0,0
Xsg13cmos5l_decap_8_1104 VPWR VGND sg13cmos5l_decap_8
* cell instance sg13cmos5l_decap_8_1105 r0 *1 0,0
Xsg13cmos5l_decap_8_1105 VPWR VGND sg13cmos5l_decap_8
* cell instance sg13cmos5l_decap_8_1106 r0 *1 0,0
Xsg13cmos5l_decap_8_1106 VPWR VGND sg13cmos5l_decap_8
* cell instance sg13cmos5l_decap_8_1107 r0 *1 0,0
Xsg13cmos5l_decap_8_1107 VPWR VGND sg13cmos5l_decap_8
* cell instance sg13cmos5l_decap_8_1108 r0 *1 0,0
Xsg13cmos5l_decap_8_1108 VPWR VGND sg13cmos5l_decap_8
* cell instance sg13cmos5l_decap_8_1109 r0 *1 0,0
Xsg13cmos5l_decap_8_1109 VPWR VGND sg13cmos5l_decap_8
* cell instance sg13cmos5l_decap_8_1110 r0 *1 0,0
Xsg13cmos5l_decap_8_1110 VPWR VGND sg13cmos5l_decap_8
* cell instance sg13cmos5l_decap_8_1111 r0 *1 0,0
Xsg13cmos5l_decap_8_1111 VPWR VGND sg13cmos5l_decap_8
* cell instance sg13cmos5l_decap_8_1112 r0 *1 0,0
Xsg13cmos5l_decap_8_1112 VPWR VGND sg13cmos5l_decap_8
* cell instance sg13cmos5l_decap_8_1113 r0 *1 0,0
Xsg13cmos5l_decap_8_1113 VPWR VGND sg13cmos5l_decap_8
* cell instance sg13cmos5l_decap_8_1114 r0 *1 0,0
Xsg13cmos5l_decap_8_1114 VPWR VGND sg13cmos5l_decap_8
* cell instance sg13cmos5l_decap_8_1115 r0 *1 0,0
Xsg13cmos5l_decap_8_1115 VPWR VGND sg13cmos5l_decap_8
* cell instance sg13cmos5l_decap_8_1116 r0 *1 0,0
Xsg13cmos5l_decap_8_1116 VPWR VGND sg13cmos5l_decap_8
* cell instance sg13cmos5l_decap_8_1117 r0 *1 0,0
Xsg13cmos5l_decap_8_1117 VPWR VGND sg13cmos5l_decap_8
* cell instance sg13cmos5l_decap_8_1118 r0 *1 0,0
Xsg13cmos5l_decap_8_1118 VPWR VGND sg13cmos5l_decap_8
* cell instance sg13cmos5l_decap_8_1119 r0 *1 0,0
Xsg13cmos5l_decap_8_1119 VPWR VGND sg13cmos5l_decap_8
* cell instance sg13cmos5l_decap_8_1120 r0 *1 0,0
Xsg13cmos5l_decap_8_1120 VPWR VGND sg13cmos5l_decap_8
* cell instance sg13cmos5l_decap_8_1121 r0 *1 0,0
Xsg13cmos5l_decap_8_1121 VPWR VGND sg13cmos5l_decap_8
* cell instance sg13cmos5l_decap_8_1122 r0 *1 0,0
Xsg13cmos5l_decap_8_1122 VPWR VGND sg13cmos5l_decap_8
* cell instance sg13cmos5l_decap_8_1123 r0 *1 0,0
Xsg13cmos5l_decap_8_1123 VPWR VGND sg13cmos5l_decap_8
* cell instance sg13cmos5l_decap_8_1124 r0 *1 0,0
Xsg13cmos5l_decap_8_1124 VPWR VGND sg13cmos5l_decap_8
* cell instance sg13cmos5l_decap_8_1125 r0 *1 0,0
Xsg13cmos5l_decap_8_1125 VPWR VGND sg13cmos5l_decap_8
* cell instance sg13cmos5l_decap_8_1126 r0 *1 0,0
Xsg13cmos5l_decap_8_1126 VPWR VGND sg13cmos5l_decap_8
* cell instance sg13cmos5l_decap_8_1127 r0 *1 0,0
Xsg13cmos5l_decap_8_1127 VPWR VGND sg13cmos5l_decap_8
* cell instance sg13cmos5l_decap_8_1128 r0 *1 0,0
Xsg13cmos5l_decap_8_1128 VPWR VGND sg13cmos5l_decap_8
* cell instance sg13cmos5l_decap_8_1129 r0 *1 0,0
Xsg13cmos5l_decap_8_1129 VPWR VGND sg13cmos5l_decap_8
* cell instance sg13cmos5l_decap_8_1130 r0 *1 0,0
Xsg13cmos5l_decap_8_1130 VPWR VGND sg13cmos5l_decap_8
* cell instance sg13cmos5l_decap_8_1131 r0 *1 0,0
Xsg13cmos5l_decap_8_1131 VPWR VGND sg13cmos5l_decap_8
* cell instance sg13cmos5l_decap_8_1132 r0 *1 0,0
Xsg13cmos5l_decap_8_1132 VPWR VGND sg13cmos5l_decap_8
* cell instance sg13cmos5l_decap_8_1133 r0 *1 0,0
Xsg13cmos5l_decap_8_1133 VPWR VGND sg13cmos5l_decap_8
* cell instance sg13cmos5l_decap_8_1134 r0 *1 0,0
Xsg13cmos5l_decap_8_1134 VPWR VGND sg13cmos5l_decap_8
* cell instance sg13cmos5l_decap_8_1135 r0 *1 0,0
Xsg13cmos5l_decap_8_1135 VPWR VGND sg13cmos5l_decap_8
* cell instance sg13cmos5l_decap_8_1136 r0 *1 0,0
Xsg13cmos5l_decap_8_1136 VPWR VGND sg13cmos5l_decap_8
* cell instance sg13cmos5l_decap_8_1137 r0 *1 0,0
Xsg13cmos5l_decap_8_1137 VPWR VGND sg13cmos5l_decap_8
* cell instance sg13cmos5l_decap_8_1138 r0 *1 0,0
Xsg13cmos5l_decap_8_1138 VPWR VGND sg13cmos5l_decap_8
* cell instance sg13cmos5l_decap_8_1139 r0 *1 0,0
Xsg13cmos5l_decap_8_1139 VPWR VGND sg13cmos5l_decap_8
* cell instance sg13cmos5l_decap_8_1140 r0 *1 0,0
Xsg13cmos5l_decap_8_1140 VPWR VGND sg13cmos5l_decap_8
* cell instance sg13cmos5l_decap_8_1141 r0 *1 0,0
Xsg13cmos5l_decap_8_1141 VPWR VGND sg13cmos5l_decap_8
* cell instance sg13cmos5l_decap_8_1142 r0 *1 0,0
Xsg13cmos5l_decap_8_1142 VPWR VGND sg13cmos5l_decap_8
* cell instance sg13cmos5l_decap_8_1143 r0 *1 0,0
Xsg13cmos5l_decap_8_1143 VPWR VGND sg13cmos5l_decap_8
* cell instance sg13cmos5l_decap_8_1144 r0 *1 0,0
Xsg13cmos5l_decap_8_1144 VPWR VGND sg13cmos5l_decap_8
* cell instance sg13cmos5l_decap_8_1145 r0 *1 0,0
Xsg13cmos5l_decap_8_1145 VPWR VGND sg13cmos5l_decap_8
* cell instance sg13cmos5l_decap_8_1146 r0 *1 0,0
Xsg13cmos5l_decap_8_1146 VPWR VGND sg13cmos5l_decap_8
* cell instance sg13cmos5l_decap_8_1147 r0 *1 0,0
Xsg13cmos5l_decap_8_1147 VPWR VGND sg13cmos5l_decap_8
* cell instance sg13cmos5l_decap_8_1148 r0 *1 0,0
Xsg13cmos5l_decap_8_1148 VPWR VGND sg13cmos5l_decap_8
* cell instance sg13cmos5l_decap_8_1149 r0 *1 0,0
Xsg13cmos5l_decap_8_1149 VPWR VGND sg13cmos5l_decap_8
* cell instance sg13cmos5l_decap_8_1150 r0 *1 0,0
Xsg13cmos5l_decap_8_1150 VPWR VGND sg13cmos5l_decap_8
* cell instance sg13cmos5l_decap_8_1151 r0 *1 0,0
Xsg13cmos5l_decap_8_1151 VPWR VGND sg13cmos5l_decap_8
* cell instance sg13cmos5l_decap_8_1152 r0 *1 0,0
Xsg13cmos5l_decap_8_1152 VPWR VGND sg13cmos5l_decap_8
* cell instance sg13cmos5l_decap_8_1153 r0 *1 0,0
Xsg13cmos5l_decap_8_1153 VPWR VGND sg13cmos5l_decap_8
* cell instance sg13cmos5l_decap_8_1154 r0 *1 0,0
Xsg13cmos5l_decap_8_1154 VPWR VGND sg13cmos5l_decap_8
* cell instance sg13cmos5l_decap_8_1155 r0 *1 0,0
Xsg13cmos5l_decap_8_1155 VPWR VGND sg13cmos5l_decap_8
* cell instance sg13cmos5l_decap_8_1156 r0 *1 0,0
Xsg13cmos5l_decap_8_1156 VPWR VGND sg13cmos5l_decap_8
* cell instance sg13cmos5l_decap_8_1157 r0 *1 0,0
Xsg13cmos5l_decap_8_1157 VPWR VGND sg13cmos5l_decap_8
* cell instance sg13cmos5l_decap_8_1158 r0 *1 0,0
Xsg13cmos5l_decap_8_1158 VPWR VGND sg13cmos5l_decap_8
* cell instance sg13cmos5l_decap_8_1159 r0 *1 0,0
Xsg13cmos5l_decap_8_1159 VPWR VGND sg13cmos5l_decap_8
* cell instance sg13cmos5l_decap_8_1160 r0 *1 0,0
Xsg13cmos5l_decap_8_1160 VPWR VGND sg13cmos5l_decap_8
* cell instance sg13cmos5l_decap_8_1161 r0 *1 0,0
Xsg13cmos5l_decap_8_1161 VPWR VGND sg13cmos5l_decap_8
* cell instance sg13cmos5l_decap_8_1162 r0 *1 0,0
Xsg13cmos5l_decap_8_1162 VPWR VGND sg13cmos5l_decap_8
* cell instance sg13cmos5l_decap_8_1163 r0 *1 0,0
Xsg13cmos5l_decap_8_1163 VPWR VGND sg13cmos5l_decap_8
* cell instance sg13cmos5l_decap_8_1164 r0 *1 0,0
Xsg13cmos5l_decap_8_1164 VPWR VGND sg13cmos5l_decap_8
* cell instance sg13cmos5l_decap_8_1165 r0 *1 0,0
Xsg13cmos5l_decap_8_1165 VPWR VGND sg13cmos5l_decap_8
* cell instance sg13cmos5l_decap_8_1166 r0 *1 0,0
Xsg13cmos5l_decap_8_1166 VPWR VGND sg13cmos5l_decap_8
* cell instance sg13cmos5l_decap_8_1167 r0 *1 0,0
Xsg13cmos5l_decap_8_1167 VPWR VGND sg13cmos5l_decap_8
* cell instance sg13cmos5l_decap_8_1168 r0 *1 0,0
Xsg13cmos5l_decap_8_1168 VPWR VGND sg13cmos5l_decap_8
* cell instance sg13cmos5l_decap_8_1169 r0 *1 0,0
Xsg13cmos5l_decap_8_1169 VPWR VGND sg13cmos5l_decap_8
* cell instance sg13cmos5l_decap_8_1170 r0 *1 0,0
Xsg13cmos5l_decap_8_1170 VPWR VGND sg13cmos5l_decap_8
* cell instance sg13cmos5l_decap_8_1171 r0 *1 0,0
Xsg13cmos5l_decap_8_1171 VPWR VGND sg13cmos5l_decap_8
* cell instance sg13cmos5l_decap_8_1172 r0 *1 0,0
Xsg13cmos5l_decap_8_1172 VPWR VGND sg13cmos5l_decap_8
* cell instance sg13cmos5l_decap_8_1173 r0 *1 0,0
Xsg13cmos5l_decap_8_1173 VPWR VGND sg13cmos5l_decap_8
* cell instance sg13cmos5l_decap_8_1174 r0 *1 0,0
Xsg13cmos5l_decap_8_1174 VPWR VGND sg13cmos5l_decap_8
* cell instance sg13cmos5l_decap_8_1175 r0 *1 0,0
Xsg13cmos5l_decap_8_1175 VPWR VGND sg13cmos5l_decap_8
* cell instance sg13cmos5l_decap_8_1176 r0 *1 0,0
Xsg13cmos5l_decap_8_1176 VPWR VGND sg13cmos5l_decap_8
* cell instance sg13cmos5l_decap_8_1177 r0 *1 0,0
Xsg13cmos5l_decap_8_1177 VPWR VGND sg13cmos5l_decap_8
* cell instance sg13cmos5l_decap_8_1178 r0 *1 0,0
Xsg13cmos5l_decap_8_1178 VPWR VGND sg13cmos5l_decap_8
* cell instance sg13cmos5l_decap_8_1179 r0 *1 0,0
Xsg13cmos5l_decap_8_1179 VPWR VGND sg13cmos5l_decap_8
* cell instance sg13cmos5l_decap_8_1180 r0 *1 0,0
Xsg13cmos5l_decap_8_1180 VPWR VGND sg13cmos5l_decap_8
* cell instance sg13cmos5l_decap_8_1181 r0 *1 0,0
Xsg13cmos5l_decap_8_1181 VPWR VGND sg13cmos5l_decap_8
* cell instance sg13cmos5l_decap_8_1182 r0 *1 0,0
Xsg13cmos5l_decap_8_1182 VPWR VGND sg13cmos5l_decap_8
* cell instance sg13cmos5l_decap_8_1183 r0 *1 0,0
Xsg13cmos5l_decap_8_1183 VPWR VGND sg13cmos5l_decap_8
* cell instance sg13cmos5l_decap_8_1184 r0 *1 0,0
Xsg13cmos5l_decap_8_1184 VPWR VGND sg13cmos5l_decap_8
* cell instance sg13cmos5l_decap_8_1185 r0 *1 0,0
Xsg13cmos5l_decap_8_1185 VPWR VGND sg13cmos5l_decap_8
* cell instance sg13cmos5l_decap_8_1186 r0 *1 0,0
Xsg13cmos5l_decap_8_1186 VPWR VGND sg13cmos5l_decap_8
* cell instance sg13cmos5l_decap_8_1187 r0 *1 0,0
Xsg13cmos5l_decap_8_1187 VPWR VGND sg13cmos5l_decap_8
* cell instance sg13cmos5l_decap_8_1188 r0 *1 0,0
Xsg13cmos5l_decap_8_1188 VPWR VGND sg13cmos5l_decap_8
* cell instance sg13cmos5l_decap_8_1189 r0 *1 0,0
Xsg13cmos5l_decap_8_1189 VPWR VGND sg13cmos5l_decap_8
* cell instance sg13cmos5l_decap_8_1190 r0 *1 0,0
Xsg13cmos5l_decap_8_1190 VPWR VGND sg13cmos5l_decap_8
* cell instance sg13cmos5l_decap_8_1191 r0 *1 0,0
Xsg13cmos5l_decap_8_1191 VPWR VGND sg13cmos5l_decap_8
* cell instance sg13cmos5l_decap_8_1192 r0 *1 0,0
Xsg13cmos5l_decap_8_1192 VPWR VGND sg13cmos5l_decap_8
* cell instance sg13cmos5l_decap_8_1193 r0 *1 0,0
Xsg13cmos5l_decap_8_1193 VPWR VGND sg13cmos5l_decap_8
* cell instance sg13cmos5l_decap_8_1194 r0 *1 0,0
Xsg13cmos5l_decap_8_1194 VPWR VGND sg13cmos5l_decap_8
* cell instance sg13cmos5l_decap_8_1195 r0 *1 0,0
Xsg13cmos5l_decap_8_1195 VPWR VGND sg13cmos5l_decap_8
* cell instance sg13cmos5l_decap_8_1196 r0 *1 0,0
Xsg13cmos5l_decap_8_1196 VPWR VGND sg13cmos5l_decap_8
* cell instance sg13cmos5l_decap_8_1197 r0 *1 0,0
Xsg13cmos5l_decap_8_1197 VPWR VGND sg13cmos5l_decap_8
* cell instance sg13cmos5l_decap_8_1198 r0 *1 0,0
Xsg13cmos5l_decap_8_1198 VPWR VGND sg13cmos5l_decap_8
* cell instance sg13cmos5l_decap_8_1199 r0 *1 0,0
Xsg13cmos5l_decap_8_1199 VPWR VGND sg13cmos5l_decap_8
* cell instance sg13cmos5l_decap_8_1200 r0 *1 0,0
Xsg13cmos5l_decap_8_1200 VPWR VGND sg13cmos5l_decap_8
* cell instance sg13cmos5l_decap_8_1201 r0 *1 0,0
Xsg13cmos5l_decap_8_1201 VPWR VGND sg13cmos5l_decap_8
* cell instance sg13cmos5l_decap_8_1202 r0 *1 0,0
Xsg13cmos5l_decap_8_1202 VPWR VGND sg13cmos5l_decap_8
* cell instance sg13cmos5l_decap_8_1203 r0 *1 0,0
Xsg13cmos5l_decap_8_1203 VPWR VGND sg13cmos5l_decap_8
* cell instance sg13cmos5l_decap_8_1204 r0 *1 0,0
Xsg13cmos5l_decap_8_1204 VPWR VGND sg13cmos5l_decap_8
* cell instance sg13cmos5l_decap_8_1205 r0 *1 0,0
Xsg13cmos5l_decap_8_1205 VPWR VGND sg13cmos5l_decap_8
* cell instance sg13cmos5l_decap_8_1206 r0 *1 0,0
Xsg13cmos5l_decap_8_1206 VPWR VGND sg13cmos5l_decap_8
* cell instance sg13cmos5l_decap_8_1207 r0 *1 0,0
Xsg13cmos5l_decap_8_1207 VPWR VGND sg13cmos5l_decap_8
* cell instance sg13cmos5l_decap_8_1208 r0 *1 0,0
Xsg13cmos5l_decap_8_1208 VPWR VGND sg13cmos5l_decap_8
* cell instance sg13cmos5l_decap_8_1209 r0 *1 0,0
Xsg13cmos5l_decap_8_1209 VPWR VGND sg13cmos5l_decap_8
* cell instance sg13cmos5l_decap_8_1210 r0 *1 0,0
Xsg13cmos5l_decap_8_1210 VPWR VGND sg13cmos5l_decap_8
* cell instance sg13cmos5l_decap_8_1211 r0 *1 0,0
Xsg13cmos5l_decap_8_1211 VPWR VGND sg13cmos5l_decap_8
* cell instance sg13cmos5l_decap_8_1212 r0 *1 0,0
Xsg13cmos5l_decap_8_1212 VPWR VGND sg13cmos5l_decap_8
* cell instance sg13cmos5l_decap_8_1213 r0 *1 0,0
Xsg13cmos5l_decap_8_1213 VPWR VGND sg13cmos5l_decap_8
* cell instance sg13cmos5l_decap_8_1214 r0 *1 0,0
Xsg13cmos5l_decap_8_1214 VPWR VGND sg13cmos5l_decap_8
* cell instance sg13cmos5l_decap_8_1215 r0 *1 0,0
Xsg13cmos5l_decap_8_1215 VPWR VGND sg13cmos5l_decap_8
* cell instance sg13cmos5l_decap_8_1216 r0 *1 0,0
Xsg13cmos5l_decap_8_1216 VPWR VGND sg13cmos5l_decap_8
* cell instance sg13cmos5l_decap_8_1217 r0 *1 0,0
Xsg13cmos5l_decap_8_1217 VPWR VGND sg13cmos5l_decap_8
* cell instance sg13cmos5l_decap_8_1218 r0 *1 0,0
Xsg13cmos5l_decap_8_1218 VPWR VGND sg13cmos5l_decap_8
* cell instance sg13cmos5l_decap_8_1219 r0 *1 0,0
Xsg13cmos5l_decap_8_1219 VPWR VGND sg13cmos5l_decap_8
* cell instance sg13cmos5l_decap_8_1220 r0 *1 0,0
Xsg13cmos5l_decap_8_1220 VPWR VGND sg13cmos5l_decap_8
* cell instance sg13cmos5l_decap_8_1221 r0 *1 0,0
Xsg13cmos5l_decap_8_1221 VPWR VGND sg13cmos5l_decap_8
* cell instance sg13cmos5l_decap_8_1222 r0 *1 0,0
Xsg13cmos5l_decap_8_1222 VPWR VGND sg13cmos5l_decap_8
* cell instance sg13cmos5l_decap_8_1223 r0 *1 0,0
Xsg13cmos5l_decap_8_1223 VPWR VGND sg13cmos5l_decap_8
* cell instance sg13cmos5l_decap_8_1224 r0 *1 0,0
Xsg13cmos5l_decap_8_1224 VPWR VGND sg13cmos5l_decap_8
* cell instance sg13cmos5l_decap_8_1225 r0 *1 0,0
Xsg13cmos5l_decap_8_1225 VPWR VGND sg13cmos5l_decap_8
* cell instance sg13cmos5l_decap_8_1226 r0 *1 0,0
Xsg13cmos5l_decap_8_1226 VPWR VGND sg13cmos5l_decap_8
* cell instance sg13cmos5l_decap_8_1227 r0 *1 0,0
Xsg13cmos5l_decap_8_1227 VPWR VGND sg13cmos5l_decap_8
* cell instance sg13cmos5l_decap_8_1228 r0 *1 0,0
Xsg13cmos5l_decap_8_1228 VPWR VGND sg13cmos5l_decap_8
* cell instance sg13cmos5l_decap_8_1229 r0 *1 0,0
Xsg13cmos5l_decap_8_1229 VPWR VGND sg13cmos5l_decap_8
* cell instance sg13cmos5l_decap_8_1230 r0 *1 0,0
Xsg13cmos5l_decap_8_1230 VPWR VGND sg13cmos5l_decap_8
* cell instance sg13cmos5l_decap_8_1231 r0 *1 0,0
Xsg13cmos5l_decap_8_1231 VPWR VGND sg13cmos5l_decap_8
* cell instance sg13cmos5l_decap_8_1232 r0 *1 0,0
Xsg13cmos5l_decap_8_1232 VPWR VGND sg13cmos5l_decap_8
* cell instance sg13cmos5l_decap_8_1233 r0 *1 0,0
Xsg13cmos5l_decap_8_1233 VPWR VGND sg13cmos5l_decap_8
* cell instance sg13cmos5l_decap_8_1234 r0 *1 0,0
Xsg13cmos5l_decap_8_1234 VPWR VGND sg13cmos5l_decap_8
* cell instance sg13cmos5l_decap_8_1235 r0 *1 0,0
Xsg13cmos5l_decap_8_1235 VPWR VGND sg13cmos5l_decap_8
* cell instance sg13cmos5l_decap_8_1236 r0 *1 0,0
Xsg13cmos5l_decap_8_1236 VPWR VGND sg13cmos5l_decap_8
* cell instance sg13cmos5l_decap_8_1237 r0 *1 0,0
Xsg13cmos5l_decap_8_1237 VPWR VGND sg13cmos5l_decap_8
* cell instance sg13cmos5l_decap_8_1238 r0 *1 0,0
Xsg13cmos5l_decap_8_1238 VPWR VGND sg13cmos5l_decap_8
* cell instance sg13cmos5l_decap_8_1239 r0 *1 0,0
Xsg13cmos5l_decap_8_1239 VPWR VGND sg13cmos5l_decap_8
* cell instance sg13cmos5l_decap_8_1240 r0 *1 0,0
Xsg13cmos5l_decap_8_1240 VPWR VGND sg13cmos5l_decap_8
* cell instance sg13cmos5l_decap_8_1241 r0 *1 0,0
Xsg13cmos5l_decap_8_1241 VPWR VGND sg13cmos5l_decap_8
* cell instance sg13cmos5l_decap_8_1242 r0 *1 0,0
Xsg13cmos5l_decap_8_1242 VPWR VGND sg13cmos5l_decap_8
* cell instance sg13cmos5l_decap_8_1243 r0 *1 0,0
Xsg13cmos5l_decap_8_1243 VPWR VGND sg13cmos5l_decap_8
* cell instance sg13cmos5l_decap_8_1244 r0 *1 0,0
Xsg13cmos5l_decap_8_1244 VPWR VGND sg13cmos5l_decap_8
* cell instance sg13cmos5l_decap_8_1245 r0 *1 0,0
Xsg13cmos5l_decap_8_1245 VPWR VGND sg13cmos5l_decap_8
* cell instance sg13cmos5l_decap_8_1246 r0 *1 0,0
Xsg13cmos5l_decap_8_1246 VPWR VGND sg13cmos5l_decap_8
* cell instance sg13cmos5l_decap_8_1247 r0 *1 0,0
Xsg13cmos5l_decap_8_1247 VPWR VGND sg13cmos5l_decap_8
* cell instance sg13cmos5l_decap_8_1248 r0 *1 0,0
Xsg13cmos5l_decap_8_1248 VPWR VGND sg13cmos5l_decap_8
* cell instance sg13cmos5l_decap_8_1249 r0 *1 0,0
Xsg13cmos5l_decap_8_1249 VPWR VGND sg13cmos5l_decap_8
* cell instance sg13cmos5l_decap_8_1250 r0 *1 0,0
Xsg13cmos5l_decap_8_1250 VPWR VGND sg13cmos5l_decap_8
* cell instance sg13cmos5l_decap_8_1251 r0 *1 0,0
Xsg13cmos5l_decap_8_1251 VPWR VGND sg13cmos5l_decap_8
* cell instance sg13cmos5l_decap_8_1252 r0 *1 0,0
Xsg13cmos5l_decap_8_1252 VPWR VGND sg13cmos5l_decap_8
* cell instance sg13cmos5l_decap_8_1253 r0 *1 0,0
Xsg13cmos5l_decap_8_1253 VPWR VGND sg13cmos5l_decap_8
* cell instance sg13cmos5l_decap_8_1254 r0 *1 0,0
Xsg13cmos5l_decap_8_1254 VPWR VGND sg13cmos5l_decap_8
* cell instance sg13cmos5l_decap_8_1255 r0 *1 0,0
Xsg13cmos5l_decap_8_1255 VPWR VGND sg13cmos5l_decap_8
* cell instance sg13cmos5l_decap_8_1256 r0 *1 0,0
Xsg13cmos5l_decap_8_1256 VPWR VGND sg13cmos5l_decap_8
* cell instance sg13cmos5l_decap_8_1257 r0 *1 0,0
Xsg13cmos5l_decap_8_1257 VPWR VGND sg13cmos5l_decap_8
* cell instance sg13cmos5l_decap_8_1258 r0 *1 0,0
Xsg13cmos5l_decap_8_1258 VPWR VGND sg13cmos5l_decap_8
* cell instance sg13cmos5l_decap_8_1259 r0 *1 0,0
Xsg13cmos5l_decap_8_1259 VPWR VGND sg13cmos5l_decap_8
* cell instance sg13cmos5l_decap_8_1260 r0 *1 0,0
Xsg13cmos5l_decap_8_1260 VPWR VGND sg13cmos5l_decap_8
* cell instance sg13cmos5l_decap_8_1261 r0 *1 0,0
Xsg13cmos5l_decap_8_1261 VPWR VGND sg13cmos5l_decap_8
* cell instance sg13cmos5l_decap_8_1262 r0 *1 0,0
Xsg13cmos5l_decap_8_1262 VPWR VGND sg13cmos5l_decap_8
* cell instance sg13cmos5l_decap_8_1263 r0 *1 0,0
Xsg13cmos5l_decap_8_1263 VPWR VGND sg13cmos5l_decap_8
* cell instance sg13cmos5l_decap_8_1264 r0 *1 0,0
Xsg13cmos5l_decap_8_1264 VPWR VGND sg13cmos5l_decap_8
* cell instance sg13cmos5l_decap_8_1265 r0 *1 0,0
Xsg13cmos5l_decap_8_1265 VPWR VGND sg13cmos5l_decap_8
* cell instance sg13cmos5l_decap_8_1266 r0 *1 0,0
Xsg13cmos5l_decap_8_1266 VPWR VGND sg13cmos5l_decap_8
* cell instance sg13cmos5l_decap_8_1267 r0 *1 0,0
Xsg13cmos5l_decap_8_1267 VPWR VGND sg13cmos5l_decap_8
* cell instance sg13cmos5l_decap_8_1268 r0 *1 0,0
Xsg13cmos5l_decap_8_1268 VPWR VGND sg13cmos5l_decap_8
* cell instance sg13cmos5l_decap_8_1269 r0 *1 0,0
Xsg13cmos5l_decap_8_1269 VPWR VGND sg13cmos5l_decap_8
* cell instance sg13cmos5l_decap_8_1270 r0 *1 0,0
Xsg13cmos5l_decap_8_1270 VPWR VGND sg13cmos5l_decap_8
* cell instance sg13cmos5l_decap_8_1271 r0 *1 0,0
Xsg13cmos5l_decap_8_1271 VPWR VGND sg13cmos5l_decap_8
* cell instance sg13cmos5l_decap_8_1272 r0 *1 0,0
Xsg13cmos5l_decap_8_1272 VPWR VGND sg13cmos5l_decap_8
* cell instance sg13cmos5l_decap_8_1273 r0 *1 0,0
Xsg13cmos5l_decap_8_1273 VPWR VGND sg13cmos5l_decap_8
* cell instance sg13cmos5l_decap_8_1274 r0 *1 0,0
Xsg13cmos5l_decap_8_1274 VPWR VGND sg13cmos5l_decap_8
* cell instance sg13cmos5l_decap_8_1275 r0 *1 0,0
Xsg13cmos5l_decap_8_1275 VPWR VGND sg13cmos5l_decap_8
* cell instance sg13cmos5l_decap_8_1276 r0 *1 0,0
Xsg13cmos5l_decap_8_1276 VPWR VGND sg13cmos5l_decap_8
* cell instance sg13cmos5l_decap_8_1277 r0 *1 0,0
Xsg13cmos5l_decap_8_1277 VPWR VGND sg13cmos5l_decap_8
* cell instance sg13cmos5l_decap_8_1278 r0 *1 0,0
Xsg13cmos5l_decap_8_1278 VPWR VGND sg13cmos5l_decap_8
* cell instance sg13cmos5l_decap_8_1279 r0 *1 0,0
Xsg13cmos5l_decap_8_1279 VPWR VGND sg13cmos5l_decap_8
* cell instance sg13cmos5l_decap_8_1280 r0 *1 0,0
Xsg13cmos5l_decap_8_1280 VPWR VGND sg13cmos5l_decap_8
* cell instance sg13cmos5l_decap_8_1281 r0 *1 0,0
Xsg13cmos5l_decap_8_1281 VPWR VGND sg13cmos5l_decap_8
* cell instance sg13cmos5l_decap_8_1282 r0 *1 0,0
Xsg13cmos5l_decap_8_1282 VPWR VGND sg13cmos5l_decap_8
* cell instance sg13cmos5l_decap_8_1283 r0 *1 0,0
Xsg13cmos5l_decap_8_1283 VPWR VGND sg13cmos5l_decap_8
* cell instance sg13cmos5l_decap_8_1284 r0 *1 0,0
Xsg13cmos5l_decap_8_1284 VPWR VGND sg13cmos5l_decap_8
* cell instance sg13cmos5l_decap_8_1285 r0 *1 0,0
Xsg13cmos5l_decap_8_1285 VPWR VGND sg13cmos5l_decap_8
* cell instance sg13cmos5l_decap_8_1286 r0 *1 0,0
Xsg13cmos5l_decap_8_1286 VPWR VGND sg13cmos5l_decap_8
* cell instance sg13cmos5l_decap_8_1287 r0 *1 0,0
Xsg13cmos5l_decap_8_1287 VPWR VGND sg13cmos5l_decap_8
* cell instance sg13cmos5l_decap_8_1288 r0 *1 0,0
Xsg13cmos5l_decap_8_1288 VPWR VGND sg13cmos5l_decap_8
* cell instance sg13cmos5l_decap_8_1289 r0 *1 0,0
Xsg13cmos5l_decap_8_1289 VPWR VGND sg13cmos5l_decap_8
* cell instance sg13cmos5l_decap_8_1290 r0 *1 0,0
Xsg13cmos5l_decap_8_1290 VPWR VGND sg13cmos5l_decap_8
* cell instance sg13cmos5l_decap_8_1291 r0 *1 0,0
Xsg13cmos5l_decap_8_1291 VPWR VGND sg13cmos5l_decap_8
* cell instance sg13cmos5l_decap_8_1292 r0 *1 0,0
Xsg13cmos5l_decap_8_1292 VPWR VGND sg13cmos5l_decap_8
* cell instance sg13cmos5l_decap_8_1293 r0 *1 0,0
Xsg13cmos5l_decap_8_1293 VPWR VGND sg13cmos5l_decap_8
* cell instance sg13cmos5l_decap_8_1294 r0 *1 0,0
Xsg13cmos5l_decap_8_1294 VPWR VGND sg13cmos5l_decap_8
* cell instance sg13cmos5l_decap_8_1295 r0 *1 0,0
Xsg13cmos5l_decap_8_1295 VPWR VGND sg13cmos5l_decap_8
* cell instance sg13cmos5l_decap_8_1296 r0 *1 0,0
Xsg13cmos5l_decap_8_1296 VPWR VGND sg13cmos5l_decap_8
* cell instance sg13cmos5l_decap_8_1297 r0 *1 0,0
Xsg13cmos5l_decap_8_1297 VPWR VGND sg13cmos5l_decap_8
* cell instance sg13cmos5l_decap_8_1298 r0 *1 0,0
Xsg13cmos5l_decap_8_1298 VPWR VGND sg13cmos5l_decap_8
* cell instance sg13cmos5l_decap_8_1299 r0 *1 0,0
Xsg13cmos5l_decap_8_1299 VPWR VGND sg13cmos5l_decap_8
* cell instance sg13cmos5l_decap_8_1300 r0 *1 0,0
Xsg13cmos5l_decap_8_1300 VPWR VGND sg13cmos5l_decap_8
* cell instance sg13cmos5l_decap_8_1301 r0 *1 0,0
Xsg13cmos5l_decap_8_1301 VPWR VGND sg13cmos5l_decap_8
* cell instance sg13cmos5l_decap_8_1302 r0 *1 0,0
Xsg13cmos5l_decap_8_1302 VPWR VGND sg13cmos5l_decap_8
* cell instance sg13cmos5l_decap_8_1303 r0 *1 0,0
Xsg13cmos5l_decap_8_1303 VPWR VGND sg13cmos5l_decap_8
* cell instance sg13cmos5l_decap_8_1304 r0 *1 0,0
Xsg13cmos5l_decap_8_1304 VPWR VGND sg13cmos5l_decap_8
* cell instance sg13cmos5l_decap_8_1305 r0 *1 0,0
Xsg13cmos5l_decap_8_1305 VPWR VGND sg13cmos5l_decap_8
* cell instance sg13cmos5l_decap_8_1306 r0 *1 0,0
Xsg13cmos5l_decap_8_1306 VPWR VGND sg13cmos5l_decap_8
* cell instance sg13cmos5l_decap_8_1307 r0 *1 0,0
Xsg13cmos5l_decap_8_1307 VPWR VGND sg13cmos5l_decap_8
* cell instance sg13cmos5l_decap_8_1308 r0 *1 0,0
Xsg13cmos5l_decap_8_1308 VPWR VGND sg13cmos5l_decap_8
* cell instance sg13cmos5l_decap_8_1309 r0 *1 0,0
Xsg13cmos5l_decap_8_1309 VPWR VGND sg13cmos5l_decap_8
* cell instance sg13cmos5l_decap_8_1310 r0 *1 0,0
Xsg13cmos5l_decap_8_1310 VPWR VGND sg13cmos5l_decap_8
* cell instance sg13cmos5l_decap_8_1311 r0 *1 0,0
Xsg13cmos5l_decap_8_1311 VPWR VGND sg13cmos5l_decap_8
* cell instance sg13cmos5l_decap_8_1312 r0 *1 0,0
Xsg13cmos5l_decap_8_1312 VPWR VGND sg13cmos5l_decap_8
* cell instance sg13cmos5l_decap_8_1313 r0 *1 0,0
Xsg13cmos5l_decap_8_1313 VPWR VGND sg13cmos5l_decap_8
* cell instance sg13cmos5l_decap_8_1314 r0 *1 0,0
Xsg13cmos5l_decap_8_1314 VPWR VGND sg13cmos5l_decap_8
* cell instance sg13cmos5l_decap_8_1315 r0 *1 0,0
Xsg13cmos5l_decap_8_1315 VPWR VGND sg13cmos5l_decap_8
* cell instance sg13cmos5l_decap_8_1316 r0 *1 0,0
Xsg13cmos5l_decap_8_1316 VPWR VGND sg13cmos5l_decap_8
* cell instance sg13cmos5l_decap_8_1317 r0 *1 0,0
Xsg13cmos5l_decap_8_1317 VPWR VGND sg13cmos5l_decap_8
* cell instance sg13cmos5l_decap_8_1318 r0 *1 0,0
Xsg13cmos5l_decap_8_1318 VPWR VGND sg13cmos5l_decap_8
* cell instance sg13cmos5l_decap_8_1319 r0 *1 0,0
Xsg13cmos5l_decap_8_1319 VPWR VGND sg13cmos5l_decap_8
* cell instance sg13cmos5l_decap_8_1320 r0 *1 0,0
Xsg13cmos5l_decap_8_1320 VPWR VGND sg13cmos5l_decap_8
* cell instance sg13cmos5l_decap_8_1321 r0 *1 0,0
Xsg13cmos5l_decap_8_1321 VPWR VGND sg13cmos5l_decap_8
* cell instance sg13cmos5l_decap_8_1322 r0 *1 0,0
Xsg13cmos5l_decap_8_1322 VPWR VGND sg13cmos5l_decap_8
* cell instance sg13cmos5l_decap_8_1323 r0 *1 0,0
Xsg13cmos5l_decap_8_1323 VPWR VGND sg13cmos5l_decap_8
* cell instance sg13cmos5l_decap_8_1324 r0 *1 0,0
Xsg13cmos5l_decap_8_1324 VPWR VGND sg13cmos5l_decap_8
* cell instance sg13cmos5l_decap_8_1325 r0 *1 0,0
Xsg13cmos5l_decap_8_1325 VPWR VGND sg13cmos5l_decap_8
* cell instance sg13cmos5l_decap_8_1326 r0 *1 0,0
Xsg13cmos5l_decap_8_1326 VPWR VGND sg13cmos5l_decap_8
* cell instance sg13cmos5l_decap_8_1327 r0 *1 0,0
Xsg13cmos5l_decap_8_1327 VPWR VGND sg13cmos5l_decap_8
* cell instance sg13cmos5l_decap_8_1328 r0 *1 0,0
Xsg13cmos5l_decap_8_1328 VPWR VGND sg13cmos5l_decap_8
* cell instance sg13cmos5l_decap_8_1329 r0 *1 0,0
Xsg13cmos5l_decap_8_1329 VPWR VGND sg13cmos5l_decap_8
* cell instance sg13cmos5l_decap_8_1330 r0 *1 0,0
Xsg13cmos5l_decap_8_1330 VPWR VGND sg13cmos5l_decap_8
* cell instance sg13cmos5l_decap_8_1331 r0 *1 0,0
Xsg13cmos5l_decap_8_1331 VPWR VGND sg13cmos5l_decap_8
* cell instance sg13cmos5l_decap_8_1332 r0 *1 0,0
Xsg13cmos5l_decap_8_1332 VPWR VGND sg13cmos5l_decap_8
* cell instance sg13cmos5l_decap_8_1333 r0 *1 0,0
Xsg13cmos5l_decap_8_1333 VPWR VGND sg13cmos5l_decap_8
* cell instance sg13cmos5l_decap_8_1334 r0 *1 0,0
Xsg13cmos5l_decap_8_1334 VPWR VGND sg13cmos5l_decap_8
* cell instance sg13cmos5l_decap_8_1335 r0 *1 0,0
Xsg13cmos5l_decap_8_1335 VPWR VGND sg13cmos5l_decap_8
* cell instance sg13cmos5l_decap_8_1336 r0 *1 0,0
Xsg13cmos5l_decap_8_1336 VPWR VGND sg13cmos5l_decap_8
* cell instance sg13cmos5l_decap_8_1337 r0 *1 0,0
Xsg13cmos5l_decap_8_1337 VPWR VGND sg13cmos5l_decap_8
* cell instance sg13cmos5l_decap_8_1338 r0 *1 0,0
Xsg13cmos5l_decap_8_1338 VPWR VGND sg13cmos5l_decap_8
* cell instance sg13cmos5l_decap_8_1339 r0 *1 0,0
Xsg13cmos5l_decap_8_1339 VPWR VGND sg13cmos5l_decap_8
* cell instance sg13cmos5l_decap_8_1340 r0 *1 0,0
Xsg13cmos5l_decap_8_1340 VPWR VGND sg13cmos5l_decap_8
* cell instance sg13cmos5l_decap_8_1341 r0 *1 0,0
Xsg13cmos5l_decap_8_1341 VPWR VGND sg13cmos5l_decap_8
* cell instance sg13cmos5l_decap_8_1342 r0 *1 0,0
Xsg13cmos5l_decap_8_1342 VPWR VGND sg13cmos5l_decap_8
* cell instance sg13cmos5l_decap_8_1343 r0 *1 0,0
Xsg13cmos5l_decap_8_1343 VPWR VGND sg13cmos5l_decap_8
* cell instance sg13cmos5l_decap_8_1344 r0 *1 0,0
Xsg13cmos5l_decap_8_1344 VPWR VGND sg13cmos5l_decap_8
* cell instance sg13cmos5l_decap_8_1345 r0 *1 0,0
Xsg13cmos5l_decap_8_1345 VPWR VGND sg13cmos5l_decap_8
* cell instance sg13cmos5l_decap_8_1346 r0 *1 0,0
Xsg13cmos5l_decap_8_1346 VPWR VGND sg13cmos5l_decap_8
* cell instance sg13cmos5l_decap_8_1347 r0 *1 0,0
Xsg13cmos5l_decap_8_1347 VPWR VGND sg13cmos5l_decap_8
* cell instance sg13cmos5l_decap_8_1348 r0 *1 0,0
Xsg13cmos5l_decap_8_1348 VPWR VGND sg13cmos5l_decap_8
* cell instance sg13cmos5l_decap_8_1349 r0 *1 0,0
Xsg13cmos5l_decap_8_1349 VPWR VGND sg13cmos5l_decap_8
* cell instance sg13cmos5l_decap_8_1350 r0 *1 0,0
Xsg13cmos5l_decap_8_1350 VPWR VGND sg13cmos5l_decap_8
* cell instance sg13cmos5l_decap_8_1351 r0 *1 0,0
Xsg13cmos5l_decap_8_1351 VPWR VGND sg13cmos5l_decap_8
* cell instance sg13cmos5l_decap_8_1352 r0 *1 0,0
Xsg13cmos5l_decap_8_1352 VPWR VGND sg13cmos5l_decap_8
* cell instance sg13cmos5l_decap_8_1353 r0 *1 0,0
Xsg13cmos5l_decap_8_1353 VPWR VGND sg13cmos5l_decap_8
* cell instance sg13cmos5l_decap_8_1354 r0 *1 0,0
Xsg13cmos5l_decap_8_1354 VPWR VGND sg13cmos5l_decap_8
* cell instance sg13cmos5l_decap_8_1355 r0 *1 0,0
Xsg13cmos5l_decap_8_1355 VPWR VGND sg13cmos5l_decap_8
* cell instance sg13cmos5l_decap_8_1356 r0 *1 0,0
Xsg13cmos5l_decap_8_1356 VPWR VGND sg13cmos5l_decap_8
* cell instance sg13cmos5l_decap_8_1357 r0 *1 0,0
Xsg13cmos5l_decap_8_1357 VPWR VGND sg13cmos5l_decap_8
* cell instance sg13cmos5l_decap_8_1358 r0 *1 0,0
Xsg13cmos5l_decap_8_1358 VPWR VGND sg13cmos5l_decap_8
* cell instance sg13cmos5l_decap_8_1359 r0 *1 0,0
Xsg13cmos5l_decap_8_1359 VPWR VGND sg13cmos5l_decap_8
* cell instance sg13cmos5l_decap_8_1360 r0 *1 0,0
Xsg13cmos5l_decap_8_1360 VPWR VGND sg13cmos5l_decap_8
* cell instance sg13cmos5l_decap_8_1361 r0 *1 0,0
Xsg13cmos5l_decap_8_1361 VPWR VGND sg13cmos5l_decap_8
* cell instance sg13cmos5l_decap_8_1362 r0 *1 0,0
Xsg13cmos5l_decap_8_1362 VPWR VGND sg13cmos5l_decap_8
* cell instance sg13cmos5l_decap_8_1363 r0 *1 0,0
Xsg13cmos5l_decap_8_1363 VPWR VGND sg13cmos5l_decap_8
* cell instance sg13cmos5l_decap_8_1364 r0 *1 0,0
Xsg13cmos5l_decap_8_1364 VPWR VGND sg13cmos5l_decap_8
* cell instance sg13cmos5l_decap_8_1365 r0 *1 0,0
Xsg13cmos5l_decap_8_1365 VPWR VGND sg13cmos5l_decap_8
* cell instance sg13cmos5l_decap_8_1366 r0 *1 0,0
Xsg13cmos5l_decap_8_1366 VPWR VGND sg13cmos5l_decap_8
* cell instance sg13cmos5l_decap_8_1367 r0 *1 0,0
Xsg13cmos5l_decap_8_1367 VPWR VGND sg13cmos5l_decap_8
* cell instance sg13cmos5l_decap_8_1368 r0 *1 0,0
Xsg13cmos5l_decap_8_1368 VPWR VGND sg13cmos5l_decap_8
* cell instance sg13cmos5l_decap_8_1369 r0 *1 0,0
Xsg13cmos5l_decap_8_1369 VPWR VGND sg13cmos5l_decap_8
* cell instance sg13cmos5l_decap_8_1370 r0 *1 0,0
Xsg13cmos5l_decap_8_1370 VPWR VGND sg13cmos5l_decap_8
* cell instance sg13cmos5l_decap_8_1371 r0 *1 0,0
Xsg13cmos5l_decap_8_1371 VPWR VGND sg13cmos5l_decap_8
* cell instance sg13cmos5l_decap_8_1372 r0 *1 0,0
Xsg13cmos5l_decap_8_1372 VPWR VGND sg13cmos5l_decap_8
* cell instance sg13cmos5l_decap_8_1373 r0 *1 0,0
Xsg13cmos5l_decap_8_1373 VPWR VGND sg13cmos5l_decap_8
* cell instance sg13cmos5l_decap_8_1374 r0 *1 0,0
Xsg13cmos5l_decap_8_1374 VPWR VGND sg13cmos5l_decap_8
* cell instance sg13cmos5l_decap_8_1375 r0 *1 0,0
Xsg13cmos5l_decap_8_1375 VPWR VGND sg13cmos5l_decap_8
* cell instance sg13cmos5l_decap_8_1376 r0 *1 0,0
Xsg13cmos5l_decap_8_1376 VPWR VGND sg13cmos5l_decap_8
* cell instance sg13cmos5l_decap_8_1377 r0 *1 0,0
Xsg13cmos5l_decap_8_1377 VPWR VGND sg13cmos5l_decap_8
* cell instance sg13cmos5l_decap_8_1378 r0 *1 0,0
Xsg13cmos5l_decap_8_1378 VPWR VGND sg13cmos5l_decap_8
* cell instance sg13cmos5l_decap_8_1379 r0 *1 0,0
Xsg13cmos5l_decap_8_1379 VPWR VGND sg13cmos5l_decap_8
* cell instance sg13cmos5l_decap_8_1380 r0 *1 0,0
Xsg13cmos5l_decap_8_1380 VPWR VGND sg13cmos5l_decap_8
* cell instance sg13cmos5l_decap_8_1381 r0 *1 0,0
Xsg13cmos5l_decap_8_1381 VPWR VGND sg13cmos5l_decap_8
* cell instance sg13cmos5l_decap_8_1382 r0 *1 0,0
Xsg13cmos5l_decap_8_1382 VPWR VGND sg13cmos5l_decap_8
* cell instance sg13cmos5l_decap_8_1383 r0 *1 0,0
Xsg13cmos5l_decap_8_1383 VPWR VGND sg13cmos5l_decap_8
* cell instance sg13cmos5l_decap_8_1384 r0 *1 0,0
Xsg13cmos5l_decap_8_1384 VPWR VGND sg13cmos5l_decap_8
* cell instance sg13cmos5l_decap_8_1385 r0 *1 0,0
Xsg13cmos5l_decap_8_1385 VPWR VGND sg13cmos5l_decap_8
* cell instance sg13cmos5l_decap_8_1386 r0 *1 0,0
Xsg13cmos5l_decap_8_1386 VPWR VGND sg13cmos5l_decap_8
* cell instance sg13cmos5l_decap_8_1387 r0 *1 0,0
Xsg13cmos5l_decap_8_1387 VPWR VGND sg13cmos5l_decap_8
* cell instance sg13cmos5l_decap_8_1388 r0 *1 0,0
Xsg13cmos5l_decap_8_1388 VPWR VGND sg13cmos5l_decap_8
* cell instance sg13cmos5l_decap_8_1389 r0 *1 0,0
Xsg13cmos5l_decap_8_1389 VPWR VGND sg13cmos5l_decap_8
* cell instance sg13cmos5l_decap_8_1390 r0 *1 0,0
Xsg13cmos5l_decap_8_1390 VPWR VGND sg13cmos5l_decap_8
* cell instance sg13cmos5l_decap_8_1391 r0 *1 0,0
Xsg13cmos5l_decap_8_1391 VPWR VGND sg13cmos5l_decap_8
* cell instance sg13cmos5l_decap_8_1392 r0 *1 0,0
Xsg13cmos5l_decap_8_1392 VPWR VGND sg13cmos5l_decap_8
* cell instance sg13cmos5l_decap_8_1393 r0 *1 0,0
Xsg13cmos5l_decap_8_1393 VPWR VGND sg13cmos5l_decap_8
* cell instance sg13cmos5l_decap_8_1394 r0 *1 0,0
Xsg13cmos5l_decap_8_1394 VPWR VGND sg13cmos5l_decap_8
* cell instance sg13cmos5l_decap_8_1395 r0 *1 0,0
Xsg13cmos5l_decap_8_1395 VPWR VGND sg13cmos5l_decap_8
* cell instance sg13cmos5l_decap_8_1396 r0 *1 0,0
Xsg13cmos5l_decap_8_1396 VPWR VGND sg13cmos5l_decap_8
* cell instance sg13cmos5l_decap_8_1397 r0 *1 0,0
Xsg13cmos5l_decap_8_1397 VPWR VGND sg13cmos5l_decap_8
* cell instance sg13cmos5l_decap_8_1398 r0 *1 0,0
Xsg13cmos5l_decap_8_1398 VPWR VGND sg13cmos5l_decap_8
* cell instance sg13cmos5l_decap_8_1399 r0 *1 0,0
Xsg13cmos5l_decap_8_1399 VPWR VGND sg13cmos5l_decap_8
* cell instance sg13cmos5l_decap_8_1400 r0 *1 0,0
Xsg13cmos5l_decap_8_1400 VPWR VGND sg13cmos5l_decap_8
* cell instance sg13cmos5l_decap_8_1401 r0 *1 0,0
Xsg13cmos5l_decap_8_1401 VPWR VGND sg13cmos5l_decap_8
* cell instance sg13cmos5l_decap_8_1402 r0 *1 0,0
Xsg13cmos5l_decap_8_1402 VPWR VGND sg13cmos5l_decap_8
* cell instance sg13cmos5l_decap_8_1403 r0 *1 0,0
Xsg13cmos5l_decap_8_1403 VPWR VGND sg13cmos5l_decap_8
* cell instance sg13cmos5l_decap_8_1404 r0 *1 0,0
Xsg13cmos5l_decap_8_1404 VPWR VGND sg13cmos5l_decap_8
* cell instance sg13cmos5l_decap_8_1405 r0 *1 0,0
Xsg13cmos5l_decap_8_1405 VPWR VGND sg13cmos5l_decap_8
* cell instance sg13cmos5l_decap_8_1406 r0 *1 0,0
Xsg13cmos5l_decap_8_1406 VPWR VGND sg13cmos5l_decap_8
* cell instance sg13cmos5l_decap_8_1407 r0 *1 0,0
Xsg13cmos5l_decap_8_1407 VPWR VGND sg13cmos5l_decap_8
* cell instance sg13cmos5l_decap_8_1408 r0 *1 0,0
Xsg13cmos5l_decap_8_1408 VPWR VGND sg13cmos5l_decap_8
* cell instance sg13cmos5l_decap_8_1409 r0 *1 0,0
Xsg13cmos5l_decap_8_1409 VPWR VGND sg13cmos5l_decap_8
* cell instance sg13cmos5l_decap_8_1410 r0 *1 0,0
Xsg13cmos5l_decap_8_1410 VPWR VGND sg13cmos5l_decap_8
* cell instance sg13cmos5l_decap_8_1411 r0 *1 0,0
Xsg13cmos5l_decap_8_1411 VPWR VGND sg13cmos5l_decap_8
* cell instance sg13cmos5l_decap_8_1412 r0 *1 0,0
Xsg13cmos5l_decap_8_1412 VPWR VGND sg13cmos5l_decap_8
* cell instance sg13cmos5l_decap_8_1413 r0 *1 0,0
Xsg13cmos5l_decap_8_1413 VPWR VGND sg13cmos5l_decap_8
* cell instance sg13cmos5l_decap_8_1414 r0 *1 0,0
Xsg13cmos5l_decap_8_1414 VPWR VGND sg13cmos5l_decap_8
* cell instance sg13cmos5l_decap_8_1415 r0 *1 0,0
Xsg13cmos5l_decap_8_1415 VPWR VGND sg13cmos5l_decap_8
* cell instance sg13cmos5l_decap_8_1416 r0 *1 0,0
Xsg13cmos5l_decap_8_1416 VPWR VGND sg13cmos5l_decap_8
* cell instance sg13cmos5l_decap_8_1417 r0 *1 0,0
Xsg13cmos5l_decap_8_1417 VPWR VGND sg13cmos5l_decap_8
* cell instance sg13cmos5l_decap_8_1418 r0 *1 0,0
Xsg13cmos5l_decap_8_1418 VPWR VGND sg13cmos5l_decap_8
* cell instance sg13cmos5l_decap_8_1419 r0 *1 0,0
Xsg13cmos5l_decap_8_1419 VPWR VGND sg13cmos5l_decap_8
* cell instance sg13cmos5l_decap_8_1420 r0 *1 0,0
Xsg13cmos5l_decap_8_1420 VPWR VGND sg13cmos5l_decap_8
* cell instance sg13cmos5l_decap_8_1421 r0 *1 0,0
Xsg13cmos5l_decap_8_1421 VPWR VGND sg13cmos5l_decap_8
* cell instance sg13cmos5l_decap_8_1422 r0 *1 0,0
Xsg13cmos5l_decap_8_1422 VPWR VGND sg13cmos5l_decap_8
* cell instance sg13cmos5l_decap_8_1423 r0 *1 0,0
Xsg13cmos5l_decap_8_1423 VPWR VGND sg13cmos5l_decap_8
* cell instance sg13cmos5l_decap_8_1424 r0 *1 0,0
Xsg13cmos5l_decap_8_1424 VPWR VGND sg13cmos5l_decap_8
* cell instance sg13cmos5l_decap_8_1425 r0 *1 0,0
Xsg13cmos5l_decap_8_1425 VPWR VGND sg13cmos5l_decap_8
* cell instance sg13cmos5l_decap_8_1426 r0 *1 0,0
Xsg13cmos5l_decap_8_1426 VPWR VGND sg13cmos5l_decap_8
* cell instance sg13cmos5l_decap_8_1427 r0 *1 0,0
Xsg13cmos5l_decap_8_1427 VPWR VGND sg13cmos5l_decap_8
* cell instance sg13cmos5l_decap_8_1428 r0 *1 0,0
Xsg13cmos5l_decap_8_1428 VPWR VGND sg13cmos5l_decap_8
* cell instance sg13cmos5l_decap_8_1429 r0 *1 0,0
Xsg13cmos5l_decap_8_1429 VPWR VGND sg13cmos5l_decap_8
* cell instance sg13cmos5l_decap_8_1430 r0 *1 0,0
Xsg13cmos5l_decap_8_1430 VPWR VGND sg13cmos5l_decap_8
* cell instance sg13cmos5l_decap_8_1431 r0 *1 0,0
Xsg13cmos5l_decap_8_1431 VPWR VGND sg13cmos5l_decap_8
* cell instance sg13cmos5l_decap_8_1432 r0 *1 0,0
Xsg13cmos5l_decap_8_1432 VPWR VGND sg13cmos5l_decap_8
* cell instance sg13cmos5l_decap_8_1433 r0 *1 0,0
Xsg13cmos5l_decap_8_1433 VPWR VGND sg13cmos5l_decap_8
* cell instance sg13cmos5l_decap_8_1434 r0 *1 0,0
Xsg13cmos5l_decap_8_1434 VPWR VGND sg13cmos5l_decap_8
* cell instance sg13cmos5l_decap_8_1435 r0 *1 0,0
Xsg13cmos5l_decap_8_1435 VPWR VGND sg13cmos5l_decap_8
* cell instance sg13cmos5l_decap_8_1436 r0 *1 0,0
Xsg13cmos5l_decap_8_1436 VPWR VGND sg13cmos5l_decap_8
* cell instance sg13cmos5l_decap_8_1437 r0 *1 0,0
Xsg13cmos5l_decap_8_1437 VPWR VGND sg13cmos5l_decap_8
* cell instance sg13cmos5l_decap_8_1438 r0 *1 0,0
Xsg13cmos5l_decap_8_1438 VPWR VGND sg13cmos5l_decap_8
* cell instance sg13cmos5l_decap_8_1439 r0 *1 0,0
Xsg13cmos5l_decap_8_1439 VPWR VGND sg13cmos5l_decap_8
* cell instance sg13cmos5l_decap_8_1440 r0 *1 0,0
Xsg13cmos5l_decap_8_1440 VPWR VGND sg13cmos5l_decap_8
* cell instance sg13cmos5l_decap_8_1441 r0 *1 0,0
Xsg13cmos5l_decap_8_1441 VPWR VGND sg13cmos5l_decap_8
* cell instance sg13cmos5l_decap_8_1442 r0 *1 0,0
Xsg13cmos5l_decap_8_1442 VPWR VGND sg13cmos5l_decap_8
* cell instance sg13cmos5l_decap_8_1443 r0 *1 0,0
Xsg13cmos5l_decap_8_1443 VPWR VGND sg13cmos5l_decap_8
* cell instance sg13cmos5l_decap_8_1444 r0 *1 0,0
Xsg13cmos5l_decap_8_1444 VPWR VGND sg13cmos5l_decap_8
* cell instance sg13cmos5l_decap_8_1445 r0 *1 0,0
Xsg13cmos5l_decap_8_1445 VPWR VGND sg13cmos5l_decap_8
* cell instance sg13cmos5l_decap_8_1446 r0 *1 0,0
Xsg13cmos5l_decap_8_1446 VPWR VGND sg13cmos5l_decap_8
* cell instance sg13cmos5l_decap_8_1447 r0 *1 0,0
Xsg13cmos5l_decap_8_1447 VPWR VGND sg13cmos5l_decap_8
* cell instance sg13cmos5l_decap_8_1448 r0 *1 0,0
Xsg13cmos5l_decap_8_1448 VPWR VGND sg13cmos5l_decap_8
* cell instance sg13cmos5l_decap_8_1449 r0 *1 0,0
Xsg13cmos5l_decap_8_1449 VPWR VGND sg13cmos5l_decap_8
* cell instance sg13cmos5l_decap_8_1450 r0 *1 0,0
Xsg13cmos5l_decap_8_1450 VPWR VGND sg13cmos5l_decap_8
* cell instance sg13cmos5l_decap_8_1451 r0 *1 0,0
Xsg13cmos5l_decap_8_1451 VPWR VGND sg13cmos5l_decap_8
* cell instance sg13cmos5l_decap_8_1452 r0 *1 0,0
Xsg13cmos5l_decap_8_1452 VPWR VGND sg13cmos5l_decap_8
* cell instance sg13cmos5l_decap_8_1453 r0 *1 0,0
Xsg13cmos5l_decap_8_1453 VPWR VGND sg13cmos5l_decap_8
* cell instance sg13cmos5l_decap_8_1454 r0 *1 0,0
Xsg13cmos5l_decap_8_1454 VPWR VGND sg13cmos5l_decap_8
* cell instance sg13cmos5l_decap_8_1455 r0 *1 0,0
Xsg13cmos5l_decap_8_1455 VPWR VGND sg13cmos5l_decap_8
* cell instance sg13cmos5l_decap_8_1456 r0 *1 0,0
Xsg13cmos5l_decap_8_1456 VPWR VGND sg13cmos5l_decap_8
* cell instance sg13cmos5l_decap_8_1457 r0 *1 0,0
Xsg13cmos5l_decap_8_1457 VPWR VGND sg13cmos5l_decap_8
* cell instance sg13cmos5l_decap_8_1458 r0 *1 0,0
Xsg13cmos5l_decap_8_1458 VPWR VGND sg13cmos5l_decap_8
* cell instance sg13cmos5l_decap_8_1459 r0 *1 0,0
Xsg13cmos5l_decap_8_1459 VPWR VGND sg13cmos5l_decap_8
* cell instance sg13cmos5l_decap_8_1460 r0 *1 0,0
Xsg13cmos5l_decap_8_1460 VPWR VGND sg13cmos5l_decap_8
* cell instance sg13cmos5l_decap_8_1461 r0 *1 0,0
Xsg13cmos5l_decap_8_1461 VPWR VGND sg13cmos5l_decap_8
* cell instance sg13cmos5l_decap_8_1462 r0 *1 0,0
Xsg13cmos5l_decap_8_1462 VPWR VGND sg13cmos5l_decap_8
* cell instance sg13cmos5l_decap_8_1463 r0 *1 0,0
Xsg13cmos5l_decap_8_1463 VPWR VGND sg13cmos5l_decap_8
* cell instance sg13cmos5l_decap_8_1464 r0 *1 0,0
Xsg13cmos5l_decap_8_1464 VPWR VGND sg13cmos5l_decap_8
* cell instance sg13cmos5l_decap_8_1465 r0 *1 0,0
Xsg13cmos5l_decap_8_1465 VPWR VGND sg13cmos5l_decap_8
* cell instance sg13cmos5l_decap_8_1466 r0 *1 0,0
Xsg13cmos5l_decap_8_1466 VPWR VGND sg13cmos5l_decap_8
* cell instance sg13cmos5l_decap_8_1467 r0 *1 0,0
Xsg13cmos5l_decap_8_1467 VPWR VGND sg13cmos5l_decap_8
* cell instance sg13cmos5l_decap_8_1468 r0 *1 0,0
Xsg13cmos5l_decap_8_1468 VPWR VGND sg13cmos5l_decap_8
* cell instance sg13cmos5l_decap_8_1469 r0 *1 0,0
Xsg13cmos5l_decap_8_1469 VPWR VGND sg13cmos5l_decap_8
* cell instance sg13cmos5l_decap_8_1470 r0 *1 0,0
Xsg13cmos5l_decap_8_1470 VPWR VGND sg13cmos5l_decap_8
* cell instance sg13cmos5l_decap_8_1471 r0 *1 0,0
Xsg13cmos5l_decap_8_1471 VPWR VGND sg13cmos5l_decap_8
* cell instance sg13cmos5l_decap_8_1472 r0 *1 0,0
Xsg13cmos5l_decap_8_1472 VPWR VGND sg13cmos5l_decap_8
* cell instance sg13cmos5l_decap_8_1473 r0 *1 0,0
Xsg13cmos5l_decap_8_1473 VPWR VGND sg13cmos5l_decap_8
* cell instance sg13cmos5l_decap_8_1474 r0 *1 0,0
Xsg13cmos5l_decap_8_1474 VPWR VGND sg13cmos5l_decap_8
* cell instance sg13cmos5l_decap_8_1475 r0 *1 0,0
Xsg13cmos5l_decap_8_1475 VPWR VGND sg13cmos5l_decap_8
* cell instance sg13cmos5l_decap_8_1476 r0 *1 0,0
Xsg13cmos5l_decap_8_1476 VPWR VGND sg13cmos5l_decap_8
* cell instance sg13cmos5l_decap_8_1477 r0 *1 0,0
Xsg13cmos5l_decap_8_1477 VPWR VGND sg13cmos5l_decap_8
* cell instance sg13cmos5l_decap_8_1478 r0 *1 0,0
Xsg13cmos5l_decap_8_1478 VPWR VGND sg13cmos5l_decap_8
* cell instance sg13cmos5l_decap_8_1479 r0 *1 0,0
Xsg13cmos5l_decap_8_1479 VPWR VGND sg13cmos5l_decap_8
* cell instance sg13cmos5l_decap_8_1480 r0 *1 0,0
Xsg13cmos5l_decap_8_1480 VPWR VGND sg13cmos5l_decap_8
* cell instance sg13cmos5l_decap_8_1481 r0 *1 0,0
Xsg13cmos5l_decap_8_1481 VPWR VGND sg13cmos5l_decap_8
* cell instance sg13cmos5l_decap_8_1482 r0 *1 0,0
Xsg13cmos5l_decap_8_1482 VPWR VGND sg13cmos5l_decap_8
* cell instance sg13cmos5l_decap_8_1483 r0 *1 0,0
Xsg13cmos5l_decap_8_1483 VPWR VGND sg13cmos5l_decap_8
* cell instance sg13cmos5l_decap_8_1484 r0 *1 0,0
Xsg13cmos5l_decap_8_1484 VPWR VGND sg13cmos5l_decap_8
* cell instance sg13cmos5l_decap_8_1485 r0 *1 0,0
Xsg13cmos5l_decap_8_1485 VPWR VGND sg13cmos5l_decap_8
* cell instance sg13cmos5l_decap_8_1486 r0 *1 0,0
Xsg13cmos5l_decap_8_1486 VPWR VGND sg13cmos5l_decap_8
* cell instance sg13cmos5l_decap_8_1487 r0 *1 0,0
Xsg13cmos5l_decap_8_1487 VPWR VGND sg13cmos5l_decap_8
* cell instance sg13cmos5l_decap_8_1488 r0 *1 0,0
Xsg13cmos5l_decap_8_1488 VPWR VGND sg13cmos5l_decap_8
* cell instance sg13cmos5l_decap_8_1489 r0 *1 0,0
Xsg13cmos5l_decap_8_1489 VPWR VGND sg13cmos5l_decap_8
* cell instance sg13cmos5l_decap_8_1490 r0 *1 0,0
Xsg13cmos5l_decap_8_1490 VPWR VGND sg13cmos5l_decap_8
* cell instance sg13cmos5l_decap_8_1491 r0 *1 0,0
Xsg13cmos5l_decap_8_1491 VPWR VGND sg13cmos5l_decap_8
* cell instance sg13cmos5l_decap_8_1492 r0 *1 0,0
Xsg13cmos5l_decap_8_1492 VPWR VGND sg13cmos5l_decap_8
* cell instance sg13cmos5l_decap_8_1493 r0 *1 0,0
Xsg13cmos5l_decap_8_1493 VPWR VGND sg13cmos5l_decap_8
* cell instance sg13cmos5l_decap_8_1494 r0 *1 0,0
Xsg13cmos5l_decap_8_1494 VPWR VGND sg13cmos5l_decap_8
* cell instance sg13cmos5l_decap_8_1495 r0 *1 0,0
Xsg13cmos5l_decap_8_1495 VPWR VGND sg13cmos5l_decap_8
* cell instance sg13cmos5l_decap_8_1496 r0 *1 0,0
Xsg13cmos5l_decap_8_1496 VPWR VGND sg13cmos5l_decap_8
* cell instance sg13cmos5l_decap_8_1497 r0 *1 0,0
Xsg13cmos5l_decap_8_1497 VPWR VGND sg13cmos5l_decap_8
* cell instance sg13cmos5l_decap_8_1498 r0 *1 0,0
Xsg13cmos5l_decap_8_1498 VPWR VGND sg13cmos5l_decap_8
* cell instance sg13cmos5l_decap_8_1499 r0 *1 0,0
Xsg13cmos5l_decap_8_1499 VPWR VGND sg13cmos5l_decap_8
* cell instance sg13cmos5l_decap_8_1500 r0 *1 0,0
Xsg13cmos5l_decap_8_1500 VPWR VGND sg13cmos5l_decap_8
* cell instance sg13cmos5l_decap_8_1501 r0 *1 0,0
Xsg13cmos5l_decap_8_1501 VPWR VGND sg13cmos5l_decap_8
* cell instance sg13cmos5l_decap_8_1502 r0 *1 0,0
Xsg13cmos5l_decap_8_1502 VPWR VGND sg13cmos5l_decap_8
* cell instance sg13cmos5l_decap_8_1503 r0 *1 0,0
Xsg13cmos5l_decap_8_1503 VPWR VGND sg13cmos5l_decap_8
* cell instance sg13cmos5l_decap_8_1504 r0 *1 0,0
Xsg13cmos5l_decap_8_1504 VPWR VGND sg13cmos5l_decap_8
* cell instance sg13cmos5l_decap_8_1505 r0 *1 0,0
Xsg13cmos5l_decap_8_1505 VPWR VGND sg13cmos5l_decap_8
* cell instance sg13cmos5l_decap_8_1506 r0 *1 0,0
Xsg13cmos5l_decap_8_1506 VPWR VGND sg13cmos5l_decap_8
* cell instance sg13cmos5l_decap_8_1507 r0 *1 0,0
Xsg13cmos5l_decap_8_1507 VPWR VGND sg13cmos5l_decap_8
* cell instance sg13cmos5l_decap_8_1508 r0 *1 0,0
Xsg13cmos5l_decap_8_1508 VPWR VGND sg13cmos5l_decap_8
* cell instance sg13cmos5l_decap_8_1509 r0 *1 0,0
Xsg13cmos5l_decap_8_1509 VPWR VGND sg13cmos5l_decap_8
* cell instance sg13cmos5l_decap_8_1510 r0 *1 0,0
Xsg13cmos5l_decap_8_1510 VPWR VGND sg13cmos5l_decap_8
* cell instance sg13cmos5l_decap_8_1511 r0 *1 0,0
Xsg13cmos5l_decap_8_1511 VPWR VGND sg13cmos5l_decap_8
* cell instance sg13cmos5l_decap_8_1512 r0 *1 0,0
Xsg13cmos5l_decap_8_1512 VPWR VGND sg13cmos5l_decap_8
* cell instance sg13cmos5l_decap_8_1513 r0 *1 0,0
Xsg13cmos5l_decap_8_1513 VPWR VGND sg13cmos5l_decap_8
* cell instance sg13cmos5l_decap_8_1514 r0 *1 0,0
Xsg13cmos5l_decap_8_1514 VPWR VGND sg13cmos5l_decap_8
* cell instance sg13cmos5l_decap_8_1515 r0 *1 0,0
Xsg13cmos5l_decap_8_1515 VPWR VGND sg13cmos5l_decap_8
* cell instance sg13cmos5l_decap_8_1516 r0 *1 0,0
Xsg13cmos5l_decap_8_1516 VPWR VGND sg13cmos5l_decap_8
* cell instance sg13cmos5l_decap_8_1517 r0 *1 0,0
Xsg13cmos5l_decap_8_1517 VPWR VGND sg13cmos5l_decap_8
* cell instance sg13cmos5l_decap_8_1518 r0 *1 0,0
Xsg13cmos5l_decap_8_1518 VPWR VGND sg13cmos5l_decap_8
* cell instance sg13cmos5l_decap_8_1519 r0 *1 0,0
Xsg13cmos5l_decap_8_1519 VPWR VGND sg13cmos5l_decap_8
* cell instance sg13cmos5l_decap_8_1520 r0 *1 0,0
Xsg13cmos5l_decap_8_1520 VPWR VGND sg13cmos5l_decap_8
* cell instance sg13cmos5l_decap_8_1521 r0 *1 0,0
Xsg13cmos5l_decap_8_1521 VPWR VGND sg13cmos5l_decap_8
* cell instance sg13cmos5l_decap_8_1522 r0 *1 0,0
Xsg13cmos5l_decap_8_1522 VPWR VGND sg13cmos5l_decap_8
* cell instance sg13cmos5l_decap_8_1523 r0 *1 0,0
Xsg13cmos5l_decap_8_1523 VPWR VGND sg13cmos5l_decap_8
* cell instance sg13cmos5l_decap_8_1524 r0 *1 0,0
Xsg13cmos5l_decap_8_1524 VPWR VGND sg13cmos5l_decap_8
* cell instance sg13cmos5l_decap_8_1525 r0 *1 0,0
Xsg13cmos5l_decap_8_1525 VPWR VGND sg13cmos5l_decap_8
* cell instance sg13cmos5l_decap_8_1526 r0 *1 0,0
Xsg13cmos5l_decap_8_1526 VPWR VGND sg13cmos5l_decap_8
* cell instance sg13cmos5l_decap_8_1527 r0 *1 0,0
Xsg13cmos5l_decap_8_1527 VPWR VGND sg13cmos5l_decap_8
* cell instance sg13cmos5l_decap_8_1528 r0 *1 0,0
Xsg13cmos5l_decap_8_1528 VPWR VGND sg13cmos5l_decap_8
* cell instance sg13cmos5l_decap_8_1529 r0 *1 0,0
Xsg13cmos5l_decap_8_1529 VPWR VGND sg13cmos5l_decap_8
* cell instance sg13cmos5l_decap_8_1530 r0 *1 0,0
Xsg13cmos5l_decap_8_1530 VPWR VGND sg13cmos5l_decap_8
* cell instance sg13cmos5l_decap_8_1531 r0 *1 0,0
Xsg13cmos5l_decap_8_1531 VPWR VGND sg13cmos5l_decap_8
* cell instance sg13cmos5l_decap_8_1532 r0 *1 0,0
Xsg13cmos5l_decap_8_1532 VPWR VGND sg13cmos5l_decap_8
* cell instance sg13cmos5l_decap_8_1533 r0 *1 0,0
Xsg13cmos5l_decap_8_1533 VPWR VGND sg13cmos5l_decap_8
* cell instance sg13cmos5l_decap_8_1534 r0 *1 0,0
Xsg13cmos5l_decap_8_1534 VPWR VGND sg13cmos5l_decap_8
* cell instance sg13cmos5l_decap_8_1535 r0 *1 0,0
Xsg13cmos5l_decap_8_1535 VPWR VGND sg13cmos5l_decap_8
* cell instance sg13cmos5l_decap_8_1536 r0 *1 0,0
Xsg13cmos5l_decap_8_1536 VPWR VGND sg13cmos5l_decap_8
* cell instance sg13cmos5l_decap_8_1537 r0 *1 0,0
Xsg13cmos5l_decap_8_1537 VPWR VGND sg13cmos5l_decap_8
* cell instance sg13cmos5l_decap_8_1538 r0 *1 0,0
Xsg13cmos5l_decap_8_1538 VPWR VGND sg13cmos5l_decap_8
* cell instance sg13cmos5l_decap_8_1539 r0 *1 0,0
Xsg13cmos5l_decap_8_1539 VPWR VGND sg13cmos5l_decap_8
* cell instance sg13cmos5l_decap_8_1540 r0 *1 0,0
Xsg13cmos5l_decap_8_1540 VPWR VGND sg13cmos5l_decap_8
* cell instance sg13cmos5l_decap_8_1541 r0 *1 0,0
Xsg13cmos5l_decap_8_1541 VPWR VGND sg13cmos5l_decap_8
* cell instance sg13cmos5l_decap_8_1542 r0 *1 0,0
Xsg13cmos5l_decap_8_1542 VPWR VGND sg13cmos5l_decap_8
* cell instance sg13cmos5l_decap_8_1543 r0 *1 0,0
Xsg13cmos5l_decap_8_1543 VPWR VGND sg13cmos5l_decap_8
* cell instance sg13cmos5l_decap_8_1544 r0 *1 0,0
Xsg13cmos5l_decap_8_1544 VPWR VGND sg13cmos5l_decap_8
* cell instance sg13cmos5l_decap_8_1545 r0 *1 0,0
Xsg13cmos5l_decap_8_1545 VPWR VGND sg13cmos5l_decap_8
* cell instance sg13cmos5l_decap_8_1546 r0 *1 0,0
Xsg13cmos5l_decap_8_1546 VPWR VGND sg13cmos5l_decap_8
* cell instance sg13cmos5l_decap_8_1547 r0 *1 0,0
Xsg13cmos5l_decap_8_1547 VPWR VGND sg13cmos5l_decap_8
* cell instance sg13cmos5l_decap_8_1548 r0 *1 0,0
Xsg13cmos5l_decap_8_1548 VPWR VGND sg13cmos5l_decap_8
* cell instance sg13cmos5l_decap_8_1549 r0 *1 0,0
Xsg13cmos5l_decap_8_1549 VPWR VGND sg13cmos5l_decap_8
* cell instance sg13cmos5l_decap_8_1550 r0 *1 0,0
Xsg13cmos5l_decap_8_1550 VPWR VGND sg13cmos5l_decap_8
* cell instance sg13cmos5l_decap_8_1551 r0 *1 0,0
Xsg13cmos5l_decap_8_1551 VPWR VGND sg13cmos5l_decap_8
* cell instance sg13cmos5l_decap_8_1552 r0 *1 0,0
Xsg13cmos5l_decap_8_1552 VPWR VGND sg13cmos5l_decap_8
* cell instance sg13cmos5l_decap_8_1553 r0 *1 0,0
Xsg13cmos5l_decap_8_1553 VPWR VGND sg13cmos5l_decap_8
* cell instance sg13cmos5l_decap_8_1554 r0 *1 0,0
Xsg13cmos5l_decap_8_1554 VPWR VGND sg13cmos5l_decap_8
* cell instance sg13cmos5l_decap_8_1555 r0 *1 0,0
Xsg13cmos5l_decap_8_1555 VPWR VGND sg13cmos5l_decap_8
* cell instance sg13cmos5l_decap_8_1556 r0 *1 0,0
Xsg13cmos5l_decap_8_1556 VPWR VGND sg13cmos5l_decap_8
* cell instance sg13cmos5l_decap_8_1557 r0 *1 0,0
Xsg13cmos5l_decap_8_1557 VPWR VGND sg13cmos5l_decap_8
* cell instance sg13cmos5l_decap_8_1558 r0 *1 0,0
Xsg13cmos5l_decap_8_1558 VPWR VGND sg13cmos5l_decap_8
* cell instance sg13cmos5l_decap_8_1559 r0 *1 0,0
Xsg13cmos5l_decap_8_1559 VPWR VGND sg13cmos5l_decap_8
* cell instance sg13cmos5l_decap_8_1560 r0 *1 0,0
Xsg13cmos5l_decap_8_1560 VPWR VGND sg13cmos5l_decap_8
* cell instance sg13cmos5l_decap_8_1561 r0 *1 0,0
Xsg13cmos5l_decap_8_1561 VPWR VGND sg13cmos5l_decap_8
* cell instance sg13cmos5l_decap_8_1562 r0 *1 0,0
Xsg13cmos5l_decap_8_1562 VPWR VGND sg13cmos5l_decap_8
* cell instance sg13cmos5l_decap_8_1563 r0 *1 0,0
Xsg13cmos5l_decap_8_1563 VPWR VGND sg13cmos5l_decap_8
* cell instance sg13cmos5l_decap_8_1564 r0 *1 0,0
Xsg13cmos5l_decap_8_1564 VPWR VGND sg13cmos5l_decap_8
* cell instance sg13cmos5l_decap_8_1565 r0 *1 0,0
Xsg13cmos5l_decap_8_1565 VPWR VGND sg13cmos5l_decap_8
* cell instance sg13cmos5l_decap_8_1566 r0 *1 0,0
Xsg13cmos5l_decap_8_1566 VPWR VGND sg13cmos5l_decap_8
* cell instance sg13cmos5l_decap_8_1567 r0 *1 0,0
Xsg13cmos5l_decap_8_1567 VPWR VGND sg13cmos5l_decap_8
* cell instance sg13cmos5l_decap_8_1568 r0 *1 0,0
Xsg13cmos5l_decap_8_1568 VPWR VGND sg13cmos5l_decap_8
* cell instance sg13cmos5l_decap_8_1569 r0 *1 0,0
Xsg13cmos5l_decap_8_1569 VPWR VGND sg13cmos5l_decap_8
* cell instance sg13cmos5l_decap_8_1570 r0 *1 0,0
Xsg13cmos5l_decap_8_1570 VPWR VGND sg13cmos5l_decap_8
* cell instance sg13cmos5l_decap_8_1571 r0 *1 0,0
Xsg13cmos5l_decap_8_1571 VPWR VGND sg13cmos5l_decap_8
* cell instance sg13cmos5l_decap_8_1572 r0 *1 0,0
Xsg13cmos5l_decap_8_1572 VPWR VGND sg13cmos5l_decap_8
* cell instance sg13cmos5l_decap_8_1573 r0 *1 0,0
Xsg13cmos5l_decap_8_1573 VPWR VGND sg13cmos5l_decap_8
* cell instance sg13cmos5l_decap_8_1574 r0 *1 0,0
Xsg13cmos5l_decap_8_1574 VPWR VGND sg13cmos5l_decap_8
* cell instance sg13cmos5l_decap_8_1575 r0 *1 0,0
Xsg13cmos5l_decap_8_1575 VPWR VGND sg13cmos5l_decap_8
* cell instance sg13cmos5l_decap_8_1576 r0 *1 0,0
Xsg13cmos5l_decap_8_1576 VPWR VGND sg13cmos5l_decap_8
* cell instance sg13cmos5l_decap_8_1577 r0 *1 0,0
Xsg13cmos5l_decap_8_1577 VPWR VGND sg13cmos5l_decap_8
* cell instance sg13cmos5l_decap_8_1578 r0 *1 0,0
Xsg13cmos5l_decap_8_1578 VPWR VGND sg13cmos5l_decap_8
* cell instance sg13cmos5l_decap_8_1579 r0 *1 0,0
Xsg13cmos5l_decap_8_1579 VPWR VGND sg13cmos5l_decap_8
* cell instance sg13cmos5l_decap_8_1580 r0 *1 0,0
Xsg13cmos5l_decap_8_1580 VPWR VGND sg13cmos5l_decap_8
* cell instance sg13cmos5l_decap_8_1581 r0 *1 0,0
Xsg13cmos5l_decap_8_1581 VPWR VGND sg13cmos5l_decap_8
* cell instance sg13cmos5l_decap_8_1582 r0 *1 0,0
Xsg13cmos5l_decap_8_1582 VPWR VGND sg13cmos5l_decap_8
* cell instance sg13cmos5l_decap_8_1583 r0 *1 0,0
Xsg13cmos5l_decap_8_1583 VPWR VGND sg13cmos5l_decap_8
* cell instance sg13cmos5l_decap_8_1584 r0 *1 0,0
Xsg13cmos5l_decap_8_1584 VPWR VGND sg13cmos5l_decap_8
* cell instance sg13cmos5l_decap_8_1585 r0 *1 0,0
Xsg13cmos5l_decap_8_1585 VPWR VGND sg13cmos5l_decap_8
* cell instance sg13cmos5l_decap_8_1586 r0 *1 0,0
Xsg13cmos5l_decap_8_1586 VPWR VGND sg13cmos5l_decap_8
* cell instance sg13cmos5l_decap_8_1587 r0 *1 0,0
Xsg13cmos5l_decap_8_1587 VPWR VGND sg13cmos5l_decap_8
* cell instance sg13cmos5l_decap_8_1588 r0 *1 0,0
Xsg13cmos5l_decap_8_1588 VPWR VGND sg13cmos5l_decap_8
* cell instance sg13cmos5l_decap_8_1589 r0 *1 0,0
Xsg13cmos5l_decap_8_1589 VPWR VGND sg13cmos5l_decap_8
* cell instance sg13cmos5l_decap_8_1590 r0 *1 0,0
Xsg13cmos5l_decap_8_1590 VPWR VGND sg13cmos5l_decap_8
* cell instance sg13cmos5l_decap_8_1591 r0 *1 0,0
Xsg13cmos5l_decap_8_1591 VPWR VGND sg13cmos5l_decap_8
* cell instance sg13cmos5l_decap_8_1592 r0 *1 0,0
Xsg13cmos5l_decap_8_1592 VPWR VGND sg13cmos5l_decap_8
* cell instance sg13cmos5l_decap_8_1593 r0 *1 0,0
Xsg13cmos5l_decap_8_1593 VPWR VGND sg13cmos5l_decap_8
* cell instance sg13cmos5l_decap_8_1594 r0 *1 0,0
Xsg13cmos5l_decap_8_1594 VPWR VGND sg13cmos5l_decap_8
* cell instance sg13cmos5l_decap_8_1595 r0 *1 0,0
Xsg13cmos5l_decap_8_1595 VPWR VGND sg13cmos5l_decap_8
* cell instance sg13cmos5l_decap_8_1596 r0 *1 0,0
Xsg13cmos5l_decap_8_1596 VPWR VGND sg13cmos5l_decap_8
* cell instance sg13cmos5l_decap_8_1597 r0 *1 0,0
Xsg13cmos5l_decap_8_1597 VPWR VGND sg13cmos5l_decap_8
* cell instance sg13cmos5l_decap_8_1598 r0 *1 0,0
Xsg13cmos5l_decap_8_1598 VPWR VGND sg13cmos5l_decap_8
* cell instance sg13cmos5l_decap_8_1599 r0 *1 0,0
Xsg13cmos5l_decap_8_1599 VPWR VGND sg13cmos5l_decap_8
* cell instance sg13cmos5l_decap_8_1600 r0 *1 0,0
Xsg13cmos5l_decap_8_1600 VPWR VGND sg13cmos5l_decap_8
* cell instance sg13cmos5l_decap_8_1601 r0 *1 0,0
Xsg13cmos5l_decap_8_1601 VPWR VGND sg13cmos5l_decap_8
* cell instance sg13cmos5l_decap_8_1602 r0 *1 0,0
Xsg13cmos5l_decap_8_1602 VPWR VGND sg13cmos5l_decap_8
* cell instance sg13cmos5l_decap_8_1603 r0 *1 0,0
Xsg13cmos5l_decap_8_1603 VPWR VGND sg13cmos5l_decap_8
* cell instance sg13cmos5l_decap_8_1604 r0 *1 0,0
Xsg13cmos5l_decap_8_1604 VPWR VGND sg13cmos5l_decap_8
* cell instance sg13cmos5l_decap_8_1605 r0 *1 0,0
Xsg13cmos5l_decap_8_1605 VPWR VGND sg13cmos5l_decap_8
* cell instance sg13cmos5l_decap_8_1606 r0 *1 0,0
Xsg13cmos5l_decap_8_1606 VPWR VGND sg13cmos5l_decap_8
* cell instance sg13cmos5l_decap_8_1607 r0 *1 0,0
Xsg13cmos5l_decap_8_1607 VPWR VGND sg13cmos5l_decap_8
* cell instance sg13cmos5l_decap_8_1608 r0 *1 0,0
Xsg13cmos5l_decap_8_1608 VPWR VGND sg13cmos5l_decap_8
* cell instance sg13cmos5l_decap_8_1609 r0 *1 0,0
Xsg13cmos5l_decap_8_1609 VPWR VGND sg13cmos5l_decap_8
* cell instance sg13cmos5l_decap_8_1610 r0 *1 0,0
Xsg13cmos5l_decap_8_1610 VPWR VGND sg13cmos5l_decap_8
* cell instance sg13cmos5l_decap_8_1611 r0 *1 0,0
Xsg13cmos5l_decap_8_1611 VPWR VGND sg13cmos5l_decap_8
* cell instance sg13cmos5l_decap_8_1612 r0 *1 0,0
Xsg13cmos5l_decap_8_1612 VPWR VGND sg13cmos5l_decap_8
* cell instance sg13cmos5l_decap_8_1613 r0 *1 0,0
Xsg13cmos5l_decap_8_1613 VPWR VGND sg13cmos5l_decap_8
* cell instance sg13cmos5l_decap_8_1614 r0 *1 0,0
Xsg13cmos5l_decap_8_1614 VPWR VGND sg13cmos5l_decap_8
* cell instance sg13cmos5l_decap_8_1615 r0 *1 0,0
Xsg13cmos5l_decap_8_1615 VPWR VGND sg13cmos5l_decap_8
* cell instance sg13cmos5l_decap_8_1616 r0 *1 0,0
Xsg13cmos5l_decap_8_1616 VPWR VGND sg13cmos5l_decap_8
* cell instance sg13cmos5l_decap_8_1617 r0 *1 0,0
Xsg13cmos5l_decap_8_1617 VPWR VGND sg13cmos5l_decap_8
* cell instance sg13cmos5l_decap_8_1618 r0 *1 0,0
Xsg13cmos5l_decap_8_1618 VPWR VGND sg13cmos5l_decap_8
* cell instance sg13cmos5l_decap_8_1619 r0 *1 0,0
Xsg13cmos5l_decap_8_1619 VPWR VGND sg13cmos5l_decap_8
* cell instance sg13cmos5l_decap_8_1620 r0 *1 0,0
Xsg13cmos5l_decap_8_1620 VPWR VGND sg13cmos5l_decap_8
* cell instance sg13cmos5l_decap_8_1621 r0 *1 0,0
Xsg13cmos5l_decap_8_1621 VPWR VGND sg13cmos5l_decap_8
* cell instance sg13cmos5l_decap_8_1622 r0 *1 0,0
Xsg13cmos5l_decap_8_1622 VPWR VGND sg13cmos5l_decap_8
* cell instance sg13cmos5l_decap_8_1623 r0 *1 0,0
Xsg13cmos5l_decap_8_1623 VPWR VGND sg13cmos5l_decap_8
* cell instance sg13cmos5l_decap_8_1624 r0 *1 0,0
Xsg13cmos5l_decap_8_1624 VPWR VGND sg13cmos5l_decap_8
* cell instance sg13cmos5l_decap_8_1625 r0 *1 0,0
Xsg13cmos5l_decap_8_1625 VPWR VGND sg13cmos5l_decap_8
* cell instance sg13cmos5l_decap_8_1626 r0 *1 0,0
Xsg13cmos5l_decap_8_1626 VPWR VGND sg13cmos5l_decap_8
* cell instance sg13cmos5l_decap_8_1627 r0 *1 0,0
Xsg13cmos5l_decap_8_1627 VPWR VGND sg13cmos5l_decap_8
* cell instance sg13cmos5l_decap_8_1628 r0 *1 0,0
Xsg13cmos5l_decap_8_1628 VPWR VGND sg13cmos5l_decap_8
* cell instance sg13cmos5l_decap_8_1629 r0 *1 0,0
Xsg13cmos5l_decap_8_1629 VPWR VGND sg13cmos5l_decap_8
* cell instance sg13cmos5l_decap_8_1630 r0 *1 0,0
Xsg13cmos5l_decap_8_1630 VPWR VGND sg13cmos5l_decap_8
* cell instance sg13cmos5l_decap_8_1631 r0 *1 0,0
Xsg13cmos5l_decap_8_1631 VPWR VGND sg13cmos5l_decap_8
* cell instance sg13cmos5l_decap_8_1632 r0 *1 0,0
Xsg13cmos5l_decap_8_1632 VPWR VGND sg13cmos5l_decap_8
* cell instance sg13cmos5l_decap_8_1633 r0 *1 0,0
Xsg13cmos5l_decap_8_1633 VPWR VGND sg13cmos5l_decap_8
* cell instance sg13cmos5l_decap_8_1634 r0 *1 0,0
Xsg13cmos5l_decap_8_1634 VPWR VGND sg13cmos5l_decap_8
* cell instance sg13cmos5l_decap_8_1635 r0 *1 0,0
Xsg13cmos5l_decap_8_1635 VPWR VGND sg13cmos5l_decap_8
* cell instance sg13cmos5l_decap_8_1636 r0 *1 0,0
Xsg13cmos5l_decap_8_1636 VPWR VGND sg13cmos5l_decap_8
* cell instance sg13cmos5l_decap_8_1637 r0 *1 0,0
Xsg13cmos5l_decap_8_1637 VPWR VGND sg13cmos5l_decap_8
* cell instance sg13cmos5l_decap_8_1638 r0 *1 0,0
Xsg13cmos5l_decap_8_1638 VPWR VGND sg13cmos5l_decap_8
* cell instance sg13cmos5l_decap_8_1639 r0 *1 0,0
Xsg13cmos5l_decap_8_1639 VPWR VGND sg13cmos5l_decap_8
* cell instance sg13cmos5l_decap_8_1640 r0 *1 0,0
Xsg13cmos5l_decap_8_1640 VPWR VGND sg13cmos5l_decap_8
* cell instance sg13cmos5l_decap_8_1641 r0 *1 0,0
Xsg13cmos5l_decap_8_1641 VPWR VGND sg13cmos5l_decap_8
* cell instance sg13cmos5l_decap_8_1642 r0 *1 0,0
Xsg13cmos5l_decap_8_1642 VPWR VGND sg13cmos5l_decap_8
* cell instance sg13cmos5l_decap_8_1643 r0 *1 0,0
Xsg13cmos5l_decap_8_1643 VPWR VGND sg13cmos5l_decap_8
* cell instance sg13cmos5l_decap_8_1644 r0 *1 0,0
Xsg13cmos5l_decap_8_1644 VPWR VGND sg13cmos5l_decap_8
* cell instance sg13cmos5l_decap_8_1645 r0 *1 0,0
Xsg13cmos5l_decap_8_1645 VPWR VGND sg13cmos5l_decap_8
* cell instance sg13cmos5l_decap_8_1646 r0 *1 0,0
Xsg13cmos5l_decap_8_1646 VPWR VGND sg13cmos5l_decap_8
* cell instance sg13cmos5l_decap_8_1647 r0 *1 0,0
Xsg13cmos5l_decap_8_1647 VPWR VGND sg13cmos5l_decap_8
* cell instance sg13cmos5l_decap_8_1648 r0 *1 0,0
Xsg13cmos5l_decap_8_1648 VPWR VGND sg13cmos5l_decap_8
* cell instance sg13cmos5l_decap_8_1649 r0 *1 0,0
Xsg13cmos5l_decap_8_1649 VPWR VGND sg13cmos5l_decap_8
* cell instance sg13cmos5l_decap_8_1650 r0 *1 0,0
Xsg13cmos5l_decap_8_1650 VPWR VGND sg13cmos5l_decap_8
* cell instance sg13cmos5l_decap_8_1651 r0 *1 0,0
Xsg13cmos5l_decap_8_1651 VPWR VGND sg13cmos5l_decap_8
* cell instance sg13cmos5l_decap_8_1652 r0 *1 0,0
Xsg13cmos5l_decap_8_1652 VPWR VGND sg13cmos5l_decap_8
* cell instance sg13cmos5l_decap_8_1653 r0 *1 0,0
Xsg13cmos5l_decap_8_1653 VPWR VGND sg13cmos5l_decap_8
* cell instance sg13cmos5l_decap_8_1654 r0 *1 0,0
Xsg13cmos5l_decap_8_1654 VPWR VGND sg13cmos5l_decap_8
* cell instance sg13cmos5l_decap_8_1655 r0 *1 0,0
Xsg13cmos5l_decap_8_1655 VPWR VGND sg13cmos5l_decap_8
* cell instance sg13cmos5l_decap_8_1656 r0 *1 0,0
Xsg13cmos5l_decap_8_1656 VPWR VGND sg13cmos5l_decap_8
* cell instance sg13cmos5l_decap_8_1657 r0 *1 0,0
Xsg13cmos5l_decap_8_1657 VPWR VGND sg13cmos5l_decap_8
* cell instance sg13cmos5l_decap_8_1658 r0 *1 0,0
Xsg13cmos5l_decap_8_1658 VPWR VGND sg13cmos5l_decap_8
* cell instance sg13cmos5l_decap_8_1659 r0 *1 0,0
Xsg13cmos5l_decap_8_1659 VPWR VGND sg13cmos5l_decap_8
* cell instance sg13cmos5l_decap_8_1660 r0 *1 0,0
Xsg13cmos5l_decap_8_1660 VPWR VGND sg13cmos5l_decap_8
* cell instance sg13cmos5l_decap_8_1661 r0 *1 0,0
Xsg13cmos5l_decap_8_1661 VPWR VGND sg13cmos5l_decap_8
* cell instance sg13cmos5l_decap_8_1662 r0 *1 0,0
Xsg13cmos5l_decap_8_1662 VPWR VGND sg13cmos5l_decap_8
* cell instance sg13cmos5l_decap_8_1663 r0 *1 0,0
Xsg13cmos5l_decap_8_1663 VPWR VGND sg13cmos5l_decap_8
* cell instance sg13cmos5l_decap_8_1664 r0 *1 0,0
Xsg13cmos5l_decap_8_1664 VPWR VGND sg13cmos5l_decap_8
* cell instance sg13cmos5l_decap_8_1665 r0 *1 0,0
Xsg13cmos5l_decap_8_1665 VPWR VGND sg13cmos5l_decap_8
* cell instance sg13cmos5l_decap_8_1666 r0 *1 0,0
Xsg13cmos5l_decap_8_1666 VPWR VGND sg13cmos5l_decap_8
* cell instance sg13cmos5l_decap_8_1667 r0 *1 0,0
Xsg13cmos5l_decap_8_1667 VPWR VGND sg13cmos5l_decap_8
* cell instance sg13cmos5l_decap_8_1668 r0 *1 0,0
Xsg13cmos5l_decap_8_1668 VPWR VGND sg13cmos5l_decap_8
* cell instance sg13cmos5l_decap_8_1669 r0 *1 0,0
Xsg13cmos5l_decap_8_1669 VPWR VGND sg13cmos5l_decap_8
* cell instance sg13cmos5l_decap_8_1670 r0 *1 0,0
Xsg13cmos5l_decap_8_1670 VPWR VGND sg13cmos5l_decap_8
* cell instance sg13cmos5l_decap_8_1671 r0 *1 0,0
Xsg13cmos5l_decap_8_1671 VPWR VGND sg13cmos5l_decap_8
* cell instance sg13cmos5l_decap_8_1672 r0 *1 0,0
Xsg13cmos5l_decap_8_1672 VPWR VGND sg13cmos5l_decap_8
* cell instance sg13cmos5l_decap_8_1673 r0 *1 0,0
Xsg13cmos5l_decap_8_1673 VPWR VGND sg13cmos5l_decap_8
* cell instance sg13cmos5l_decap_8_1674 r0 *1 0,0
Xsg13cmos5l_decap_8_1674 VPWR VGND sg13cmos5l_decap_8
* cell instance sg13cmos5l_decap_8_1675 r0 *1 0,0
Xsg13cmos5l_decap_8_1675 VPWR VGND sg13cmos5l_decap_8
* cell instance sg13cmos5l_decap_8_1676 r0 *1 0,0
Xsg13cmos5l_decap_8_1676 VPWR VGND sg13cmos5l_decap_8
* cell instance sg13cmos5l_decap_8_1677 r0 *1 0,0
Xsg13cmos5l_decap_8_1677 VPWR VGND sg13cmos5l_decap_8
* cell instance sg13cmos5l_decap_8_1678 r0 *1 0,0
Xsg13cmos5l_decap_8_1678 VPWR VGND sg13cmos5l_decap_8
* cell instance sg13cmos5l_decap_8_1679 r0 *1 0,0
Xsg13cmos5l_decap_8_1679 VPWR VGND sg13cmos5l_decap_8
* cell instance sg13cmos5l_decap_8_1680 r0 *1 0,0
Xsg13cmos5l_decap_8_1680 VPWR VGND sg13cmos5l_decap_8
* cell instance sg13cmos5l_decap_8_1681 r0 *1 0,0
Xsg13cmos5l_decap_8_1681 VPWR VGND sg13cmos5l_decap_8
* cell instance sg13cmos5l_decap_8_1682 r0 *1 0,0
Xsg13cmos5l_decap_8_1682 VPWR VGND sg13cmos5l_decap_8
* cell instance sg13cmos5l_decap_8_1683 r0 *1 0,0
Xsg13cmos5l_decap_8_1683 VPWR VGND sg13cmos5l_decap_8
* cell instance sg13cmos5l_decap_8_1684 r0 *1 0,0
Xsg13cmos5l_decap_8_1684 VPWR VGND sg13cmos5l_decap_8
* cell instance sg13cmos5l_decap_8_1685 r0 *1 0,0
Xsg13cmos5l_decap_8_1685 VPWR VGND sg13cmos5l_decap_8
* cell instance sg13cmos5l_decap_8_1686 r0 *1 0,0
Xsg13cmos5l_decap_8_1686 VPWR VGND sg13cmos5l_decap_8
* cell instance sg13cmos5l_decap_8_1687 r0 *1 0,0
Xsg13cmos5l_decap_8_1687 VPWR VGND sg13cmos5l_decap_8
* cell instance sg13cmos5l_decap_8_1688 r0 *1 0,0
Xsg13cmos5l_decap_8_1688 VPWR VGND sg13cmos5l_decap_8
* cell instance sg13cmos5l_decap_8_1689 r0 *1 0,0
Xsg13cmos5l_decap_8_1689 VPWR VGND sg13cmos5l_decap_8
* cell instance sg13cmos5l_decap_8_1690 r0 *1 0,0
Xsg13cmos5l_decap_8_1690 VPWR VGND sg13cmos5l_decap_8
* cell instance sg13cmos5l_decap_8_1691 r0 *1 0,0
Xsg13cmos5l_decap_8_1691 VPWR VGND sg13cmos5l_decap_8
* cell instance sg13cmos5l_decap_8_1692 r0 *1 0,0
Xsg13cmos5l_decap_8_1692 VPWR VGND sg13cmos5l_decap_8
* cell instance sg13cmos5l_decap_8_1693 r0 *1 0,0
Xsg13cmos5l_decap_8_1693 VPWR VGND sg13cmos5l_decap_8
* cell instance sg13cmos5l_decap_8_1694 r0 *1 0,0
Xsg13cmos5l_decap_8_1694 VPWR VGND sg13cmos5l_decap_8
* cell instance sg13cmos5l_decap_8_1695 r0 *1 0,0
Xsg13cmos5l_decap_8_1695 VPWR VGND sg13cmos5l_decap_8
* cell instance sg13cmos5l_decap_8_1696 r0 *1 0,0
Xsg13cmos5l_decap_8_1696 VPWR VGND sg13cmos5l_decap_8
* cell instance sg13cmos5l_decap_8_1697 r0 *1 0,0
Xsg13cmos5l_decap_8_1697 VPWR VGND sg13cmos5l_decap_8
* cell instance sg13cmos5l_decap_8_1698 r0 *1 0,0
Xsg13cmos5l_decap_8_1698 VPWR VGND sg13cmos5l_decap_8
* cell instance sg13cmos5l_decap_8_1699 r0 *1 0,0
Xsg13cmos5l_decap_8_1699 VPWR VGND sg13cmos5l_decap_8
* cell instance sg13cmos5l_decap_8_1700 r0 *1 0,0
Xsg13cmos5l_decap_8_1700 VPWR VGND sg13cmos5l_decap_8
* cell instance sg13cmos5l_decap_8_1701 r0 *1 0,0
Xsg13cmos5l_decap_8_1701 VPWR VGND sg13cmos5l_decap_8
* cell instance sg13cmos5l_decap_8_1702 r0 *1 0,0
Xsg13cmos5l_decap_8_1702 VPWR VGND sg13cmos5l_decap_8
* cell instance sg13cmos5l_decap_8_1703 r0 *1 0,0
Xsg13cmos5l_decap_8_1703 VPWR VGND sg13cmos5l_decap_8
* cell instance sg13cmos5l_decap_8_1704 r0 *1 0,0
Xsg13cmos5l_decap_8_1704 VPWR VGND sg13cmos5l_decap_8
* cell instance sg13cmos5l_decap_8_1705 r0 *1 0,0
Xsg13cmos5l_decap_8_1705 VPWR VGND sg13cmos5l_decap_8
* cell instance sg13cmos5l_decap_8_1706 r0 *1 0,0
Xsg13cmos5l_decap_8_1706 VPWR VGND sg13cmos5l_decap_8
* cell instance sg13cmos5l_decap_8_1707 r0 *1 0,0
Xsg13cmos5l_decap_8_1707 VPWR VGND sg13cmos5l_decap_8
* cell instance sg13cmos5l_decap_8_1708 r0 *1 0,0
Xsg13cmos5l_decap_8_1708 VPWR VGND sg13cmos5l_decap_8
* cell instance sg13cmos5l_decap_8_1709 r0 *1 0,0
Xsg13cmos5l_decap_8_1709 VPWR VGND sg13cmos5l_decap_8
* cell instance sg13cmos5l_decap_8_1710 r0 *1 0,0
Xsg13cmos5l_decap_8_1710 VPWR VGND sg13cmos5l_decap_8
* cell instance sg13cmos5l_decap_8_1711 r0 *1 0,0
Xsg13cmos5l_decap_8_1711 VPWR VGND sg13cmos5l_decap_8
* cell instance sg13cmos5l_decap_8_1712 r0 *1 0,0
Xsg13cmos5l_decap_8_1712 VPWR VGND sg13cmos5l_decap_8
* cell instance sg13cmos5l_decap_8_1713 r0 *1 0,0
Xsg13cmos5l_decap_8_1713 VPWR VGND sg13cmos5l_decap_8
* cell instance sg13cmos5l_decap_8_1714 r0 *1 0,0
Xsg13cmos5l_decap_8_1714 VPWR VGND sg13cmos5l_decap_8
* cell instance sg13cmos5l_decap_8_1715 r0 *1 0,0
Xsg13cmos5l_decap_8_1715 VPWR VGND sg13cmos5l_decap_8
* cell instance sg13cmos5l_decap_8_1716 r0 *1 0,0
Xsg13cmos5l_decap_8_1716 VPWR VGND sg13cmos5l_decap_8
* cell instance sg13cmos5l_decap_8_1717 r0 *1 0,0
Xsg13cmos5l_decap_8_1717 VPWR VGND sg13cmos5l_decap_8
* cell instance sg13cmos5l_decap_8_1718 r0 *1 0,0
Xsg13cmos5l_decap_8_1718 VPWR VGND sg13cmos5l_decap_8
* cell instance sg13cmos5l_decap_8_1719 r0 *1 0,0
Xsg13cmos5l_decap_8_1719 VPWR VGND sg13cmos5l_decap_8
* cell instance sg13cmos5l_decap_8_1720 r0 *1 0,0
Xsg13cmos5l_decap_8_1720 VPWR VGND sg13cmos5l_decap_8
* cell instance sg13cmos5l_decap_8_1721 r0 *1 0,0
Xsg13cmos5l_decap_8_1721 VPWR VGND sg13cmos5l_decap_8
* cell instance sg13cmos5l_decap_8_1722 r0 *1 0,0
Xsg13cmos5l_decap_8_1722 VPWR VGND sg13cmos5l_decap_8
* cell instance sg13cmos5l_decap_8_1723 r0 *1 0,0
Xsg13cmos5l_decap_8_1723 VPWR VGND sg13cmos5l_decap_8
* cell instance sg13cmos5l_decap_8_1724 r0 *1 0,0
Xsg13cmos5l_decap_8_1724 VPWR VGND sg13cmos5l_decap_8
* cell instance sg13cmos5l_decap_8_1725 r0 *1 0,0
Xsg13cmos5l_decap_8_1725 VPWR VGND sg13cmos5l_decap_8
* cell instance sg13cmos5l_decap_8_1726 r0 *1 0,0
Xsg13cmos5l_decap_8_1726 VPWR VGND sg13cmos5l_decap_8
* cell instance sg13cmos5l_decap_8_1727 r0 *1 0,0
Xsg13cmos5l_decap_8_1727 VPWR VGND sg13cmos5l_decap_8
* cell instance sg13cmos5l_decap_8_1728 r0 *1 0,0
Xsg13cmos5l_decap_8_1728 VPWR VGND sg13cmos5l_decap_8
* cell instance sg13cmos5l_decap_8_1729 r0 *1 0,0
Xsg13cmos5l_decap_8_1729 VPWR VGND sg13cmos5l_decap_8
* cell instance sg13cmos5l_decap_8_1730 r0 *1 0,0
Xsg13cmos5l_decap_8_1730 VPWR VGND sg13cmos5l_decap_8
* cell instance sg13cmos5l_decap_8_1731 r0 *1 0,0
Xsg13cmos5l_decap_8_1731 VPWR VGND sg13cmos5l_decap_8
* cell instance sg13cmos5l_decap_8_1732 r0 *1 0,0
Xsg13cmos5l_decap_8_1732 VPWR VGND sg13cmos5l_decap_8
* cell instance sg13cmos5l_decap_8_1733 r0 *1 0,0
Xsg13cmos5l_decap_8_1733 VPWR VGND sg13cmos5l_decap_8
* cell instance sg13cmos5l_decap_8_1734 r0 *1 0,0
Xsg13cmos5l_decap_8_1734 VPWR VGND sg13cmos5l_decap_8
* cell instance sg13cmos5l_decap_8_1735 r0 *1 0,0
Xsg13cmos5l_decap_8_1735 VPWR VGND sg13cmos5l_decap_8
* cell instance sg13cmos5l_decap_8_1736 r0 *1 0,0
Xsg13cmos5l_decap_8_1736 VPWR VGND sg13cmos5l_decap_8
* cell instance sg13cmos5l_decap_8_1737 r0 *1 0,0
Xsg13cmos5l_decap_8_1737 VPWR VGND sg13cmos5l_decap_8
* cell instance sg13cmos5l_decap_8_1738 r0 *1 0,0
Xsg13cmos5l_decap_8_1738 VPWR VGND sg13cmos5l_decap_8
* cell instance sg13cmos5l_decap_8_1739 r0 *1 0,0
Xsg13cmos5l_decap_8_1739 VPWR VGND sg13cmos5l_decap_8
* cell instance sg13cmos5l_decap_8_1740 r0 *1 0,0
Xsg13cmos5l_decap_8_1740 VPWR VGND sg13cmos5l_decap_8
* cell instance sg13cmos5l_decap_8_1741 r0 *1 0,0
Xsg13cmos5l_decap_8_1741 VPWR VGND sg13cmos5l_decap_8
* cell instance sg13cmos5l_decap_8_1742 r0 *1 0,0
Xsg13cmos5l_decap_8_1742 VPWR VGND sg13cmos5l_decap_8
* cell instance sg13cmos5l_decap_8_1743 r0 *1 0,0
Xsg13cmos5l_decap_8_1743 VPWR VGND sg13cmos5l_decap_8
* cell instance sg13cmos5l_decap_8_1744 r0 *1 0,0
Xsg13cmos5l_decap_8_1744 VPWR VGND sg13cmos5l_decap_8
* cell instance sg13cmos5l_decap_8_1745 r0 *1 0,0
Xsg13cmos5l_decap_8_1745 VPWR VGND sg13cmos5l_decap_8
* cell instance sg13cmos5l_decap_8_1746 r0 *1 0,0
Xsg13cmos5l_decap_8_1746 VPWR VGND sg13cmos5l_decap_8
* cell instance sg13cmos5l_decap_8_1747 r0 *1 0,0
Xsg13cmos5l_decap_8_1747 VPWR VGND sg13cmos5l_decap_8
* cell instance sg13cmos5l_decap_8_1748 r0 *1 0,0
Xsg13cmos5l_decap_8_1748 VPWR VGND sg13cmos5l_decap_8
* cell instance sg13cmos5l_decap_8_1749 r0 *1 0,0
Xsg13cmos5l_decap_8_1749 VPWR VGND sg13cmos5l_decap_8
* cell instance sg13cmos5l_decap_8_1750 r0 *1 0,0
Xsg13cmos5l_decap_8_1750 VPWR VGND sg13cmos5l_decap_8
* cell instance sg13cmos5l_decap_8_1751 r0 *1 0,0
Xsg13cmos5l_decap_8_1751 VPWR VGND sg13cmos5l_decap_8
* cell instance sg13cmos5l_decap_8_1752 r0 *1 0,0
Xsg13cmos5l_decap_8_1752 VPWR VGND sg13cmos5l_decap_8
* cell instance sg13cmos5l_decap_8_1753 r0 *1 0,0
Xsg13cmos5l_decap_8_1753 VPWR VGND sg13cmos5l_decap_8
* cell instance sg13cmos5l_decap_8_1754 r0 *1 0,0
Xsg13cmos5l_decap_8_1754 VPWR VGND sg13cmos5l_decap_8
* cell instance sg13cmos5l_decap_8_1755 r0 *1 0,0
Xsg13cmos5l_decap_8_1755 VPWR VGND sg13cmos5l_decap_8
* cell instance sg13cmos5l_decap_8_1756 r0 *1 0,0
Xsg13cmos5l_decap_8_1756 VPWR VGND sg13cmos5l_decap_8
* cell instance sg13cmos5l_decap_8_1757 r0 *1 0,0
Xsg13cmos5l_decap_8_1757 VPWR VGND sg13cmos5l_decap_8
* cell instance sg13cmos5l_decap_8_1758 r0 *1 0,0
Xsg13cmos5l_decap_8_1758 VPWR VGND sg13cmos5l_decap_8
* cell instance sg13cmos5l_decap_8_1759 r0 *1 0,0
Xsg13cmos5l_decap_8_1759 VPWR VGND sg13cmos5l_decap_8
* cell instance sg13cmos5l_decap_8_1760 r0 *1 0,0
Xsg13cmos5l_decap_8_1760 VPWR VGND sg13cmos5l_decap_8
* cell instance sg13cmos5l_decap_8_1761 r0 *1 0,0
Xsg13cmos5l_decap_8_1761 VPWR VGND sg13cmos5l_decap_8
* cell instance sg13cmos5l_decap_8_1762 r0 *1 0,0
Xsg13cmos5l_decap_8_1762 VPWR VGND sg13cmos5l_decap_8
* cell instance sg13cmos5l_decap_8_1763 r0 *1 0,0
Xsg13cmos5l_decap_8_1763 VPWR VGND sg13cmos5l_decap_8
* cell instance sg13cmos5l_decap_8_1764 r0 *1 0,0
Xsg13cmos5l_decap_8_1764 VPWR VGND sg13cmos5l_decap_8
* cell instance sg13cmos5l_decap_8_1765 r0 *1 0,0
Xsg13cmos5l_decap_8_1765 VPWR VGND sg13cmos5l_decap_8
* cell instance sg13cmos5l_decap_8_1766 r0 *1 0,0
Xsg13cmos5l_decap_8_1766 VPWR VGND sg13cmos5l_decap_8
* cell instance sg13cmos5l_decap_8_1767 r0 *1 0,0
Xsg13cmos5l_decap_8_1767 VPWR VGND sg13cmos5l_decap_8
* cell instance sg13cmos5l_decap_8_1768 r0 *1 0,0
Xsg13cmos5l_decap_8_1768 VPWR VGND sg13cmos5l_decap_8
* cell instance sg13cmos5l_decap_8_1769 r0 *1 0,0
Xsg13cmos5l_decap_8_1769 VPWR VGND sg13cmos5l_decap_8
* cell instance sg13cmos5l_decap_8_1770 r0 *1 0,0
Xsg13cmos5l_decap_8_1770 VPWR VGND sg13cmos5l_decap_8
* cell instance sg13cmos5l_decap_8_1771 r0 *1 0,0
Xsg13cmos5l_decap_8_1771 VPWR VGND sg13cmos5l_decap_8
* cell instance sg13cmos5l_decap_8_1772 r0 *1 0,0
Xsg13cmos5l_decap_8_1772 VPWR VGND sg13cmos5l_decap_8
* cell instance sg13cmos5l_decap_8_1773 r0 *1 0,0
Xsg13cmos5l_decap_8_1773 VPWR VGND sg13cmos5l_decap_8
* cell instance sg13cmos5l_decap_8_1774 r0 *1 0,0
Xsg13cmos5l_decap_8_1774 VPWR VGND sg13cmos5l_decap_8
* cell instance sg13cmos5l_decap_8_1775 r0 *1 0,0
Xsg13cmos5l_decap_8_1775 VPWR VGND sg13cmos5l_decap_8
* cell instance sg13cmos5l_decap_8_1776 r0 *1 0,0
Xsg13cmos5l_decap_8_1776 VPWR VGND sg13cmos5l_decap_8
* cell instance sg13cmos5l_decap_8_1777 r0 *1 0,0
Xsg13cmos5l_decap_8_1777 VPWR VGND sg13cmos5l_decap_8
* cell instance sg13cmos5l_decap_8_1778 r0 *1 0,0
Xsg13cmos5l_decap_8_1778 VPWR VGND sg13cmos5l_decap_8
* cell instance sg13cmos5l_decap_8_1779 r0 *1 0,0
Xsg13cmos5l_decap_8_1779 VPWR VGND sg13cmos5l_decap_8
* cell instance sg13cmos5l_decap_8_1780 r0 *1 0,0
Xsg13cmos5l_decap_8_1780 VPWR VGND sg13cmos5l_decap_8
* cell instance sg13cmos5l_decap_8_1781 r0 *1 0,0
Xsg13cmos5l_decap_8_1781 VPWR VGND sg13cmos5l_decap_8
* cell instance sg13cmos5l_decap_8_1782 r0 *1 0,0
Xsg13cmos5l_decap_8_1782 VPWR VGND sg13cmos5l_decap_8
* cell instance sg13cmos5l_decap_8_1783 r0 *1 0,0
Xsg13cmos5l_decap_8_1783 VPWR VGND sg13cmos5l_decap_8
* cell instance sg13cmos5l_decap_8_1784 r0 *1 0,0
Xsg13cmos5l_decap_8_1784 VPWR VGND sg13cmos5l_decap_8
* cell instance sg13cmos5l_decap_8_1785 r0 *1 0,0
Xsg13cmos5l_decap_8_1785 VPWR VGND sg13cmos5l_decap_8
* cell instance sg13cmos5l_decap_8_1786 r0 *1 0,0
Xsg13cmos5l_decap_8_1786 VPWR VGND sg13cmos5l_decap_8
* cell instance sg13cmos5l_decap_8_1787 r0 *1 0,0
Xsg13cmos5l_decap_8_1787 VPWR VGND sg13cmos5l_decap_8
* cell instance sg13cmos5l_decap_8_1788 r0 *1 0,0
Xsg13cmos5l_decap_8_1788 VPWR VGND sg13cmos5l_decap_8
* cell instance sg13cmos5l_decap_8_1789 r0 *1 0,0
Xsg13cmos5l_decap_8_1789 VPWR VGND sg13cmos5l_decap_8
* cell instance sg13cmos5l_decap_8_1790 r0 *1 0,0
Xsg13cmos5l_decap_8_1790 VPWR VGND sg13cmos5l_decap_8
* cell instance sg13cmos5l_decap_8_1791 r0 *1 0,0
Xsg13cmos5l_decap_8_1791 VPWR VGND sg13cmos5l_decap_8
* cell instance sg13cmos5l_decap_8_1792 r0 *1 0,0
Xsg13cmos5l_decap_8_1792 VPWR VGND sg13cmos5l_decap_8
* cell instance sg13cmos5l_decap_8_1793 r0 *1 0,0
Xsg13cmos5l_decap_8_1793 VPWR VGND sg13cmos5l_decap_8
* cell instance sg13cmos5l_decap_8_1794 r0 *1 0,0
Xsg13cmos5l_decap_8_1794 VPWR VGND sg13cmos5l_decap_8
* cell instance sg13cmos5l_decap_8_1795 r0 *1 0,0
Xsg13cmos5l_decap_8_1795 VPWR VGND sg13cmos5l_decap_8
* cell instance sg13cmos5l_decap_8_1796 r0 *1 0,0
Xsg13cmos5l_decap_8_1796 VPWR VGND sg13cmos5l_decap_8
* cell instance sg13cmos5l_decap_8_1797 r0 *1 0,0
Xsg13cmos5l_decap_8_1797 VPWR VGND sg13cmos5l_decap_8
* cell instance sg13cmos5l_decap_8_1798 r0 *1 0,0
Xsg13cmos5l_decap_8_1798 VPWR VGND sg13cmos5l_decap_8
* cell instance sg13cmos5l_decap_8_1799 r0 *1 0,0
Xsg13cmos5l_decap_8_1799 VPWR VGND sg13cmos5l_decap_8
* cell instance sg13cmos5l_decap_8_1800 r0 *1 0,0
Xsg13cmos5l_decap_8_1800 VPWR VGND sg13cmos5l_decap_8
* cell instance sg13cmos5l_decap_8_1801 r0 *1 0,0
Xsg13cmos5l_decap_8_1801 VPWR VGND sg13cmos5l_decap_8
* cell instance sg13cmos5l_decap_8_1802 r0 *1 0,0
Xsg13cmos5l_decap_8_1802 VPWR VGND sg13cmos5l_decap_8
* cell instance sg13cmos5l_decap_8_1803 r0 *1 0,0
Xsg13cmos5l_decap_8_1803 VPWR VGND sg13cmos5l_decap_8
* cell instance sg13cmos5l_decap_8_1804 r0 *1 0,0
Xsg13cmos5l_decap_8_1804 VPWR VGND sg13cmos5l_decap_8
* cell instance sg13cmos5l_decap_8_1805 r0 *1 0,0
Xsg13cmos5l_decap_8_1805 VPWR VGND sg13cmos5l_decap_8
* cell instance sg13cmos5l_decap_8_1806 r0 *1 0,0
Xsg13cmos5l_decap_8_1806 VPWR VGND sg13cmos5l_decap_8
* cell instance sg13cmos5l_decap_8_1807 r0 *1 0,0
Xsg13cmos5l_decap_8_1807 VPWR VGND sg13cmos5l_decap_8
* cell instance sg13cmos5l_decap_8_1808 r0 *1 0,0
Xsg13cmos5l_decap_8_1808 VPWR VGND sg13cmos5l_decap_8
* cell instance sg13cmos5l_decap_8_1809 r0 *1 0,0
Xsg13cmos5l_decap_8_1809 VPWR VGND sg13cmos5l_decap_8
* cell instance sg13cmos5l_decap_8_1810 r0 *1 0,0
Xsg13cmos5l_decap_8_1810 VPWR VGND sg13cmos5l_decap_8
* cell instance sg13cmos5l_decap_8_1811 r0 *1 0,0
Xsg13cmos5l_decap_8_1811 VPWR VGND sg13cmos5l_decap_8
* cell instance sg13cmos5l_decap_8_1812 r0 *1 0,0
Xsg13cmos5l_decap_8_1812 VPWR VGND sg13cmos5l_decap_8
* cell instance sg13cmos5l_decap_8_1813 r0 *1 0,0
Xsg13cmos5l_decap_8_1813 VPWR VGND sg13cmos5l_decap_8
* cell instance sg13cmos5l_decap_8_1814 r0 *1 0,0
Xsg13cmos5l_decap_8_1814 VPWR VGND sg13cmos5l_decap_8
* cell instance sg13cmos5l_decap_8_1815 r0 *1 0,0
Xsg13cmos5l_decap_8_1815 VPWR VGND sg13cmos5l_decap_8
* cell instance sg13cmos5l_decap_8_1816 r0 *1 0,0
Xsg13cmos5l_decap_8_1816 VPWR VGND sg13cmos5l_decap_8
* cell instance sg13cmos5l_decap_8_1817 r0 *1 0,0
Xsg13cmos5l_decap_8_1817 VPWR VGND sg13cmos5l_decap_8
* cell instance sg13cmos5l_decap_8_1818 r0 *1 0,0
Xsg13cmos5l_decap_8_1818 VPWR VGND sg13cmos5l_decap_8
* cell instance sg13cmos5l_decap_8_1819 r0 *1 0,0
Xsg13cmos5l_decap_8_1819 VPWR VGND sg13cmos5l_decap_8
* cell instance sg13cmos5l_decap_8_1820 r0 *1 0,0
Xsg13cmos5l_decap_8_1820 VPWR VGND sg13cmos5l_decap_8
* cell instance sg13cmos5l_decap_8_1821 r0 *1 0,0
Xsg13cmos5l_decap_8_1821 VPWR VGND sg13cmos5l_decap_8
* cell instance sg13cmos5l_decap_8_1822 r0 *1 0,0
Xsg13cmos5l_decap_8_1822 VPWR VGND sg13cmos5l_decap_8
* cell instance sg13cmos5l_decap_8_1823 r0 *1 0,0
Xsg13cmos5l_decap_8_1823 VPWR VGND sg13cmos5l_decap_8
* cell instance sg13cmos5l_decap_8_1824 r0 *1 0,0
Xsg13cmos5l_decap_8_1824 VPWR VGND sg13cmos5l_decap_8
* cell instance sg13cmos5l_decap_8_1825 r0 *1 0,0
Xsg13cmos5l_decap_8_1825 VPWR VGND sg13cmos5l_decap_8
* cell instance sg13cmos5l_decap_8_1826 r0 *1 0,0
Xsg13cmos5l_decap_8_1826 VPWR VGND sg13cmos5l_decap_8
* cell instance sg13cmos5l_decap_8_1827 r0 *1 0,0
Xsg13cmos5l_decap_8_1827 VPWR VGND sg13cmos5l_decap_8
* cell instance sg13cmos5l_decap_8_1828 r0 *1 0,0
Xsg13cmos5l_decap_8_1828 VPWR VGND sg13cmos5l_decap_8
* cell instance sg13cmos5l_decap_8_1829 r0 *1 0,0
Xsg13cmos5l_decap_8_1829 VPWR VGND sg13cmos5l_decap_8
* cell instance sg13cmos5l_decap_8_1830 r0 *1 0,0
Xsg13cmos5l_decap_8_1830 VPWR VGND sg13cmos5l_decap_8
* cell instance sg13cmos5l_decap_8_1831 r0 *1 0,0
Xsg13cmos5l_decap_8_1831 VPWR VGND sg13cmos5l_decap_8
* cell instance sg13cmos5l_decap_8_1832 r0 *1 0,0
Xsg13cmos5l_decap_8_1832 VPWR VGND sg13cmos5l_decap_8
* cell instance sg13cmos5l_decap_8_1833 r0 *1 0,0
Xsg13cmos5l_decap_8_1833 VPWR VGND sg13cmos5l_decap_8
* cell instance sg13cmos5l_decap_8_1834 r0 *1 0,0
Xsg13cmos5l_decap_8_1834 VPWR VGND sg13cmos5l_decap_8
* cell instance sg13cmos5l_decap_8_1835 r0 *1 0,0
Xsg13cmos5l_decap_8_1835 VPWR VGND sg13cmos5l_decap_8
* cell instance sg13cmos5l_decap_8_1836 r0 *1 0,0
Xsg13cmos5l_decap_8_1836 VPWR VGND sg13cmos5l_decap_8
* cell instance sg13cmos5l_decap_8_1837 r0 *1 0,0
Xsg13cmos5l_decap_8_1837 VPWR VGND sg13cmos5l_decap_8
* cell instance sg13cmos5l_decap_8_1838 r0 *1 0,0
Xsg13cmos5l_decap_8_1838 VPWR VGND sg13cmos5l_decap_8
* cell instance sg13cmos5l_decap_8_1839 r0 *1 0,0
Xsg13cmos5l_decap_8_1839 VPWR VGND sg13cmos5l_decap_8
* cell instance sg13cmos5l_decap_8_1840 r0 *1 0,0
Xsg13cmos5l_decap_8_1840 VPWR VGND sg13cmos5l_decap_8
* cell instance sg13cmos5l_decap_8_1841 r0 *1 0,0
Xsg13cmos5l_decap_8_1841 VPWR VGND sg13cmos5l_decap_8
* cell instance sg13cmos5l_decap_8_1842 r0 *1 0,0
Xsg13cmos5l_decap_8_1842 VPWR VGND sg13cmos5l_decap_8
* cell instance sg13cmos5l_decap_8_1843 r0 *1 0,0
Xsg13cmos5l_decap_8_1843 VPWR VGND sg13cmos5l_decap_8
* cell instance sg13cmos5l_decap_8_1844 r0 *1 0,0
Xsg13cmos5l_decap_8_1844 VPWR VGND sg13cmos5l_decap_8
* cell instance sg13cmos5l_decap_8_1845 r0 *1 0,0
Xsg13cmos5l_decap_8_1845 VPWR VGND sg13cmos5l_decap_8
* cell instance sg13cmos5l_decap_8_1846 r0 *1 0,0
Xsg13cmos5l_decap_8_1846 VPWR VGND sg13cmos5l_decap_8
* cell instance sg13cmos5l_decap_8_1847 r0 *1 0,0
Xsg13cmos5l_decap_8_1847 VPWR VGND sg13cmos5l_decap_8
* cell instance sg13cmos5l_decap_8_1848 r0 *1 0,0
Xsg13cmos5l_decap_8_1848 VPWR VGND sg13cmos5l_decap_8
* cell instance sg13cmos5l_decap_8_1849 r0 *1 0,0
Xsg13cmos5l_decap_8_1849 VPWR VGND sg13cmos5l_decap_8
* cell instance sg13cmos5l_decap_8_1850 r0 *1 0,0
Xsg13cmos5l_decap_8_1850 VPWR VGND sg13cmos5l_decap_8
* cell instance sg13cmos5l_decap_8_1851 r0 *1 0,0
Xsg13cmos5l_decap_8_1851 VPWR VGND sg13cmos5l_decap_8
* cell instance sg13cmos5l_decap_8_1852 r0 *1 0,0
Xsg13cmos5l_decap_8_1852 VPWR VGND sg13cmos5l_decap_8
* cell instance sg13cmos5l_decap_8_1853 r0 *1 0,0
Xsg13cmos5l_decap_8_1853 VPWR VGND sg13cmos5l_decap_8
* cell instance sg13cmos5l_decap_8_1854 r0 *1 0,0
Xsg13cmos5l_decap_8_1854 VPWR VGND sg13cmos5l_decap_8
* cell instance sg13cmos5l_decap_8_1855 r0 *1 0,0
Xsg13cmos5l_decap_8_1855 VPWR VGND sg13cmos5l_decap_8
* cell instance sg13cmos5l_decap_8_1856 r0 *1 0,0
Xsg13cmos5l_decap_8_1856 VPWR VGND sg13cmos5l_decap_8
* cell instance sg13cmos5l_decap_8_1857 r0 *1 0,0
Xsg13cmos5l_decap_8_1857 VPWR VGND sg13cmos5l_decap_8
* cell instance sg13cmos5l_decap_8_1858 r0 *1 0,0
Xsg13cmos5l_decap_8_1858 VPWR VGND sg13cmos5l_decap_8
* cell instance sg13cmos5l_decap_8_1859 r0 *1 0,0
Xsg13cmos5l_decap_8_1859 VPWR VGND sg13cmos5l_decap_8
* cell instance sg13cmos5l_decap_8_1860 r0 *1 0,0
Xsg13cmos5l_decap_8_1860 VPWR VGND sg13cmos5l_decap_8
* cell instance sg13cmos5l_decap_8_1861 r0 *1 0,0
Xsg13cmos5l_decap_8_1861 VPWR VGND sg13cmos5l_decap_8
* cell instance sg13cmos5l_decap_8_1862 r0 *1 0,0
Xsg13cmos5l_decap_8_1862 VPWR VGND sg13cmos5l_decap_8
* cell instance sg13cmos5l_decap_8_1863 r0 *1 0,0
Xsg13cmos5l_decap_8_1863 VPWR VGND sg13cmos5l_decap_8
* cell instance sg13cmos5l_decap_8_1864 r0 *1 0,0
Xsg13cmos5l_decap_8_1864 VPWR VGND sg13cmos5l_decap_8
* cell instance sg13cmos5l_decap_8_1865 r0 *1 0,0
Xsg13cmos5l_decap_8_1865 VPWR VGND sg13cmos5l_decap_8
* cell instance sg13cmos5l_decap_8_1866 r0 *1 0,0
Xsg13cmos5l_decap_8_1866 VPWR VGND sg13cmos5l_decap_8
* cell instance sg13cmos5l_decap_8_1867 r0 *1 0,0
Xsg13cmos5l_decap_8_1867 VPWR VGND sg13cmos5l_decap_8
* cell instance sg13cmos5l_decap_8_1868 r0 *1 0,0
Xsg13cmos5l_decap_8_1868 VPWR VGND sg13cmos5l_decap_8
* cell instance sg13cmos5l_decap_8_1869 r0 *1 0,0
Xsg13cmos5l_decap_8_1869 VPWR VGND sg13cmos5l_decap_8
* cell instance sg13cmos5l_decap_8_1870 r0 *1 0,0
Xsg13cmos5l_decap_8_1870 VPWR VGND sg13cmos5l_decap_8
* cell instance sg13cmos5l_decap_8_1871 r0 *1 0,0
Xsg13cmos5l_decap_8_1871 VPWR VGND sg13cmos5l_decap_8
* cell instance sg13cmos5l_decap_8_1872 r0 *1 0,0
Xsg13cmos5l_decap_8_1872 VPWR VGND sg13cmos5l_decap_8
* cell instance sg13cmos5l_decap_8_1873 r0 *1 0,0
Xsg13cmos5l_decap_8_1873 VPWR VGND sg13cmos5l_decap_8
* cell instance sg13cmos5l_decap_8_1874 r0 *1 0,0
Xsg13cmos5l_decap_8_1874 VPWR VGND sg13cmos5l_decap_8
* cell instance sg13cmos5l_decap_8_1875 r0 *1 0,0
Xsg13cmos5l_decap_8_1875 VPWR VGND sg13cmos5l_decap_8
* cell instance sg13cmos5l_decap_8_1876 r0 *1 0,0
Xsg13cmos5l_decap_8_1876 VPWR VGND sg13cmos5l_decap_8
* cell instance sg13cmos5l_decap_8_1877 r0 *1 0,0
Xsg13cmos5l_decap_8_1877 VPWR VGND sg13cmos5l_decap_8
* cell instance sg13cmos5l_decap_8_1878 r0 *1 0,0
Xsg13cmos5l_decap_8_1878 VPWR VGND sg13cmos5l_decap_8
* cell instance sg13cmos5l_decap_8_1879 r0 *1 0,0
Xsg13cmos5l_decap_8_1879 VPWR VGND sg13cmos5l_decap_8
* cell instance sg13cmos5l_decap_8_1880 r0 *1 0,0
Xsg13cmos5l_decap_8_1880 VPWR VGND sg13cmos5l_decap_8
* cell instance sg13cmos5l_decap_8_1881 r0 *1 0,0
Xsg13cmos5l_decap_8_1881 VPWR VGND sg13cmos5l_decap_8
* cell instance sg13cmos5l_decap_8_1882 r0 *1 0,0
Xsg13cmos5l_decap_8_1882 VPWR VGND sg13cmos5l_decap_8
* cell instance sg13cmos5l_decap_8_1883 r0 *1 0,0
Xsg13cmos5l_decap_8_1883 VPWR VGND sg13cmos5l_decap_8
* cell instance sg13cmos5l_decap_8_1884 r0 *1 0,0
Xsg13cmos5l_decap_8_1884 VPWR VGND sg13cmos5l_decap_8
* cell instance sg13cmos5l_decap_8_1885 r0 *1 0,0
Xsg13cmos5l_decap_8_1885 VPWR VGND sg13cmos5l_decap_8
* cell instance sg13cmos5l_decap_8_1886 r0 *1 0,0
Xsg13cmos5l_decap_8_1886 VPWR VGND sg13cmos5l_decap_8
* cell instance sg13cmos5l_decap_8_1887 r0 *1 0,0
Xsg13cmos5l_decap_8_1887 VPWR VGND sg13cmos5l_decap_8
* cell instance sg13cmos5l_decap_8_1888 r0 *1 0,0
Xsg13cmos5l_decap_8_1888 VPWR VGND sg13cmos5l_decap_8
* cell instance sg13cmos5l_decap_8_1889 r0 *1 0,0
Xsg13cmos5l_decap_8_1889 VPWR VGND sg13cmos5l_decap_8
* cell instance sg13cmos5l_decap_8_1890 r0 *1 0,0
Xsg13cmos5l_decap_8_1890 VPWR VGND sg13cmos5l_decap_8
* cell instance sg13cmos5l_decap_8_1891 r0 *1 0,0
Xsg13cmos5l_decap_8_1891 VPWR VGND sg13cmos5l_decap_8
* cell instance sg13cmos5l_decap_8_1892 r0 *1 0,0
Xsg13cmos5l_decap_8_1892 VPWR VGND sg13cmos5l_decap_8
* cell instance sg13cmos5l_decap_8_1893 r0 *1 0,0
Xsg13cmos5l_decap_8_1893 VPWR VGND sg13cmos5l_decap_8
* cell instance sg13cmos5l_decap_8_1894 r0 *1 0,0
Xsg13cmos5l_decap_8_1894 VPWR VGND sg13cmos5l_decap_8
* cell instance sg13cmos5l_decap_8_1895 r0 *1 0,0
Xsg13cmos5l_decap_8_1895 VPWR VGND sg13cmos5l_decap_8
* cell instance sg13cmos5l_decap_8_1896 r0 *1 0,0
Xsg13cmos5l_decap_8_1896 VPWR VGND sg13cmos5l_decap_8
* cell instance sg13cmos5l_decap_8_1897 r0 *1 0,0
Xsg13cmos5l_decap_8_1897 VPWR VGND sg13cmos5l_decap_8
* cell instance sg13cmos5l_decap_8_1898 r0 *1 0,0
Xsg13cmos5l_decap_8_1898 VPWR VGND sg13cmos5l_decap_8
* cell instance sg13cmos5l_decap_8_1899 r0 *1 0,0
Xsg13cmos5l_decap_8_1899 VPWR VGND sg13cmos5l_decap_8
* cell instance sg13cmos5l_decap_8_1900 r0 *1 0,0
Xsg13cmos5l_decap_8_1900 VPWR VGND sg13cmos5l_decap_8
* cell instance sg13cmos5l_decap_8_1901 r0 *1 0,0
Xsg13cmos5l_decap_8_1901 VPWR VGND sg13cmos5l_decap_8
* cell instance sg13cmos5l_decap_8_1902 r0 *1 0,0
Xsg13cmos5l_decap_8_1902 VPWR VGND sg13cmos5l_decap_8
* cell instance sg13cmos5l_decap_8_1903 r0 *1 0,0
Xsg13cmos5l_decap_8_1903 VPWR VGND sg13cmos5l_decap_8
* cell instance sg13cmos5l_decap_8_1904 r0 *1 0,0
Xsg13cmos5l_decap_8_1904 VPWR VGND sg13cmos5l_decap_8
* cell instance sg13cmos5l_decap_8_1905 r0 *1 0,0
Xsg13cmos5l_decap_8_1905 VPWR VGND sg13cmos5l_decap_8
* cell instance sg13cmos5l_decap_8_1906 r0 *1 0,0
Xsg13cmos5l_decap_8_1906 VPWR VGND sg13cmos5l_decap_8
* cell instance sg13cmos5l_decap_8_1907 r0 *1 0,0
Xsg13cmos5l_decap_8_1907 VPWR VGND sg13cmos5l_decap_8
* cell instance sg13cmos5l_decap_8_1908 r0 *1 0,0
Xsg13cmos5l_decap_8_1908 VPWR VGND sg13cmos5l_decap_8
* cell instance sg13cmos5l_decap_8_1909 r0 *1 0,0
Xsg13cmos5l_decap_8_1909 VPWR VGND sg13cmos5l_decap_8
* cell instance sg13cmos5l_decap_8_1910 r0 *1 0,0
Xsg13cmos5l_decap_8_1910 VPWR VGND sg13cmos5l_decap_8
* cell instance sg13cmos5l_decap_8_1911 r0 *1 0,0
Xsg13cmos5l_decap_8_1911 VPWR VGND sg13cmos5l_decap_8
* cell instance sg13cmos5l_decap_8_1912 r0 *1 0,0
Xsg13cmos5l_decap_8_1912 VPWR VGND sg13cmos5l_decap_8
* cell instance sg13cmos5l_decap_8_1913 r0 *1 0,0
Xsg13cmos5l_decap_8_1913 VPWR VGND sg13cmos5l_decap_8
* cell instance sg13cmos5l_decap_8_1914 r0 *1 0,0
Xsg13cmos5l_decap_8_1914 VPWR VGND sg13cmos5l_decap_8
* cell instance sg13cmos5l_decap_8_1915 r0 *1 0,0
Xsg13cmos5l_decap_8_1915 VPWR VGND sg13cmos5l_decap_8
* cell instance sg13cmos5l_decap_8_1916 r0 *1 0,0
Xsg13cmos5l_decap_8_1916 VPWR VGND sg13cmos5l_decap_8
* cell instance sg13cmos5l_decap_8_1917 r0 *1 0,0
Xsg13cmos5l_decap_8_1917 VPWR VGND sg13cmos5l_decap_8
* cell instance sg13cmos5l_decap_8_1918 r0 *1 0,0
Xsg13cmos5l_decap_8_1918 VPWR VGND sg13cmos5l_decap_8
* cell instance sg13cmos5l_decap_8_1919 r0 *1 0,0
Xsg13cmos5l_decap_8_1919 VPWR VGND sg13cmos5l_decap_8
* cell instance sg13cmos5l_decap_8_1920 r0 *1 0,0
Xsg13cmos5l_decap_8_1920 VPWR VGND sg13cmos5l_decap_8
* cell instance sg13cmos5l_decap_8_1921 r0 *1 0,0
Xsg13cmos5l_decap_8_1921 VPWR VGND sg13cmos5l_decap_8
* cell instance sg13cmos5l_decap_8_1922 r0 *1 0,0
Xsg13cmos5l_decap_8_1922 VPWR VGND sg13cmos5l_decap_8
* cell instance sg13cmos5l_decap_8_1923 r0 *1 0,0
Xsg13cmos5l_decap_8_1923 VPWR VGND sg13cmos5l_decap_8
* cell instance sg13cmos5l_decap_8_1924 r0 *1 0,0
Xsg13cmos5l_decap_8_1924 VPWR VGND sg13cmos5l_decap_8
* cell instance sg13cmos5l_decap_8_1925 r0 *1 0,0
Xsg13cmos5l_decap_8_1925 VPWR VGND sg13cmos5l_decap_8
* cell instance sg13cmos5l_decap_8_1926 r0 *1 0,0
Xsg13cmos5l_decap_8_1926 VPWR VGND sg13cmos5l_decap_8
* cell instance sg13cmos5l_decap_8_1927 r0 *1 0,0
Xsg13cmos5l_decap_8_1927 VPWR VGND sg13cmos5l_decap_8
* cell instance sg13cmos5l_decap_8_1928 r0 *1 0,0
Xsg13cmos5l_decap_8_1928 VPWR VGND sg13cmos5l_decap_8
* cell instance sg13cmos5l_decap_8_1929 r0 *1 0,0
Xsg13cmos5l_decap_8_1929 VPWR VGND sg13cmos5l_decap_8
* cell instance sg13cmos5l_decap_8_1930 r0 *1 0,0
Xsg13cmos5l_decap_8_1930 VPWR VGND sg13cmos5l_decap_8
* cell instance sg13cmos5l_decap_8_1931 r0 *1 0,0
Xsg13cmos5l_decap_8_1931 VPWR VGND sg13cmos5l_decap_8
* cell instance sg13cmos5l_decap_8_1932 r0 *1 0,0
Xsg13cmos5l_decap_8_1932 VPWR VGND sg13cmos5l_decap_8
* cell instance sg13cmos5l_decap_8_1933 r0 *1 0,0
Xsg13cmos5l_decap_8_1933 VPWR VGND sg13cmos5l_decap_8
* cell instance sg13cmos5l_decap_8_1934 r0 *1 0,0
Xsg13cmos5l_decap_8_1934 VPWR VGND sg13cmos5l_decap_8
* cell instance sg13cmos5l_decap_8_1935 r0 *1 0,0
Xsg13cmos5l_decap_8_1935 VPWR VGND sg13cmos5l_decap_8
* cell instance sg13cmos5l_decap_8_1936 r0 *1 0,0
Xsg13cmos5l_decap_8_1936 VPWR VGND sg13cmos5l_decap_8
* cell instance sg13cmos5l_decap_8_1937 r0 *1 0,0
Xsg13cmos5l_decap_8_1937 VPWR VGND sg13cmos5l_decap_8
* cell instance sg13cmos5l_decap_8_1938 r0 *1 0,0
Xsg13cmos5l_decap_8_1938 VPWR VGND sg13cmos5l_decap_8
* cell instance sg13cmos5l_decap_8_1939 r0 *1 0,0
Xsg13cmos5l_decap_8_1939 VPWR VGND sg13cmos5l_decap_8
* cell instance sg13cmos5l_decap_8_1940 r0 *1 0,0
Xsg13cmos5l_decap_8_1940 VPWR VGND sg13cmos5l_decap_8
* cell instance sg13cmos5l_decap_8_1941 r0 *1 0,0
Xsg13cmos5l_decap_8_1941 VPWR VGND sg13cmos5l_decap_8
* cell instance sg13cmos5l_decap_8_1942 r0 *1 0,0
Xsg13cmos5l_decap_8_1942 VPWR VGND sg13cmos5l_decap_8
* cell instance sg13cmos5l_decap_8_1943 r0 *1 0,0
Xsg13cmos5l_decap_8_1943 VPWR VGND sg13cmos5l_decap_8
* cell instance sg13cmos5l_decap_8_1944 r0 *1 0,0
Xsg13cmos5l_decap_8_1944 VPWR VGND sg13cmos5l_decap_8
* cell instance sg13cmos5l_decap_8_1945 r0 *1 0,0
Xsg13cmos5l_decap_8_1945 VPWR VGND sg13cmos5l_decap_8
* cell instance sg13cmos5l_decap_8_1946 r0 *1 0,0
Xsg13cmos5l_decap_8_1946 VPWR VGND sg13cmos5l_decap_8
* cell instance sg13cmos5l_decap_8_1947 r0 *1 0,0
Xsg13cmos5l_decap_8_1947 VPWR VGND sg13cmos5l_decap_8
* cell instance sg13cmos5l_decap_8_1948 r0 *1 0,0
Xsg13cmos5l_decap_8_1948 VPWR VGND sg13cmos5l_decap_8
* cell instance sg13cmos5l_decap_8_1949 r0 *1 0,0
Xsg13cmos5l_decap_8_1949 VPWR VGND sg13cmos5l_decap_8
* cell instance sg13cmos5l_decap_8_1950 r0 *1 0,0
Xsg13cmos5l_decap_8_1950 VPWR VGND sg13cmos5l_decap_8
* cell instance sg13cmos5l_decap_8_1951 r0 *1 0,0
Xsg13cmos5l_decap_8_1951 VPWR VGND sg13cmos5l_decap_8
* cell instance sg13cmos5l_decap_8_1952 r0 *1 0,0
Xsg13cmos5l_decap_8_1952 VPWR VGND sg13cmos5l_decap_8
* cell instance sg13cmos5l_decap_8_1953 r0 *1 0,0
Xsg13cmos5l_decap_8_1953 VPWR VGND sg13cmos5l_decap_8
* cell instance sg13cmos5l_decap_8_1954 r0 *1 0,0
Xsg13cmos5l_decap_8_1954 VPWR VGND sg13cmos5l_decap_8
* cell instance sg13cmos5l_decap_8_1955 r0 *1 0,0
Xsg13cmos5l_decap_8_1955 VPWR VGND sg13cmos5l_decap_8
* cell instance sg13cmos5l_decap_8_1956 r0 *1 0,0
Xsg13cmos5l_decap_8_1956 VPWR VGND sg13cmos5l_decap_8
* cell instance sg13cmos5l_decap_8_1957 r0 *1 0,0
Xsg13cmos5l_decap_8_1957 VPWR VGND sg13cmos5l_decap_8
* cell instance sg13cmos5l_decap_8_1958 r0 *1 0,0
Xsg13cmos5l_decap_8_1958 VPWR VGND sg13cmos5l_decap_8
* cell instance sg13cmos5l_decap_8_1959 r0 *1 0,0
Xsg13cmos5l_decap_8_1959 VPWR VGND sg13cmos5l_decap_8
* cell instance sg13cmos5l_decap_8_1960 r0 *1 0,0
Xsg13cmos5l_decap_8_1960 VPWR VGND sg13cmos5l_decap_8
* cell instance sg13cmos5l_decap_8_1961 r0 *1 0,0
Xsg13cmos5l_decap_8_1961 VPWR VGND sg13cmos5l_decap_8
* cell instance sg13cmos5l_decap_8_1962 r0 *1 0,0
Xsg13cmos5l_decap_8_1962 VPWR VGND sg13cmos5l_decap_8
* cell instance sg13cmos5l_decap_8_1963 r0 *1 0,0
Xsg13cmos5l_decap_8_1963 VPWR VGND sg13cmos5l_decap_8
* cell instance sg13cmos5l_decap_8_1964 r0 *1 0,0
Xsg13cmos5l_decap_8_1964 VPWR VGND sg13cmos5l_decap_8
* cell instance sg13cmos5l_decap_8_1965 r0 *1 0,0
Xsg13cmos5l_decap_8_1965 VPWR VGND sg13cmos5l_decap_8
* cell instance sg13cmos5l_decap_8_1966 r0 *1 0,0
Xsg13cmos5l_decap_8_1966 VPWR VGND sg13cmos5l_decap_8
* cell instance sg13cmos5l_decap_8_1967 r0 *1 0,0
Xsg13cmos5l_decap_8_1967 VPWR VGND sg13cmos5l_decap_8
* cell instance sg13cmos5l_decap_8_1968 r0 *1 0,0
Xsg13cmos5l_decap_8_1968 VPWR VGND sg13cmos5l_decap_8
* cell instance sg13cmos5l_decap_8_1969 r0 *1 0,0
Xsg13cmos5l_decap_8_1969 VPWR VGND sg13cmos5l_decap_8
* cell instance sg13cmos5l_decap_8_1970 r0 *1 0,0
Xsg13cmos5l_decap_8_1970 VPWR VGND sg13cmos5l_decap_8
* cell instance sg13cmos5l_decap_8_1971 r0 *1 0,0
Xsg13cmos5l_decap_8_1971 VPWR VGND sg13cmos5l_decap_8
* cell instance sg13cmos5l_decap_8_1972 r0 *1 0,0
Xsg13cmos5l_decap_8_1972 VPWR VGND sg13cmos5l_decap_8
* cell instance sg13cmos5l_decap_8_1973 r0 *1 0,0
Xsg13cmos5l_decap_8_1973 VPWR VGND sg13cmos5l_decap_8
* cell instance sg13cmos5l_decap_8_1974 r0 *1 0,0
Xsg13cmos5l_decap_8_1974 VPWR VGND sg13cmos5l_decap_8
* cell instance sg13cmos5l_decap_8_1975 r0 *1 0,0
Xsg13cmos5l_decap_8_1975 VPWR VGND sg13cmos5l_decap_8
* cell instance sg13cmos5l_decap_8_1976 r0 *1 0,0
Xsg13cmos5l_decap_8_1976 VPWR VGND sg13cmos5l_decap_8
* cell instance sg13cmos5l_decap_8_1977 r0 *1 0,0
Xsg13cmos5l_decap_8_1977 VPWR VGND sg13cmos5l_decap_8
* cell instance sg13cmos5l_decap_8_1978 r0 *1 0,0
Xsg13cmos5l_decap_8_1978 VPWR VGND sg13cmos5l_decap_8
* cell instance sg13cmos5l_decap_8_1979 r0 *1 0,0
Xsg13cmos5l_decap_8_1979 VPWR VGND sg13cmos5l_decap_8
* cell instance sg13cmos5l_decap_8_1980 r0 *1 0,0
Xsg13cmos5l_decap_8_1980 VPWR VGND sg13cmos5l_decap_8
* cell instance sg13cmos5l_decap_8_1981 r0 *1 0,0
Xsg13cmos5l_decap_8_1981 VPWR VGND sg13cmos5l_decap_8
* cell instance sg13cmos5l_decap_8_1982 r0 *1 0,0
Xsg13cmos5l_decap_8_1982 VPWR VGND sg13cmos5l_decap_8
* cell instance sg13cmos5l_decap_8_1983 r0 *1 0,0
Xsg13cmos5l_decap_8_1983 VPWR VGND sg13cmos5l_decap_8
* cell instance sg13cmos5l_decap_8_1984 r0 *1 0,0
Xsg13cmos5l_decap_8_1984 VPWR VGND sg13cmos5l_decap_8
* cell instance sg13cmos5l_decap_8_1985 r0 *1 0,0
Xsg13cmos5l_decap_8_1985 VPWR VGND sg13cmos5l_decap_8
* cell instance sg13cmos5l_decap_8_1986 r0 *1 0,0
Xsg13cmos5l_decap_8_1986 VPWR VGND sg13cmos5l_decap_8
* cell instance sg13cmos5l_decap_8_1987 r0 *1 0,0
Xsg13cmos5l_decap_8_1987 VPWR VGND sg13cmos5l_decap_8
* cell instance sg13cmos5l_decap_8_1988 r0 *1 0,0
Xsg13cmos5l_decap_8_1988 VPWR VGND sg13cmos5l_decap_8
* cell instance sg13cmos5l_decap_8_1989 r0 *1 0,0
Xsg13cmos5l_decap_8_1989 VPWR VGND sg13cmos5l_decap_8
* cell instance sg13cmos5l_decap_8_1990 r0 *1 0,0
Xsg13cmos5l_decap_8_1990 VPWR VGND sg13cmos5l_decap_8
* cell instance sg13cmos5l_decap_8_1991 r0 *1 0,0
Xsg13cmos5l_decap_8_1991 VPWR VGND sg13cmos5l_decap_8
* cell instance sg13cmos5l_decap_8_1992 r0 *1 0,0
Xsg13cmos5l_decap_8_1992 VPWR VGND sg13cmos5l_decap_8
* cell instance sg13cmos5l_decap_8_1993 r0 *1 0,0
Xsg13cmos5l_decap_8_1993 VPWR VGND sg13cmos5l_decap_8
* cell instance sg13cmos5l_decap_8_1994 r0 *1 0,0
Xsg13cmos5l_decap_8_1994 VPWR VGND sg13cmos5l_decap_8
* cell instance sg13cmos5l_decap_8_1995 r0 *1 0,0
Xsg13cmos5l_decap_8_1995 VPWR VGND sg13cmos5l_decap_8
* cell instance sg13cmos5l_decap_8_1996 r0 *1 0,0
Xsg13cmos5l_decap_8_1996 VPWR VGND sg13cmos5l_decap_8
* cell instance sg13cmos5l_decap_8_1997 r0 *1 0,0
Xsg13cmos5l_decap_8_1997 VPWR VGND sg13cmos5l_decap_8
* cell instance sg13cmos5l_decap_8_1998 r0 *1 0,0
Xsg13cmos5l_decap_8_1998 VPWR VGND sg13cmos5l_decap_8
* cell instance sg13cmos5l_decap_8_1999 r0 *1 0,0
Xsg13cmos5l_decap_8_1999 VPWR VGND sg13cmos5l_decap_8
* cell instance sg13cmos5l_decap_8_2000 r0 *1 0,0
Xsg13cmos5l_decap_8_2000 VPWR VGND sg13cmos5l_decap_8
* cell instance sg13cmos5l_decap_8_2001 r0 *1 0,0
Xsg13cmos5l_decap_8_2001 VPWR VGND sg13cmos5l_decap_8
* cell instance sg13cmos5l_decap_8_2002 r0 *1 0,0
Xsg13cmos5l_decap_8_2002 VPWR VGND sg13cmos5l_decap_8
* cell instance sg13cmos5l_decap_8_2003 r0 *1 0,0
Xsg13cmos5l_decap_8_2003 VPWR VGND sg13cmos5l_decap_8
* cell instance sg13cmos5l_decap_8_2004 r0 *1 0,0
Xsg13cmos5l_decap_8_2004 VPWR VGND sg13cmos5l_decap_8
* cell instance sg13cmos5l_decap_8_2005 r0 *1 0,0
Xsg13cmos5l_decap_8_2005 VPWR VGND sg13cmos5l_decap_8
* cell instance sg13cmos5l_decap_8_2006 r0 *1 0,0
Xsg13cmos5l_decap_8_2006 VPWR VGND sg13cmos5l_decap_8
* cell instance sg13cmos5l_decap_8_2007 r0 *1 0,0
Xsg13cmos5l_decap_8_2007 VPWR VGND sg13cmos5l_decap_8
* cell instance sg13cmos5l_decap_8_2008 r0 *1 0,0
Xsg13cmos5l_decap_8_2008 VPWR VGND sg13cmos5l_decap_8
* cell instance sg13cmos5l_decap_8_2009 r0 *1 0,0
Xsg13cmos5l_decap_8_2009 VPWR VGND sg13cmos5l_decap_8
* cell instance sg13cmos5l_decap_8_2010 r0 *1 0,0
Xsg13cmos5l_decap_8_2010 VPWR VGND sg13cmos5l_decap_8
* cell instance sg13cmos5l_decap_8_2011 r0 *1 0,0
Xsg13cmos5l_decap_8_2011 VPWR VGND sg13cmos5l_decap_8
* cell instance sg13cmos5l_decap_8_2012 r0 *1 0,0
Xsg13cmos5l_decap_8_2012 VPWR VGND sg13cmos5l_decap_8
* cell instance sg13cmos5l_decap_8_2013 r0 *1 0,0
Xsg13cmos5l_decap_8_2013 VPWR VGND sg13cmos5l_decap_8
* cell instance sg13cmos5l_decap_8_2014 r0 *1 0,0
Xsg13cmos5l_decap_8_2014 VPWR VGND sg13cmos5l_decap_8
* cell instance sg13cmos5l_decap_8_2015 r0 *1 0,0
Xsg13cmos5l_decap_8_2015 VPWR VGND sg13cmos5l_decap_8
* cell instance sg13cmos5l_decap_8_2016 r0 *1 0,0
Xsg13cmos5l_decap_8_2016 VPWR VGND sg13cmos5l_decap_8
* cell instance sg13cmos5l_decap_8_2017 r0 *1 0,0
Xsg13cmos5l_decap_8_2017 VPWR VGND sg13cmos5l_decap_8
* cell instance sg13cmos5l_decap_8_2018 r0 *1 0,0
Xsg13cmos5l_decap_8_2018 VPWR VGND sg13cmos5l_decap_8
* cell instance sg13cmos5l_decap_8_2019 r0 *1 0,0
Xsg13cmos5l_decap_8_2019 VPWR VGND sg13cmos5l_decap_8
* cell instance sg13cmos5l_decap_8_2020 r0 *1 0,0
Xsg13cmos5l_decap_8_2020 VPWR VGND sg13cmos5l_decap_8
* cell instance sg13cmos5l_decap_8_2021 r0 *1 0,0
Xsg13cmos5l_decap_8_2021 VPWR VGND sg13cmos5l_decap_8
* cell instance sg13cmos5l_decap_8_2022 r0 *1 0,0
Xsg13cmos5l_decap_8_2022 VPWR VGND sg13cmos5l_decap_8
* cell instance sg13cmos5l_decap_8_2023 r0 *1 0,0
Xsg13cmos5l_decap_8_2023 VPWR VGND sg13cmos5l_decap_8
* cell instance sg13cmos5l_decap_8_2024 r0 *1 0,0
Xsg13cmos5l_decap_8_2024 VPWR VGND sg13cmos5l_decap_8
* cell instance sg13cmos5l_decap_8_2025 r0 *1 0,0
Xsg13cmos5l_decap_8_2025 VPWR VGND sg13cmos5l_decap_8
* cell instance sg13cmos5l_decap_8_2026 r0 *1 0,0
Xsg13cmos5l_decap_8_2026 VPWR VGND sg13cmos5l_decap_8
* cell instance sg13cmos5l_decap_8_2027 r0 *1 0,0
Xsg13cmos5l_decap_8_2027 VPWR VGND sg13cmos5l_decap_8
* cell instance sg13cmos5l_decap_8_2028 r0 *1 0,0
Xsg13cmos5l_decap_8_2028 VPWR VGND sg13cmos5l_decap_8
* cell instance sg13cmos5l_decap_8_2029 r0 *1 0,0
Xsg13cmos5l_decap_8_2029 VPWR VGND sg13cmos5l_decap_8
* cell instance sg13cmos5l_decap_8_2030 r0 *1 0,0
Xsg13cmos5l_decap_8_2030 VPWR VGND sg13cmos5l_decap_8
* cell instance sg13cmos5l_decap_8_2031 r0 *1 0,0
Xsg13cmos5l_decap_8_2031 VPWR VGND sg13cmos5l_decap_8
* cell instance sg13cmos5l_decap_8_2032 r0 *1 0,0
Xsg13cmos5l_decap_8_2032 VPWR VGND sg13cmos5l_decap_8
* cell instance sg13cmos5l_decap_8_2033 r0 *1 0,0
Xsg13cmos5l_decap_8_2033 VPWR VGND sg13cmos5l_decap_8
* cell instance sg13cmos5l_decap_8_2034 r0 *1 0,0
Xsg13cmos5l_decap_8_2034 VPWR VGND sg13cmos5l_decap_8
* cell instance sg13cmos5l_decap_8_2035 r0 *1 0,0
Xsg13cmos5l_decap_8_2035 VPWR VGND sg13cmos5l_decap_8
* cell instance sg13cmos5l_decap_8_2036 r0 *1 0,0
Xsg13cmos5l_decap_8_2036 VPWR VGND sg13cmos5l_decap_8
* cell instance sg13cmos5l_decap_8_2037 r0 *1 0,0
Xsg13cmos5l_decap_8_2037 VPWR VGND sg13cmos5l_decap_8
* cell instance sg13cmos5l_decap_8_2038 r0 *1 0,0
Xsg13cmos5l_decap_8_2038 VPWR VGND sg13cmos5l_decap_8
* cell instance sg13cmos5l_decap_8_2039 r0 *1 0,0
Xsg13cmos5l_decap_8_2039 VPWR VGND sg13cmos5l_decap_8
* cell instance sg13cmos5l_decap_8_2040 r0 *1 0,0
Xsg13cmos5l_decap_8_2040 VPWR VGND sg13cmos5l_decap_8
* cell instance sg13cmos5l_decap_8_2041 r0 *1 0,0
Xsg13cmos5l_decap_8_2041 VPWR VGND sg13cmos5l_decap_8
* cell instance sg13cmos5l_decap_8_2042 r0 *1 0,0
Xsg13cmos5l_decap_8_2042 VPWR VGND sg13cmos5l_decap_8
* cell instance sg13cmos5l_decap_8_2043 r0 *1 0,0
Xsg13cmos5l_decap_8_2043 VPWR VGND sg13cmos5l_decap_8
* cell instance sg13cmos5l_decap_8_2044 r0 *1 0,0
Xsg13cmos5l_decap_8_2044 VPWR VGND sg13cmos5l_decap_8
* cell instance sg13cmos5l_decap_8_2045 r0 *1 0,0
Xsg13cmos5l_decap_8_2045 VPWR VGND sg13cmos5l_decap_8
* cell instance sg13cmos5l_decap_8_2046 r0 *1 0,0
Xsg13cmos5l_decap_8_2046 VPWR VGND sg13cmos5l_decap_8
* cell instance sg13cmos5l_decap_8_2047 r0 *1 0,0
Xsg13cmos5l_decap_8_2047 VPWR VGND sg13cmos5l_decap_8
* cell instance sg13cmos5l_decap_8_2048 r0 *1 0,0
Xsg13cmos5l_decap_8_2048 VPWR VGND sg13cmos5l_decap_8
* cell instance sg13cmos5l_decap_8_2049 r0 *1 0,0
Xsg13cmos5l_decap_8_2049 VPWR VGND sg13cmos5l_decap_8
* cell instance sg13cmos5l_decap_8_2050 r0 *1 0,0
Xsg13cmos5l_decap_8_2050 VPWR VGND sg13cmos5l_decap_8
* cell instance sg13cmos5l_decap_8_2051 r0 *1 0,0
Xsg13cmos5l_decap_8_2051 VPWR VGND sg13cmos5l_decap_8
* cell instance sg13cmos5l_decap_8_2052 r0 *1 0,0
Xsg13cmos5l_decap_8_2052 VPWR VGND sg13cmos5l_decap_8
* cell instance sg13cmos5l_decap_8_2053 r0 *1 0,0
Xsg13cmos5l_decap_8_2053 VPWR VGND sg13cmos5l_decap_8
* cell instance sg13cmos5l_decap_8_2054 r0 *1 0,0
Xsg13cmos5l_decap_8_2054 VPWR VGND sg13cmos5l_decap_8
* cell instance sg13cmos5l_decap_8_2055 r0 *1 0,0
Xsg13cmos5l_decap_8_2055 VPWR VGND sg13cmos5l_decap_8
* cell instance sg13cmos5l_decap_8_2056 r0 *1 0,0
Xsg13cmos5l_decap_8_2056 VPWR VGND sg13cmos5l_decap_8
* cell instance sg13cmos5l_decap_8_2057 r0 *1 0,0
Xsg13cmos5l_decap_8_2057 VPWR VGND sg13cmos5l_decap_8
* cell instance sg13cmos5l_decap_8_2058 r0 *1 0,0
Xsg13cmos5l_decap_8_2058 VPWR VGND sg13cmos5l_decap_8
* cell instance sg13cmos5l_decap_8_2059 r0 *1 0,0
Xsg13cmos5l_decap_8_2059 VPWR VGND sg13cmos5l_decap_8
* cell instance sg13cmos5l_decap_8_2060 r0 *1 0,0
Xsg13cmos5l_decap_8_2060 VPWR VGND sg13cmos5l_decap_8
* cell instance sg13cmos5l_decap_8_2061 r0 *1 0,0
Xsg13cmos5l_decap_8_2061 VPWR VGND sg13cmos5l_decap_8
* cell instance sg13cmos5l_decap_8_2062 r0 *1 0,0
Xsg13cmos5l_decap_8_2062 VPWR VGND sg13cmos5l_decap_8
* cell instance sg13cmos5l_decap_8_2063 r0 *1 0,0
Xsg13cmos5l_decap_8_2063 VPWR VGND sg13cmos5l_decap_8
* cell instance sg13cmos5l_decap_8_2064 r0 *1 0,0
Xsg13cmos5l_decap_8_2064 VPWR VGND sg13cmos5l_decap_8
* cell instance sg13cmos5l_decap_8_2065 r0 *1 0,0
Xsg13cmos5l_decap_8_2065 VPWR VGND sg13cmos5l_decap_8
* cell instance sg13cmos5l_decap_8_2066 r0 *1 0,0
Xsg13cmos5l_decap_8_2066 VPWR VGND sg13cmos5l_decap_8
* cell instance sg13cmos5l_decap_8_2067 r0 *1 0,0
Xsg13cmos5l_decap_8_2067 VPWR VGND sg13cmos5l_decap_8
* cell instance sg13cmos5l_decap_8_2068 r0 *1 0,0
Xsg13cmos5l_decap_8_2068 VPWR VGND sg13cmos5l_decap_8
* cell instance sg13cmos5l_decap_8_2069 r0 *1 0,0
Xsg13cmos5l_decap_8_2069 VPWR VGND sg13cmos5l_decap_8
* cell instance sg13cmos5l_decap_8_2070 r0 *1 0,0
Xsg13cmos5l_decap_8_2070 VPWR VGND sg13cmos5l_decap_8
* cell instance sg13cmos5l_decap_8_2071 r0 *1 0,0
Xsg13cmos5l_decap_8_2071 VPWR VGND sg13cmos5l_decap_8
* cell instance sg13cmos5l_decap_8_2072 r0 *1 0,0
Xsg13cmos5l_decap_8_2072 VPWR VGND sg13cmos5l_decap_8
* cell instance sg13cmos5l_decap_8_2073 r0 *1 0,0
Xsg13cmos5l_decap_8_2073 VPWR VGND sg13cmos5l_decap_8
* cell instance sg13cmos5l_decap_8_2074 r0 *1 0,0
Xsg13cmos5l_decap_8_2074 VPWR VGND sg13cmos5l_decap_8
* cell instance sg13cmos5l_decap_8_2075 r0 *1 0,0
Xsg13cmos5l_decap_8_2075 VPWR VGND sg13cmos5l_decap_8
* cell instance sg13cmos5l_decap_8_2076 r0 *1 0,0
Xsg13cmos5l_decap_8_2076 VPWR VGND sg13cmos5l_decap_8
* cell instance sg13cmos5l_decap_8_2077 r0 *1 0,0
Xsg13cmos5l_decap_8_2077 VPWR VGND sg13cmos5l_decap_8
* cell instance sg13cmos5l_decap_8_2078 r0 *1 0,0
Xsg13cmos5l_decap_8_2078 VPWR VGND sg13cmos5l_decap_8
* cell instance sg13cmos5l_decap_8_2079 r0 *1 0,0
Xsg13cmos5l_decap_8_2079 VPWR VGND sg13cmos5l_decap_8
* cell instance sg13cmos5l_decap_8_2080 r0 *1 0,0
Xsg13cmos5l_decap_8_2080 VPWR VGND sg13cmos5l_decap_8
* cell instance sg13cmos5l_decap_8_2081 r0 *1 0,0
Xsg13cmos5l_decap_8_2081 VPWR VGND sg13cmos5l_decap_8
* cell instance sg13cmos5l_decap_8_2082 r0 *1 0,0
Xsg13cmos5l_decap_8_2082 VPWR VGND sg13cmos5l_decap_8
* cell instance sg13cmos5l_decap_8_2083 r0 *1 0,0
Xsg13cmos5l_decap_8_2083 VPWR VGND sg13cmos5l_decap_8
* cell instance sg13cmos5l_decap_8_2084 r0 *1 0,0
Xsg13cmos5l_decap_8_2084 VPWR VGND sg13cmos5l_decap_8
* cell instance sg13cmos5l_decap_8_2085 r0 *1 0,0
Xsg13cmos5l_decap_8_2085 VPWR VGND sg13cmos5l_decap_8
* cell instance sg13cmos5l_decap_8_2086 r0 *1 0,0
Xsg13cmos5l_decap_8_2086 VPWR VGND sg13cmos5l_decap_8
* cell instance sg13cmos5l_decap_8_2087 r0 *1 0,0
Xsg13cmos5l_decap_8_2087 VPWR VGND sg13cmos5l_decap_8
* cell instance sg13cmos5l_decap_8_2088 r0 *1 0,0
Xsg13cmos5l_decap_8_2088 VPWR VGND sg13cmos5l_decap_8
* cell instance sg13cmos5l_decap_8_2089 r0 *1 0,0
Xsg13cmos5l_decap_8_2089 VPWR VGND sg13cmos5l_decap_8
* cell instance sg13cmos5l_decap_8_2090 r0 *1 0,0
Xsg13cmos5l_decap_8_2090 VPWR VGND sg13cmos5l_decap_8
* cell instance sg13cmos5l_decap_8_2091 r0 *1 0,0
Xsg13cmos5l_decap_8_2091 VPWR VGND sg13cmos5l_decap_8
* cell instance sg13cmos5l_decap_8_2092 r0 *1 0,0
Xsg13cmos5l_decap_8_2092 VPWR VGND sg13cmos5l_decap_8
* cell instance sg13cmos5l_decap_8_2093 r0 *1 0,0
Xsg13cmos5l_decap_8_2093 VPWR VGND sg13cmos5l_decap_8
* cell instance sg13cmos5l_decap_8_2094 r0 *1 0,0
Xsg13cmos5l_decap_8_2094 VPWR VGND sg13cmos5l_decap_8
* cell instance sg13cmos5l_decap_8_2095 r0 *1 0,0
Xsg13cmos5l_decap_8_2095 VPWR VGND sg13cmos5l_decap_8
* cell instance sg13cmos5l_decap_8_2096 r0 *1 0,0
Xsg13cmos5l_decap_8_2096 VPWR VGND sg13cmos5l_decap_8
* cell instance sg13cmos5l_decap_8_2097 r0 *1 0,0
Xsg13cmos5l_decap_8_2097 VPWR VGND sg13cmos5l_decap_8
* cell instance sg13cmos5l_decap_8_2098 r0 *1 0,0
Xsg13cmos5l_decap_8_2098 VPWR VGND sg13cmos5l_decap_8
* cell instance sg13cmos5l_decap_8_2099 r0 *1 0,0
Xsg13cmos5l_decap_8_2099 VPWR VGND sg13cmos5l_decap_8
* cell instance sg13cmos5l_decap_8_2100 r0 *1 0,0
Xsg13cmos5l_decap_8_2100 VPWR VGND sg13cmos5l_decap_8
* cell instance sg13cmos5l_decap_8_2101 r0 *1 0,0
Xsg13cmos5l_decap_8_2101 VPWR VGND sg13cmos5l_decap_8
* cell instance sg13cmos5l_decap_8_2102 r0 *1 0,0
Xsg13cmos5l_decap_8_2102 VPWR VGND sg13cmos5l_decap_8
* cell instance sg13cmos5l_decap_8_2103 r0 *1 0,0
Xsg13cmos5l_decap_8_2103 VPWR VGND sg13cmos5l_decap_8
* cell instance sg13cmos5l_decap_8_2104 r0 *1 0,0
Xsg13cmos5l_decap_8_2104 VPWR VGND sg13cmos5l_decap_8
* cell instance sg13cmos5l_decap_8_2105 r0 *1 0,0
Xsg13cmos5l_decap_8_2105 VPWR VGND sg13cmos5l_decap_8
* cell instance sg13cmos5l_decap_8_2106 r0 *1 0,0
Xsg13cmos5l_decap_8_2106 VPWR VGND sg13cmos5l_decap_8
* cell instance sg13cmos5l_decap_8_2107 r0 *1 0,0
Xsg13cmos5l_decap_8_2107 VPWR VGND sg13cmos5l_decap_8
* cell instance sg13cmos5l_decap_8_2108 r0 *1 0,0
Xsg13cmos5l_decap_8_2108 VPWR VGND sg13cmos5l_decap_8
* cell instance sg13cmos5l_decap_8_2109 r0 *1 0,0
Xsg13cmos5l_decap_8_2109 VPWR VGND sg13cmos5l_decap_8
* cell instance sg13cmos5l_decap_8_2110 r0 *1 0,0
Xsg13cmos5l_decap_8_2110 VPWR VGND sg13cmos5l_decap_8
* cell instance sg13cmos5l_decap_8_2111 r0 *1 0,0
Xsg13cmos5l_decap_8_2111 VPWR VGND sg13cmos5l_decap_8
* cell instance sg13cmos5l_decap_8_2112 r0 *1 0,0
Xsg13cmos5l_decap_8_2112 VPWR VGND sg13cmos5l_decap_8
* cell instance sg13cmos5l_decap_8_2113 r0 *1 0,0
Xsg13cmos5l_decap_8_2113 VPWR VGND sg13cmos5l_decap_8
* cell instance sg13cmos5l_decap_8_2114 r0 *1 0,0
Xsg13cmos5l_decap_8_2114 VPWR VGND sg13cmos5l_decap_8
* cell instance sg13cmos5l_decap_8_2115 r0 *1 0,0
Xsg13cmos5l_decap_8_2115 VPWR VGND sg13cmos5l_decap_8
* cell instance sg13cmos5l_decap_8_2116 r0 *1 0,0
Xsg13cmos5l_decap_8_2116 VPWR VGND sg13cmos5l_decap_8
* cell instance sg13cmos5l_decap_8_2117 r0 *1 0,0
Xsg13cmos5l_decap_8_2117 VPWR VGND sg13cmos5l_decap_8
* cell instance sg13cmos5l_decap_8_2118 r0 *1 0,0
Xsg13cmos5l_decap_8_2118 VPWR VGND sg13cmos5l_decap_8
* cell instance sg13cmos5l_decap_8_2119 r0 *1 0,0
Xsg13cmos5l_decap_8_2119 VPWR VGND sg13cmos5l_decap_8
* cell instance sg13cmos5l_decap_8_2120 r0 *1 0,0
Xsg13cmos5l_decap_8_2120 VPWR VGND sg13cmos5l_decap_8
* cell instance sg13cmos5l_decap_8_2121 r0 *1 0,0
Xsg13cmos5l_decap_8_2121 VPWR VGND sg13cmos5l_decap_8
* cell instance sg13cmos5l_decap_8_2122 r0 *1 0,0
Xsg13cmos5l_decap_8_2122 VPWR VGND sg13cmos5l_decap_8
* cell instance sg13cmos5l_decap_8_2123 r0 *1 0,0
Xsg13cmos5l_decap_8_2123 VPWR VGND sg13cmos5l_decap_8
* cell instance sg13cmos5l_decap_8_2124 r0 *1 0,0
Xsg13cmos5l_decap_8_2124 VPWR VGND sg13cmos5l_decap_8
* cell instance sg13cmos5l_decap_8_2125 r0 *1 0,0
Xsg13cmos5l_decap_8_2125 VPWR VGND sg13cmos5l_decap_8
* cell instance sg13cmos5l_decap_8_2126 r0 *1 0,0
Xsg13cmos5l_decap_8_2126 VPWR VGND sg13cmos5l_decap_8
* cell instance sg13cmos5l_decap_8_2127 r0 *1 0,0
Xsg13cmos5l_decap_8_2127 VPWR VGND sg13cmos5l_decap_8
* cell instance sg13cmos5l_decap_8_2128 r0 *1 0,0
Xsg13cmos5l_decap_8_2128 VPWR VGND sg13cmos5l_decap_8
* cell instance sg13cmos5l_decap_8_2129 r0 *1 0,0
Xsg13cmos5l_decap_8_2129 VPWR VGND sg13cmos5l_decap_8
* cell instance sg13cmos5l_decap_8_2130 r0 *1 0,0
Xsg13cmos5l_decap_8_2130 VPWR VGND sg13cmos5l_decap_8
* cell instance sg13cmos5l_decap_8_2131 r0 *1 0,0
Xsg13cmos5l_decap_8_2131 VPWR VGND sg13cmos5l_decap_8
* cell instance sg13cmos5l_decap_8_2132 r0 *1 0,0
Xsg13cmos5l_decap_8_2132 VPWR VGND sg13cmos5l_decap_8
* cell instance sg13cmos5l_decap_8_2133 r0 *1 0,0
Xsg13cmos5l_decap_8_2133 VPWR VGND sg13cmos5l_decap_8
* cell instance sg13cmos5l_decap_8_2134 r0 *1 0,0
Xsg13cmos5l_decap_8_2134 VPWR VGND sg13cmos5l_decap_8
* cell instance sg13cmos5l_decap_8_2135 r0 *1 0,0
Xsg13cmos5l_decap_8_2135 VPWR VGND sg13cmos5l_decap_8
* cell instance sg13cmos5l_decap_8_2136 r0 *1 0,0
Xsg13cmos5l_decap_8_2136 VPWR VGND sg13cmos5l_decap_8
* cell instance sg13cmos5l_decap_8_2137 r0 *1 0,0
Xsg13cmos5l_decap_8_2137 VPWR VGND sg13cmos5l_decap_8
* cell instance sg13cmos5l_decap_8_2138 r0 *1 0,0
Xsg13cmos5l_decap_8_2138 VPWR VGND sg13cmos5l_decap_8
* cell instance sg13cmos5l_decap_8_2139 r0 *1 0,0
Xsg13cmos5l_decap_8_2139 VPWR VGND sg13cmos5l_decap_8
* cell instance sg13cmos5l_decap_8_2140 r0 *1 0,0
Xsg13cmos5l_decap_8_2140 VPWR VGND sg13cmos5l_decap_8
* cell instance sg13cmos5l_decap_8_2141 r0 *1 0,0
Xsg13cmos5l_decap_8_2141 VPWR VGND sg13cmos5l_decap_8
* cell instance sg13cmos5l_decap_8_2142 r0 *1 0,0
Xsg13cmos5l_decap_8_2142 VPWR VGND sg13cmos5l_decap_8
* cell instance sg13cmos5l_decap_8_2143 r0 *1 0,0
Xsg13cmos5l_decap_8_2143 VPWR VGND sg13cmos5l_decap_8
* cell instance sg13cmos5l_decap_8_2144 r0 *1 0,0
Xsg13cmos5l_decap_8_2144 VPWR VGND sg13cmos5l_decap_8
* cell instance sg13cmos5l_decap_8_2145 r0 *1 0,0
Xsg13cmos5l_decap_8_2145 VPWR VGND sg13cmos5l_decap_8
* cell instance sg13cmos5l_decap_8_2146 r0 *1 0,0
Xsg13cmos5l_decap_8_2146 VPWR VGND sg13cmos5l_decap_8
* cell instance sg13cmos5l_decap_8_2147 r0 *1 0,0
Xsg13cmos5l_decap_8_2147 VPWR VGND sg13cmos5l_decap_8
* cell instance sg13cmos5l_decap_8_2148 r0 *1 0,0
Xsg13cmos5l_decap_8_2148 VPWR VGND sg13cmos5l_decap_8
* cell instance sg13cmos5l_decap_8_2149 r0 *1 0,0
Xsg13cmos5l_decap_8_2149 VPWR VGND sg13cmos5l_decap_8
* cell instance sg13cmos5l_decap_8_2150 r0 *1 0,0
Xsg13cmos5l_decap_8_2150 VPWR VGND sg13cmos5l_decap_8
* cell instance sg13cmos5l_decap_8_2151 r0 *1 0,0
Xsg13cmos5l_decap_8_2151 VPWR VGND sg13cmos5l_decap_8
* cell instance sg13cmos5l_decap_8_2152 r0 *1 0,0
Xsg13cmos5l_decap_8_2152 VPWR VGND sg13cmos5l_decap_8
* cell instance sg13cmos5l_decap_8_2153 r0 *1 0,0
Xsg13cmos5l_decap_8_2153 VPWR VGND sg13cmos5l_decap_8
* cell instance sg13cmos5l_decap_8_2154 r0 *1 0,0
Xsg13cmos5l_decap_8_2154 VPWR VGND sg13cmos5l_decap_8
* cell instance sg13cmos5l_decap_8_2155 r0 *1 0,0
Xsg13cmos5l_decap_8_2155 VPWR VGND sg13cmos5l_decap_8
* cell instance sg13cmos5l_decap_8_2156 r0 *1 0,0
Xsg13cmos5l_decap_8_2156 VPWR VGND sg13cmos5l_decap_8
* cell instance sg13cmos5l_decap_8_2157 r0 *1 0,0
Xsg13cmos5l_decap_8_2157 VPWR VGND sg13cmos5l_decap_8
* cell instance sg13cmos5l_decap_8_2158 r0 *1 0,0
Xsg13cmos5l_decap_8_2158 VPWR VGND sg13cmos5l_decap_8
* cell instance sg13cmos5l_decap_8_2159 r0 *1 0,0
Xsg13cmos5l_decap_8_2159 VPWR VGND sg13cmos5l_decap_8
* cell instance sg13cmos5l_decap_8_2160 r0 *1 0,0
Xsg13cmos5l_decap_8_2160 VPWR VGND sg13cmos5l_decap_8
* cell instance sg13cmos5l_decap_8_2161 r0 *1 0,0
Xsg13cmos5l_decap_8_2161 VPWR VGND sg13cmos5l_decap_8
* cell instance sg13cmos5l_decap_8_2162 r0 *1 0,0
Xsg13cmos5l_decap_8_2162 VPWR VGND sg13cmos5l_decap_8
* cell instance sg13cmos5l_decap_8_2163 r0 *1 0,0
Xsg13cmos5l_decap_8_2163 VPWR VGND sg13cmos5l_decap_8
* cell instance sg13cmos5l_decap_8_2164 r0 *1 0,0
Xsg13cmos5l_decap_8_2164 VPWR VGND sg13cmos5l_decap_8
* cell instance sg13cmos5l_decap_8_2165 r0 *1 0,0
Xsg13cmos5l_decap_8_2165 VPWR VGND sg13cmos5l_decap_8
* cell instance sg13cmos5l_decap_8_2166 r0 *1 0,0
Xsg13cmos5l_decap_8_2166 VPWR VGND sg13cmos5l_decap_8
* cell instance sg13cmos5l_decap_8_2167 r0 *1 0,0
Xsg13cmos5l_decap_8_2167 VPWR VGND sg13cmos5l_decap_8
* cell instance sg13cmos5l_decap_8_2168 r0 *1 0,0
Xsg13cmos5l_decap_8_2168 VPWR VGND sg13cmos5l_decap_8
* cell instance sg13cmos5l_decap_8_2169 r0 *1 0,0
Xsg13cmos5l_decap_8_2169 VPWR VGND sg13cmos5l_decap_8
* cell instance sg13cmos5l_decap_8_2170 r0 *1 0,0
Xsg13cmos5l_decap_8_2170 VPWR VGND sg13cmos5l_decap_8
* cell instance sg13cmos5l_decap_8_2171 r0 *1 0,0
Xsg13cmos5l_decap_8_2171 VPWR VGND sg13cmos5l_decap_8
* cell instance sg13cmos5l_decap_8_2172 r0 *1 0,0
Xsg13cmos5l_decap_8_2172 VPWR VGND sg13cmos5l_decap_8
* cell instance sg13cmos5l_decap_8_2173 r0 *1 0,0
Xsg13cmos5l_decap_8_2173 VPWR VGND sg13cmos5l_decap_8
* cell instance sg13cmos5l_decap_8_2174 r0 *1 0,0
Xsg13cmos5l_decap_8_2174 VPWR VGND sg13cmos5l_decap_8
* cell instance sg13cmos5l_decap_8_2175 r0 *1 0,0
Xsg13cmos5l_decap_8_2175 VPWR VGND sg13cmos5l_decap_8
* cell instance sg13cmos5l_decap_8_2176 r0 *1 0,0
Xsg13cmos5l_decap_8_2176 VPWR VGND sg13cmos5l_decap_8
* cell instance sg13cmos5l_decap_8_2177 r0 *1 0,0
Xsg13cmos5l_decap_8_2177 VPWR VGND sg13cmos5l_decap_8
* cell instance sg13cmos5l_decap_8_2178 r0 *1 0,0
Xsg13cmos5l_decap_8_2178 VPWR VGND sg13cmos5l_decap_8
* cell instance sg13cmos5l_decap_8_2179 r0 *1 0,0
Xsg13cmos5l_decap_8_2179 VPWR VGND sg13cmos5l_decap_8
* cell instance sg13cmos5l_decap_8_2180 r0 *1 0,0
Xsg13cmos5l_decap_8_2180 VPWR VGND sg13cmos5l_decap_8
* cell instance sg13cmos5l_decap_8_2181 r0 *1 0,0
Xsg13cmos5l_decap_8_2181 VPWR VGND sg13cmos5l_decap_8
* cell instance sg13cmos5l_decap_8_2182 r0 *1 0,0
Xsg13cmos5l_decap_8_2182 VPWR VGND sg13cmos5l_decap_8
* cell instance sg13cmos5l_decap_8_2183 r0 *1 0,0
Xsg13cmos5l_decap_8_2183 VPWR VGND sg13cmos5l_decap_8
* cell instance sg13cmos5l_decap_8_2184 r0 *1 0,0
Xsg13cmos5l_decap_8_2184 VPWR VGND sg13cmos5l_decap_8
* cell instance sg13cmos5l_decap_8_2185 r0 *1 0,0
Xsg13cmos5l_decap_8_2185 VPWR VGND sg13cmos5l_decap_8
* cell instance sg13cmos5l_decap_8_2186 r0 *1 0,0
Xsg13cmos5l_decap_8_2186 VPWR VGND sg13cmos5l_decap_8
* cell instance sg13cmos5l_decap_8_2187 r0 *1 0,0
Xsg13cmos5l_decap_8_2187 VPWR VGND sg13cmos5l_decap_8
* cell instance sg13cmos5l_decap_8_2188 r0 *1 0,0
Xsg13cmos5l_decap_8_2188 VPWR VGND sg13cmos5l_decap_8
* cell instance sg13cmos5l_decap_8_2189 r0 *1 0,0
Xsg13cmos5l_decap_8_2189 VPWR VGND sg13cmos5l_decap_8
* cell instance sg13cmos5l_decap_8_2190 r0 *1 0,0
Xsg13cmos5l_decap_8_2190 VPWR VGND sg13cmos5l_decap_8
* cell instance sg13cmos5l_decap_8_2191 r0 *1 0,0
Xsg13cmos5l_decap_8_2191 VPWR VGND sg13cmos5l_decap_8
* cell instance sg13cmos5l_decap_8_2192 r0 *1 0,0
Xsg13cmos5l_decap_8_2192 VPWR VGND sg13cmos5l_decap_8
* cell instance sg13cmos5l_decap_8_2193 r0 *1 0,0
Xsg13cmos5l_decap_8_2193 VPWR VGND sg13cmos5l_decap_8
* cell instance sg13cmos5l_decap_8_2194 r0 *1 0,0
Xsg13cmos5l_decap_8_2194 VPWR VGND sg13cmos5l_decap_8
* cell instance sg13cmos5l_decap_8_2195 r0 *1 0,0
Xsg13cmos5l_decap_8_2195 VPWR VGND sg13cmos5l_decap_8
* cell instance sg13cmos5l_decap_8_2196 r0 *1 0,0
Xsg13cmos5l_decap_8_2196 VPWR VGND sg13cmos5l_decap_8
* cell instance sg13cmos5l_decap_8_2197 r0 *1 0,0
Xsg13cmos5l_decap_8_2197 VPWR VGND sg13cmos5l_decap_8
* cell instance sg13cmos5l_decap_8_2198 r0 *1 0,0
Xsg13cmos5l_decap_8_2198 VPWR VGND sg13cmos5l_decap_8
* cell instance sg13cmos5l_decap_8_2199 r0 *1 0,0
Xsg13cmos5l_decap_8_2199 VPWR VGND sg13cmos5l_decap_8
* cell instance sg13cmos5l_decap_8_2200 r0 *1 0,0
Xsg13cmos5l_decap_8_2200 VPWR VGND sg13cmos5l_decap_8
* cell instance sg13cmos5l_decap_8_2201 r0 *1 0,0
Xsg13cmos5l_decap_8_2201 VPWR VGND sg13cmos5l_decap_8
* cell instance sg13cmos5l_decap_8_2202 r0 *1 0,0
Xsg13cmos5l_decap_8_2202 VPWR VGND sg13cmos5l_decap_8
* cell instance sg13cmos5l_decap_8_2203 r0 *1 0,0
Xsg13cmos5l_decap_8_2203 VPWR VGND sg13cmos5l_decap_8
* cell instance sg13cmos5l_decap_8_2204 r0 *1 0,0
Xsg13cmos5l_decap_8_2204 VPWR VGND sg13cmos5l_decap_8
* cell instance sg13cmos5l_decap_8_2205 r0 *1 0,0
Xsg13cmos5l_decap_8_2205 VPWR VGND sg13cmos5l_decap_8
* cell instance sg13cmos5l_decap_8_2206 r0 *1 0,0
Xsg13cmos5l_decap_8_2206 VPWR VGND sg13cmos5l_decap_8
* cell instance sg13cmos5l_decap_8_2207 r0 *1 0,0
Xsg13cmos5l_decap_8_2207 VPWR VGND sg13cmos5l_decap_8
* cell instance sg13cmos5l_decap_8_2208 r0 *1 0,0
Xsg13cmos5l_decap_8_2208 VPWR VGND sg13cmos5l_decap_8
* cell instance sg13cmos5l_decap_8_2209 r0 *1 0,0
Xsg13cmos5l_decap_8_2209 VPWR VGND sg13cmos5l_decap_8
* cell instance sg13cmos5l_decap_8_2210 r0 *1 0,0
Xsg13cmos5l_decap_8_2210 VPWR VGND sg13cmos5l_decap_8
* cell instance sg13cmos5l_decap_8_2211 r0 *1 0,0
Xsg13cmos5l_decap_8_2211 VPWR VGND sg13cmos5l_decap_8
* cell instance sg13cmos5l_decap_8_2212 r0 *1 0,0
Xsg13cmos5l_decap_8_2212 VPWR VGND sg13cmos5l_decap_8
* cell instance sg13cmos5l_decap_8_2213 r0 *1 0,0
Xsg13cmos5l_decap_8_2213 VPWR VGND sg13cmos5l_decap_8
* cell instance sg13cmos5l_decap_8_2214 r0 *1 0,0
Xsg13cmos5l_decap_8_2214 VPWR VGND sg13cmos5l_decap_8
* cell instance sg13cmos5l_decap_8_2215 r0 *1 0,0
Xsg13cmos5l_decap_8_2215 VPWR VGND sg13cmos5l_decap_8
* cell instance sg13cmos5l_decap_8_2216 r0 *1 0,0
Xsg13cmos5l_decap_8_2216 VPWR VGND sg13cmos5l_decap_8
* cell instance sg13cmos5l_decap_8_2217 r0 *1 0,0
Xsg13cmos5l_decap_8_2217 VPWR VGND sg13cmos5l_decap_8
* cell instance sg13cmos5l_decap_8_2218 r0 *1 0,0
Xsg13cmos5l_decap_8_2218 VPWR VGND sg13cmos5l_decap_8
* cell instance sg13cmos5l_decap_8_2219 r0 *1 0,0
Xsg13cmos5l_decap_8_2219 VPWR VGND sg13cmos5l_decap_8
* cell instance sg13cmos5l_decap_8_2220 r0 *1 0,0
Xsg13cmos5l_decap_8_2220 VPWR VGND sg13cmos5l_decap_8
* cell instance sg13cmos5l_decap_8_2221 r0 *1 0,0
Xsg13cmos5l_decap_8_2221 VPWR VGND sg13cmos5l_decap_8
* cell instance sg13cmos5l_decap_8_2222 r0 *1 0,0
Xsg13cmos5l_decap_8_2222 VPWR VGND sg13cmos5l_decap_8
* cell instance sg13cmos5l_decap_8_2223 r0 *1 0,0
Xsg13cmos5l_decap_8_2223 VPWR VGND sg13cmos5l_decap_8
* cell instance sg13cmos5l_decap_8_2224 r0 *1 0,0
Xsg13cmos5l_decap_8_2224 VPWR VGND sg13cmos5l_decap_8
* cell instance sg13cmos5l_decap_8_2225 r0 *1 0,0
Xsg13cmos5l_decap_8_2225 VPWR VGND sg13cmos5l_decap_8
* cell instance sg13cmos5l_decap_8_2226 r0 *1 0,0
Xsg13cmos5l_decap_8_2226 VPWR VGND sg13cmos5l_decap_8
* cell instance sg13cmos5l_decap_8_2227 r0 *1 0,0
Xsg13cmos5l_decap_8_2227 VPWR VGND sg13cmos5l_decap_8
* cell instance sg13cmos5l_decap_8_2228 r0 *1 0,0
Xsg13cmos5l_decap_8_2228 VPWR VGND sg13cmos5l_decap_8
* cell instance sg13cmos5l_decap_8_2229 r0 *1 0,0
Xsg13cmos5l_decap_8_2229 VPWR VGND sg13cmos5l_decap_8
* cell instance sg13cmos5l_decap_8_2230 r0 *1 0,0
Xsg13cmos5l_decap_8_2230 VPWR VGND sg13cmos5l_decap_8
* cell instance sg13cmos5l_decap_8_2231 r0 *1 0,0
Xsg13cmos5l_decap_8_2231 VPWR VGND sg13cmos5l_decap_8
* cell instance sg13cmos5l_decap_8_2232 r0 *1 0,0
Xsg13cmos5l_decap_8_2232 VPWR VGND sg13cmos5l_decap_8
* cell instance sg13cmos5l_decap_8_2233 r0 *1 0,0
Xsg13cmos5l_decap_8_2233 VPWR VGND sg13cmos5l_decap_8
* cell instance sg13cmos5l_decap_8_2234 r0 *1 0,0
Xsg13cmos5l_decap_8_2234 VPWR VGND sg13cmos5l_decap_8
* cell instance sg13cmos5l_decap_8_2235 r0 *1 0,0
Xsg13cmos5l_decap_8_2235 VPWR VGND sg13cmos5l_decap_8
* cell instance sg13cmos5l_decap_8_2236 r0 *1 0,0
Xsg13cmos5l_decap_8_2236 VPWR VGND sg13cmos5l_decap_8
* cell instance sg13cmos5l_decap_8_2237 r0 *1 0,0
Xsg13cmos5l_decap_8_2237 VPWR VGND sg13cmos5l_decap_8
* cell instance sg13cmos5l_decap_8_2238 r0 *1 0,0
Xsg13cmos5l_decap_8_2238 VPWR VGND sg13cmos5l_decap_8
* cell instance sg13cmos5l_decap_8_2239 r0 *1 0,0
Xsg13cmos5l_decap_8_2239 VPWR VGND sg13cmos5l_decap_8
* cell instance sg13cmos5l_decap_8_2240 r0 *1 0,0
Xsg13cmos5l_decap_8_2240 VPWR VGND sg13cmos5l_decap_8
* cell instance sg13cmos5l_decap_8_2241 r0 *1 0,0
Xsg13cmos5l_decap_8_2241 VPWR VGND sg13cmos5l_decap_8
* cell instance sg13cmos5l_decap_8_2242 r0 *1 0,0
Xsg13cmos5l_decap_8_2242 VPWR VGND sg13cmos5l_decap_8
* cell instance sg13cmos5l_decap_8_2243 r0 *1 0,0
Xsg13cmos5l_decap_8_2243 VPWR VGND sg13cmos5l_decap_8
* cell instance sg13cmos5l_decap_8_2244 r0 *1 0,0
Xsg13cmos5l_decap_8_2244 VPWR VGND sg13cmos5l_decap_8
* cell instance sg13cmos5l_decap_8_2245 r0 *1 0,0
Xsg13cmos5l_decap_8_2245 VPWR VGND sg13cmos5l_decap_8
* cell instance sg13cmos5l_decap_8_2246 r0 *1 0,0
Xsg13cmos5l_decap_8_2246 VPWR VGND sg13cmos5l_decap_8
* cell instance sg13cmos5l_decap_8_2247 r0 *1 0,0
Xsg13cmos5l_decap_8_2247 VPWR VGND sg13cmos5l_decap_8
* cell instance sg13cmos5l_decap_8_2248 r0 *1 0,0
Xsg13cmos5l_decap_8_2248 VPWR VGND sg13cmos5l_decap_8
* cell instance sg13cmos5l_decap_8_2249 r0 *1 0,0
Xsg13cmos5l_decap_8_2249 VPWR VGND sg13cmos5l_decap_8
* cell instance sg13cmos5l_decap_8_2250 r0 *1 0,0
Xsg13cmos5l_decap_8_2250 VPWR VGND sg13cmos5l_decap_8
* cell instance sg13cmos5l_decap_8_2251 r0 *1 0,0
Xsg13cmos5l_decap_8_2251 VPWR VGND sg13cmos5l_decap_8
* cell instance sg13cmos5l_decap_8_2252 r0 *1 0,0
Xsg13cmos5l_decap_8_2252 VPWR VGND sg13cmos5l_decap_8
* cell instance sg13cmos5l_decap_8_2253 r0 *1 0,0
Xsg13cmos5l_decap_8_2253 VPWR VGND sg13cmos5l_decap_8
* cell instance sg13cmos5l_decap_8_2254 r0 *1 0,0
Xsg13cmos5l_decap_8_2254 VPWR VGND sg13cmos5l_decap_8
* cell instance sg13cmos5l_decap_8_2255 r0 *1 0,0
Xsg13cmos5l_decap_8_2255 VPWR VGND sg13cmos5l_decap_8
* cell instance sg13cmos5l_decap_8_2256 r0 *1 0,0
Xsg13cmos5l_decap_8_2256 VPWR VGND sg13cmos5l_decap_8
* cell instance sg13cmos5l_decap_8_2257 r0 *1 0,0
Xsg13cmos5l_decap_8_2257 VPWR VGND sg13cmos5l_decap_8
* cell instance sg13cmos5l_decap_8_2258 r0 *1 0,0
Xsg13cmos5l_decap_8_2258 VPWR VGND sg13cmos5l_decap_8
* cell instance sg13cmos5l_decap_8_2259 r0 *1 0,0
Xsg13cmos5l_decap_8_2259 VPWR VGND sg13cmos5l_decap_8
* cell instance sg13cmos5l_decap_8_2260 r0 *1 0,0
Xsg13cmos5l_decap_8_2260 VPWR VGND sg13cmos5l_decap_8
* cell instance sg13cmos5l_decap_8_2261 r0 *1 0,0
Xsg13cmos5l_decap_8_2261 VPWR VGND sg13cmos5l_decap_8
* cell instance sg13cmos5l_decap_8_2262 r0 *1 0,0
Xsg13cmos5l_decap_8_2262 VPWR VGND sg13cmos5l_decap_8
* cell instance sg13cmos5l_decap_8_2263 r0 *1 0,0
Xsg13cmos5l_decap_8_2263 VPWR VGND sg13cmos5l_decap_8
* cell instance sg13cmos5l_decap_8_2264 r0 *1 0,0
Xsg13cmos5l_decap_8_2264 VPWR VGND sg13cmos5l_decap_8
* cell instance sg13cmos5l_decap_8_2265 r0 *1 0,0
Xsg13cmos5l_decap_8_2265 VPWR VGND sg13cmos5l_decap_8
* cell instance sg13cmos5l_decap_8_2266 r0 *1 0,0
Xsg13cmos5l_decap_8_2266 VPWR VGND sg13cmos5l_decap_8
* cell instance sg13cmos5l_decap_8_2267 r0 *1 0,0
Xsg13cmos5l_decap_8_2267 VPWR VGND sg13cmos5l_decap_8
* cell instance sg13cmos5l_decap_8_2268 r0 *1 0,0
Xsg13cmos5l_decap_8_2268 VPWR VGND sg13cmos5l_decap_8
* cell instance sg13cmos5l_decap_8_2269 r0 *1 0,0
Xsg13cmos5l_decap_8_2269 VPWR VGND sg13cmos5l_decap_8
* cell instance sg13cmos5l_decap_8_2270 r0 *1 0,0
Xsg13cmos5l_decap_8_2270 VPWR VGND sg13cmos5l_decap_8
* cell instance sg13cmos5l_decap_8_2271 r0 *1 0,0
Xsg13cmos5l_decap_8_2271 VPWR VGND sg13cmos5l_decap_8
* cell instance sg13cmos5l_decap_8_2272 r0 *1 0,0
Xsg13cmos5l_decap_8_2272 VPWR VGND sg13cmos5l_decap_8
* cell instance sg13cmos5l_decap_8_2273 r0 *1 0,0
Xsg13cmos5l_decap_8_2273 VPWR VGND sg13cmos5l_decap_8
* cell instance sg13cmos5l_decap_8_2274 r0 *1 0,0
Xsg13cmos5l_decap_8_2274 VPWR VGND sg13cmos5l_decap_8
* cell instance sg13cmos5l_decap_8_2275 r0 *1 0,0
Xsg13cmos5l_decap_8_2275 VPWR VGND sg13cmos5l_decap_8
* cell instance sg13cmos5l_decap_8_2276 r0 *1 0,0
Xsg13cmos5l_decap_8_2276 VPWR VGND sg13cmos5l_decap_8
* cell instance sg13cmos5l_decap_8_2277 r0 *1 0,0
Xsg13cmos5l_decap_8_2277 VPWR VGND sg13cmos5l_decap_8
* cell instance sg13cmos5l_decap_8_2278 r0 *1 0,0
Xsg13cmos5l_decap_8_2278 VPWR VGND sg13cmos5l_decap_8
* cell instance sg13cmos5l_decap_8_2279 r0 *1 0,0
Xsg13cmos5l_decap_8_2279 VPWR VGND sg13cmos5l_decap_8
* cell instance sg13cmos5l_decap_8_2280 r0 *1 0,0
Xsg13cmos5l_decap_8_2280 VPWR VGND sg13cmos5l_decap_8
* cell instance sg13cmos5l_decap_8_2281 r0 *1 0,0
Xsg13cmos5l_decap_8_2281 VPWR VGND sg13cmos5l_decap_8
* cell instance sg13cmos5l_decap_8_2282 r0 *1 0,0
Xsg13cmos5l_decap_8_2282 VPWR VGND sg13cmos5l_decap_8
* cell instance sg13cmos5l_decap_8_2283 r0 *1 0,0
Xsg13cmos5l_decap_8_2283 VPWR VGND sg13cmos5l_decap_8
* cell instance sg13cmos5l_decap_8_2284 r0 *1 0,0
Xsg13cmos5l_decap_8_2284 VPWR VGND sg13cmos5l_decap_8
* cell instance sg13cmos5l_decap_8_2285 r0 *1 0,0
Xsg13cmos5l_decap_8_2285 VPWR VGND sg13cmos5l_decap_8
* cell instance sg13cmos5l_decap_8_2286 r0 *1 0,0
Xsg13cmos5l_decap_8_2286 VPWR VGND sg13cmos5l_decap_8
* cell instance sg13cmos5l_decap_8_2287 r0 *1 0,0
Xsg13cmos5l_decap_8_2287 VPWR VGND sg13cmos5l_decap_8
* cell instance sg13cmos5l_decap_8_2288 r0 *1 0,0
Xsg13cmos5l_decap_8_2288 VPWR VGND sg13cmos5l_decap_8
* cell instance sg13cmos5l_decap_8_2289 r0 *1 0,0
Xsg13cmos5l_decap_8_2289 VPWR VGND sg13cmos5l_decap_8
* cell instance sg13cmos5l_decap_8_2290 r0 *1 0,0
Xsg13cmos5l_decap_8_2290 VPWR VGND sg13cmos5l_decap_8
* cell instance sg13cmos5l_decap_8_2291 r0 *1 0,0
Xsg13cmos5l_decap_8_2291 VPWR VGND sg13cmos5l_decap_8
* cell instance sg13cmos5l_decap_8_2292 r0 *1 0,0
Xsg13cmos5l_decap_8_2292 VPWR VGND sg13cmos5l_decap_8
* cell instance sg13cmos5l_decap_8_2293 r0 *1 0,0
Xsg13cmos5l_decap_8_2293 VPWR VGND sg13cmos5l_decap_8
* cell instance sg13cmos5l_decap_8_2294 r0 *1 0,0
Xsg13cmos5l_decap_8_2294 VPWR VGND sg13cmos5l_decap_8
* cell instance sg13cmos5l_decap_8_2295 r0 *1 0,0
Xsg13cmos5l_decap_8_2295 VPWR VGND sg13cmos5l_decap_8
* cell instance sg13cmos5l_decap_8_2296 r0 *1 0,0
Xsg13cmos5l_decap_8_2296 VPWR VGND sg13cmos5l_decap_8
* cell instance sg13cmos5l_decap_8_2297 r0 *1 0,0
Xsg13cmos5l_decap_8_2297 VPWR VGND sg13cmos5l_decap_8
* cell instance sg13cmos5l_decap_8_2298 r0 *1 0,0
Xsg13cmos5l_decap_8_2298 VPWR VGND sg13cmos5l_decap_8
* cell instance sg13cmos5l_decap_8_2299 r0 *1 0,0
Xsg13cmos5l_decap_8_2299 VPWR VGND sg13cmos5l_decap_8
* cell instance sg13cmos5l_decap_8_2300 r0 *1 0,0
Xsg13cmos5l_decap_8_2300 VPWR VGND sg13cmos5l_decap_8
* cell instance sg13cmos5l_decap_8_2301 r0 *1 0,0
Xsg13cmos5l_decap_8_2301 VPWR VGND sg13cmos5l_decap_8
* cell instance sg13cmos5l_decap_8_2302 r0 *1 0,0
Xsg13cmos5l_decap_8_2302 VPWR VGND sg13cmos5l_decap_8
* cell instance sg13cmos5l_decap_8_2303 r0 *1 0,0
Xsg13cmos5l_decap_8_2303 VPWR VGND sg13cmos5l_decap_8
* cell instance sg13cmos5l_decap_8_2304 r0 *1 0,0
Xsg13cmos5l_decap_8_2304 VPWR VGND sg13cmos5l_decap_8
* cell instance sg13cmos5l_decap_8_2305 r0 *1 0,0
Xsg13cmos5l_decap_8_2305 VPWR VGND sg13cmos5l_decap_8
* cell instance sg13cmos5l_decap_8_2306 r0 *1 0,0
Xsg13cmos5l_decap_8_2306 VPWR VGND sg13cmos5l_decap_8
* cell instance sg13cmos5l_decap_8_2307 r0 *1 0,0
Xsg13cmos5l_decap_8_2307 VPWR VGND sg13cmos5l_decap_8
* cell instance sg13cmos5l_decap_8_2308 r0 *1 0,0
Xsg13cmos5l_decap_8_2308 VPWR VGND sg13cmos5l_decap_8
* cell instance sg13cmos5l_decap_8_2309 r0 *1 0,0
Xsg13cmos5l_decap_8_2309 VPWR VGND sg13cmos5l_decap_8
* cell instance sg13cmos5l_decap_8_2310 r0 *1 0,0
Xsg13cmos5l_decap_8_2310 VPWR VGND sg13cmos5l_decap_8
* cell instance sg13cmos5l_decap_8_2311 r0 *1 0,0
Xsg13cmos5l_decap_8_2311 VPWR VGND sg13cmos5l_decap_8
* cell instance sg13cmos5l_decap_8_2312 r0 *1 0,0
Xsg13cmos5l_decap_8_2312 VPWR VGND sg13cmos5l_decap_8
* cell instance sg13cmos5l_decap_8_2313 r0 *1 0,0
Xsg13cmos5l_decap_8_2313 VPWR VGND sg13cmos5l_decap_8
* cell instance sg13cmos5l_decap_8_2314 r0 *1 0,0
Xsg13cmos5l_decap_8_2314 VPWR VGND sg13cmos5l_decap_8
* cell instance sg13cmos5l_decap_8_2315 r0 *1 0,0
Xsg13cmos5l_decap_8_2315 VPWR VGND sg13cmos5l_decap_8
* cell instance sg13cmos5l_decap_8_2316 r0 *1 0,0
Xsg13cmos5l_decap_8_2316 VPWR VGND sg13cmos5l_decap_8
* cell instance sg13cmos5l_decap_8_2317 r0 *1 0,0
Xsg13cmos5l_decap_8_2317 VPWR VGND sg13cmos5l_decap_8
* cell instance sg13cmos5l_decap_8_2318 r0 *1 0,0
Xsg13cmos5l_decap_8_2318 VPWR VGND sg13cmos5l_decap_8
* cell instance sg13cmos5l_decap_8_2319 r0 *1 0,0
Xsg13cmos5l_decap_8_2319 VPWR VGND sg13cmos5l_decap_8
* cell instance sg13cmos5l_decap_8_2320 r0 *1 0,0
Xsg13cmos5l_decap_8_2320 VPWR VGND sg13cmos5l_decap_8
* cell instance sg13cmos5l_decap_8_2321 r0 *1 0,0
Xsg13cmos5l_decap_8_2321 VPWR VGND sg13cmos5l_decap_8
* cell instance sg13cmos5l_decap_8_2322 r0 *1 0,0
Xsg13cmos5l_decap_8_2322 VPWR VGND sg13cmos5l_decap_8
* cell instance sg13cmos5l_decap_8_2323 r0 *1 0,0
Xsg13cmos5l_decap_8_2323 VPWR VGND sg13cmos5l_decap_8
* cell instance sg13cmos5l_decap_8_2324 r0 *1 0,0
Xsg13cmos5l_decap_8_2324 VPWR VGND sg13cmos5l_decap_8
* cell instance sg13cmos5l_decap_8_2325 r0 *1 0,0
Xsg13cmos5l_decap_8_2325 VPWR VGND sg13cmos5l_decap_8
* cell instance sg13cmos5l_decap_8_2326 r0 *1 0,0
Xsg13cmos5l_decap_8_2326 VPWR VGND sg13cmos5l_decap_8
* cell instance sg13cmos5l_decap_8_2327 r0 *1 0,0
Xsg13cmos5l_decap_8_2327 VPWR VGND sg13cmos5l_decap_8
* cell instance sg13cmos5l_decap_8_2328 r0 *1 0,0
Xsg13cmos5l_decap_8_2328 VPWR VGND sg13cmos5l_decap_8
* cell instance sg13cmos5l_decap_8_2329 r0 *1 0,0
Xsg13cmos5l_decap_8_2329 VPWR VGND sg13cmos5l_decap_8
* cell instance sg13cmos5l_decap_8_2330 r0 *1 0,0
Xsg13cmos5l_decap_8_2330 VPWR VGND sg13cmos5l_decap_8
* cell instance sg13cmos5l_decap_8_2331 r0 *1 0,0
Xsg13cmos5l_decap_8_2331 VPWR VGND sg13cmos5l_decap_8
* cell instance sg13cmos5l_decap_8_2332 r0 *1 0,0
Xsg13cmos5l_decap_8_2332 VPWR VGND sg13cmos5l_decap_8
* cell instance sg13cmos5l_decap_8_2333 r0 *1 0,0
Xsg13cmos5l_decap_8_2333 VPWR VGND sg13cmos5l_decap_8
* cell instance sg13cmos5l_decap_8_2334 r0 *1 0,0
Xsg13cmos5l_decap_8_2334 VPWR VGND sg13cmos5l_decap_8
* cell instance sg13cmos5l_decap_8_2335 r0 *1 0,0
Xsg13cmos5l_decap_8_2335 VPWR VGND sg13cmos5l_decap_8
* cell instance sg13cmos5l_decap_8_2336 r0 *1 0,0
Xsg13cmos5l_decap_8_2336 VPWR VGND sg13cmos5l_decap_8
* cell instance sg13cmos5l_decap_8_2337 r0 *1 0,0
Xsg13cmos5l_decap_8_2337 VPWR VGND sg13cmos5l_decap_8
* cell instance sg13cmos5l_decap_8_2338 r0 *1 0,0
Xsg13cmos5l_decap_8_2338 VPWR VGND sg13cmos5l_decap_8
* cell instance sg13cmos5l_decap_8_2339 r0 *1 0,0
Xsg13cmos5l_decap_8_2339 VPWR VGND sg13cmos5l_decap_8
* cell instance sg13cmos5l_decap_8_2340 r0 *1 0,0
Xsg13cmos5l_decap_8_2340 VPWR VGND sg13cmos5l_decap_8
* cell instance sg13cmos5l_decap_8_2341 r0 *1 0,0
Xsg13cmos5l_decap_8_2341 VPWR VGND sg13cmos5l_decap_8
* cell instance sg13cmos5l_decap_8_2342 r0 *1 0,0
Xsg13cmos5l_decap_8_2342 VPWR VGND sg13cmos5l_decap_8
* cell instance sg13cmos5l_decap_8_2343 r0 *1 0,0
Xsg13cmos5l_decap_8_2343 VPWR VGND sg13cmos5l_decap_8
* cell instance sg13cmos5l_decap_8_2344 r0 *1 0,0
Xsg13cmos5l_decap_8_2344 VPWR VGND sg13cmos5l_decap_8
* cell instance sg13cmos5l_decap_8_2345 r0 *1 0,0
Xsg13cmos5l_decap_8_2345 VPWR VGND sg13cmos5l_decap_8
* cell instance sg13cmos5l_decap_8_2346 r0 *1 0,0
Xsg13cmos5l_decap_8_2346 VPWR VGND sg13cmos5l_decap_8
* cell instance sg13cmos5l_decap_8_2347 r0 *1 0,0
Xsg13cmos5l_decap_8_2347 VPWR VGND sg13cmos5l_decap_8
* cell instance sg13cmos5l_decap_8_2348 r0 *1 0,0
Xsg13cmos5l_decap_8_2348 VPWR VGND sg13cmos5l_decap_8
* cell instance sg13cmos5l_decap_8_2349 r0 *1 0,0
Xsg13cmos5l_decap_8_2349 VPWR VGND sg13cmos5l_decap_8
* cell instance sg13cmos5l_decap_8_2350 r0 *1 0,0
Xsg13cmos5l_decap_8_2350 VPWR VGND sg13cmos5l_decap_8
* cell instance sg13cmos5l_decap_8_2351 r0 *1 0,0
Xsg13cmos5l_decap_8_2351 VPWR VGND sg13cmos5l_decap_8
* cell instance sg13cmos5l_decap_8_2352 r0 *1 0,0
Xsg13cmos5l_decap_8_2352 VPWR VGND sg13cmos5l_decap_8
* cell instance sg13cmos5l_decap_8_2353 r0 *1 0,0
Xsg13cmos5l_decap_8_2353 VPWR VGND sg13cmos5l_decap_8
* cell instance sg13cmos5l_decap_8_2354 r0 *1 0,0
Xsg13cmos5l_decap_8_2354 VPWR VGND sg13cmos5l_decap_8
* cell instance sg13cmos5l_decap_8_2355 r0 *1 0,0
Xsg13cmos5l_decap_8_2355 VPWR VGND sg13cmos5l_decap_8
* cell instance sg13cmos5l_decap_8_2356 r0 *1 0,0
Xsg13cmos5l_decap_8_2356 VPWR VGND sg13cmos5l_decap_8
* cell instance sg13cmos5l_decap_8_2357 r0 *1 0,0
Xsg13cmos5l_decap_8_2357 VPWR VGND sg13cmos5l_decap_8
* cell instance sg13cmos5l_decap_8_2358 r0 *1 0,0
Xsg13cmos5l_decap_8_2358 VPWR VGND sg13cmos5l_decap_8
* cell instance sg13cmos5l_decap_8_2359 r0 *1 0,0
Xsg13cmos5l_decap_8_2359 VPWR VGND sg13cmos5l_decap_8
* cell instance sg13cmos5l_decap_8_2360 r0 *1 0,0
Xsg13cmos5l_decap_8_2360 VPWR VGND sg13cmos5l_decap_8
* cell instance sg13cmos5l_decap_8_2361 r0 *1 0,0
Xsg13cmos5l_decap_8_2361 VPWR VGND sg13cmos5l_decap_8
* cell instance sg13cmos5l_decap_8_2362 r0 *1 0,0
Xsg13cmos5l_decap_8_2362 VPWR VGND sg13cmos5l_decap_8
* cell instance sg13cmos5l_decap_8_2363 r0 *1 0,0
Xsg13cmos5l_decap_8_2363 VPWR VGND sg13cmos5l_decap_8
* cell instance sg13cmos5l_decap_8_2364 r0 *1 0,0
Xsg13cmos5l_decap_8_2364 VPWR VGND sg13cmos5l_decap_8
* cell instance sg13cmos5l_decap_8_2365 r0 *1 0,0
Xsg13cmos5l_decap_8_2365 VPWR VGND sg13cmos5l_decap_8
* cell instance sg13cmos5l_decap_8_2366 r0 *1 0,0
Xsg13cmos5l_decap_8_2366 VPWR VGND sg13cmos5l_decap_8
* cell instance sg13cmos5l_decap_8_2367 r0 *1 0,0
Xsg13cmos5l_decap_8_2367 VPWR VGND sg13cmos5l_decap_8
* cell instance sg13cmos5l_decap_8_2368 r0 *1 0,0
Xsg13cmos5l_decap_8_2368 VPWR VGND sg13cmos5l_decap_8
* cell instance sg13cmos5l_decap_8_2369 r0 *1 0,0
Xsg13cmos5l_decap_8_2369 VPWR VGND sg13cmos5l_decap_8
* cell instance sg13cmos5l_decap_8_2370 r0 *1 0,0
Xsg13cmos5l_decap_8_2370 VPWR VGND sg13cmos5l_decap_8
* cell instance sg13cmos5l_decap_8_2371 r0 *1 0,0
Xsg13cmos5l_decap_8_2371 VPWR VGND sg13cmos5l_decap_8
* cell instance sg13cmos5l_decap_8_2372 r0 *1 0,0
Xsg13cmos5l_decap_8_2372 VPWR VGND sg13cmos5l_decap_8
* cell instance sg13cmos5l_decap_8_2373 r0 *1 0,0
Xsg13cmos5l_decap_8_2373 VPWR VGND sg13cmos5l_decap_8
* cell instance sg13cmos5l_decap_8_2374 r0 *1 0,0
Xsg13cmos5l_decap_8_2374 VPWR VGND sg13cmos5l_decap_8
* cell instance sg13cmos5l_decap_8_2375 r0 *1 0,0
Xsg13cmos5l_decap_8_2375 VPWR VGND sg13cmos5l_decap_8
* cell instance sg13cmos5l_decap_8_2376 r0 *1 0,0
Xsg13cmos5l_decap_8_2376 VPWR VGND sg13cmos5l_decap_8
* cell instance sg13cmos5l_decap_8_2377 r0 *1 0,0
Xsg13cmos5l_decap_8_2377 VPWR VGND sg13cmos5l_decap_8
* cell instance sg13cmos5l_decap_8_2378 r0 *1 0,0
Xsg13cmos5l_decap_8_2378 VPWR VGND sg13cmos5l_decap_8
* cell instance sg13cmos5l_decap_8_2379 r0 *1 0,0
Xsg13cmos5l_decap_8_2379 VPWR VGND sg13cmos5l_decap_8
* cell instance sg13cmos5l_decap_8_2380 r0 *1 0,0
Xsg13cmos5l_decap_8_2380 VPWR VGND sg13cmos5l_decap_8
* cell instance sg13cmos5l_decap_8_2381 r0 *1 0,0
Xsg13cmos5l_decap_8_2381 VPWR VGND sg13cmos5l_decap_8
* cell instance sg13cmos5l_decap_8_2382 r0 *1 0,0
Xsg13cmos5l_decap_8_2382 VPWR VGND sg13cmos5l_decap_8
* cell instance sg13cmos5l_decap_8_2383 r0 *1 0,0
Xsg13cmos5l_decap_8_2383 VPWR VGND sg13cmos5l_decap_8
* cell instance sg13cmos5l_decap_8_2384 r0 *1 0,0
Xsg13cmos5l_decap_8_2384 VPWR VGND sg13cmos5l_decap_8
* cell instance sg13cmos5l_decap_8_2385 r0 *1 0,0
Xsg13cmos5l_decap_8_2385 VPWR VGND sg13cmos5l_decap_8
* cell instance sg13cmos5l_decap_8_2386 r0 *1 0,0
Xsg13cmos5l_decap_8_2386 VPWR VGND sg13cmos5l_decap_8
* cell instance sg13cmos5l_decap_8_2387 r0 *1 0,0
Xsg13cmos5l_decap_8_2387 VPWR VGND sg13cmos5l_decap_8
* cell instance sg13cmos5l_decap_8_2388 r0 *1 0,0
Xsg13cmos5l_decap_8_2388 VPWR VGND sg13cmos5l_decap_8
* cell instance sg13cmos5l_decap_8_2389 r0 *1 0,0
Xsg13cmos5l_decap_8_2389 VPWR VGND sg13cmos5l_decap_8
* cell instance sg13cmos5l_decap_8_2390 r0 *1 0,0
Xsg13cmos5l_decap_8_2390 VPWR VGND sg13cmos5l_decap_8
* cell instance sg13cmos5l_decap_8_2391 r0 *1 0,0
Xsg13cmos5l_decap_8_2391 VPWR VGND sg13cmos5l_decap_8
* cell instance sg13cmos5l_decap_8_2392 r0 *1 0,0
Xsg13cmos5l_decap_8_2392 VPWR VGND sg13cmos5l_decap_8
* cell instance sg13cmos5l_decap_8_2393 r0 *1 0,0
Xsg13cmos5l_decap_8_2393 VPWR VGND sg13cmos5l_decap_8
* cell instance sg13cmos5l_decap_8_2394 r0 *1 0,0
Xsg13cmos5l_decap_8_2394 VPWR VGND sg13cmos5l_decap_8
* cell instance sg13cmos5l_decap_8_2395 r0 *1 0,0
Xsg13cmos5l_decap_8_2395 VPWR VGND sg13cmos5l_decap_8
* cell instance sg13cmos5l_decap_8_2396 r0 *1 0,0
Xsg13cmos5l_decap_8_2396 VPWR VGND sg13cmos5l_decap_8
* cell instance sg13cmos5l_decap_8_2397 r0 *1 0,0
Xsg13cmos5l_decap_8_2397 VPWR VGND sg13cmos5l_decap_8
* cell instance sg13cmos5l_decap_8_2398 r0 *1 0,0
Xsg13cmos5l_decap_8_2398 VPWR VGND sg13cmos5l_decap_8
* cell instance sg13cmos5l_decap_8_2399 r0 *1 0,0
Xsg13cmos5l_decap_8_2399 VPWR VGND sg13cmos5l_decap_8
* cell instance sg13cmos5l_decap_8_2400 r0 *1 0,0
Xsg13cmos5l_decap_8_2400 VPWR VGND sg13cmos5l_decap_8
* cell instance sg13cmos5l_decap_8_2401 r0 *1 0,0
Xsg13cmos5l_decap_8_2401 VPWR VGND sg13cmos5l_decap_8
* cell instance sg13cmos5l_decap_8_2402 r0 *1 0,0
Xsg13cmos5l_decap_8_2402 VPWR VGND sg13cmos5l_decap_8
* cell instance sg13cmos5l_decap_8_2403 r0 *1 0,0
Xsg13cmos5l_decap_8_2403 VPWR VGND sg13cmos5l_decap_8
* cell instance sg13cmos5l_decap_8_2404 r0 *1 0,0
Xsg13cmos5l_decap_8_2404 VPWR VGND sg13cmos5l_decap_8
* cell instance sg13cmos5l_decap_8_2405 r0 *1 0,0
Xsg13cmos5l_decap_8_2405 VPWR VGND sg13cmos5l_decap_8
* cell instance sg13cmos5l_decap_8_2406 r0 *1 0,0
Xsg13cmos5l_decap_8_2406 VPWR VGND sg13cmos5l_decap_8
* cell instance sg13cmos5l_decap_8_2407 r0 *1 0,0
Xsg13cmos5l_decap_8_2407 VPWR VGND sg13cmos5l_decap_8
* cell instance sg13cmos5l_decap_8_2408 r0 *1 0,0
Xsg13cmos5l_decap_8_2408 VPWR VGND sg13cmos5l_decap_8
* cell instance sg13cmos5l_decap_8_2409 r0 *1 0,0
Xsg13cmos5l_decap_8_2409 VPWR VGND sg13cmos5l_decap_8
* cell instance sg13cmos5l_decap_8_2410 r0 *1 0,0
Xsg13cmos5l_decap_8_2410 VPWR VGND sg13cmos5l_decap_8
* cell instance sg13cmos5l_decap_8_2411 r0 *1 0,0
Xsg13cmos5l_decap_8_2411 VPWR VGND sg13cmos5l_decap_8
* cell instance sg13cmos5l_decap_8_2412 r0 *1 0,0
Xsg13cmos5l_decap_8_2412 VPWR VGND sg13cmos5l_decap_8
* cell instance sg13cmos5l_decap_8_2413 r0 *1 0,0
Xsg13cmos5l_decap_8_2413 VPWR VGND sg13cmos5l_decap_8
* cell instance sg13cmos5l_decap_8_2414 r0 *1 0,0
Xsg13cmos5l_decap_8_2414 VPWR VGND sg13cmos5l_decap_8
* cell instance sg13cmos5l_decap_8_2415 r0 *1 0,0
Xsg13cmos5l_decap_8_2415 VPWR VGND sg13cmos5l_decap_8
* cell instance sg13cmos5l_decap_8_2416 r0 *1 0,0
Xsg13cmos5l_decap_8_2416 VPWR VGND sg13cmos5l_decap_8
* cell instance sg13cmos5l_decap_8_2417 r0 *1 0,0
Xsg13cmos5l_decap_8_2417 VPWR VGND sg13cmos5l_decap_8
* cell instance sg13cmos5l_decap_8_2418 r0 *1 0,0
Xsg13cmos5l_decap_8_2418 VPWR VGND sg13cmos5l_decap_8
* cell instance sg13cmos5l_decap_8_2419 r0 *1 0,0
Xsg13cmos5l_decap_8_2419 VPWR VGND sg13cmos5l_decap_8
* cell instance sg13cmos5l_decap_8_2420 r0 *1 0,0
Xsg13cmos5l_decap_8_2420 VPWR VGND sg13cmos5l_decap_8
* cell instance sg13cmos5l_decap_8_2421 r0 *1 0,0
Xsg13cmos5l_decap_8_2421 VPWR VGND sg13cmos5l_decap_8
* cell instance sg13cmos5l_decap_8_2422 r0 *1 0,0
Xsg13cmos5l_decap_8_2422 VPWR VGND sg13cmos5l_decap_8
* cell instance sg13cmos5l_decap_8_2423 r0 *1 0,0
Xsg13cmos5l_decap_8_2423 VPWR VGND sg13cmos5l_decap_8
* cell instance sg13cmos5l_decap_8_2424 r0 *1 0,0
Xsg13cmos5l_decap_8_2424 VPWR VGND sg13cmos5l_decap_8
* cell instance sg13cmos5l_decap_8_2425 r0 *1 0,0
Xsg13cmos5l_decap_8_2425 VPWR VGND sg13cmos5l_decap_8
* cell instance sg13cmos5l_decap_8_2426 r0 *1 0,0
Xsg13cmos5l_decap_8_2426 VPWR VGND sg13cmos5l_decap_8
* cell instance sg13cmos5l_decap_8_2427 r0 *1 0,0
Xsg13cmos5l_decap_8_2427 VPWR VGND sg13cmos5l_decap_8
* cell instance sg13cmos5l_decap_8_2428 r0 *1 0,0
Xsg13cmos5l_decap_8_2428 VPWR VGND sg13cmos5l_decap_8
* cell instance sg13cmos5l_decap_8_2429 r0 *1 0,0
Xsg13cmos5l_decap_8_2429 VPWR VGND sg13cmos5l_decap_8
* cell instance sg13cmos5l_decap_8_2430 r0 *1 0,0
Xsg13cmos5l_decap_8_2430 VPWR VGND sg13cmos5l_decap_8
* cell instance sg13cmos5l_decap_8_2431 r0 *1 0,0
Xsg13cmos5l_decap_8_2431 VPWR VGND sg13cmos5l_decap_8
* cell instance sg13cmos5l_decap_8_2432 r0 *1 0,0
Xsg13cmos5l_decap_8_2432 VPWR VGND sg13cmos5l_decap_8
* cell instance sg13cmos5l_decap_8_2433 r0 *1 0,0
Xsg13cmos5l_decap_8_2433 VPWR VGND sg13cmos5l_decap_8
* cell instance sg13cmos5l_decap_8_2434 r0 *1 0,0
Xsg13cmos5l_decap_8_2434 VPWR VGND sg13cmos5l_decap_8
* cell instance sg13cmos5l_decap_8_2435 r0 *1 0,0
Xsg13cmos5l_decap_8_2435 VPWR VGND sg13cmos5l_decap_8
* cell instance sg13cmos5l_decap_8_2436 r0 *1 0,0
Xsg13cmos5l_decap_8_2436 VPWR VGND sg13cmos5l_decap_8
* cell instance sg13cmos5l_decap_8_2437 r0 *1 0,0
Xsg13cmos5l_decap_8_2437 VPWR VGND sg13cmos5l_decap_8
* cell instance sg13cmos5l_decap_8_2438 r0 *1 0,0
Xsg13cmos5l_decap_8_2438 VPWR VGND sg13cmos5l_decap_8
* cell instance sg13cmos5l_decap_8_2439 r0 *1 0,0
Xsg13cmos5l_decap_8_2439 VPWR VGND sg13cmos5l_decap_8
* cell instance sg13cmos5l_decap_8_2440 r0 *1 0,0
Xsg13cmos5l_decap_8_2440 VPWR VGND sg13cmos5l_decap_8
* cell instance sg13cmos5l_decap_8_2441 r0 *1 0,0
Xsg13cmos5l_decap_8_2441 VPWR VGND sg13cmos5l_decap_8
* cell instance sg13cmos5l_decap_8_2442 r0 *1 0,0
Xsg13cmos5l_decap_8_2442 VPWR VGND sg13cmos5l_decap_8
* cell instance sg13cmos5l_decap_8_2443 r0 *1 0,0
Xsg13cmos5l_decap_8_2443 VPWR VGND sg13cmos5l_decap_8
* cell instance sg13cmos5l_decap_8_2444 r0 *1 0,0
Xsg13cmos5l_decap_8_2444 VPWR VGND sg13cmos5l_decap_8
* cell instance sg13cmos5l_decap_8_2445 r0 *1 0,0
Xsg13cmos5l_decap_8_2445 VPWR VGND sg13cmos5l_decap_8
* cell instance sg13cmos5l_decap_8_2446 r0 *1 0,0
Xsg13cmos5l_decap_8_2446 VPWR VGND sg13cmos5l_decap_8
* cell instance sg13cmos5l_decap_8_2447 r0 *1 0,0
Xsg13cmos5l_decap_8_2447 VPWR VGND sg13cmos5l_decap_8
* cell instance sg13cmos5l_decap_8_2448 r0 *1 0,0
Xsg13cmos5l_decap_8_2448 VPWR VGND sg13cmos5l_decap_8
* cell instance sg13cmos5l_decap_8_2449 r0 *1 0,0
Xsg13cmos5l_decap_8_2449 VPWR VGND sg13cmos5l_decap_8
* cell instance sg13cmos5l_decap_8_2450 r0 *1 0,0
Xsg13cmos5l_decap_8_2450 VPWR VGND sg13cmos5l_decap_8
* cell instance sg13cmos5l_decap_8_2451 r0 *1 0,0
Xsg13cmos5l_decap_8_2451 VPWR VGND sg13cmos5l_decap_8
* cell instance sg13cmos5l_decap_8_2452 r0 *1 0,0
Xsg13cmos5l_decap_8_2452 VPWR VGND sg13cmos5l_decap_8
* cell instance sg13cmos5l_decap_8_2453 r0 *1 0,0
Xsg13cmos5l_decap_8_2453 VPWR VGND sg13cmos5l_decap_8
* cell instance sg13cmos5l_decap_8_2454 r0 *1 0,0
Xsg13cmos5l_decap_8_2454 VPWR VGND sg13cmos5l_decap_8
* cell instance sg13cmos5l_decap_8_2455 r0 *1 0,0
Xsg13cmos5l_decap_8_2455 VPWR VGND sg13cmos5l_decap_8
* cell instance sg13cmos5l_decap_8_2456 r0 *1 0,0
Xsg13cmos5l_decap_8_2456 VPWR VGND sg13cmos5l_decap_8
* cell instance sg13cmos5l_decap_8_2457 r0 *1 0,0
Xsg13cmos5l_decap_8_2457 VPWR VGND sg13cmos5l_decap_8
* cell instance sg13cmos5l_decap_8_2458 r0 *1 0,0
Xsg13cmos5l_decap_8_2458 VPWR VGND sg13cmos5l_decap_8
* cell instance sg13cmos5l_decap_8_2459 r0 *1 0,0
Xsg13cmos5l_decap_8_2459 VPWR VGND sg13cmos5l_decap_8
* cell instance sg13cmos5l_decap_8_2460 r0 *1 0,0
Xsg13cmos5l_decap_8_2460 VPWR VGND sg13cmos5l_decap_8
* cell instance sg13cmos5l_decap_8_2461 r0 *1 0,0
Xsg13cmos5l_decap_8_2461 VPWR VGND sg13cmos5l_decap_8
* cell instance sg13cmos5l_decap_8_2462 r0 *1 0,0
Xsg13cmos5l_decap_8_2462 VPWR VGND sg13cmos5l_decap_8
* cell instance sg13cmos5l_decap_8_2463 r0 *1 0,0
Xsg13cmos5l_decap_8_2463 VPWR VGND sg13cmos5l_decap_8
* cell instance sg13cmos5l_decap_8_2464 r0 *1 0,0
Xsg13cmos5l_decap_8_2464 VPWR VGND sg13cmos5l_decap_8
* cell instance sg13cmos5l_decap_8_2465 r0 *1 0,0
Xsg13cmos5l_decap_8_2465 VPWR VGND sg13cmos5l_decap_8
* cell instance sg13cmos5l_decap_8_2466 r0 *1 0,0
Xsg13cmos5l_decap_8_2466 VPWR VGND sg13cmos5l_decap_8
* cell instance sg13cmos5l_decap_8_2467 r0 *1 0,0
Xsg13cmos5l_decap_8_2467 VPWR VGND sg13cmos5l_decap_8
* cell instance sg13cmos5l_decap_8_2468 r0 *1 0,0
Xsg13cmos5l_decap_8_2468 VPWR VGND sg13cmos5l_decap_8
* cell instance sg13cmos5l_decap_8_2469 r0 *1 0,0
Xsg13cmos5l_decap_8_2469 VPWR VGND sg13cmos5l_decap_8
* cell instance sg13cmos5l_decap_8_2470 r0 *1 0,0
Xsg13cmos5l_decap_8_2470 VPWR VGND sg13cmos5l_decap_8
* cell instance sg13cmos5l_decap_8_2471 r0 *1 0,0
Xsg13cmos5l_decap_8_2471 VPWR VGND sg13cmos5l_decap_8
* cell instance sg13cmos5l_decap_8_2472 r0 *1 0,0
Xsg13cmos5l_decap_8_2472 VPWR VGND sg13cmos5l_decap_8
* cell instance sg13cmos5l_decap_8_2473 r0 *1 0,0
Xsg13cmos5l_decap_8_2473 VPWR VGND sg13cmos5l_decap_8
* cell instance sg13cmos5l_decap_8_2474 r0 *1 0,0
Xsg13cmos5l_decap_8_2474 VPWR VGND sg13cmos5l_decap_8
* cell instance sg13cmos5l_decap_8_2475 r0 *1 0,0
Xsg13cmos5l_decap_8_2475 VPWR VGND sg13cmos5l_decap_8
* cell instance sg13cmos5l_decap_8_2476 r0 *1 0,0
Xsg13cmos5l_decap_8_2476 VPWR VGND sg13cmos5l_decap_8
* cell instance sg13cmos5l_decap_8_2477 r0 *1 0,0
Xsg13cmos5l_decap_8_2477 VPWR VGND sg13cmos5l_decap_8
* cell instance sg13cmos5l_decap_8_2478 r0 *1 0,0
Xsg13cmos5l_decap_8_2478 VPWR VGND sg13cmos5l_decap_8
* cell instance sg13cmos5l_decap_8_2479 r0 *1 0,0
Xsg13cmos5l_decap_8_2479 VPWR VGND sg13cmos5l_decap_8
* cell instance sg13cmos5l_decap_8_2480 r0 *1 0,0
Xsg13cmos5l_decap_8_2480 VPWR VGND sg13cmos5l_decap_8
* cell instance sg13cmos5l_decap_8_2481 r0 *1 0,0
Xsg13cmos5l_decap_8_2481 VPWR VGND sg13cmos5l_decap_8
* cell instance sg13cmos5l_decap_8_2482 r0 *1 0,0
Xsg13cmos5l_decap_8_2482 VPWR VGND sg13cmos5l_decap_8
* cell instance sg13cmos5l_decap_8_2483 r0 *1 0,0
Xsg13cmos5l_decap_8_2483 VPWR VGND sg13cmos5l_decap_8
* cell instance sg13cmos5l_decap_8_2484 r0 *1 0,0
Xsg13cmos5l_decap_8_2484 VPWR VGND sg13cmos5l_decap_8
* cell instance sg13cmos5l_decap_8_2485 r0 *1 0,0
Xsg13cmos5l_decap_8_2485 VPWR VGND sg13cmos5l_decap_8
* cell instance sg13cmos5l_decap_8_2486 r0 *1 0,0
Xsg13cmos5l_decap_8_2486 VPWR VGND sg13cmos5l_decap_8
* cell instance sg13cmos5l_decap_8_2487 r0 *1 0,0
Xsg13cmos5l_decap_8_2487 VPWR VGND sg13cmos5l_decap_8
* cell instance sg13cmos5l_decap_8_2488 r0 *1 0,0
Xsg13cmos5l_decap_8_2488 VPWR VGND sg13cmos5l_decap_8
* cell instance sg13cmos5l_decap_8_2489 r0 *1 0,0
Xsg13cmos5l_decap_8_2489 VPWR VGND sg13cmos5l_decap_8
* cell instance sg13cmos5l_decap_8_2490 r0 *1 0,0
Xsg13cmos5l_decap_8_2490 VPWR VGND sg13cmos5l_decap_8
* cell instance sg13cmos5l_decap_8_2491 r0 *1 0,0
Xsg13cmos5l_decap_8_2491 VPWR VGND sg13cmos5l_decap_8
* cell instance sg13cmos5l_decap_8_2492 r0 *1 0,0
Xsg13cmos5l_decap_8_2492 VPWR VGND sg13cmos5l_decap_8
* cell instance sg13cmos5l_decap_8_2493 r0 *1 0,0
Xsg13cmos5l_decap_8_2493 VPWR VGND sg13cmos5l_decap_8
* cell instance sg13cmos5l_decap_8_2494 r0 *1 0,0
Xsg13cmos5l_decap_8_2494 VPWR VGND sg13cmos5l_decap_8
* cell instance sg13cmos5l_decap_8_2495 r0 *1 0,0
Xsg13cmos5l_decap_8_2495 VPWR VGND sg13cmos5l_decap_8
* cell instance sg13cmos5l_decap_8_2496 r0 *1 0,0
Xsg13cmos5l_decap_8_2496 VPWR VGND sg13cmos5l_decap_8
* cell instance sg13cmos5l_decap_8_2497 r0 *1 0,0
Xsg13cmos5l_decap_8_2497 VPWR VGND sg13cmos5l_decap_8
* cell instance sg13cmos5l_decap_8_2498 r0 *1 0,0
Xsg13cmos5l_decap_8_2498 VPWR VGND sg13cmos5l_decap_8
* cell instance sg13cmos5l_decap_8_2499 r0 *1 0,0
Xsg13cmos5l_decap_8_2499 VPWR VGND sg13cmos5l_decap_8
* cell instance sg13cmos5l_decap_8_2500 r0 *1 0,0
Xsg13cmos5l_decap_8_2500 VPWR VGND sg13cmos5l_decap_8
* cell instance sg13cmos5l_decap_8_2501 r0 *1 0,0
Xsg13cmos5l_decap_8_2501 VPWR VGND sg13cmos5l_decap_8
* cell instance sg13cmos5l_decap_8_2502 r0 *1 0,0
Xsg13cmos5l_decap_8_2502 VPWR VGND sg13cmos5l_decap_8
* cell instance sg13cmos5l_decap_8_2503 r0 *1 0,0
Xsg13cmos5l_decap_8_2503 VPWR VGND sg13cmos5l_decap_8
* cell instance sg13cmos5l_decap_8_2504 r0 *1 0,0
Xsg13cmos5l_decap_8_2504 VPWR VGND sg13cmos5l_decap_8
* cell instance sg13cmos5l_decap_8_2505 r0 *1 0,0
Xsg13cmos5l_decap_8_2505 VPWR VGND sg13cmos5l_decap_8
* cell instance sg13cmos5l_decap_8_2506 r0 *1 0,0
Xsg13cmos5l_decap_8_2506 VPWR VGND sg13cmos5l_decap_8
* cell instance sg13cmos5l_decap_8_2507 r0 *1 0,0
Xsg13cmos5l_decap_8_2507 VPWR VGND sg13cmos5l_decap_8
* cell instance sg13cmos5l_decap_8_2508 r0 *1 0,0
Xsg13cmos5l_decap_8_2508 VPWR VGND sg13cmos5l_decap_8
* cell instance sg13cmos5l_decap_8_2509 r0 *1 0,0
Xsg13cmos5l_decap_8_2509 VPWR VGND sg13cmos5l_decap_8
* cell instance sg13cmos5l_decap_8_2510 r0 *1 0,0
Xsg13cmos5l_decap_8_2510 VPWR VGND sg13cmos5l_decap_8
* cell instance sg13cmos5l_decap_8_2511 r0 *1 0,0
Xsg13cmos5l_decap_8_2511 VPWR VGND sg13cmos5l_decap_8
* cell instance sg13cmos5l_decap_8_2512 r0 *1 0,0
Xsg13cmos5l_decap_8_2512 VPWR VGND sg13cmos5l_decap_8
* cell instance sg13cmos5l_decap_8_2513 r0 *1 0,0
Xsg13cmos5l_decap_8_2513 VPWR VGND sg13cmos5l_decap_8
* cell instance sg13cmos5l_decap_8_2514 r0 *1 0,0
Xsg13cmos5l_decap_8_2514 VPWR VGND sg13cmos5l_decap_8
* cell instance sg13cmos5l_decap_8_2515 r0 *1 0,0
Xsg13cmos5l_decap_8_2515 VPWR VGND sg13cmos5l_decap_8
* cell instance sg13cmos5l_decap_8_2516 r0 *1 0,0
Xsg13cmos5l_decap_8_2516 VPWR VGND sg13cmos5l_decap_8
* cell instance sg13cmos5l_decap_8_2517 r0 *1 0,0
Xsg13cmos5l_decap_8_2517 VPWR VGND sg13cmos5l_decap_8
* cell instance sg13cmos5l_decap_8_2518 r0 *1 0,0
Xsg13cmos5l_decap_8_2518 VPWR VGND sg13cmos5l_decap_8
* cell instance sg13cmos5l_decap_8_2519 r0 *1 0,0
Xsg13cmos5l_decap_8_2519 VPWR VGND sg13cmos5l_decap_8
* cell instance sg13cmos5l_decap_8_2520 r0 *1 0,0
Xsg13cmos5l_decap_8_2520 VPWR VGND sg13cmos5l_decap_8
* cell instance sg13cmos5l_decap_8_2521 r0 *1 0,0
Xsg13cmos5l_decap_8_2521 VPWR VGND sg13cmos5l_decap_8
* cell instance sg13cmos5l_decap_8_2522 r0 *1 0,0
Xsg13cmos5l_decap_8_2522 VPWR VGND sg13cmos5l_decap_8
* cell instance sg13cmos5l_decap_8_2523 r0 *1 0,0
Xsg13cmos5l_decap_8_2523 VPWR VGND sg13cmos5l_decap_8
* cell instance sg13cmos5l_decap_8_2524 r0 *1 0,0
Xsg13cmos5l_decap_8_2524 VPWR VGND sg13cmos5l_decap_8
* cell instance sg13cmos5l_decap_8_2525 r0 *1 0,0
Xsg13cmos5l_decap_8_2525 VPWR VGND sg13cmos5l_decap_8
* cell instance sg13cmos5l_decap_8_2526 r0 *1 0,0
Xsg13cmos5l_decap_8_2526 VPWR VGND sg13cmos5l_decap_8
* cell instance sg13cmos5l_decap_8_2527 r0 *1 0,0
Xsg13cmos5l_decap_8_2527 VPWR VGND sg13cmos5l_decap_8
* cell instance sg13cmos5l_decap_8_2528 r0 *1 0,0
Xsg13cmos5l_decap_8_2528 VPWR VGND sg13cmos5l_decap_8
* cell instance sg13cmos5l_decap_8_2529 r0 *1 0,0
Xsg13cmos5l_decap_8_2529 VPWR VGND sg13cmos5l_decap_8
* cell instance sg13cmos5l_decap_8_2530 r0 *1 0,0
Xsg13cmos5l_decap_8_2530 VPWR VGND sg13cmos5l_decap_8
* cell instance sg13cmos5l_decap_8_2531 r0 *1 0,0
Xsg13cmos5l_decap_8_2531 VPWR VGND sg13cmos5l_decap_8
* cell instance sg13cmos5l_decap_8_2532 r0 *1 0,0
Xsg13cmos5l_decap_8_2532 VPWR VGND sg13cmos5l_decap_8
* cell instance sg13cmos5l_decap_8_2533 r0 *1 0,0
Xsg13cmos5l_decap_8_2533 VPWR VGND sg13cmos5l_decap_8
* cell instance sg13cmos5l_decap_8_2534 r0 *1 0,0
Xsg13cmos5l_decap_8_2534 VPWR VGND sg13cmos5l_decap_8
* cell instance sg13cmos5l_decap_8_2535 r0 *1 0,0
Xsg13cmos5l_decap_8_2535 VPWR VGND sg13cmos5l_decap_8
* cell instance sg13cmos5l_decap_8_2536 r0 *1 0,0
Xsg13cmos5l_decap_8_2536 VPWR VGND sg13cmos5l_decap_8
* cell instance sg13cmos5l_decap_8_2537 r0 *1 0,0
Xsg13cmos5l_decap_8_2537 VPWR VGND sg13cmos5l_decap_8
* cell instance sg13cmos5l_decap_8_2538 r0 *1 0,0
Xsg13cmos5l_decap_8_2538 VPWR VGND sg13cmos5l_decap_8
* cell instance sg13cmos5l_decap_8_2539 r0 *1 0,0
Xsg13cmos5l_decap_8_2539 VPWR VGND sg13cmos5l_decap_8
* cell instance sg13cmos5l_decap_8_2540 r0 *1 0,0
Xsg13cmos5l_decap_8_2540 VPWR VGND sg13cmos5l_decap_8
* cell instance sg13cmos5l_decap_8_2541 r0 *1 0,0
Xsg13cmos5l_decap_8_2541 VPWR VGND sg13cmos5l_decap_8
* cell instance sg13cmos5l_decap_8_2542 r0 *1 0,0
Xsg13cmos5l_decap_8_2542 VPWR VGND sg13cmos5l_decap_8
* cell instance sg13cmos5l_decap_8_2543 r0 *1 0,0
Xsg13cmos5l_decap_8_2543 VPWR VGND sg13cmos5l_decap_8
* cell instance sg13cmos5l_decap_8_2544 r0 *1 0,0
Xsg13cmos5l_decap_8_2544 VPWR VGND sg13cmos5l_decap_8
* cell instance sg13cmos5l_decap_8_2545 r0 *1 0,0
Xsg13cmos5l_decap_8_2545 VPWR VGND sg13cmos5l_decap_8
* cell instance sg13cmos5l_decap_8_2546 r0 *1 0,0
Xsg13cmos5l_decap_8_2546 VPWR VGND sg13cmos5l_decap_8
* cell instance sg13cmos5l_decap_8_2547 r0 *1 0,0
Xsg13cmos5l_decap_8_2547 VPWR VGND sg13cmos5l_decap_8
* cell instance sg13cmos5l_decap_8_2548 r0 *1 0,0
Xsg13cmos5l_decap_8_2548 VPWR VGND sg13cmos5l_decap_8
* cell instance sg13cmos5l_decap_8_2549 r0 *1 0,0
Xsg13cmos5l_decap_8_2549 VPWR VGND sg13cmos5l_decap_8
* cell instance sg13cmos5l_decap_8_2550 r0 *1 0,0
Xsg13cmos5l_decap_8_2550 VPWR VGND sg13cmos5l_decap_8
* cell instance sg13cmos5l_decap_8_2551 r0 *1 0,0
Xsg13cmos5l_decap_8_2551 VPWR VGND sg13cmos5l_decap_8
* cell instance sg13cmos5l_decap_8_2552 r0 *1 0,0
Xsg13cmos5l_decap_8_2552 VPWR VGND sg13cmos5l_decap_8
* cell instance sg13cmos5l_decap_8_2553 r0 *1 0,0
Xsg13cmos5l_decap_8_2553 VPWR VGND sg13cmos5l_decap_8
* cell instance sg13cmos5l_decap_8_2554 r0 *1 0,0
Xsg13cmos5l_decap_8_2554 VPWR VGND sg13cmos5l_decap_8
* cell instance sg13cmos5l_decap_8_2555 r0 *1 0,0
Xsg13cmos5l_decap_8_2555 VPWR VGND sg13cmos5l_decap_8
* cell instance sg13cmos5l_decap_8_2556 r0 *1 0,0
Xsg13cmos5l_decap_8_2556 VPWR VGND sg13cmos5l_decap_8
* cell instance sg13cmos5l_decap_8_2557 r0 *1 0,0
Xsg13cmos5l_decap_8_2557 VPWR VGND sg13cmos5l_decap_8
* cell instance sg13cmos5l_decap_8_2558 r0 *1 0,0
Xsg13cmos5l_decap_8_2558 VPWR VGND sg13cmos5l_decap_8
* cell instance sg13cmos5l_decap_8_2559 r0 *1 0,0
Xsg13cmos5l_decap_8_2559 VPWR VGND sg13cmos5l_decap_8
* cell instance sg13cmos5l_decap_8_2560 r0 *1 0,0
Xsg13cmos5l_decap_8_2560 VPWR VGND sg13cmos5l_decap_8
* cell instance sg13cmos5l_decap_8_2561 r0 *1 0,0
Xsg13cmos5l_decap_8_2561 VPWR VGND sg13cmos5l_decap_8
* cell instance sg13cmos5l_decap_8_2562 r0 *1 0,0
Xsg13cmos5l_decap_8_2562 VPWR VGND sg13cmos5l_decap_8
* cell instance sg13cmos5l_decap_8_2563 r0 *1 0,0
Xsg13cmos5l_decap_8_2563 VPWR VGND sg13cmos5l_decap_8
* cell instance sg13cmos5l_decap_8_2564 r0 *1 0,0
Xsg13cmos5l_decap_8_2564 VPWR VGND sg13cmos5l_decap_8
* cell instance sg13cmos5l_decap_8_2565 r0 *1 0,0
Xsg13cmos5l_decap_8_2565 VPWR VGND sg13cmos5l_decap_8
* cell instance sg13cmos5l_decap_8_2566 r0 *1 0,0
Xsg13cmos5l_decap_8_2566 VPWR VGND sg13cmos5l_decap_8
* cell instance sg13cmos5l_decap_8_2567 r0 *1 0,0
Xsg13cmos5l_decap_8_2567 VPWR VGND sg13cmos5l_decap_8
* cell instance sg13cmos5l_decap_8_2568 r0 *1 0,0
Xsg13cmos5l_decap_8_2568 VPWR VGND sg13cmos5l_decap_8
* cell instance sg13cmos5l_decap_8_2569 r0 *1 0,0
Xsg13cmos5l_decap_8_2569 VPWR VGND sg13cmos5l_decap_8
* cell instance sg13cmos5l_decap_8_2570 r0 *1 0,0
Xsg13cmos5l_decap_8_2570 VPWR VGND sg13cmos5l_decap_8
* cell instance sg13cmos5l_decap_8_2571 r0 *1 0,0
Xsg13cmos5l_decap_8_2571 VPWR VGND sg13cmos5l_decap_8
* cell instance sg13cmos5l_decap_8_2572 r0 *1 0,0
Xsg13cmos5l_decap_8_2572 VPWR VGND sg13cmos5l_decap_8
* cell instance sg13cmos5l_decap_8_2573 r0 *1 0,0
Xsg13cmos5l_decap_8_2573 VPWR VGND sg13cmos5l_decap_8
* cell instance sg13cmos5l_decap_8_2574 r0 *1 0,0
Xsg13cmos5l_decap_8_2574 VPWR VGND sg13cmos5l_decap_8
* cell instance sg13cmos5l_decap_8_2575 r0 *1 0,0
Xsg13cmos5l_decap_8_2575 VPWR VGND sg13cmos5l_decap_8
* cell instance sg13cmos5l_decap_8_2576 r0 *1 0,0
Xsg13cmos5l_decap_8_2576 VPWR VGND sg13cmos5l_decap_8
* cell instance sg13cmos5l_decap_8_2577 r0 *1 0,0
Xsg13cmos5l_decap_8_2577 VPWR VGND sg13cmos5l_decap_8
* cell instance sg13cmos5l_decap_8_2578 r0 *1 0,0
Xsg13cmos5l_decap_8_2578 VPWR VGND sg13cmos5l_decap_8
* cell instance sg13cmos5l_decap_8_2579 r0 *1 0,0
Xsg13cmos5l_decap_8_2579 VPWR VGND sg13cmos5l_decap_8
* cell instance sg13cmos5l_decap_8_2580 r0 *1 0,0
Xsg13cmos5l_decap_8_2580 VPWR VGND sg13cmos5l_decap_8
* cell instance sg13cmos5l_decap_8_2581 r0 *1 0,0
Xsg13cmos5l_decap_8_2581 VPWR VGND sg13cmos5l_decap_8
* cell instance sg13cmos5l_decap_8_2582 r0 *1 0,0
Xsg13cmos5l_decap_8_2582 VPWR VGND sg13cmos5l_decap_8
* cell instance sg13cmos5l_decap_8_2583 r0 *1 0,0
Xsg13cmos5l_decap_8_2583 VPWR VGND sg13cmos5l_decap_8
* cell instance sg13cmos5l_decap_8_2584 r0 *1 0,0
Xsg13cmos5l_decap_8_2584 VPWR VGND sg13cmos5l_decap_8
* cell instance sg13cmos5l_decap_8_2585 r0 *1 0,0
Xsg13cmos5l_decap_8_2585 VPWR VGND sg13cmos5l_decap_8
* cell instance sg13cmos5l_decap_8_2586 r0 *1 0,0
Xsg13cmos5l_decap_8_2586 VPWR VGND sg13cmos5l_decap_8
* cell instance sg13cmos5l_decap_8_2587 r0 *1 0,0
Xsg13cmos5l_decap_8_2587 VPWR VGND sg13cmos5l_decap_8
* cell instance sg13cmos5l_decap_8_2588 r0 *1 0,0
Xsg13cmos5l_decap_8_2588 VPWR VGND sg13cmos5l_decap_8
* cell instance sg13cmos5l_decap_8_2589 r0 *1 0,0
Xsg13cmos5l_decap_8_2589 VPWR VGND sg13cmos5l_decap_8
* cell instance sg13cmos5l_decap_8_2590 r0 *1 0,0
Xsg13cmos5l_decap_8_2590 VPWR VGND sg13cmos5l_decap_8
* cell instance sg13cmos5l_decap_8_2591 r0 *1 0,0
Xsg13cmos5l_decap_8_2591 VPWR VGND sg13cmos5l_decap_8
* cell instance sg13cmos5l_decap_8_2592 r0 *1 0,0
Xsg13cmos5l_decap_8_2592 VPWR VGND sg13cmos5l_decap_8
* cell instance sg13cmos5l_decap_8_2593 r0 *1 0,0
Xsg13cmos5l_decap_8_2593 VPWR VGND sg13cmos5l_decap_8
* cell instance sg13cmos5l_decap_8_2594 r0 *1 0,0
Xsg13cmos5l_decap_8_2594 VPWR VGND sg13cmos5l_decap_8
* cell instance sg13cmos5l_decap_8_2595 r0 *1 0,0
Xsg13cmos5l_decap_8_2595 VPWR VGND sg13cmos5l_decap_8
* cell instance sg13cmos5l_decap_8_2596 r0 *1 0,0
Xsg13cmos5l_decap_8_2596 VPWR VGND sg13cmos5l_decap_8
* cell instance sg13cmos5l_decap_8_2597 r0 *1 0,0
Xsg13cmos5l_decap_8_2597 VPWR VGND sg13cmos5l_decap_8
* cell instance sg13cmos5l_decap_8_2598 r0 *1 0,0
Xsg13cmos5l_decap_8_2598 VPWR VGND sg13cmos5l_decap_8
* cell instance sg13cmos5l_decap_8_2599 r0 *1 0,0
Xsg13cmos5l_decap_8_2599 VPWR VGND sg13cmos5l_decap_8
* cell instance sg13cmos5l_decap_8_2600 r0 *1 0,0
Xsg13cmos5l_decap_8_2600 VPWR VGND sg13cmos5l_decap_8
* cell instance sg13cmos5l_decap_8_2601 r0 *1 0,0
Xsg13cmos5l_decap_8_2601 VPWR VGND sg13cmos5l_decap_8
* cell instance sg13cmos5l_decap_8_2602 r0 *1 0,0
Xsg13cmos5l_decap_8_2602 VPWR VGND sg13cmos5l_decap_8
* cell instance sg13cmos5l_decap_8_2603 r0 *1 0,0
Xsg13cmos5l_decap_8_2603 VPWR VGND sg13cmos5l_decap_8
* cell instance sg13cmos5l_decap_8_2604 r0 *1 0,0
Xsg13cmos5l_decap_8_2604 VPWR VGND sg13cmos5l_decap_8
* cell instance sg13cmos5l_decap_8_2605 r0 *1 0,0
Xsg13cmos5l_decap_8_2605 VPWR VGND sg13cmos5l_decap_8
* cell instance sg13cmos5l_decap_8_2606 r0 *1 0,0
Xsg13cmos5l_decap_8_2606 VPWR VGND sg13cmos5l_decap_8
* cell instance sg13cmos5l_decap_8_2607 r0 *1 0,0
Xsg13cmos5l_decap_8_2607 VPWR VGND sg13cmos5l_decap_8
* cell instance sg13cmos5l_decap_8_2608 r0 *1 0,0
Xsg13cmos5l_decap_8_2608 VPWR VGND sg13cmos5l_decap_8
* cell instance sg13cmos5l_decap_8_2609 r0 *1 0,0
Xsg13cmos5l_decap_8_2609 VPWR VGND sg13cmos5l_decap_8
* cell instance sg13cmos5l_decap_8_2610 r0 *1 0,0
Xsg13cmos5l_decap_8_2610 VPWR VGND sg13cmos5l_decap_8
* cell instance sg13cmos5l_decap_8_2611 r0 *1 0,0
Xsg13cmos5l_decap_8_2611 VPWR VGND sg13cmos5l_decap_8
* cell instance sg13cmos5l_decap_8_2612 r0 *1 0,0
Xsg13cmos5l_decap_8_2612 VPWR VGND sg13cmos5l_decap_8
* cell instance sg13cmos5l_decap_8_2613 r0 *1 0,0
Xsg13cmos5l_decap_8_2613 VPWR VGND sg13cmos5l_decap_8
* cell instance sg13cmos5l_decap_8_2614 r0 *1 0,0
Xsg13cmos5l_decap_8_2614 VPWR VGND sg13cmos5l_decap_8
* cell instance sg13cmos5l_decap_8_2615 r0 *1 0,0
Xsg13cmos5l_decap_8_2615 VPWR VGND sg13cmos5l_decap_8
* cell instance sg13cmos5l_decap_8_2616 r0 *1 0,0
Xsg13cmos5l_decap_8_2616 VPWR VGND sg13cmos5l_decap_8
* cell instance sg13cmos5l_decap_8_2617 r0 *1 0,0
Xsg13cmos5l_decap_8_2617 VPWR VGND sg13cmos5l_decap_8
* cell instance sg13cmos5l_decap_8_2618 r0 *1 0,0
Xsg13cmos5l_decap_8_2618 VPWR VGND sg13cmos5l_decap_8
* cell instance sg13cmos5l_decap_8_2619 r0 *1 0,0
Xsg13cmos5l_decap_8_2619 VPWR VGND sg13cmos5l_decap_8
* cell instance sg13cmos5l_decap_8_2620 r0 *1 0,0
Xsg13cmos5l_decap_8_2620 VPWR VGND sg13cmos5l_decap_8
* cell instance sg13cmos5l_decap_8_2621 r0 *1 0,0
Xsg13cmos5l_decap_8_2621 VPWR VGND sg13cmos5l_decap_8
* cell instance sg13cmos5l_decap_8_2622 r0 *1 0,0
Xsg13cmos5l_decap_8_2622 VPWR VGND sg13cmos5l_decap_8
* cell instance sg13cmos5l_decap_8_2623 r0 *1 0,0
Xsg13cmos5l_decap_8_2623 VPWR VGND sg13cmos5l_decap_8
* cell instance sg13cmos5l_decap_8_2624 r0 *1 0,0
Xsg13cmos5l_decap_8_2624 VPWR VGND sg13cmos5l_decap_8
* cell instance sg13cmos5l_decap_8_2625 r0 *1 0,0
Xsg13cmos5l_decap_8_2625 VPWR VGND sg13cmos5l_decap_8
* cell instance sg13cmos5l_decap_8_2626 r0 *1 0,0
Xsg13cmos5l_decap_8_2626 VPWR VGND sg13cmos5l_decap_8
* cell instance sg13cmos5l_decap_8_2627 r0 *1 0,0
Xsg13cmos5l_decap_8_2627 VPWR VGND sg13cmos5l_decap_8
* cell instance sg13cmos5l_decap_8_2628 r0 *1 0,0
Xsg13cmos5l_decap_8_2628 VPWR VGND sg13cmos5l_decap_8
* cell instance sg13cmos5l_decap_8_2629 r0 *1 0,0
Xsg13cmos5l_decap_8_2629 VPWR VGND sg13cmos5l_decap_8
* cell instance sg13cmos5l_decap_8_2630 r0 *1 0,0
Xsg13cmos5l_decap_8_2630 VPWR VGND sg13cmos5l_decap_8
* cell instance sg13cmos5l_decap_8_2631 r0 *1 0,0
Xsg13cmos5l_decap_8_2631 VPWR VGND sg13cmos5l_decap_8
* cell instance sg13cmos5l_decap_8_2632 r0 *1 0,0
Xsg13cmos5l_decap_8_2632 VPWR VGND sg13cmos5l_decap_8
* cell instance sg13cmos5l_decap_8_2633 r0 *1 0,0
Xsg13cmos5l_decap_8_2633 VPWR VGND sg13cmos5l_decap_8
* cell instance sg13cmos5l_decap_8_2634 r0 *1 0,0
Xsg13cmos5l_decap_8_2634 VPWR VGND sg13cmos5l_decap_8
* cell instance sg13cmos5l_decap_8_2635 r0 *1 0,0
Xsg13cmos5l_decap_8_2635 VPWR VGND sg13cmos5l_decap_8
* cell instance sg13cmos5l_decap_8_2636 r0 *1 0,0
Xsg13cmos5l_decap_8_2636 VPWR VGND sg13cmos5l_decap_8
* cell instance sg13cmos5l_decap_8_2637 r0 *1 0,0
Xsg13cmos5l_decap_8_2637 VPWR VGND sg13cmos5l_decap_8
* cell instance sg13cmos5l_decap_8_2638 r0 *1 0,0
Xsg13cmos5l_decap_8_2638 VPWR VGND sg13cmos5l_decap_8
* cell instance sg13cmos5l_decap_8_2639 r0 *1 0,0
Xsg13cmos5l_decap_8_2639 VPWR VGND sg13cmos5l_decap_8
* cell instance sg13cmos5l_decap_8_2640 r0 *1 0,0
Xsg13cmos5l_decap_8_2640 VPWR VGND sg13cmos5l_decap_8
* cell instance sg13cmos5l_decap_8_2641 r0 *1 0,0
Xsg13cmos5l_decap_8_2641 VPWR VGND sg13cmos5l_decap_8
* cell instance sg13cmos5l_decap_8_2642 r0 *1 0,0
Xsg13cmos5l_decap_8_2642 VPWR VGND sg13cmos5l_decap_8
* cell instance sg13cmos5l_decap_8_2643 r0 *1 0,0
Xsg13cmos5l_decap_8_2643 VPWR VGND sg13cmos5l_decap_8
* cell instance sg13cmos5l_decap_8_2644 r0 *1 0,0
Xsg13cmos5l_decap_8_2644 VPWR VGND sg13cmos5l_decap_8
* cell instance sg13cmos5l_decap_8_2645 r0 *1 0,0
Xsg13cmos5l_decap_8_2645 VPWR VGND sg13cmos5l_decap_8
* cell instance sg13cmos5l_decap_8_2646 r0 *1 0,0
Xsg13cmos5l_decap_8_2646 VPWR VGND sg13cmos5l_decap_8
* cell instance sg13cmos5l_decap_8_2647 r0 *1 0,0
Xsg13cmos5l_decap_8_2647 VPWR VGND sg13cmos5l_decap_8
* cell instance sg13cmos5l_decap_8_2648 r0 *1 0,0
Xsg13cmos5l_decap_8_2648 VPWR VGND sg13cmos5l_decap_8
* cell instance sg13cmos5l_decap_8_2649 r0 *1 0,0
Xsg13cmos5l_decap_8_2649 VPWR VGND sg13cmos5l_decap_8
* cell instance sg13cmos5l_decap_8_2650 r0 *1 0,0
Xsg13cmos5l_decap_8_2650 VPWR VGND sg13cmos5l_decap_8
* cell instance sg13cmos5l_decap_8_2651 r0 *1 0,0
Xsg13cmos5l_decap_8_2651 VPWR VGND sg13cmos5l_decap_8
* cell instance sg13cmos5l_decap_8_2652 r0 *1 0,0
Xsg13cmos5l_decap_8_2652 VPWR VGND sg13cmos5l_decap_8
* cell instance sg13cmos5l_decap_8_2653 r0 *1 0,0
Xsg13cmos5l_decap_8_2653 VPWR VGND sg13cmos5l_decap_8
* cell instance sg13cmos5l_decap_8_2654 r0 *1 0,0
Xsg13cmos5l_decap_8_2654 VPWR VGND sg13cmos5l_decap_8
* cell instance sg13cmos5l_decap_8_2655 r0 *1 0,0
Xsg13cmos5l_decap_8_2655 VPWR VGND sg13cmos5l_decap_8
* cell instance sg13cmos5l_decap_8_2656 r0 *1 0,0
Xsg13cmos5l_decap_8_2656 VPWR VGND sg13cmos5l_decap_8
* cell instance sg13cmos5l_decap_8_2657 r0 *1 0,0
Xsg13cmos5l_decap_8_2657 VPWR VGND sg13cmos5l_decap_8
* cell instance sg13cmos5l_decap_8_2658 r0 *1 0,0
Xsg13cmos5l_decap_8_2658 VPWR VGND sg13cmos5l_decap_8
* cell instance sg13cmos5l_decap_8_2659 r0 *1 0,0
Xsg13cmos5l_decap_8_2659 VPWR VGND sg13cmos5l_decap_8
* cell instance sg13cmos5l_decap_8_2660 r0 *1 0,0
Xsg13cmos5l_decap_8_2660 VPWR VGND sg13cmos5l_decap_8
* cell instance sg13cmos5l_decap_8_2661 r0 *1 0,0
Xsg13cmos5l_decap_8_2661 VPWR VGND sg13cmos5l_decap_8
* cell instance sg13cmos5l_decap_8_2662 r0 *1 0,0
Xsg13cmos5l_decap_8_2662 VPWR VGND sg13cmos5l_decap_8
* cell instance sg13cmos5l_decap_8_2663 r0 *1 0,0
Xsg13cmos5l_decap_8_2663 VPWR VGND sg13cmos5l_decap_8
* cell instance sg13cmos5l_decap_8_2664 r0 *1 0,0
Xsg13cmos5l_decap_8_2664 VPWR VGND sg13cmos5l_decap_8
* cell instance sg13cmos5l_decap_8_2665 r0 *1 0,0
Xsg13cmos5l_decap_8_2665 VPWR VGND sg13cmos5l_decap_8
* cell instance sg13cmos5l_decap_8_2666 r0 *1 0,0
Xsg13cmos5l_decap_8_2666 VPWR VGND sg13cmos5l_decap_8
* cell instance sg13cmos5l_decap_8_2667 r0 *1 0,0
Xsg13cmos5l_decap_8_2667 VPWR VGND sg13cmos5l_decap_8
* cell instance sg13cmos5l_decap_8_2668 r0 *1 0,0
Xsg13cmos5l_decap_8_2668 VPWR VGND sg13cmos5l_decap_8
* cell instance sg13cmos5l_decap_8_2669 r0 *1 0,0
Xsg13cmos5l_decap_8_2669 VPWR VGND sg13cmos5l_decap_8
* cell instance sg13cmos5l_decap_8_2670 r0 *1 0,0
Xsg13cmos5l_decap_8_2670 VPWR VGND sg13cmos5l_decap_8
* cell instance sg13cmos5l_decap_8_2671 r0 *1 0,0
Xsg13cmos5l_decap_8_2671 VPWR VGND sg13cmos5l_decap_8
* cell instance sg13cmos5l_decap_8_2672 r0 *1 0,0
Xsg13cmos5l_decap_8_2672 VPWR VGND sg13cmos5l_decap_8
* cell instance sg13cmos5l_decap_8_2673 r0 *1 0,0
Xsg13cmos5l_decap_8_2673 VPWR VGND sg13cmos5l_decap_8
* cell instance sg13cmos5l_decap_8_2674 r0 *1 0,0
Xsg13cmos5l_decap_8_2674 VPWR VGND sg13cmos5l_decap_8
* cell instance sg13cmos5l_decap_8_2675 r0 *1 0,0
Xsg13cmos5l_decap_8_2675 VPWR VGND sg13cmos5l_decap_8
* cell instance sg13cmos5l_decap_8_2676 r0 *1 0,0
Xsg13cmos5l_decap_8_2676 VPWR VGND sg13cmos5l_decap_8
* cell instance sg13cmos5l_decap_8_2677 r0 *1 0,0
Xsg13cmos5l_decap_8_2677 VPWR VGND sg13cmos5l_decap_8
* cell instance sg13cmos5l_decap_8_2678 r0 *1 0,0
Xsg13cmos5l_decap_8_2678 VPWR VGND sg13cmos5l_decap_8
* cell instance sg13cmos5l_decap_8_2679 r0 *1 0,0
Xsg13cmos5l_decap_8_2679 VPWR VGND sg13cmos5l_decap_8
* cell instance sg13cmos5l_decap_8_2680 r0 *1 0,0
Xsg13cmos5l_decap_8_2680 VPWR VGND sg13cmos5l_decap_8
* cell instance sg13cmos5l_decap_8_2681 r0 *1 0,0
Xsg13cmos5l_decap_8_2681 VPWR VGND sg13cmos5l_decap_8
* cell instance sg13cmos5l_decap_8_2682 r0 *1 0,0
Xsg13cmos5l_decap_8_2682 VPWR VGND sg13cmos5l_decap_8
* cell instance sg13cmos5l_decap_8_2683 r0 *1 0,0
Xsg13cmos5l_decap_8_2683 VPWR VGND sg13cmos5l_decap_8
* cell instance sg13cmos5l_decap_8_2684 r0 *1 0,0
Xsg13cmos5l_decap_8_2684 VPWR VGND sg13cmos5l_decap_8
* cell instance sg13cmos5l_decap_8_2685 r0 *1 0,0
Xsg13cmos5l_decap_8_2685 VPWR VGND sg13cmos5l_decap_8
* cell instance sg13cmos5l_decap_8_2686 r0 *1 0,0
Xsg13cmos5l_decap_8_2686 VPWR VGND sg13cmos5l_decap_8
* cell instance sg13cmos5l_decap_8_2687 r0 *1 0,0
Xsg13cmos5l_decap_8_2687 VPWR VGND sg13cmos5l_decap_8
* cell instance sg13cmos5l_decap_8_2688 r0 *1 0,0
Xsg13cmos5l_decap_8_2688 VPWR VGND sg13cmos5l_decap_8
* cell instance sg13cmos5l_decap_8_2689 r0 *1 0,0
Xsg13cmos5l_decap_8_2689 VPWR VGND sg13cmos5l_decap_8
* cell instance sg13cmos5l_decap_8_2690 r0 *1 0,0
Xsg13cmos5l_decap_8_2690 VPWR VGND sg13cmos5l_decap_8
* cell instance sg13cmos5l_decap_8_2691 r0 *1 0,0
Xsg13cmos5l_decap_8_2691 VPWR VGND sg13cmos5l_decap_8
* cell instance sg13cmos5l_decap_8_2692 r0 *1 0,0
Xsg13cmos5l_decap_8_2692 VPWR VGND sg13cmos5l_decap_8
* cell instance sg13cmos5l_decap_8_2693 r0 *1 0,0
Xsg13cmos5l_decap_8_2693 VPWR VGND sg13cmos5l_decap_8
* cell instance sg13cmos5l_decap_8_2694 r0 *1 0,0
Xsg13cmos5l_decap_8_2694 VPWR VGND sg13cmos5l_decap_8
* cell instance sg13cmos5l_decap_8_2695 r0 *1 0,0
Xsg13cmos5l_decap_8_2695 VPWR VGND sg13cmos5l_decap_8
* cell instance sg13cmos5l_decap_8_2696 r0 *1 0,0
Xsg13cmos5l_decap_8_2696 VPWR VGND sg13cmos5l_decap_8
* cell instance sg13cmos5l_decap_8_2697 r0 *1 0,0
Xsg13cmos5l_decap_8_2697 VPWR VGND sg13cmos5l_decap_8
* cell instance sg13cmos5l_decap_8_2698 r0 *1 0,0
Xsg13cmos5l_decap_8_2698 VPWR VGND sg13cmos5l_decap_8
* cell instance sg13cmos5l_decap_8_2699 r0 *1 0,0
Xsg13cmos5l_decap_8_2699 VPWR VGND sg13cmos5l_decap_8
* cell instance sg13cmos5l_decap_8_2700 r0 *1 0,0
Xsg13cmos5l_decap_8_2700 VPWR VGND sg13cmos5l_decap_8
* cell instance sg13cmos5l_decap_8_2701 r0 *1 0,0
Xsg13cmos5l_decap_8_2701 VPWR VGND sg13cmos5l_decap_8
* cell instance sg13cmos5l_decap_8_2702 r0 *1 0,0
Xsg13cmos5l_decap_8_2702 VPWR VGND sg13cmos5l_decap_8
* cell instance sg13cmos5l_decap_8_2703 r0 *1 0,0
Xsg13cmos5l_decap_8_2703 VPWR VGND sg13cmos5l_decap_8
* cell instance sg13cmos5l_decap_8_2704 r0 *1 0,0
Xsg13cmos5l_decap_8_2704 VPWR VGND sg13cmos5l_decap_8
* cell instance sg13cmos5l_decap_8_2705 r0 *1 0,0
Xsg13cmos5l_decap_8_2705 VPWR VGND sg13cmos5l_decap_8
* cell instance sg13cmos5l_decap_8_2706 r0 *1 0,0
Xsg13cmos5l_decap_8_2706 VPWR VGND sg13cmos5l_decap_8
* cell instance sg13cmos5l_decap_8_2707 r0 *1 0,0
Xsg13cmos5l_decap_8_2707 VPWR VGND sg13cmos5l_decap_8
* cell instance sg13cmos5l_decap_8_2708 r0 *1 0,0
Xsg13cmos5l_decap_8_2708 VPWR VGND sg13cmos5l_decap_8
* cell instance sg13cmos5l_decap_8_2709 r0 *1 0,0
Xsg13cmos5l_decap_8_2709 VPWR VGND sg13cmos5l_decap_8
* cell instance sg13cmos5l_decap_8_2710 r0 *1 0,0
Xsg13cmos5l_decap_8_2710 VPWR VGND sg13cmos5l_decap_8
* cell instance sg13cmos5l_decap_8_2711 r0 *1 0,0
Xsg13cmos5l_decap_8_2711 VPWR VGND sg13cmos5l_decap_8
* cell instance sg13cmos5l_decap_8_2712 r0 *1 0,0
Xsg13cmos5l_decap_8_2712 VPWR VGND sg13cmos5l_decap_8
* cell instance sg13cmos5l_decap_8_2713 r0 *1 0,0
Xsg13cmos5l_decap_8_2713 VPWR VGND sg13cmos5l_decap_8
* cell instance sg13cmos5l_decap_8_2714 r0 *1 0,0
Xsg13cmos5l_decap_8_2714 VPWR VGND sg13cmos5l_decap_8
* cell instance sg13cmos5l_decap_8_2715 r0 *1 0,0
Xsg13cmos5l_decap_8_2715 VPWR VGND sg13cmos5l_decap_8
* cell instance sg13cmos5l_decap_8_2716 r0 *1 0,0
Xsg13cmos5l_decap_8_2716 VPWR VGND sg13cmos5l_decap_8
* cell instance sg13cmos5l_decap_8_2717 r0 *1 0,0
Xsg13cmos5l_decap_8_2717 VPWR VGND sg13cmos5l_decap_8
* cell instance sg13cmos5l_decap_8_2718 r0 *1 0,0
Xsg13cmos5l_decap_8_2718 VPWR VGND sg13cmos5l_decap_8
* cell instance sg13cmos5l_decap_8_2719 r0 *1 0,0
Xsg13cmos5l_decap_8_2719 VPWR VGND sg13cmos5l_decap_8
* cell instance sg13cmos5l_decap_8_2720 r0 *1 0,0
Xsg13cmos5l_decap_8_2720 VPWR VGND sg13cmos5l_decap_8
* cell instance sg13cmos5l_decap_8_2721 r0 *1 0,0
Xsg13cmos5l_decap_8_2721 VPWR VGND sg13cmos5l_decap_8
* cell instance sg13cmos5l_decap_8_2722 r0 *1 0,0
Xsg13cmos5l_decap_8_2722 VPWR VGND sg13cmos5l_decap_8
* cell instance sg13cmos5l_decap_8_2723 r0 *1 0,0
Xsg13cmos5l_decap_8_2723 VPWR VGND sg13cmos5l_decap_8
* cell instance sg13cmos5l_decap_8_2724 r0 *1 0,0
Xsg13cmos5l_decap_8_2724 VPWR VGND sg13cmos5l_decap_8
* cell instance sg13cmos5l_decap_8_2725 r0 *1 0,0
Xsg13cmos5l_decap_8_2725 VPWR VGND sg13cmos5l_decap_8
* cell instance sg13cmos5l_decap_8_2726 r0 *1 0,0
Xsg13cmos5l_decap_8_2726 VPWR VGND sg13cmos5l_decap_8
* cell instance sg13cmos5l_decap_8_2727 r0 *1 0,0
Xsg13cmos5l_decap_8_2727 VPWR VGND sg13cmos5l_decap_8
* cell instance sg13cmos5l_decap_8_2728 r0 *1 0,0
Xsg13cmos5l_decap_8_2728 VPWR VGND sg13cmos5l_decap_8
* cell instance sg13cmos5l_decap_8_2729 r0 *1 0,0
Xsg13cmos5l_decap_8_2729 VPWR VGND sg13cmos5l_decap_8
* cell instance sg13cmos5l_decap_8_2730 r0 *1 0,0
Xsg13cmos5l_decap_8_2730 VPWR VGND sg13cmos5l_decap_8
* cell instance sg13cmos5l_decap_8_2731 r0 *1 0,0
Xsg13cmos5l_decap_8_2731 VPWR VGND sg13cmos5l_decap_8
* cell instance sg13cmos5l_decap_8_2732 r0 *1 0,0
Xsg13cmos5l_decap_8_2732 VPWR VGND sg13cmos5l_decap_8
* cell instance sg13cmos5l_decap_8_2733 r0 *1 0,0
Xsg13cmos5l_decap_8_2733 VPWR VGND sg13cmos5l_decap_8
* cell instance sg13cmos5l_dfrbpq_1_0 r0 *1 0,0
Xsg13cmos5l_dfrbpq_1_0 \$2229 \$285 \$2233 \$2225 VPWR VGND sg13cmos5l_dfrbpq_1
* cell instance sg13cmos5l_dfrbpq_1_1 r0 *1 0,0
Xsg13cmos5l_dfrbpq_1_1 \$2378 \$1882 \$2670 \$2662 VPWR VGND sg13cmos5l_dfrbpq_1
* cell instance sg13cmos5l_dfrbpq_1_2 r0 *1 0,0
Xsg13cmos5l_dfrbpq_1_2 \$2378 \$1789 \$3216 \$2662 VPWR VGND sg13cmos5l_dfrbpq_1
* cell instance sg13cmos5l_dfrbpq_1_3 r0 *1 0,0
Xsg13cmos5l_dfrbpq_1_3 \$2378 \$1664 \$3590 \$2662 VPWR VGND sg13cmos5l_dfrbpq_1
* cell instance sg13cmos5l_dfrbpq_1_4 r0 *1 0,0
Xsg13cmos5l_dfrbpq_1_4 \$4354 \$4191 \$4360 \$4350 VPWR VGND sg13cmos5l_dfrbpq_1
* cell instance sg13cmos5l_dfrbpq_1_5 r0 *1 0,0
Xsg13cmos5l_dfrbpq_1_5 \$4354 \$5017 \$4872 \$4350 VPWR VGND sg13cmos5l_dfrbpq_1
* cell instance sg13cmos5l_dfrbpq_1_6 r0 *1 0,0
Xsg13cmos5l_dfrbpq_1_6 \$4354 \$5272 \$5283 \$4350 VPWR VGND sg13cmos5l_dfrbpq_1
* cell instance sg13cmos5l_dfrbpq_1_7 r0 *1 0,0
Xsg13cmos5l_dfrbpq_1_7 \$4354 \$5475 \$5715 \$4350 VPWR VGND sg13cmos5l_dfrbpq_1
* cell instance sg13cmos5l_dfrbpq_1_8 r0 *1 0,0
Xsg13cmos5l_dfrbpq_1_8 \$6363 \$6337 \$6368 \$6356 VPWR VGND sg13cmos5l_dfrbpq_1
* cell instance sg13cmos5l_dfrbpq_1_9 r0 *1 0,0
Xsg13cmos5l_dfrbpq_1_9 \$6363 \$7804 \$7705 \$6356 VPWR VGND sg13cmos5l_dfrbpq_1
* cell instance sg13cmos5l_dfrbpq_1_10 r0 *1 0,0
Xsg13cmos5l_dfrbpq_1_10 \$8232 \$8230 \$8142 \$8214 VPWR VGND
+ sg13cmos5l_dfrbpq_1
* cell instance sg13cmos5l_dfrbpq_1_11 r0 *1 0,0
Xsg13cmos5l_dfrbpq_1_11 \$8232 \$8489 \$8411 \$8214 VPWR VGND
+ sg13cmos5l_dfrbpq_1
* cell instance sg13cmos5l_dfrbpq_1_12 r0 *1 0,0
Xsg13cmos5l_dfrbpq_1_12 \$11895 \$12007 \$11896 \$11894 VPWR VGND
+ sg13cmos5l_dfrbpq_1
* cell instance sg13cmos5l_dfrbpq_1_13 r0 *1 0,0
Xsg13cmos5l_dfrbpq_1_13 \$11895 \$13005 \$12704 \$11894 VPWR VGND
+ sg13cmos5l_dfrbpq_1
* cell instance sg13cmos5l_dfrbpq_1_14 r0 *1 0,0
Xsg13cmos5l_dfrbpq_1_14 \$11895 \$14036 \$13864 \$11894 VPWR VGND
+ sg13cmos5l_dfrbpq_1
* cell instance sg13cmos5l_dfrbpq_1_15 r0 *1 0,0
Xsg13cmos5l_dfrbpq_1_15 \$11895 \$15070 uio_out[5] \$12927 VPWR VGND
+ sg13cmos5l_dfrbpq_1
* cell instance sg13cmos5l_dfrbpq_1_16 r0 *1 0,0
Xsg13cmos5l_dfrbpq_1_16 \$2378 \$79 \$2383 \$2225 VPWR VGND sg13cmos5l_dfrbpq_1
* cell instance sg13cmos5l_dfrbpq_1_17 r0 *1 0,0
Xsg13cmos5l_dfrbpq_1_17 \$2378 \$4044 \$4076 \$2662 VPWR VGND
+ sg13cmos5l_dfrbpq_1
* cell instance sg13cmos5l_dfrbpq_1_18 r0 *1 0,0
Xsg13cmos5l_dfrbpq_1_18 \$8232 \$9258 \$6482 \$8214 VPWR VGND
+ sg13cmos5l_dfrbpq_1
* cell instance sg13cmos5l_dfrbpq_1_19 r0 *1 0,0
Xsg13cmos5l_dfrbpq_1_19 \$8232 \$10030 \$9928 \$8214 VPWR VGND
+ sg13cmos5l_dfrbpq_1
* cell instance sg13cmos5l_dfrbpq_1_20 r0 *1 0,0
Xsg13cmos5l_dfrbpq_1_20 \$4354 \$4496 \$4077 \$4350 VPWR VGND
+ sg13cmos5l_dfrbpq_1
* cell instance sg13cmos5l_dfrbpq_1_21 r0 *1 0,0
Xsg13cmos5l_dfrbpq_1_21 \$8232 \$9296 \$9283 \$8214 VPWR VGND
+ sg13cmos5l_dfrbpq_1
* cell instance sg13cmos5l_dfrbpq_1_22 r0 *1 0,0
Xsg13cmos5l_dfrbpq_1_22 \$2378 \$3726 \$3736 \$2662 VPWR VGND
+ sg13cmos5l_dfrbpq_1
* cell instance sg13cmos5l_dfrbpq_1_23 r0 *1 0,0
Xsg13cmos5l_dfrbpq_1_23 \$8232 \$10764 \$6397 \$8214 VPWR VGND
+ sg13cmos5l_dfrbpq_1
* cell instance sg13cmos5l_dfrbpq_1_24 r0 *1 0,0
Xsg13cmos5l_dfrbpq_1_24 \$6363 \$6360 \$5903 \$6356 VPWR VGND
+ sg13cmos5l_dfrbpq_1
* cell instance sg13cmos5l_dfrbpq_1_25 r0 *1 0,0
Xsg13cmos5l_dfrbpq_1_25 \$6363 \$6554 \$6920 \$6356 VPWR VGND
+ sg13cmos5l_dfrbpq_1
* cell instance sg13cmos5l_dfrbpq_1_26 r0 *1 0,0
Xsg13cmos5l_dfrbpq_1_26 \$6363 \$7376 \$7491 \$6383 VPWR VGND
+ sg13cmos5l_dfrbpq_1
* cell instance sg13cmos5l_dfrbpq_1_27 r0 *1 0,0
Xsg13cmos5l_dfrbpq_1_27 \$16331 \$17131 uio_out[7] \$17322 VPWR VGND
+ sg13cmos5l_dfrbpq_1
* cell instance sg13cmos5l_dfrbpq_1_28 r0 *1 0,0
Xsg13cmos5l_dfrbpq_1_28 \$8232 \$8419 \$8531 \$8214 VPWR VGND
+ sg13cmos5l_dfrbpq_1
* cell instance sg13cmos5l_dfrbpq_1_29 r0 *1 0,0
Xsg13cmos5l_dfrbpq_1_29 \$4354 \$4654 \$4506 \$4350 VPWR VGND
+ sg13cmos5l_dfrbpq_1
* cell instance sg13cmos5l_dfrbpq_1_30 r0 *1 0,0
Xsg13cmos5l_dfrbpq_1_30 \$11895 \$16001 uio_out[4] \$11894 VPWR VGND
+ sg13cmos5l_dfrbpq_1
* cell instance sg13cmos5l_dfrbpq_1_31 r0 *1 0,0
Xsg13cmos5l_dfrbpq_1_31 \$11895 \$14335 \$14535 \$11894 VPWR VGND
+ sg13cmos5l_dfrbpq_1
* cell instance sg13cmos5l_dfrbpq_1_32 r0 *1 0,0
Xsg13cmos5l_dfrbpq_1_32 \$6363 \$7807 \$8018 \$6356 VPWR VGND
+ sg13cmos5l_dfrbpq_1
* cell instance sg13cmos5l_dfrbpq_1_33 r0 *1 0,0
Xsg13cmos5l_dfrbpq_1_33 \$11895 \$12227 \$12424 \$11894 VPWR VGND
+ sg13cmos5l_dfrbpq_1
* cell instance sg13cmos5l_dfrbpq_1_34 r0 *1 0,0
Xsg13cmos5l_dfrbpq_1_34 \$6363 \$6807 \$5926 \$6356 VPWR VGND
+ sg13cmos5l_dfrbpq_1
* cell instance sg13cmos5l_dfrbpq_1_35 r0 *1 0,0
Xsg13cmos5l_dfrbpq_1_35 \$11895 \$13402 \$13405 \$11894 VPWR VGND
+ sg13cmos5l_dfrbpq_1
* cell instance sg13cmos5l_dfrbpq_1_36 r0 *1 0,0
Xsg13cmos5l_dfrbpq_1_36 \$16331 \$17632 uio_out[2] \$17322 VPWR VGND
+ sg13cmos5l_dfrbpq_1
* cell instance sg13cmos5l_dfrbpq_1_37 r0 *1 0,0
Xsg13cmos5l_dfrbpq_1_37 \$6363 \$6374 \$6081 \$6356 VPWR VGND
+ sg13cmos5l_dfrbpq_1
* cell instance sg13cmos5l_dfrbpq_1_38 r0 *1 0,0
Xsg13cmos5l_dfrbpq_1_38 \$11895 \$9935 \$11700 \$11894 VPWR VGND
+ sg13cmos5l_dfrbpq_1
* cell instance sg13cmos5l_dfrbpq_1_39 r0 *1 0,0
Xsg13cmos5l_dfrbpq_1_39 \$16331 \$18791 \$8219 \$17322 VPWR VGND
+ sg13cmos5l_dfrbpq_1
* cell instance sg13cmos5l_dfrbpq_1_40 r0 *1 0,0
Xsg13cmos5l_dfrbpq_1_40 \$6363 \$7492 \$6094 \$6356 VPWR VGND
+ sg13cmos5l_dfrbpq_1
* cell instance sg13cmos5l_dfrbpq_1_41 r0 *1 0,0
Xsg13cmos5l_dfrbpq_1_41 \$4354 \$5021 \$4890 \$4350 VPWR VGND
+ sg13cmos5l_dfrbpq_1
* cell instance sg13cmos5l_dfrbpq_1_42 r0 *1 0,0
Xsg13cmos5l_dfrbpq_1_42 \$16331 \$19835 uio_out[6] \$17322 VPWR VGND
+ sg13cmos5l_dfrbpq_1
* cell instance sg13cmos5l_dfrbpq_1_43 r0 *1 0,0
Xsg13cmos5l_dfrbpq_1_43 \$16331 \$20021 \$20032 \$17322 VPWR VGND
+ sg13cmos5l_dfrbpq_1
* cell instance sg13cmos5l_dfrbpq_1_44 r0 *1 0,0
Xsg13cmos5l_dfrbpq_1_44 \$8232 \$8854 \$9042 \$8217 VPWR VGND
+ sg13cmos5l_dfrbpq_1
* cell instance sg13cmos5l_dfrbpq_1_45 r0 *1 0,0
Xsg13cmos5l_dfrbpq_1_45 \$11895 \$15074 \$14867 \$12927 VPWR VGND
+ sg13cmos5l_dfrbpq_1
* cell instance sg13cmos5l_dfrbpq_1_46 r0 *1 0,0
Xsg13cmos5l_dfrbpq_1_46 \$11895 \$16005 \$8494 \$12927 VPWR VGND
+ sg13cmos5l_dfrbpq_1
* cell instance sg13cmos5l_dfrbpq_1_47 r0 *1 0,0
Xsg13cmos5l_dfrbpq_1_47 \$8232 \$8421 \$8431 \$8214 VPWR VGND
+ sg13cmos5l_dfrbpq_1
* cell instance sg13cmos5l_dfrbpq_1_48 r0 *1 0,0
Xsg13cmos5l_dfrbpq_1_48 \$11895 \$12271 \$12719 \$12927 VPWR VGND
+ sg13cmos5l_dfrbpq_1
* cell instance sg13cmos5l_dfrbpq_1_49 r0 *1 0,0
Xsg13cmos5l_dfrbpq_1_49 \$6363 \$6567 \$6569 \$6383 VPWR VGND
+ sg13cmos5l_dfrbpq_1
* cell instance sg13cmos5l_dfrbpq_1_50 r0 *1 0,0
Xsg13cmos5l_dfrbpq_1_50 \$4354 \$4516 \$4517 \$4350 VPWR VGND
+ sg13cmos5l_dfrbpq_1
* cell instance sg13cmos5l_dfrbpq_1_51 r0 *1 0,0
Xsg13cmos5l_dfrbpq_1_51 \$6363 \$7809 \$7812 \$6383 VPWR VGND
+ sg13cmos5l_dfrbpq_1
* cell instance sg13cmos5l_dfrbpq_1_52 r0 *1 0,0
Xsg13cmos5l_dfrbpq_1_52 \$16331 \$20066 \$20079 \$17324 VPWR VGND
+ sg13cmos5l_dfrbpq_1
* cell instance sg13cmos5l_dfrbpq_1_53 r0 *1 0,0
Xsg13cmos5l_dfrbpq_1_53 \$16331 \$17140 \$8008 \$17322 VPWR VGND
+ sg13cmos5l_dfrbpq_1
* cell instance sg13cmos5l_dfrbpq_1_54 r0 *1 0,0
Xsg13cmos5l_dfrbpq_1_54 \$4354 \$5908 \$5300 \$4856 VPWR VGND
+ sg13cmos5l_dfrbpq_1
* cell instance sg13cmos5l_dfrbpq_1_55 r0 *1 0,0
Xsg13cmos5l_dfrbpq_1_55 \$6363 \$6082 \$5906 \$6383 VPWR VGND
+ sg13cmos5l_dfrbpq_1
* cell instance sg13cmos5l_dfrbpq_1_56 r0 *1 0,0
Xsg13cmos5l_dfrbpq_1_56 \$16331 \$16010 \$16689 \$12927 VPWR VGND
+ sg13cmos5l_dfrbpq_1
* cell instance sg13cmos5l_dfrbpq_1_57 r0 *1 0,0
Xsg13cmos5l_dfrbpq_1_57 \$8232 \$10594 \$8007 \$12927 VPWR VGND
+ sg13cmos5l_dfrbpq_1
* cell instance sg13cmos5l_dfrbpq_1_58 r0 *1 0,0
Xsg13cmos5l_dfrbpq_1_58 \$4354 \$5061 \$4896 \$4856 VPWR VGND
+ sg13cmos5l_dfrbpq_1
* cell instance sg13cmos5l_dfrbpq_1_59 r0 *1 0,0
Xsg13cmos5l_dfrbpq_1_59 \$4354 \$5487 \$5297 \$2662 VPWR VGND
+ sg13cmos5l_dfrbpq_1
* cell instance sg13cmos5l_dfrbpq_1_60 r0 *1 0,0
Xsg13cmos5l_dfrbpq_1_60 \$6363 \$6925 \$4719 \$6383 VPWR VGND
+ sg13cmos5l_dfrbpq_1
* cell instance sg13cmos5l_dfrbpq_1_61 r0 *1 0,0
Xsg13cmos5l_dfrbpq_1_61 \$16331 \$19984 \$19995 \$17324 VPWR VGND
+ sg13cmos5l_dfrbpq_1
* cell instance sg13cmos5l_dfrbpq_1_62 r0 *1 0,0
Xsg13cmos5l_dfrbpq_1_62 \$8232 \$8537 \$6396 \$8217 VPWR VGND
+ sg13cmos5l_dfrbpq_1
* cell instance sg13cmos5l_dfrbpq_1_63 r0 *1 0,0
Xsg13cmos5l_dfrbpq_1_63 \$16331 \$19241 uio_out[3] \$17322 VPWR VGND
+ sg13cmos5l_dfrbpq_1
* cell instance sg13cmos5l_dfrbpq_1_64 r0 *1 0,0
Xsg13cmos5l_dfrbpq_1_64 \$16331 \$17332 \$17153 \$17324 VPWR VGND
+ sg13cmos5l_dfrbpq_1
* cell instance sg13cmos5l_dfrbpq_1_65 r0 *1 0,0
Xsg13cmos5l_dfrbpq_1_65 \$2378 \$4045 \$3928 \$2662 VPWR VGND
+ sg13cmos5l_dfrbpq_1
* cell instance sg13cmos5l_dfrbpq_1_66 r0 *1 0,0
Xsg13cmos5l_dfrbpq_1_66 \$16331 \$18798 \$6930 \$17322 VPWR VGND
+ sg13cmos5l_dfrbpq_1
* cell instance sg13cmos5l_dfrbpq_1_67 r0 *1 0,0
Xsg13cmos5l_dfrbpq_1_67 \$2378 \$259 \$3399 \$2225 VPWR VGND sg13cmos5l_dfrbpq_1
* cell instance sg13cmos5l_dfrbpq_1_68 r0 *1 0,0
Xsg13cmos5l_dfrbpq_1_68 \$8232 \$8497 \$8218 \$8217 VPWR VGND
+ sg13cmos5l_dfrbpq_1
* cell instance sg13cmos5l_dfrbpq_1_69 r0 *1 0,0
Xsg13cmos5l_dfrbpq_1_69 \$11895 \$15365 \$15078 \$12927 VPWR VGND
+ sg13cmos5l_dfrbpq_1
* cell instance sg13cmos5l_dfrbpq_1_70 r0 *1 0,0
Xsg13cmos5l_dfrbpq_1_70 \$4354 \$5502 \$5687 \$5507 VPWR VGND
+ sg13cmos5l_dfrbpq_1
* cell instance sg13cmos5l_dfrbpq_1_71 r0 *1 0,0
Xsg13cmos5l_dfrbpq_1_71 \$4354 \$4658 \$4521 \$2705 VPWR VGND
+ sg13cmos5l_dfrbpq_1
* cell instance sg13cmos5l_dfrbpq_1_72 r0 *1 0,0
Xsg13cmos5l_dfrbpq_1_72 \$17336 \$20126 \$20088 \$16695 VPWR VGND
+ sg13cmos5l_dfrbpq_1
* cell instance sg13cmos5l_dfrbpq_1_73 r0 *1 0,0
Xsg13cmos5l_dfrbpq_1_73 \$17336 \$17334 \$5513 \$14543 VPWR VGND
+ sg13cmos5l_dfrbpq_1
* cell instance sg13cmos5l_dfrbpq_1_74 r0 *1 0,0
Xsg13cmos5l_dfrbpq_1_74 \$2378 \$651 \$2529 \$2225 VPWR VGND sg13cmos5l_dfrbpq_1
* cell instance sg13cmos5l_dfrbpq_1_75 r0 *1 0,0
Xsg13cmos5l_dfrbpq_1_75 \$16331 \$19246 \$5307 \$14543 VPWR VGND
+ sg13cmos5l_dfrbpq_1
* cell instance sg13cmos5l_dfrbpq_1_76 r0 *1 0,0
Xsg13cmos5l_dfrbpq_1_76 \$6363 \$6484 \$6496 \$6489 VPWR VGND
+ sg13cmos5l_dfrbpq_1
* cell instance sg13cmos5l_dfrbpq_1_77 r0 *1 0,0
Xsg13cmos5l_dfrbpq_1_77 \$17336 \$16653 \$16658 \$16695 VPWR VGND
+ sg13cmos5l_dfrbpq_1
* cell instance sg13cmos5l_dfrbpq_1_78 r0 *1 0,0
Xsg13cmos5l_dfrbpq_1_78 \$2844 \$5930 \$5734 \$5507 VPWR VGND
+ sg13cmos5l_dfrbpq_1
* cell instance sg13cmos5l_dfrbpq_1_79 r0 *1 0,0
Xsg13cmos5l_dfrbpq_1_79 \$11895 \$14542 \$14356 \$14543 VPWR VGND
+ sg13cmos5l_dfrbpq_1
* cell instance sg13cmos5l_dfrbpq_1_80 r0 *1 0,0
Xsg13cmos5l_dfrbpq_1_80 \$4354 \$5080 \$5091 \$5507 VPWR VGND
+ sg13cmos5l_dfrbpq_1
* cell instance sg13cmos5l_dfrbpq_1_81 r0 *1 0,0
Xsg13cmos5l_dfrbpq_1_81 \$17336 \$20050 \$20002 \$14543 VPWR VGND
+ sg13cmos5l_dfrbpq_1
* cell instance sg13cmos5l_dfrbpq_1_82 r0 *1 0,0
Xsg13cmos5l_dfrbpq_1_82 \$6363 \$7724 \$7816 \$6489 VPWR VGND
+ sg13cmos5l_dfrbpq_1
* cell instance sg13cmos5l_dfrbpq_1_83 r0 *1 0,0
Xsg13cmos5l_dfrbpq_1_83 \$6363 \$8549 \$5738 \$6489 VPWR VGND
+ sg13cmos5l_dfrbpq_1
* cell instance sg13cmos5l_dfrbpq_1_84 r0 *1 0,0
Xsg13cmos5l_dfrbpq_1_84 \$8232 \$8884 \$9046 \$6489 VPWR VGND
+ sg13cmos5l_dfrbpq_1
* cell instance sg13cmos5l_dfrbpq_1_85 r0 *1 0,0
Xsg13cmos5l_dfrbpq_1_85 \$11895 \$10596 \$9331 \$6489 VPWR VGND
+ sg13cmos5l_dfrbpq_1
* cell instance sg13cmos5l_dfrbpq_1_86 r0 *1 0,0
Xsg13cmos5l_dfrbpq_1_86 \$17336 \$15564 \$15834 \$14543 VPWR VGND
+ sg13cmos5l_dfrbpq_1
* cell instance sg13cmos5l_dfrbpq_1_87 r0 *1 0,0
Xsg13cmos5l_dfrbpq_1_87 \$17336 \$17695 \$13482 \$14543 VPWR VGND
+ sg13cmos5l_dfrbpq_1
* cell instance sg13cmos5l_dfrbpq_1_88 r0 *1 0,0
Xsg13cmos5l_dfrbpq_1_88 \$16331 \$18164 uio_out[1] \$14543 VPWR VGND
+ sg13cmos5l_dfrbpq_1
* cell instance sg13cmos5l_dfrbpq_1_89 r0 *1 0,0
Xsg13cmos5l_dfrbpq_1_89 \$2844 \$4094 \$3958 \$2705 VPWR VGND
+ sg13cmos5l_dfrbpq_1
* cell instance sg13cmos5l_dfrbpq_1_90 r0 *1 0,0
Xsg13cmos5l_dfrbpq_1_90 \$17336 \$19999 uio_out[0] \$14543 VPWR VGND
+ sg13cmos5l_dfrbpq_1
* cell instance sg13cmos5l_dfrbpq_1_91 r0 *1 0,0
Xsg13cmos5l_dfrbpq_1_91 \$2378 \$251 \$2694 \$2225 VPWR VGND sg13cmos5l_dfrbpq_1
* cell instance sg13cmos5l_dfrbpq_1_92 r0 *1 0,0
Xsg13cmos5l_dfrbpq_1_92 \$2844 \$4218 \$4485 \$2705 VPWR VGND
+ sg13cmos5l_dfrbpq_1
* cell instance sg13cmos5l_dfrbpq_1_93 r0 *1 0,0
Xsg13cmos5l_dfrbpq_1_93 \$2844 \$3763 \$2691 \$2705 VPWR VGND
+ sg13cmos5l_dfrbpq_1
* cell instance sg13cmos5l_dfrbpq_1_94 r0 *1 0,0
Xsg13cmos5l_dfrbpq_1_94 \$2378 \$1896 \$2714 \$2705 VPWR VGND
+ sg13cmos5l_dfrbpq_1
* cell instance sg13cmos5l_dfrbpq_1_95 r0 *1 0,0
Xsg13cmos5l_dfrbpq_1_95 \$2844 \$5526 \$5757 \$5507 VPWR VGND
+ sg13cmos5l_dfrbpq_1
* cell instance sg13cmos5l_dfrbpq_1_96 r0 *1 0,0
Xsg13cmos5l_dfrbpq_1_96 \$2844 \$1649 \$3612 \$2705 VPWR VGND
+ sg13cmos5l_dfrbpq_1
* cell instance sg13cmos5l_dfrbpq_1_97 r0 *1 0,0
Xsg13cmos5l_dfrbpq_1_97 \$2844 \$5256 \$5310 \$5507 VPWR VGND
+ sg13cmos5l_dfrbpq_1
* cell instance sg13cmos5l_dfrbpq_1_98 r0 *1 0,0
Xsg13cmos5l_dfrbpq_1_98 \$2844 \$1312 \$3246 \$2705 VPWR VGND
+ sg13cmos5l_dfrbpq_1
* cell instance sg13cmos5l_dfrbpq_1_99 r0 *1 0,0
Xsg13cmos5l_dfrbpq_1_99 \$2844 \$1901 \$2848 \$2705 VPWR VGND
+ sg13cmos5l_dfrbpq_1
* cell instance sg13cmos5l_dfrbpq_1_100 r0 *1 0,0
Xsg13cmos5l_dfrbpq_1_100 \$5109 \$5322 \$3062 \$5125 VPWR VGND
+ sg13cmos5l_dfrbpq_1
* cell instance sg13cmos5l_dfrbpq_1_101 r0 *1 0,0
Xsg13cmos5l_dfrbpq_1_101 \$2844 \$2546 \$2858 \$2862 VPWR VGND
+ sg13cmos5l_dfrbpq_1
* cell instance sg13cmos5l_dfrbpq_1_102 r0 *1 0,0
Xsg13cmos5l_dfrbpq_1_102 \$2844 \$4922 \$4919 \$2862 VPWR VGND
+ sg13cmos5l_dfrbpq_1
* cell instance sg13cmos5l_dfrbpq_1_103 r0 *1 0,0
Xsg13cmos5l_dfrbpq_1_103 \$5109 \$5532 \$5544 \$2862 VPWR VGND
+ sg13cmos5l_dfrbpq_1
* cell instance sg13cmos5l_dfrbpq_1_104 r0 *1 0,0
Xsg13cmos5l_dfrbpq_1_104 \$2844 \$810 \$3431 \$2862 VPWR VGND
+ sg13cmos5l_dfrbpq_1
* cell instance sg13cmos5l_dfrbpq_1_105 r0 *1 0,0
Xsg13cmos5l_dfrbpq_1_105 \$5109 \$5110 \$4935 \$2862 VPWR VGND
+ sg13cmos5l_dfrbpq_1
* cell instance sg13cmos5l_dfrbpq_1_106 r0 *1 0,0
Xsg13cmos5l_dfrbpq_1_106 \$2866 \$2552 \$2870 \$2862 VPWR VGND
+ sg13cmos5l_dfrbpq_1
* cell instance sg13cmos5l_dfrbpq_1_107 r0 *1 0,0
Xsg13cmos5l_dfrbpq_1_107 \$2866 \$3053 \$3065 \$2862 VPWR VGND
+ sg13cmos5l_dfrbpq_1
* cell instance sg13cmos5l_dfrbpq_1_108 r0 *1 0,0
Xsg13cmos5l_dfrbpq_1_108 \$5109 \$5338 \$4734 \$5125 VPWR VGND
+ sg13cmos5l_dfrbpq_1
* cell instance sg13cmos5l_dfrbpq_1_109 r0 *1 0,0
Xsg13cmos5l_dfrbpq_1_109 \$5109 \$4944 \$4940 \$5125 VPWR VGND
+ sg13cmos5l_dfrbpq_1
* cell instance sg13cmos5l_dfrbpq_1_110 r0 *1 0,0
Xsg13cmos5l_dfrbpq_1_110 \$2866 \$2028 \$2880 \$2862 VPWR VGND
+ sg13cmos5l_dfrbpq_1
* cell instance sg13cmos5l_dfrbpq_1_111 r0 *1 0,0
Xsg13cmos5l_dfrbpq_1_111 \$5109 \$4566 \$4558 \$3073 VPWR VGND
+ sg13cmos5l_dfrbpq_1
* cell instance sg13cmos5l_dfrbpq_1_112 r0 *1 0,0
Xsg13cmos5l_dfrbpq_1_112 \$5109 \$5342 \$5575 \$4579 VPWR VGND
+ sg13cmos5l_dfrbpq_1
* cell instance sg13cmos5l_dfrbpq_1_113 r0 *1 0,0
Xsg13cmos5l_dfrbpq_1_113 \$2866 \$3070 \$3270 \$3073 VPWR VGND
+ sg13cmos5l_dfrbpq_1
* cell instance sg13cmos5l_dfrbpq_1_114 r0 *1 0,0
Xsg13cmos5l_dfrbpq_1_114 \$5109 \$5136 \$4914 \$4579 VPWR VGND
+ sg13cmos5l_dfrbpq_1
* cell instance sg13cmos5l_dfrbpq_1_115 r0 *1 0,0
Xsg13cmos5l_dfrbpq_1_115 \$2866 \$3374 \$2748 \$3073 VPWR VGND
+ sg13cmos5l_dfrbpq_1
* cell instance sg13cmos5l_dfrbpq_1_116 r0 *1 0,0
Xsg13cmos5l_dfrbpq_1_116 \$2866 \$3082 \$2886 \$3073 VPWR VGND
+ sg13cmos5l_dfrbpq_1
* cell instance sg13cmos5l_dfrbpq_1_117 r0 *1 0,0
Xsg13cmos5l_dfrbpq_1_117 \$2866 \$4670 \$4586 \$4579 VPWR VGND
+ sg13cmos5l_dfrbpq_1
* cell instance sg13cmos5l_dfrbpq_1_118 r0 *1 0,0
Xsg13cmos5l_dfrbpq_1_118 \$2866 \$4957 \$5158 \$4579 VPWR VGND
+ sg13cmos5l_dfrbpq_1
* cell instance sg13cmos5l_dfrbpq_1_119 r0 *1 0,0
Xsg13cmos5l_dfrbpq_1_119 \$2866 \$3449 \$3289 \$3073 VPWR VGND
+ sg13cmos5l_dfrbpq_1
* cell instance sg13cmos5l_dfrbpq_1_120 r0 *1 0,0
Xsg13cmos5l_dfrbpq_1_120 \$2866 \$4587 \$4116 \$3073 VPWR VGND
+ sg13cmos5l_dfrbpq_1
* cell instance sg13cmos5l_dfrbpq_1_121 r0 *1 0,0
Xsg13cmos5l_dfrbpq_1_121 \$2866 \$3099 \$2892 \$3073 VPWR VGND
+ sg13cmos5l_dfrbpq_1
* cell instance sg13cmos5l_dfrbpq_1_122 r0 *1 0,0
Xsg13cmos5l_dfrbpq_1_122 \$2866 \$3460 \$3471 \$3073 VPWR VGND
+ sg13cmos5l_dfrbpq_1
* cell instance sg13cmos5l_dfrbpq_1_123 r0 *1 0,0
Xsg13cmos5l_dfrbpq_1_123 \$1299 \$2136 \$2741 \$2733 VPWR VGND
+ sg13cmos5l_dfrbpq_1
* cell instance sg13cmos5l_dfrbpq_1_124 r0 *1 0,0
Xsg13cmos5l_dfrbpq_1_124 \$1299 \$3114 \$3126 \$2733 VPWR VGND
+ sg13cmos5l_dfrbpq_1
* cell instance sg13cmos5l_dfrbpq_1_125 r0 *1 0,0
Xsg13cmos5l_dfrbpq_1_125 \$1299 \$3798 \$4247 \$2733 VPWR VGND
+ sg13cmos5l_dfrbpq_1
* cell instance sg13cmos5l_dfrbpq_1_126 r0 *1 0,0
Xsg13cmos5l_dfrbpq_1_126 \$1299 \$1576 \$2577 \$1353 VPWR VGND
+ sg13cmos5l_dfrbpq_1
* cell instance sg13cmos5l_dfrbpq_1_127 r0 *1 0,0
Xsg13cmos5l_dfrbpq_1_127 \$4783 \$5379 \$5612 \$2733 VPWR VGND
+ sg13cmos5l_dfrbpq_1
* cell instance sg13cmos5l_dfrbpq_1_128 r0 *1 0,0
Xsg13cmos5l_dfrbpq_1_128 \$1299 \$4330 \$4594 \$2733 VPWR VGND
+ sg13cmos5l_dfrbpq_1
* cell instance sg13cmos5l_dfrbpq_1_129 r0 *1 0,0
Xsg13cmos5l_dfrbpq_1_129 \$1299 \$4773 \$4606 \$2733 VPWR VGND
+ sg13cmos5l_dfrbpq_1
* cell instance sg13cmos5l_dfrbpq_1_130 r0 *1 0,0
Xsg13cmos5l_dfrbpq_1_130 \$4783 \$5185 \$5390 \$2733 VPWR VGND
+ sg13cmos5l_dfrbpq_1
* cell instance sg13cmos5l_dfrbpq_1_131 r0 *1 0,0
Xsg13cmos5l_dfrbpq_1_131 \$1299 \$2277 \$2148 \$1353 VPWR VGND
+ sg13cmos5l_dfrbpq_1
* cell instance sg13cmos5l_dfrbpq_1_132 r0 *1 0,0
Xsg13cmos5l_dfrbpq_1_132 \$4783 \$4776 \$4788 \$2733 VPWR VGND
+ sg13cmos5l_dfrbpq_1
* cell instance sg13cmos5l_dfrbpq_1_133 r0 *1 0,0
Xsg13cmos5l_dfrbpq_1_133 \$1299 \$1565 \$1717 \$1353 VPWR VGND
+ sg13cmos5l_dfrbpq_1
* cell instance sg13cmos5l_dfrbpq_1_134 r0 *1 0,0
Xsg13cmos5l_dfrbpq_1_134 \$322 \$1211 \$1466 \$318 VPWR VGND sg13cmos5l_dfrbpq_1
* cell instance sg13cmos5l_dfrbpq_1_135 r0 *1 0,0
Xsg13cmos5l_dfrbpq_1_135 \$4783 \$5194 \$5187 \$3807 VPWR VGND
+ sg13cmos5l_dfrbpq_1
* cell instance sg13cmos5l_dfrbpq_1_136 r0 *1 0,0
Xsg13cmos5l_dfrbpq_1_136 \$1299 \$828 \$1223 \$318 VPWR VGND sg13cmos5l_dfrbpq_1
* cell instance sg13cmos5l_dfrbpq_1_137 r0 *1 0,0
Xsg13cmos5l_dfrbpq_1_137 \$4783 \$4677 \$4609 \$3807 VPWR VGND
+ sg13cmos5l_dfrbpq_1
* cell instance sg13cmos5l_dfrbpq_1_138 r0 *1 0,0
Xsg13cmos5l_dfrbpq_1_138 \$3813 \$5395 \$5399 \$2750 VPWR VGND
+ sg13cmos5l_dfrbpq_1
* cell instance sg13cmos5l_dfrbpq_1_139 r0 *1 0,0
Xsg13cmos5l_dfrbpq_1_139 \$3813 \$4427 \$3892 \$3807 VPWR VGND
+ sg13cmos5l_dfrbpq_1
* cell instance sg13cmos5l_dfrbpq_1_140 r0 *1 0,0
Xsg13cmos5l_dfrbpq_1_140 \$4783 \$5398 \$5619 \$3807 VPWR VGND
+ sg13cmos5l_dfrbpq_1
* cell instance sg13cmos5l_dfrbpq_1_141 r0 *1 0,0
Xsg13cmos5l_dfrbpq_1_141 \$322 \$690 \$847 \$318 VPWR VGND sg13cmos5l_dfrbpq_1
* cell instance sg13cmos5l_dfrbpq_1_142 r0 *1 0,0
Xsg13cmos5l_dfrbpq_1_142 \$322 \$282 \$326 \$318 VPWR VGND sg13cmos5l_dfrbpq_1
* cell instance sg13cmos5l_dfrbpq_1_143 r0 *1 0,0
Xsg13cmos5l_dfrbpq_1_143 \$322 \$693 \$567 \$318 VPWR VGND sg13cmos5l_dfrbpq_1
* cell instance sg13cmos5l_dfrbpq_1_144 r0 *1 0,0
Xsg13cmos5l_dfrbpq_1_144 \$3813 \$4335 \$4444 \$3807 VPWR VGND
+ sg13cmos5l_dfrbpq_1
* cell instance sg13cmos5l_dfrbpq_1_145 r0 *1 0,0
Xsg13cmos5l_dfrbpq_1_145 \$3813 \$3648 \$3818 \$3807 VPWR VGND
+ sg13cmos5l_dfrbpq_1
* cell instance sg13cmos5l_dfrbpq_1_146 r0 *1 0,0
Xsg13cmos5l_dfrbpq_1_146 \$322 \$393 \$853 \$318 VPWR VGND sg13cmos5l_dfrbpq_1
* cell instance sg13cmos5l_dfrbpq_1_147 r0 *1 0,0
Xsg13cmos5l_dfrbpq_1_147 \$3813 \$3311 \$3132 \$3807 VPWR VGND
+ sg13cmos5l_dfrbpq_1
* cell instance sg13cmos5l_dfrbpq_1_148 r0 *1 0,0
Xsg13cmos5l_dfrbpq_1_148 \$322 \$187 \$198 \$318 VPWR VGND sg13cmos5l_dfrbpq_1
* cell instance sg13cmos5l_dfrbpq_1_149 r0 *1 0,0
Xsg13cmos5l_dfrbpq_1_149 \$322 \$705 \$461 \$318 VPWR VGND sg13cmos5l_dfrbpq_1
* cell instance sg13cmos5l_dfrbpq_1_150 r0 *1 0,0
Xsg13cmos5l_dfrbpq_1_150 \$3813 \$3820 \$3651 \$3807 VPWR VGND
+ sg13cmos5l_dfrbpq_1
* cell instance sg13cmos5l_dfrbpq_1_151 r0 *1 0,0
Xsg13cmos5l_dfrbpq_1_151 \$18784 \$20220 \$20235 \$20216 VPWR VGND
+ sg13cmos5l_dfrbpq_1
* cell instance sg13cmos5l_dfrbpq_1_152 r0 *1 0,0
Xsg13cmos5l_dfrbpq_1_152 \$3813 \$3323 \$3511 \$3502 VPWR VGND
+ sg13cmos5l_dfrbpq_1
* cell instance sg13cmos5l_dfrbpq_1_153 r0 *1 0,0
Xsg13cmos5l_dfrbpq_1_153 \$322 \$203 \$213 \$206 VPWR VGND sg13cmos5l_dfrbpq_1
* cell instance sg13cmos5l_dfrbpq_1_154 r0 *1 0,0
Xsg13cmos5l_dfrbpq_1_154 \$3813 \$6024 \$5836 \$3502 VPWR VGND
+ sg13cmos5l_dfrbpq_1
* cell instance sg13cmos5l_dfrbpq_1_155 r0 *1 0,0
Xsg13cmos5l_dfrbpq_1_155 \$322 \$471 \$518 \$206 VPWR VGND sg13cmos5l_dfrbpq_1
* cell instance sg13cmos5l_dfrbpq_1_156 r0 *1 0,0
Xsg13cmos5l_dfrbpq_1_156 \$322 \$992 \$1124 \$206 VPWR VGND sg13cmos5l_dfrbpq_1
* cell instance sg13cmos5l_dfrbpq_1_157 r0 *1 0,0
Xsg13cmos5l_dfrbpq_1_157 \$322 \$216 \$483 \$206 VPWR VGND sg13cmos5l_dfrbpq_1
* cell instance sg13cmos5l_dfrbpq_1_158 r0 *1 0,0
Xsg13cmos5l_dfrbpq_1_158 \$1980 \$3326 \$3336 \$3502 VPWR VGND
+ sg13cmos5l_dfrbpq_1
* cell instance sg13cmos5l_dfrbpq_1_159 r0 *1 0,0
Xsg13cmos5l_dfrbpq_1_159 \$322 \$593 \$486 \$206 VPWR VGND sg13cmos5l_dfrbpq_1
* cell instance sg13cmos5l_dfrbpq_1_160 r0 *1 0,0
Xsg13cmos5l_dfrbpq_1_160 \$519 \$728 \$785 \$206 VPWR VGND sg13cmos5l_dfrbpq_1
* cell instance sg13cmos5l_dfrbpq_1_161 r0 *1 0,0
Xsg13cmos5l_dfrbpq_1_161 \$18784 \$17658 \$17337 \$12998 VPWR VGND
+ sg13cmos5l_dfrbpq_1
* cell instance sg13cmos5l_dfrbpq_1_162 r0 *1 0,0
Xsg13cmos5l_dfrbpq_1_162 \$3518 \$3666 \$3895 \$3502 VPWR VGND
+ sg13cmos5l_dfrbpq_1
* cell instance sg13cmos5l_dfrbpq_1_163 r0 *1 0,0
Xsg13cmos5l_dfrbpq_1_163 \$9016 \$12556 \$8224 \$12998 VPWR VGND
+ sg13cmos5l_dfrbpq_1
* cell instance sg13cmos5l_dfrbpq_1_164 r0 *1 0,0
Xsg13cmos5l_dfrbpq_1_164 \$9016 \$9010 \$8799 \$7868 VPWR VGND
+ sg13cmos5l_dfrbpq_1
* cell instance sg13cmos5l_dfrbpq_1_165 r0 *1 0,0
Xsg13cmos5l_dfrbpq_1_165 \$9016 \$11230 \$8237 \$12998 VPWR VGND
+ sg13cmos5l_dfrbpq_1
* cell instance sg13cmos5l_dfrbpq_1_166 r0 *1 0,0
Xsg13cmos5l_dfrbpq_1_166 \$18784 \$15529 \$15719 \$12998 VPWR VGND
+ sg13cmos5l_dfrbpq_1
* cell instance sg13cmos5l_dfrbpq_1_167 r0 *1 0,0
Xsg13cmos5l_dfrbpq_1_167 \$18784 \$19856 \$19561 \$20216 VPWR VGND
+ sg13cmos5l_dfrbpq_1
* cell instance sg13cmos5l_dfrbpq_1_168 r0 *1 0,0
Xsg13cmos5l_dfrbpq_1_168 \$3518 \$2921 \$2988 \$3502 VPWR VGND
+ sg13cmos5l_dfrbpq_1
* cell instance sg13cmos5l_dfrbpq_1_169 r0 *1 0,0
Xsg13cmos5l_dfrbpq_1_169 \$9016 \$9181 \$8223 \$7868 VPWR VGND
+ sg13cmos5l_dfrbpq_1
* cell instance sg13cmos5l_dfrbpq_1_170 r0 *1 0,0
Xsg13cmos5l_dfrbpq_1_170 \$519 \$359 \$399 \$206 VPWR VGND sg13cmos5l_dfrbpq_1
* cell instance sg13cmos5l_dfrbpq_1_171 r0 *1 0,0
Xsg13cmos5l_dfrbpq_1_171 \$18784 \$16663 \$17304 \$12998 VPWR VGND
+ sg13cmos5l_dfrbpq_1
* cell instance sg13cmos5l_dfrbpq_1_172 r0 *1 0,0
Xsg13cmos5l_dfrbpq_1_172 \$4783 \$7528 \$7773 \$7868 VPWR VGND
+ sg13cmos5l_dfrbpq_1
* cell instance sg13cmos5l_dfrbpq_1_173 r0 *1 0,0
Xsg13cmos5l_dfrbpq_1_173 \$9016 \$14489 \$8222 \$12998 VPWR VGND
+ sg13cmos5l_dfrbpq_1
* cell instance sg13cmos5l_dfrbpq_1_174 r0 *1 0,0
Xsg13cmos5l_dfrbpq_1_174 \$4783 \$6777 \$6508 \$7868 VPWR VGND
+ sg13cmos5l_dfrbpq_1
* cell instance sg13cmos5l_dfrbpq_1_175 r0 *1 0,0
Xsg13cmos5l_dfrbpq_1_175 \$18784 \$20109 \$20240 \$20216 VPWR VGND
+ sg13cmos5l_dfrbpq_1
* cell instance sg13cmos5l_dfrbpq_1_176 r0 *1 0,0
Xsg13cmos5l_dfrbpq_1_176 \$3813 \$5845 \$5857 \$3502 VPWR VGND
+ sg13cmos5l_dfrbpq_1
* cell instance sg13cmos5l_dfrbpq_1_177 r0 *1 0,0
Xsg13cmos5l_dfrbpq_1_177 \$9016 \$10004 \$8802 \$7868 VPWR VGND
+ sg13cmos5l_dfrbpq_1
* cell instance sg13cmos5l_dfrbpq_1_178 r0 *1 0,0
Xsg13cmos5l_dfrbpq_1_178 \$9016 \$13475 \$8800 \$12998 VPWR VGND
+ sg13cmos5l_dfrbpq_1
* cell instance sg13cmos5l_dfrbpq_1_179 r0 *1 0,0
Xsg13cmos5l_dfrbpq_1_179 \$18784 \$18480 \$17840 \$12998 VPWR VGND
+ sg13cmos5l_dfrbpq_1
* cell instance sg13cmos5l_dfrbpq_1_180 r0 *1 0,0
Xsg13cmos5l_dfrbpq_1_180 \$519 \$607 \$748 \$206 VPWR VGND sg13cmos5l_dfrbpq_1
* cell instance sg13cmos5l_dfrbpq_1_181 r0 *1 0,0
Xsg13cmos5l_dfrbpq_1_181 \$519 \$1259 \$1004 \$233 VPWR VGND sg13cmos5l_dfrbpq_1
* cell instance sg13cmos5l_dfrbpq_1_182 r0 *1 0,0
Xsg13cmos5l_dfrbpq_1_182 \$519 \$230 \$242 \$233 VPWR VGND sg13cmos5l_dfrbpq_1
* cell instance sg13cmos5l_dfrbpq_1_183 r0 *1 0,0
Xsg13cmos5l_dfrbpq_1_183 \$3518 \$3342 \$3381 \$2792 VPWR VGND
+ sg13cmos5l_dfrbpq_1
* cell instance sg13cmos5l_dfrbpq_1_184 r0 *1 0,0
Xsg13cmos5l_dfrbpq_1_184 \$1980 \$1611 \$1620 \$1744 VPWR VGND
+ sg13cmos5l_dfrbpq_1
* cell instance sg13cmos5l_dfrbpq_1_185 r0 *1 0,0
Xsg13cmos5l_dfrbpq_1_185 \$11905 \$11710 \$8487 \$12418 VPWR VGND
+ sg13cmos5l_dfrbpq_1
* cell instance sg13cmos5l_dfrbpq_1_186 r0 *1 0,0
Xsg13cmos5l_dfrbpq_1_186 \$18784 \$19404 \$17838 \$20216 VPWR VGND
+ sg13cmos5l_dfrbpq_1
* cell instance sg13cmos5l_dfrbpq_1_187 r0 *1 0,0
Xsg13cmos5l_dfrbpq_1_187 \$1980 \$2184 \$1958 \$1744 VPWR VGND
+ sg13cmos5l_dfrbpq_1
* cell instance sg13cmos5l_dfrbpq_1_188 r0 *1 0,0
Xsg13cmos5l_dfrbpq_1_188 \$9016 \$15720 \$15538 \$12418 VPWR VGND
+ sg13cmos5l_dfrbpq_1
* cell instance sg13cmos5l_dfrbpq_1_189 r0 *1 0,0
Xsg13cmos5l_dfrbpq_1_189 \$3518 \$3717 \$3683 \$2792 VPWR VGND
+ sg13cmos5l_dfrbpq_1
* cell instance sg13cmos5l_dfrbpq_1_190 r0 *1 0,0
Xsg13cmos5l_dfrbpq_1_190 \$1980 \$2454 \$2464 \$1744 VPWR VGND
+ sg13cmos5l_dfrbpq_1
* cell instance sg13cmos5l_dfrbpq_1_191 r0 *1 0,0
Xsg13cmos5l_dfrbpq_1_191 \$18784 \$16473 \$16668 \$15213 VPWR VGND
+ sg13cmos5l_dfrbpq_1
* cell instance sg13cmos5l_dfrbpq_1_192 r0 *1 0,0
Xsg13cmos5l_dfrbpq_1_192 \$9016 \$9243 \$8804 \$9244 VPWR VGND
+ sg13cmos5l_dfrbpq_1
* cell instance sg13cmos5l_dfrbpq_1_193 r0 *1 0,0
Xsg13cmos5l_dfrbpq_1_193 \$9016 \$11234 \$8805 \$9244 VPWR VGND
+ sg13cmos5l_dfrbpq_1
* cell instance sg13cmos5l_dfrbpq_1_194 r0 *1 0,0
Xsg13cmos5l_dfrbpq_1_194 \$4783 \$6427 \$4829 \$6431 VPWR VGND
+ sg13cmos5l_dfrbpq_1
* cell instance sg13cmos5l_dfrbpq_1_195 r0 *1 0,0
Xsg13cmos5l_dfrbpq_1_195 \$11905 \$13846 \$8507 \$12418 VPWR VGND
+ sg13cmos5l_dfrbpq_1
* cell instance sg13cmos5l_dfrbpq_1_196 r0 *1 0,0
Xsg13cmos5l_dfrbpq_1_196 \$1980 \$1842 \$1960 \$1744 VPWR VGND
+ sg13cmos5l_dfrbpq_1
* cell instance sg13cmos5l_dfrbpq_1_197 r0 *1 0,0
Xsg13cmos5l_dfrbpq_1_197 \$9016 \$9428 \$8803 \$9244 VPWR VGND
+ sg13cmos5l_dfrbpq_1
* cell instance sg13cmos5l_dfrbpq_1_198 r0 *1 0,0
Xsg13cmos5l_dfrbpq_1_198 \$18784 \$17843 \$18235 \$15213 VPWR VGND
+ sg13cmos5l_dfrbpq_1
* cell instance sg13cmos5l_dfrbpq_1_199 r0 *1 0,0
Xsg13cmos5l_dfrbpq_1_199 \$11905 \$12892 \$8780 \$12418 VPWR VGND
+ sg13cmos5l_dfrbpq_1
* cell instance sg13cmos5l_dfrbpq_1_200 r0 *1 0,0
Xsg13cmos5l_dfrbpq_1_200 \$7090 \$7780 \$7967 \$6431 VPWR VGND
+ sg13cmos5l_dfrbpq_1
* cell instance sg13cmos5l_dfrbpq_1_201 r0 *1 0,0
Xsg13cmos5l_dfrbpq_1_201 \$519 \$371 \$243 \$233 VPWR VGND sg13cmos5l_dfrbpq_1
* cell instance sg13cmos5l_dfrbpq_1_202 r0 *1 0,0
Xsg13cmos5l_dfrbpq_1_202 \$3813 \$5435 \$5446 \$1249 VPWR VGND
+ sg13cmos5l_dfrbpq_1
* cell instance sg13cmos5l_dfrbpq_1_203 r0 *1 0,0
Xsg13cmos5l_dfrbpq_1_203 \$519 \$613 \$625 \$233 VPWR VGND sg13cmos5l_dfrbpq_1
* cell instance sg13cmos5l_dfrbpq_1_204 r0 *1 0,0
Xsg13cmos5l_dfrbpq_1_204 \$1980 \$1626 \$1617 \$1744 VPWR VGND
+ sg13cmos5l_dfrbpq_1
* cell instance sg13cmos5l_dfrbpq_1_205 r0 *1 0,0
Xsg13cmos5l_dfrbpq_1_205 \$4783 \$6854 \$6787 \$6431 VPWR VGND
+ sg13cmos5l_dfrbpq_1
* cell instance sg13cmos5l_dfrbpq_1_206 r0 *1 0,0
Xsg13cmos5l_dfrbpq_1_206 \$18784 \$19565 \$18963 \$15213 VPWR VGND
+ sg13cmos5l_dfrbpq_1
* cell instance sg13cmos5l_dfrbpq_1_207 r0 *1 0,0
Xsg13cmos5l_dfrbpq_1_207 \$519 \$887 \$923 \$233 VPWR VGND sg13cmos5l_dfrbpq_1
* cell instance sg13cmos5l_dfrbpq_1_208 r0 *1 0,0
Xsg13cmos5l_dfrbpq_1_208 \$519 \$1384 \$1388 \$233 VPWR VGND sg13cmos5l_dfrbpq_1
* cell instance sg13cmos5l_dfrbpq_1_209 r0 *1 0,0
Xsg13cmos5l_dfrbpq_1_209 \$519 \$502 \$504 \$233 VPWR VGND sg13cmos5l_dfrbpq_1
* cell instance sg13cmos5l_dfrbpq_1_210 r0 *1 0,0
Xsg13cmos5l_dfrbpq_1_210 \$1980 \$2365 \$2326 \$1744 VPWR VGND
+ sg13cmos5l_dfrbpq_1
* cell instance sg13cmos5l_dfrbpq_1_211 r0 *1 0,0
Xsg13cmos5l_dfrbpq_1_211 \$11905 \$15353 \$15217 \$12418 VPWR VGND
+ sg13cmos5l_dfrbpq_1
* cell instance sg13cmos5l_dfrbpq_1_212 r0 *1 0,0
Xsg13cmos5l_dfrbpq_1_212 \$9016 \$9025 \$8806 \$9244 VPWR VGND
+ sg13cmos5l_dfrbpq_1
* cell instance sg13cmos5l_dfrbpq_1_213 r0 *1 0,0
Xsg13cmos5l_dfrbpq_1_213 \$9016 \$10604 \$7971 \$9244 VPWR VGND
+ sg13cmos5l_dfrbpq_1
* cell instance sg13cmos5l_dfrbpq_1_214 r0 *1 0,0
Xsg13cmos5l_dfrbpq_1_214 \$11905 \$13850 \$8783 \$12418 VPWR VGND
+ sg13cmos5l_dfrbpq_1
* cell instance sg13cmos5l_dfrbpq_1_215 r0 *1 0,0
Xsg13cmos5l_dfrbpq_1_215 \$18784 \$16090 \$16673 \$15213 VPWR VGND
+ sg13cmos5l_dfrbpq_1
* cell instance sg13cmos5l_dfrbpq_1_216 r0 *1 0,0
Xsg13cmos5l_dfrbpq_1_216 \$9016 \$9432 \$9790 \$9244 VPWR VGND
+ sg13cmos5l_dfrbpq_1
* cell instance sg13cmos5l_dfrbpq_1_217 r0 *1 0,0
Xsg13cmos5l_dfrbpq_1_217 \$11905 \$12260 \$8782 \$12418 VPWR VGND
+ sg13cmos5l_dfrbpq_1
* cell instance sg13cmos5l_dfrbpq_1_218 r0 *1 0,0
Xsg13cmos5l_dfrbpq_1_218 \$18784 \$17846 \$17849 \$15213 VPWR VGND
+ sg13cmos5l_dfrbpq_1
* cell instance sg13cmos5l_dfrbpq_1_219 r0 *1 0,0
Xsg13cmos5l_dfrbpq_1_219 \$3518 \$3173 \$3170 \$2792 VPWR VGND
+ sg13cmos5l_dfrbpq_1
* cell instance sg13cmos5l_dfrbpq_1_220 r0 *1 0,0
Xsg13cmos5l_dfrbpq_1_220 \$18784 \$18786 \$17848 \$15213 VPWR VGND
+ sg13cmos5l_dfrbpq_1
* cell instance sg13cmos5l_dfrbpq_1_221 r0 *1 0,0
Xsg13cmos5l_dfrbpq_1_221 \$519 \$628 \$626 \$632 VPWR VGND sg13cmos5l_dfrbpq_1
* cell instance sg13cmos5l_dfrbpq_1_222 r0 *1 0,0
Xsg13cmos5l_dfrbpq_1_222 \$1980 \$2368 \$2336 \$1744 VPWR VGND
+ sg13cmos5l_dfrbpq_1
* cell instance sg13cmos5l_dfrbpq_1_223 r0 *1 0,0
Xsg13cmos5l_dfrbpq_1_223 \$7090 \$9029 \$8807 \$9253 VPWR VGND
+ sg13cmos5l_dfrbpq_1
* cell instance sg13cmos5l_dfrbpq_1_224 r0 *1 0,0
Xsg13cmos5l_dfrbpq_1_224 \$7090 \$10606 \$8811 \$9244 VPWR VGND
+ sg13cmos5l_dfrbpq_1
* cell instance sg13cmos5l_dfrbpq_1_225 r0 *1 0,0
Xsg13cmos5l_dfrbpq_1_225 \$11905 \$12908 \$8808 \$13478 VPWR VGND
+ sg13cmos5l_dfrbpq_1
* cell instance sg13cmos5l_dfrbpq_1_226 r0 *1 0,0
Xsg13cmos5l_dfrbpq_1_226 \$11905 \$14617 \$8014 \$13478 VPWR VGND
+ sg13cmos5l_dfrbpq_1
* cell instance sg13cmos5l_dfrbpq_1_227 r0 *1 0,0
Xsg13cmos5l_dfrbpq_1_227 \$7090 \$9436 \$8239 \$9244 VPWR VGND
+ sg13cmos5l_dfrbpq_1
* cell instance sg13cmos5l_dfrbpq_1_228 r0 *1 0,0
Xsg13cmos5l_dfrbpq_1_228 \$1980 \$1856 \$1982 \$2202 VPWR VGND
+ sg13cmos5l_dfrbpq_1
* cell instance sg13cmos5l_dfrbpq_1_229 r0 *1 0,0
Xsg13cmos5l_dfrbpq_1_229 \$7090 \$7542 \$7789 \$6431 VPWR VGND
+ sg13cmos5l_dfrbpq_1
* cell instance sg13cmos5l_dfrbpq_1_230 r0 *1 0,0
Xsg13cmos5l_dfrbpq_1_230 \$11905 \$11717 \$8785 \$13478 VPWR VGND
+ sg13cmos5l_dfrbpq_1
* cell instance sg13cmos5l_dfrbpq_1_231 r0 *1 0,0
Xsg13cmos5l_dfrbpq_1_231 \$18784 \$17310 \$15216 \$19099 VPWR VGND
+ sg13cmos5l_dfrbpq_1
* cell instance sg13cmos5l_dfrbpq_1_232 r0 *1 0,0
Xsg13cmos5l_dfrbpq_1_232 \$7090 \$7084 \$6861 \$6431 VPWR VGND
+ sg13cmos5l_dfrbpq_1
* cell instance sg13cmos5l_dfrbpq_1_233 r0 *1 0,0
Xsg13cmos5l_dfrbpq_1_233 \$3518 \$5871 \$5228 \$3502 VPWR VGND
+ sg13cmos5l_dfrbpq_1
* cell instance sg13cmos5l_dfrbpq_1_234 r0 *1 0,0
Xsg13cmos5l_dfrbpq_1_234 \$11905 \$15056 \$15214 \$15213 VPWR VGND
+ sg13cmos5l_dfrbpq_1
* cell instance sg13cmos5l_dfrbpq_1_235 r0 *1 0,0
Xsg13cmos5l_dfrbpq_1_235 \$18784 \$17670 \$16323 \$19099 VPWR VGND
+ sg13cmos5l_dfrbpq_1
* cell instance sg13cmos5l_dfrbpq_1_236 r0 *1 0,0
Xsg13cmos5l_dfrbpq_1_236 \$1980 \$2105 \$2200 \$2202 VPWR VGND
+ sg13cmos5l_dfrbpq_1
* cell instance sg13cmos5l_dfrbpq_1_237 r0 *1 0,0
Xsg13cmos5l_dfrbpq_1_237 \$519 \$767 \$763 \$632 VPWR VGND sg13cmos5l_dfrbpq_1
* cell instance sg13cmos5l_dfrbpq_1_238 r0 *1 0,0
Xsg13cmos5l_dfrbpq_1_238 \$11905 \$16367 \$16366 \$13478 VPWR VGND
+ sg13cmos5l_dfrbpq_1
* cell instance sg13cmos5l_dfrbpq_1_239 r0 *1 0,0
Xsg13cmos5l_dfrbpq_1_239 \$3518 \$3879 \$3889 \$2792 VPWR VGND
+ sg13cmos5l_dfrbpq_1
* cell instance sg13cmos5l_dfrbpq_1_240 r0 *1 0,0
Xsg13cmos5l_dfrbpq_1_240 \$519 \$1148 \$898 \$233 VPWR VGND sg13cmos5l_dfrbpq_1
* cell instance sg13cmos5l_dfrbpq_1_241 r0 *1 0,0
Xsg13cmos5l_dfrbpq_1_241 \$7090 \$9440 \$8240 \$9253 VPWR VGND
+ sg13cmos5l_dfrbpq_1
* cell instance sg13cmos5l_dfrbpq_1_242 r0 *1 0,0
Xsg13cmos5l_dfrbpq_1_242 \$519 \$1399 \$1280 \$632 VPWR VGND sg13cmos5l_dfrbpq_1
* cell instance sg13cmos5l_dfrbpq_1_243 r0 *1 0,0
Xsg13cmos5l_dfrbpq_1_243 \$1980 \$1525 \$1282 \$632 VPWR VGND
+ sg13cmos5l_dfrbpq_1
* cell instance sg13cmos5l_dfrbpq_1_244 r0 *1 0,0
Xsg13cmos5l_dfrbpq_1_244 \$1980 \$1636 \$1279 \$2202 VPWR VGND
+ sg13cmos5l_dfrbpq_1
* cell instance sg13cmos5l_dfrbpq_1_245 r0 *1 0,0
Xsg13cmos5l_dfrbpq_1_245 \$1980 \$2339 \$2344 \$1744 VPWR VGND
+ sg13cmos5l_dfrbpq_1
* cell instance sg13cmos5l_dfrbpq_1_246 r0 *1 0,0
Xsg13cmos5l_dfrbpq_1_246 \$1980 \$1786 \$1976 \$2202 VPWR VGND
+ sg13cmos5l_dfrbpq_1
* cell instance sg13cmos5l_dfrbpq_1_247 r0 *1 0,0
Xsg13cmos5l_dfrbpq_1_247 \$519 \$1030 \$1025 \$632 VPWR VGND sg13cmos5l_dfrbpq_1
* cell instance sg13cmos5l_dfrbpq_1_248 r0 *1 0,0
Xsg13cmos5l_dfrbpq_1_248 \$1980 \$1769 \$1765 \$2202 VPWR VGND
+ sg13cmos5l_dfrbpq_1
* cell instance sg13cmos5l_dfrbpq_1_249 r0 *1 0,0
Xsg13cmos5l_dfrbpq_1_249 \$3518 \$2786 \$2782 \$2792 VPWR VGND
+ sg13cmos5l_dfrbpq_1
* cell instance sg13cmos5l_dfrbpq_1_250 r0 *1 0,0
Xsg13cmos5l_dfrbpq_1_250 \$3518 \$2992 \$2952 \$2792 VPWR VGND
+ sg13cmos5l_dfrbpq_1
* cell instance sg13cmos5l_dfrbpq_1_251 r0 *1 0,0
Xsg13cmos5l_dfrbpq_1_251 \$3518 \$3551 \$3695 \$2792 VPWR VGND
+ sg13cmos5l_dfrbpq_1
* cell instance sg13cmos5l_dfrbpq_1_252 r0 *1 0,0
Xsg13cmos5l_dfrbpq_1_252 \$3518 \$4471 \$4317 \$1249 VPWR VGND
+ sg13cmos5l_dfrbpq_1
* cell instance sg13cmos5l_dfrbpq_1_253 r0 *1 0,0
Xsg13cmos5l_dfrbpq_1_253 \$3518 \$5241 \$5253 \$2792 VPWR VGND
+ sg13cmos5l_dfrbpq_1
* cell instance sg13cmos5l_dfrbpq_1_254 r0 *1 0,0
Xsg13cmos5l_dfrbpq_1_254 \$4783 \$6072 \$6336 \$6431 VPWR VGND
+ sg13cmos5l_dfrbpq_1
* cell instance sg13cmos5l_dfrbpq_1_255 r0 *1 0,0
Xsg13cmos5l_dfrbpq_1_255 \$7090 \$6551 \$6445 \$6431 VPWR VGND
+ sg13cmos5l_dfrbpq_1
* cell instance sg13cmos5l_dfrbpq_1_256 r0 *1 0,0
Xsg13cmos5l_dfrbpq_1_256 \$7090 \$7543 \$6862 \$6431 VPWR VGND
+ sg13cmos5l_dfrbpq_1
* cell instance sg13cmos5l_dfrbpq_1_257 r0 *1 0,0
Xsg13cmos5l_dfrbpq_1_257 \$7090 \$9031 \$8812 \$9253 VPWR VGND
+ sg13cmos5l_dfrbpq_1
* cell instance sg13cmos5l_dfrbpq_1_258 r0 *1 0,0
Xsg13cmos5l_dfrbpq_1_258 \$7090 \$9382 \$8228 \$9253 VPWR VGND
+ sg13cmos5l_dfrbpq_1
* cell instance sg13cmos5l_dfrbpq_1_259 r0 *1 0,0
Xsg13cmos5l_dfrbpq_1_259 \$7090 \$10609 \$8227 \$9253 VPWR VGND
+ sg13cmos5l_dfrbpq_1
* cell instance sg13cmos5l_dfrbpq_1_260 r0 *1 0,0
Xsg13cmos5l_dfrbpq_1_260 \$11905 \$11720 \$8226 \$13478 VPWR VGND
+ sg13cmos5l_dfrbpq_1
* cell instance sg13cmos5l_dfrbpq_1_261 r0 *1 0,0
Xsg13cmos5l_dfrbpq_1_261 \$11905 \$12913 \$8787 \$13478 VPWR VGND
+ sg13cmos5l_dfrbpq_1
* cell instance sg13cmos5l_dfrbpq_1_262 r0 *1 0,0
Xsg13cmos5l_dfrbpq_1_262 \$11905 \$13398 \$8788 \$13478 VPWR VGND
+ sg13cmos5l_dfrbpq_1
* cell instance sg13cmos5l_dfrbpq_1_263 r0 *1 0,0
Xsg13cmos5l_dfrbpq_1_263 \$11905 \$14522 \$8229 \$13478 VPWR VGND
+ sg13cmos5l_dfrbpq_1
* cell instance sg13cmos5l_dlygate4sd3_1_0 r0 *1 0,0
Xsg13cmos5l_dlygate4sd3_1_0 uio_out[5] VPWR VGND \$16000
+ sg13cmos5l_dlygate4sd3_1
* cell instance sg13cmos5l_dlygate4sd3_1_1 r0 *1 0,0
Xsg13cmos5l_dlygate4sd3_1_1 \$6073 VPWR VGND \$6337 sg13cmos5l_dlygate4sd3_1
* cell instance sg13cmos5l_dlygate4sd3_1_2 r0 *1 0,0
Xsg13cmos5l_dlygate4sd3_1_2 \$8142 VPWR VGND \$7893 sg13cmos5l_dlygate4sd3_1
* cell instance sg13cmos5l_dlygate4sd3_1_3 r0 *1 0,0
Xsg13cmos5l_dlygate4sd3_1_3 \$5471 VPWR VGND \$5475 sg13cmos5l_dlygate4sd3_1
* cell instance sg13cmos5l_dlygate4sd3_1_4 r0 *1 0,0
Xsg13cmos5l_dlygate4sd3_1_4 \$6397 VPWR VGND \$10587 sg13cmos5l_dlygate4sd3_1
* cell instance sg13cmos5l_dlygate4sd3_1_5 r0 *1 0,0
Xsg13cmos5l_dlygate4sd3_1_5 \$3740 VPWR VGND \$3726 sg13cmos5l_dlygate4sd3_1
* cell instance sg13cmos5l_dlygate4sd3_1_6 r0 *1 0,0
Xsg13cmos5l_dlygate4sd3_1_6 \$4192 VPWR VGND \$4190 sg13cmos5l_dlygate4sd3_1
* cell instance sg13cmos5l_dlygate4sd3_1_7 r0 *1 0,0
Xsg13cmos5l_dlygate4sd3_1_7 \$7705 VPWR VGND \$7208 sg13cmos5l_dlygate4sd3_1
* cell instance sg13cmos5l_dlygate4sd3_1_8 r0 *1 0,0
Xsg13cmos5l_dlygate4sd3_1_8 \$13864 VPWR VGND \$14531 sg13cmos5l_dlygate4sd3_1
* cell instance sg13cmos5l_dlygate4sd3_1_9 r0 *1 0,0
Xsg13cmos5l_dlygate4sd3_1_9 \$5283 VPWR VGND \$5479 sg13cmos5l_dlygate4sd3_1
* cell instance sg13cmos5l_dlygate4sd3_1_10 r0 *1 0,0
Xsg13cmos5l_dlygate4sd3_1_10 \$6368 VPWR VGND \$5892 sg13cmos5l_dlygate4sd3_1
* cell instance sg13cmos5l_dlygate4sd3_1_11 r0 *1 0,0
Xsg13cmos5l_dlygate4sd3_1_11 \$11896 VPWR VGND \$11897 sg13cmos5l_dlygate4sd3_1
* cell instance sg13cmos5l_dlygate4sd3_1_12 r0 *1 0,0
Xsg13cmos5l_dlygate4sd3_1_12 \$12704 VPWR VGND \$12925 sg13cmos5l_dlygate4sd3_1
* cell instance sg13cmos5l_dlygate4sd3_1_13 r0 *1 0,0
Xsg13cmos5l_dlygate4sd3_1_13 \$3902 VPWR VGND \$4044 sg13cmos5l_dlygate4sd3_1
* cell instance sg13cmos5l_dlygate4sd3_1_14 r0 *1 0,0
Xsg13cmos5l_dlygate4sd3_1_14 \$4360 VPWR VGND \$4199 sg13cmos5l_dlygate4sd3_1
* cell instance sg13cmos5l_dlygate4sd3_1_15 r0 *1 0,0
Xsg13cmos5l_dlygate4sd3_1_15 \$6920 VPWR VGND \$6918 sg13cmos5l_dlygate4sd3_1
* cell instance sg13cmos5l_dlygate4sd3_1_16 r0 *1 0,0
Xsg13cmos5l_dlygate4sd3_1_16 \$7491 VPWR VGND \$7709 sg13cmos5l_dlygate4sd3_1
* cell instance sg13cmos5l_dlygate4sd3_1_17 r0 *1 0,0
Xsg13cmos5l_dlygate4sd3_1_17 \$4077 VPWR VGND \$4320 sg13cmos5l_dlygate4sd3_1
* cell instance sg13cmos5l_dlygate4sd3_1_18 r0 *1 0,0
Xsg13cmos5l_dlygate4sd3_1_18 \$5715 VPWR VGND \$5896 sg13cmos5l_dlygate4sd3_1
* cell instance sg13cmos5l_dlygate4sd3_1_19 r0 *1 0,0
Xsg13cmos5l_dlygate4sd3_1_19 \$8411 VPWR VGND \$8416 sg13cmos5l_dlygate4sd3_1
* cell instance sg13cmos5l_dlygate4sd3_1_20 r0 *1 0,0
Xsg13cmos5l_dlygate4sd3_1_20 \$9283 VPWR VGND \$9629 sg13cmos5l_dlygate4sd3_1
* cell instance sg13cmos5l_dlygate4sd3_1_21 r0 *1 0,0
Xsg13cmos5l_dlygate4sd3_1_21 \$3917 VPWR VGND \$3741 sg13cmos5l_dlygate4sd3_1
* cell instance sg13cmos5l_dlygate4sd3_1_22 r0 *1 0,0
Xsg13cmos5l_dlygate4sd3_1_22 \$9928 VPWR VGND \$9933 sg13cmos5l_dlygate4sd3_1
* cell instance sg13cmos5l_dlygate4sd3_1_23 r0 *1 0,0
Xsg13cmos5l_dlygate4sd3_1_23 \$4872 VPWR VGND \$5051 sg13cmos5l_dlygate4sd3_1
* cell instance sg13cmos5l_dlygate4sd3_1_24 r0 *1 0,0
Xsg13cmos5l_dlygate4sd3_1_24 \$6482 VPWR VGND \$9145 sg13cmos5l_dlygate4sd3_1
* cell instance sg13cmos5l_dlygate4sd3_1_25 r0 *1 0,0
Xsg13cmos5l_dlygate4sd3_1_25 uio_out[7] VPWR VGND \$16678
+ sg13cmos5l_dlygate4sd3_1
* cell instance sg13cmos5l_dlygate4sd3_1_26 r0 *1 0,0
Xsg13cmos5l_dlygate4sd3_1_26 \$3736 VPWR VGND \$3909 sg13cmos5l_dlygate4sd3_1
* cell instance sg13cmos5l_dlygate4sd3_1_27 r0 *1 0,0
Xsg13cmos5l_dlygate4sd3_1_27 \$5903 VPWR VGND \$6466 sg13cmos5l_dlygate4sd3_1
* cell instance sg13cmos5l_dlygate4sd3_1_28 r0 *1 0,0
Xsg13cmos5l_dlygate4sd3_1_28 \$4509 VPWR VGND \$4654 sg13cmos5l_dlygate4sd3_1
* cell instance sg13cmos5l_dlygate4sd3_1_29 r0 *1 0,0
Xsg13cmos5l_dlygate4sd3_1_29 \$4076 VPWR VGND \$4084 sg13cmos5l_dlygate4sd3_1
* cell instance sg13cmos5l_dlygate4sd3_1_30 r0 *1 0,0
Xsg13cmos5l_dlygate4sd3_1_30 uio_out[4] VPWR VGND \$15682
+ sg13cmos5l_dlygate4sd3_1
* cell instance sg13cmos5l_dlygate4sd3_1_31 r0 *1 0,0
Xsg13cmos5l_dlygate4sd3_1_31 \$4879 VPWR VGND \$5021 sg13cmos5l_dlygate4sd3_1
* cell instance sg13cmos5l_dlygate4sd3_1_32 r0 *1 0,0
Xsg13cmos5l_dlygate4sd3_1_32 \$8531 VPWR VGND \$8493 sg13cmos5l_dlygate4sd3_1
* cell instance sg13cmos5l_dlygate4sd3_1_33 r0 *1 0,0
Xsg13cmos5l_dlygate4sd3_1_33 \$14535 VPWR VGND \$14533 sg13cmos5l_dlygate4sd3_1
* cell instance sg13cmos5l_dlygate4sd3_1_34 r0 *1 0,0
Xsg13cmos5l_dlygate4sd3_1_34 \$8018 VPWR VGND \$8216 sg13cmos5l_dlygate4sd3_1
* cell instance sg13cmos5l_dlygate4sd3_1_35 r0 *1 0,0
Xsg13cmos5l_dlygate4sd3_1_35 \$12424 VPWR VGND \$12926 sg13cmos5l_dlygate4sd3_1
* cell instance sg13cmos5l_dlygate4sd3_1_36 r0 *1 0,0
Xsg13cmos5l_dlygate4sd3_1_36 \$4506 VPWR VGND \$4705 sg13cmos5l_dlygate4sd3_1
* cell instance sg13cmos5l_dlygate4sd3_1_37 r0 *1 0,0
Xsg13cmos5l_dlygate4sd3_1_37 \$13405 VPWR VGND \$13404 sg13cmos5l_dlygate4sd3_1
* cell instance sg13cmos5l_dlygate4sd3_1_38 r0 *1 0,0
Xsg13cmos5l_dlygate4sd3_1_38 \$5926 VPWR VGND \$6562 sg13cmos5l_dlygate4sd3_1
* cell instance sg13cmos5l_dlygate4sd3_1_39 r0 *1 0,0
Xsg13cmos5l_dlygate4sd3_1_39 uio_out[2] VPWR VGND \$18443
+ sg13cmos5l_dlygate4sd3_1
* cell instance sg13cmos5l_dlygate4sd3_1_40 r0 *1 0,0
Xsg13cmos5l_dlygate4sd3_1_40 \$8219 VPWR VGND \$19420 sg13cmos5l_dlygate4sd3_1
* cell instance sg13cmos5l_dlygate4sd3_1_41 r0 *1 0,0
Xsg13cmos5l_dlygate4sd3_1_41 \$6081 VPWR VGND \$6377 sg13cmos5l_dlygate4sd3_1
* cell instance sg13cmos5l_dlygate4sd3_1_42 r0 *1 0,0
Xsg13cmos5l_dlygate4sd3_1_42 \$6094 VPWR VGND \$7211 sg13cmos5l_dlygate4sd3_1
* cell instance sg13cmos5l_dlygate4sd3_1_43 r0 *1 0,0
Xsg13cmos5l_dlygate4sd3_1_43 uio_out[6] VPWR VGND \$19878
+ sg13cmos5l_dlygate4sd3_1
* cell instance sg13cmos5l_dlygate4sd3_1_44 r0 *1 0,0
Xsg13cmos5l_dlygate4sd3_1_44 \$4370 VPWR VGND \$4516 sg13cmos5l_dlygate4sd3_1
* cell instance sg13cmos5l_dlygate4sd3_1_45 r0 *1 0,0
Xsg13cmos5l_dlygate4sd3_1_45 \$11700 VPWR VGND \$10770 sg13cmos5l_dlygate4sd3_1
* cell instance sg13cmos5l_dlygate4sd3_1_46 r0 *1 0,0
Xsg13cmos5l_dlygate4sd3_1_46 \$8494 VPWR VGND \$16329 sg13cmos5l_dlygate4sd3_1
* cell instance sg13cmos5l_dlygate4sd3_1_47 r0 *1 0,0
Xsg13cmos5l_dlygate4sd3_1_47 \$4890 VPWR VGND \$4701 sg13cmos5l_dlygate4sd3_1
* cell instance sg13cmos5l_dlygate4sd3_1_48 r0 *1 0,0
Xsg13cmos5l_dlygate4sd3_1_48 \$9042 VPWR VGND \$9262 sg13cmos5l_dlygate4sd3_1
* cell instance sg13cmos5l_dlygate4sd3_1_49 r0 *1 0,0
Xsg13cmos5l_dlygate4sd3_1_49 \$8431 VPWR VGND \$8790 sg13cmos5l_dlygate4sd3_1
* cell instance sg13cmos5l_dlygate4sd3_1_50 r0 *1 0,0
Xsg13cmos5l_dlygate4sd3_1_50 \$5906 VPWR VGND \$6087 sg13cmos5l_dlygate4sd3_1
* cell instance sg13cmos5l_dlygate4sd3_1_51 r0 *1 0,0
Xsg13cmos5l_dlygate4sd3_1_51 \$6569 VPWR VGND \$6568 sg13cmos5l_dlygate4sd3_1
* cell instance sg13cmos5l_dlygate4sd3_1_52 r0 *1 0,0
Xsg13cmos5l_dlygate4sd3_1_52 \$20032 VPWR VGND \$20036 sg13cmos5l_dlygate4sd3_1
* cell instance sg13cmos5l_dlygate4sd3_1_53 r0 *1 0,0
Xsg13cmos5l_dlygate4sd3_1_53 \$4517 VPWR VGND \$4511 sg13cmos5l_dlygate4sd3_1
* cell instance sg13cmos5l_dlygate4sd3_1_54 r0 *1 0,0
Xsg13cmos5l_dlygate4sd3_1_54 \$14867 VPWR VGND \$14537 sg13cmos5l_dlygate4sd3_1
* cell instance sg13cmos5l_dlygate4sd3_1_55 r0 *1 0,0
Xsg13cmos5l_dlygate4sd3_1_55 \$20079 VPWR VGND \$20078 sg13cmos5l_dlygate4sd3_1
* cell instance sg13cmos5l_dlygate4sd3_1_56 r0 *1 0,0
Xsg13cmos5l_dlygate4sd3_1_56 \$7812 VPWR VGND \$7811 sg13cmos5l_dlygate4sd3_1
* cell instance sg13cmos5l_dlygate4sd3_1_57 r0 *1 0,0
Xsg13cmos5l_dlygate4sd3_1_57 \$8008 VPWR VGND \$18444 sg13cmos5l_dlygate4sd3_1
* cell instance sg13cmos5l_dlygate4sd3_1_58 r0 *1 0,0
Xsg13cmos5l_dlygate4sd3_1_58 \$5300 VPWR VGND \$5485 sg13cmos5l_dlygate4sd3_1
* cell instance sg13cmos5l_dlygate4sd3_1_59 r0 *1 0,0
Xsg13cmos5l_dlygate4sd3_1_59 \$12719 VPWR VGND \$12929 sg13cmos5l_dlygate4sd3_1
* cell instance sg13cmos5l_dlygate4sd3_1_60 r0 *1 0,0
Xsg13cmos5l_dlygate4sd3_1_60 \$16689 VPWR VGND \$15364 sg13cmos5l_dlygate4sd3_1
* cell instance sg13cmos5l_dlygate4sd3_1_61 r0 *1 0,0
Xsg13cmos5l_dlygate4sd3_1_61 \$5297 VPWR VGND \$5295 sg13cmos5l_dlygate4sd3_1
* cell instance sg13cmos5l_dlygate4sd3_1_62 r0 *1 0,0
Xsg13cmos5l_dlygate4sd3_1_62 \$4896 VPWR VGND \$4894 sg13cmos5l_dlygate4sd3_1
* cell instance sg13cmos5l_dlygate4sd3_1_63 r0 *1 0,0
Xsg13cmos5l_dlygate4sd3_1_63 \$20080 VPWR VGND \$20066 sg13cmos5l_dlygate4sd3_1
* cell instance sg13cmos5l_dlygate4sd3_1_64 r0 *1 0,0
Xsg13cmos5l_dlygate4sd3_1_64 \$4719 VPWR VGND \$6926 sg13cmos5l_dlygate4sd3_1
* cell instance sg13cmos5l_dlygate4sd3_1_65 r0 *1 0,0
Xsg13cmos5l_dlygate4sd3_1_65 \$6396 VPWR VGND \$8775 sg13cmos5l_dlygate4sd3_1
* cell instance sg13cmos5l_dlygate4sd3_1_66 r0 *1 0,0
Xsg13cmos5l_dlygate4sd3_1_66 \$8007 VPWR VGND \$10775 sg13cmos5l_dlygate4sd3_1
* cell instance sg13cmos5l_dlygate4sd3_1_67 r0 *1 0,0
Xsg13cmos5l_dlygate4sd3_1_67 \$6930 VPWR VGND \$18484 sg13cmos5l_dlygate4sd3_1
* cell instance sg13cmos5l_dlygate4sd3_1_68 r0 *1 0,0
Xsg13cmos5l_dlygate4sd3_1_68 \$14343 VPWR VGND \$14541 sg13cmos5l_dlygate4sd3_1
* cell instance sg13cmos5l_dlygate4sd3_1_69 r0 *1 0,0
Xsg13cmos5l_dlygate4sd3_1_69 \$20087 VPWR VGND \$20126 sg13cmos5l_dlygate4sd3_1
* cell instance sg13cmos5l_dlygate4sd3_1_70 r0 *1 0,0
Xsg13cmos5l_dlygate4sd3_1_70 \$9637 VPWR VGND \$7217 sg13cmos5l_dlygate4sd3_1
* cell instance sg13cmos5l_dlygate4sd3_1_71 r0 *1 0,0
Xsg13cmos5l_dlygate4sd3_1_71 \$4524 VPWR VGND \$4658 sg13cmos5l_dlygate4sd3_1
* cell instance sg13cmos5l_dlygate4sd3_1_72 r0 *1 0,0
Xsg13cmos5l_dlygate4sd3_1_72 \$16011 VPWR VGND \$15077 sg13cmos5l_dlygate4sd3_1
* cell instance sg13cmos5l_dlygate4sd3_1_73 r0 *1 0,0
Xsg13cmos5l_dlygate4sd3_1_73 \$13482 VPWR VGND \$14872 sg13cmos5l_dlygate4sd3_1
* cell instance sg13cmos5l_dlygate4sd3_1_74 r0 *1 0,0
Xsg13cmos5l_dlygate4sd3_1_74 uio_out[3] VPWR VGND \$19424
+ sg13cmos5l_dlygate4sd3_1
* cell instance sg13cmos5l_dlygate4sd3_1_75 r0 *1 0,0
Xsg13cmos5l_dlygate4sd3_1_75 \$15078 VPWR VGND \$14879 sg13cmos5l_dlygate4sd3_1
* cell instance sg13cmos5l_dlygate4sd3_1_76 r0 *1 0,0
Xsg13cmos5l_dlygate4sd3_1_76 \$17153 VPWR VGND \$16218 sg13cmos5l_dlygate4sd3_1
* cell instance sg13cmos5l_dlygate4sd3_1_77 r0 *1 0,0
Xsg13cmos5l_dlygate4sd3_1_77 \$19995 VPWR VGND \$20042 sg13cmos5l_dlygate4sd3_1
* cell instance sg13cmos5l_dlygate4sd3_1_78 r0 *1 0,0
Xsg13cmos5l_dlygate4sd3_1_78 \$14621 VPWR VGND \$14042 sg13cmos5l_dlygate4sd3_1
* cell instance sg13cmos5l_dlygate4sd3_1_79 r0 *1 0,0
Xsg13cmos5l_dlygate4sd3_1_79 \$5076 VPWR VGND \$5080 sg13cmos5l_dlygate4sd3_1
* cell instance sg13cmos5l_dlygate4sd3_1_80 r0 *1 0,0
Xsg13cmos5l_dlygate4sd3_1_80 \$20088 VPWR VGND \$20084 sg13cmos5l_dlygate4sd3_1
* cell instance sg13cmos5l_dlygate4sd3_1_81 r0 *1 0,0
Xsg13cmos5l_dlygate4sd3_1_81 \$8218 VPWR VGND \$8792 sg13cmos5l_dlygate4sd3_1
* cell instance sg13cmos5l_dlygate4sd3_1_82 r0 *1 0,0
Xsg13cmos5l_dlygate4sd3_1_82 \$9638 VPWR VGND \$7220 sg13cmos5l_dlygate4sd3_1
* cell instance sg13cmos5l_dlygate4sd3_1_83 r0 *1 0,0
Xsg13cmos5l_dlygate4sd3_1_83 \$5687 VPWR VGND \$5728 sg13cmos5l_dlygate4sd3_1
* cell instance sg13cmos5l_dlygate4sd3_1_84 r0 *1 0,0
Xsg13cmos5l_dlygate4sd3_1_84 \$5513 VPWR VGND \$17690 sg13cmos5l_dlygate4sd3_1
* cell instance sg13cmos5l_dlygate4sd3_1_85 r0 *1 0,0
Xsg13cmos5l_dlygate4sd3_1_85 \$4521 VPWR VGND \$4210 sg13cmos5l_dlygate4sd3_1
* cell instance sg13cmos5l_dlygate4sd3_1_86 r0 *1 0,0
Xsg13cmos5l_dlygate4sd3_1_86 \$5307 VPWR VGND \$19425 sg13cmos5l_dlygate4sd3_1
* cell instance sg13cmos5l_dlygate4sd3_1_87 r0 *1 0,0
Xsg13cmos5l_dlygate4sd3_1_87 \$10050 VPWR VGND \$7562 sg13cmos5l_dlygate4sd3_1
* cell instance sg13cmos5l_dlygate4sd3_1_88 r0 *1 0,0
Xsg13cmos5l_dlygate4sd3_1_88 \$13840 VPWR VGND \$13406 sg13cmos5l_dlygate4sd3_1
* cell instance sg13cmos5l_dlygate4sd3_1_89 r0 *1 0,0
Xsg13cmos5l_dlygate4sd3_1_89 \$5734 VPWR VGND \$5737 sg13cmos5l_dlygate4sd3_1
* cell instance sg13cmos5l_dlygate4sd3_1_90 r0 *1 0,0
Xsg13cmos5l_dlygate4sd3_1_90 \$7816 VPWR VGND \$7814 sg13cmos5l_dlygate4sd3_1
* cell instance sg13cmos5l_dlygate4sd3_1_91 r0 *1 0,0
Xsg13cmos5l_dlygate4sd3_1_91 \$11273 VPWR VGND \$11902 sg13cmos5l_dlygate4sd3_1
* cell instance sg13cmos5l_dlygate4sd3_1_92 r0 *1 0,0
Xsg13cmos5l_dlygate4sd3_1_92 \$14043 VPWR VGND \$13407 sg13cmos5l_dlygate4sd3_1
* cell instance sg13cmos5l_dlygate4sd3_1_93 r0 *1 0,0
Xsg13cmos5l_dlygate4sd3_1_93 uio_out[1] VPWR VGND \$18929
+ sg13cmos5l_dlygate4sd3_1
* cell instance sg13cmos5l_dlygate4sd3_1_94 r0 *1 0,0
Xsg13cmos5l_dlygate4sd3_1_94 \$14356 VPWR VGND \$15079 sg13cmos5l_dlygate4sd3_1
* cell instance sg13cmos5l_dlygate4sd3_1_95 r0 *1 0,0
Xsg13cmos5l_dlygate4sd3_1_95 \$9331 VPWR VGND \$11274 sg13cmos5l_dlygate4sd3_1
* cell instance sg13cmos5l_dlygate4sd3_1_96 r0 *1 0,0
Xsg13cmos5l_dlygate4sd3_1_96 \$6496 VPWR VGND \$6406 sg13cmos5l_dlygate4sd3_1
* cell instance sg13cmos5l_dlygate4sd3_1_97 r0 *1 0,0
Xsg13cmos5l_dlygate4sd3_1_97 \$16014 VPWR VGND \$16219 sg13cmos5l_dlygate4sd3_1
* cell instance sg13cmos5l_dlygate4sd3_1_98 r0 *1 0,0
Xsg13cmos5l_dlygate4sd3_1_98 \$16658 VPWR VGND \$16691 sg13cmos5l_dlygate4sd3_1
* cell instance sg13cmos5l_dlygate4sd3_1_99 r0 *1 0,0
Xsg13cmos5l_dlygate4sd3_1_99 \$5738 VPWR VGND \$8794 sg13cmos5l_dlygate4sd3_1
* cell instance sg13cmos5l_dlygate4sd3_1_100 r0 *1 0,0
Xsg13cmos5l_dlygate4sd3_1_100 \$9046 VPWR VGND \$9221 sg13cmos5l_dlygate4sd3_1
* cell instance sg13cmos5l_dlygate4sd3_1_101 r0 *1 0,0
Xsg13cmos5l_dlygate4sd3_1_101 \$15834 VPWR VGND \$15080 sg13cmos5l_dlygate4sd3_1
* cell instance sg13cmos5l_dlygate4sd3_1_102 r0 *1 0,0
Xsg13cmos5l_dlygate4sd3_1_102 \$20002 VPWR VGND \$20019 sg13cmos5l_dlygate4sd3_1
* cell instance sg13cmos5l_dlygate4sd3_1_103 r0 *1 0,0
Xsg13cmos5l_dlygate4sd3_1_103 uio_out[0] VPWR VGND \$19889
+ sg13cmos5l_dlygate4sd3_1
* cell instance sg13cmos5l_dlygate4sd3_1_104 r0 *1 0,0
Xsg13cmos5l_dlygate4sd3_1_104 \$4485 VPWR VGND \$4385 sg13cmos5l_dlygate4sd3_1
* cell instance sg13cmos5l_dlygate4sd3_1_105 r0 *1 0,0
Xsg13cmos5l_dlygate4sd3_1_105 \$5091 VPWR VGND \$5079 sg13cmos5l_dlygate4sd3_1
* cell instance sg13cmos5l_dlygate4sd3_1_106 r0 *1 0,0
Xsg13cmos5l_dlygate4sd3_1_106 \$5310 VPWR VGND \$5102 sg13cmos5l_dlygate4sd3_1
* cell instance sg13cmos5l_dlygate4sd3_1_107 r0 *1 0,0
Xsg13cmos5l_dlygate4sd3_1_107 \$5757 VPWR VGND \$5525 sg13cmos5l_dlygate4sd3_1
* cell instance sg13cmos5l_dlygate4sd3_1_108 r0 *1 0,0
Xsg13cmos5l_dlygate4sd3_1_108 \$5544 VPWR VGND \$5531 sg13cmos5l_dlygate4sd3_1
* cell instance sg13cmos5l_dlygate4sd3_1_109 r0 *1 0,0
Xsg13cmos5l_dlygate4sd3_1_109 \$4919 VPWR VGND \$5024 sg13cmos5l_dlygate4sd3_1
* cell instance sg13cmos5l_dlygate4sd3_1_110 r0 *1 0,0
Xsg13cmos5l_dlygate4sd3_1_110 \$3062 VPWR VGND \$5528 sg13cmos5l_dlygate4sd3_1
* cell instance sg13cmos5l_dlygate4sd3_1_111 r0 *1 0,0
Xsg13cmos5l_dlygate4sd3_1_111 \$4935 VPWR VGND \$4934 sg13cmos5l_dlygate4sd3_1
* cell instance sg13cmos5l_dlygate4sd3_1_112 r0 *1 0,0
Xsg13cmos5l_dlygate4sd3_1_112 \$3256 VPWR VGND \$3053 sg13cmos5l_dlygate4sd3_1
* cell instance sg13cmos5l_dlygate4sd3_1_113 r0 *1 0,0
Xsg13cmos5l_dlygate4sd3_1_113 \$4734 VPWR VGND \$5335 sg13cmos5l_dlygate4sd3_1
* cell instance sg13cmos5l_dlygate4sd3_1_114 r0 *1 0,0
Xsg13cmos5l_dlygate4sd3_1_114 \$4940 VPWR VGND \$4942 sg13cmos5l_dlygate4sd3_1
* cell instance sg13cmos5l_dlygate4sd3_1_115 r0 *1 0,0
Xsg13cmos5l_dlygate4sd3_1_115 \$3065 VPWR VGND \$3260 sg13cmos5l_dlygate4sd3_1
* cell instance sg13cmos5l_dlygate4sd3_1_116 r0 *1 0,0
Xsg13cmos5l_dlygate4sd3_1_116 \$3068 VPWR VGND \$3070 sg13cmos5l_dlygate4sd3_1
* cell instance sg13cmos5l_dlygate4sd3_1_117 r0 *1 0,0
Xsg13cmos5l_dlygate4sd3_1_117 \$4558 VPWR VGND \$4561 sg13cmos5l_dlygate4sd3_1
* cell instance sg13cmos5l_dlygate4sd3_1_118 r0 *1 0,0
Xsg13cmos5l_dlygate4sd3_1_118 \$5575 VPWR VGND \$5345 sg13cmos5l_dlygate4sd3_1
* cell instance sg13cmos5l_dlygate4sd3_1_119 r0 *1 0,0
Xsg13cmos5l_dlygate4sd3_1_119 \$3270 VPWR VGND \$3264 sg13cmos5l_dlygate4sd3_1
* cell instance sg13cmos5l_dlygate4sd3_1_120 r0 *1 0,0
Xsg13cmos5l_dlygate4sd3_1_120 \$4914 VPWR VGND \$5027 sg13cmos5l_dlygate4sd3_1
* cell instance sg13cmos5l_dlygate4sd3_1_121 r0 *1 0,0
Xsg13cmos5l_dlygate4sd3_1_121 \$5347 VPWR VGND \$5579 sg13cmos5l_dlygate4sd3_1
* cell instance sg13cmos5l_dlygate4sd3_1_122 r0 *1 0,0
Xsg13cmos5l_dlygate4sd3_1_122 \$4575 VPWR VGND \$4670 sg13cmos5l_dlygate4sd3_1
* cell instance sg13cmos5l_dlygate4sd3_1_123 r0 *1 0,0
Xsg13cmos5l_dlygate4sd3_1_123 \$2886 VPWR VGND \$2885 sg13cmos5l_dlygate4sd3_1
* cell instance sg13cmos5l_dlygate4sd3_1_124 r0 *1 0,0
Xsg13cmos5l_dlygate4sd3_1_124 \$4586 VPWR VGND \$4574 sg13cmos5l_dlygate4sd3_1
* cell instance sg13cmos5l_dlygate4sd3_1_125 r0 *1 0,0
Xsg13cmos5l_dlygate4sd3_1_125 \$3955 VPWR VGND \$4243 sg13cmos5l_dlygate4sd3_1
* cell instance sg13cmos5l_dlygate4sd3_1_126 r0 *1 0,0
Xsg13cmos5l_dlygate4sd3_1_126 \$3446 VPWR VGND \$3449 sg13cmos5l_dlygate4sd3_1
* cell instance sg13cmos5l_dlygate4sd3_1_127 r0 *1 0,0
Xsg13cmos5l_dlygate4sd3_1_127 \$3284 VPWR VGND \$3288 sg13cmos5l_dlygate4sd3_1
* cell instance sg13cmos5l_dlygate4sd3_1_128 r0 *1 0,0
Xsg13cmos5l_dlygate4sd3_1_128 \$5353 VPWR VGND \$5962 sg13cmos5l_dlygate4sd3_1
* cell instance sg13cmos5l_dlygate4sd3_1_129 r0 *1 0,0
Xsg13cmos5l_dlygate4sd3_1_129 \$5957 VPWR VGND \$5789 sg13cmos5l_dlygate4sd3_1
* cell instance sg13cmos5l_dlygate4sd3_1_130 r0 *1 0,0
Xsg13cmos5l_dlygate4sd3_1_130 \$3289 VPWR VGND \$3283 sg13cmos5l_dlygate4sd3_1
* cell instance sg13cmos5l_dlygate4sd3_1_131 r0 *1 0,0
Xsg13cmos5l_dlygate4sd3_1_131 \$5158 VPWR VGND \$4953 sg13cmos5l_dlygate4sd3_1
* cell instance sg13cmos5l_dlygate4sd3_1_132 r0 *1 0,0
Xsg13cmos5l_dlygate4sd3_1_132 \$5788 VPWR VGND \$5959 sg13cmos5l_dlygate4sd3_1
* cell instance sg13cmos5l_dlygate4sd3_1_133 r0 *1 0,0
Xsg13cmos5l_dlygate4sd3_1_133 \$4960 VPWR VGND \$5591 sg13cmos5l_dlygate4sd3_1
* cell instance sg13cmos5l_dlygate4sd3_1_134 r0 *1 0,0
Xsg13cmos5l_dlygate4sd3_1_134 \$5357 VPWR VGND \$5355 sg13cmos5l_dlygate4sd3_1
* cell instance sg13cmos5l_dlygate4sd3_1_135 r0 *1 0,0
Xsg13cmos5l_dlygate4sd3_1_135 \$5162 VPWR VGND \$5971 sg13cmos5l_dlygate4sd3_1
* cell instance sg13cmos5l_dlygate4sd3_1_136 r0 *1 0,0
Xsg13cmos5l_dlygate4sd3_1_136 \$3631 VPWR VGND \$3460 sg13cmos5l_dlygate4sd3_1
* cell instance sg13cmos5l_dlygate4sd3_1_137 r0 *1 0,0
Xsg13cmos5l_dlygate4sd3_1_137 \$4116 VPWR VGND \$4590 sg13cmos5l_dlygate4sd3_1
* cell instance sg13cmos5l_dlygate4sd3_1_138 r0 *1 0,0
Xsg13cmos5l_dlygate4sd3_1_138 \$2892 VPWR VGND \$2975 sg13cmos5l_dlygate4sd3_1
* cell instance sg13cmos5l_dlygate4sd3_1_139 r0 *1 0,0
Xsg13cmos5l_dlygate4sd3_1_139 \$3788 VPWR VGND \$3632 sg13cmos5l_dlygate4sd3_1
* cell instance sg13cmos5l_dlygate4sd3_1_140 r0 *1 0,0
Xsg13cmos5l_dlygate4sd3_1_140 \$5361 VPWR VGND \$5803 sg13cmos5l_dlygate4sd3_1
* cell instance sg13cmos5l_dlygate4sd3_1_141 r0 *1 0,0
Xsg13cmos5l_dlygate4sd3_1_141 \$4964 VPWR VGND \$5164 sg13cmos5l_dlygate4sd3_1
* cell instance sg13cmos5l_dlygate4sd3_1_142 r0 *1 0,0
Xsg13cmos5l_dlygate4sd3_1_142 \$3471 VPWR VGND \$3789 sg13cmos5l_dlygate4sd3_1
* cell instance sg13cmos5l_dlygate4sd3_1_143 r0 *1 0,0
Xsg13cmos5l_dlygate4sd3_1_143 \$4966 VPWR VGND \$4965 sg13cmos5l_dlygate4sd3_1
* cell instance sg13cmos5l_dlygate4sd3_1_144 r0 *1 0,0
Xsg13cmos5l_dlygate4sd3_1_144 \$4247 VPWR VGND \$3961 sg13cmos5l_dlygate4sd3_1
* cell instance sg13cmos5l_dlygate4sd3_1_145 r0 *1 0,0
Xsg13cmos5l_dlygate4sd3_1_145 \$5364 VPWR VGND \$5363 sg13cmos5l_dlygate4sd3_1
* cell instance sg13cmos5l_dlygate4sd3_1_146 r0 *1 0,0
Xsg13cmos5l_dlygate4sd3_1_146 \$5171 VPWR VGND \$6197 sg13cmos5l_dlygate4sd3_1
* cell instance sg13cmos5l_dlygate4sd3_1_147 r0 *1 0,0
Xsg13cmos5l_dlygate4sd3_1_147 \$5808 VPWR VGND \$5989 sg13cmos5l_dlygate4sd3_1
* cell instance sg13cmos5l_dlygate4sd3_1_148 r0 *1 0,0
Xsg13cmos5l_dlygate4sd3_1_148 \$3126 VPWR VGND \$3113 sg13cmos5l_dlygate4sd3_1
* cell instance sg13cmos5l_dlygate4sd3_1_149 r0 *1 0,0
Xsg13cmos5l_dlygate4sd3_1_149 \$4969 VPWR VGND \$5597 sg13cmos5l_dlygate4sd3_1
* cell instance sg13cmos5l_dlygate4sd3_1_150 r0 *1 0,0
Xsg13cmos5l_dlygate4sd3_1_150 \$5595 VPWR VGND \$6201 sg13cmos5l_dlygate4sd3_1
* cell instance sg13cmos5l_dlygate4sd3_1_151 r0 *1 0,0
Xsg13cmos5l_dlygate4sd3_1_151 \$4971 VPWR VGND \$4970 sg13cmos5l_dlygate4sd3_1
* cell instance sg13cmos5l_dlygate4sd3_1_152 r0 *1 0,0
Xsg13cmos5l_dlygate4sd3_1_152 \$5599 VPWR VGND \$5810 sg13cmos5l_dlygate4sd3_1
* cell instance sg13cmos5l_dlygate4sd3_1_153 r0 *1 0,0
Xsg13cmos5l_dlygate4sd3_1_153 \$4973 VPWR VGND \$4977 sg13cmos5l_dlygate4sd3_1
* cell instance sg13cmos5l_dlygate4sd3_1_154 r0 *1 0,0
Xsg13cmos5l_dlygate4sd3_1_154 \$5601 VPWR VGND \$5600 sg13cmos5l_dlygate4sd3_1
* cell instance sg13cmos5l_dlygate4sd3_1_155 r0 *1 0,0
Xsg13cmos5l_dlygate4sd3_1_155 \$5998 VPWR VGND \$6205 sg13cmos5l_dlygate4sd3_1
* cell instance sg13cmos5l_dlygate4sd3_1_156 r0 *1 0,0
Xsg13cmos5l_dlygate4sd3_1_156 \$4768 VPWR VGND \$5257 sg13cmos5l_dlygate4sd3_1
* cell instance sg13cmos5l_dlygate4sd3_1_157 r0 *1 0,0
Xsg13cmos5l_dlygate4sd3_1_157 \$5391 VPWR VGND \$5360 sg13cmos5l_dlygate4sd3_1
* cell instance sg13cmos5l_dlygate4sd3_1_158 r0 *1 0,0
Xsg13cmos5l_dlygate4sd3_1_158 \$5372 VPWR VGND \$5814 sg13cmos5l_dlygate4sd3_1
* cell instance sg13cmos5l_dlygate4sd3_1_159 r0 *1 0,0
Xsg13cmos5l_dlygate4sd3_1_159 \$4979 VPWR VGND \$4978 sg13cmos5l_dlygate4sd3_1
* cell instance sg13cmos5l_dlygate4sd3_1_160 r0 *1 0,0
Xsg13cmos5l_dlygate4sd3_1_160 \$4594 VPWR VGND \$4252 sg13cmos5l_dlygate4sd3_1
* cell instance sg13cmos5l_dlygate4sd3_1_161 r0 *1 0,0
Xsg13cmos5l_dlygate4sd3_1_161 \$5374 VPWR VGND \$5373 sg13cmos5l_dlygate4sd3_1
* cell instance sg13cmos5l_dlygate4sd3_1_162 r0 *1 0,0
Xsg13cmos5l_dlygate4sd3_1_162 \$4788 VPWR VGND \$4967 sg13cmos5l_dlygate4sd3_1
* cell instance sg13cmos5l_dlygate4sd3_1_163 r0 *1 0,0
Xsg13cmos5l_dlygate4sd3_1_163 \$5612 VPWR VGND \$4769 sg13cmos5l_dlygate4sd3_1
* cell instance sg13cmos5l_dlygate4sd3_1_164 r0 *1 0,0
Xsg13cmos5l_dlygate4sd3_1_164 \$4259 VPWR VGND \$4330 sg13cmos5l_dlygate4sd3_1
* cell instance sg13cmos5l_dlygate4sd3_1_165 r0 *1 0,0
Xsg13cmos5l_dlygate4sd3_1_165 \$4606 VPWR VGND \$4980 sg13cmos5l_dlygate4sd3_1
* cell instance sg13cmos5l_dlygate4sd3_1_166 r0 *1 0,0
Xsg13cmos5l_dlygate4sd3_1_166 \$5187 VPWR VGND \$4972 sg13cmos5l_dlygate4sd3_1
* cell instance sg13cmos5l_dlygate4sd3_1_167 r0 *1 0,0
Xsg13cmos5l_dlygate4sd3_1_167 \$5390 VPWR VGND \$5375 sg13cmos5l_dlygate4sd3_1
* cell instance sg13cmos5l_dlygate4sd3_1_168 r0 *1 0,0
Xsg13cmos5l_dlygate4sd3_1_168 \$6002 VPWR VGND \$6225 sg13cmos5l_dlygate4sd3_1
* cell instance sg13cmos5l_dlygate4sd3_1_169 r0 *1 0,0
Xsg13cmos5l_dlygate4sd3_1_169 \$5619 VPWR VGND \$5396 sg13cmos5l_dlygate4sd3_1
* cell instance sg13cmos5l_dlygate4sd3_1_170 r0 *1 0,0
Xsg13cmos5l_dlygate4sd3_1_170 \$4609 VPWR VGND \$4423 sg13cmos5l_dlygate4sd3_1
* cell instance sg13cmos5l_dlygate4sd3_1_171 r0 *1 0,0
Xsg13cmos5l_dlygate4sd3_1_171 \$6230 VPWR VGND \$6235 sg13cmos5l_dlygate4sd3_1
* cell instance sg13cmos5l_dlygate4sd3_1_172 r0 *1 0,0
Xsg13cmos5l_dlygate4sd3_1_172 \$5399 VPWR VGND \$5392 sg13cmos5l_dlygate4sd3_1
* cell instance sg13cmos5l_dlygate4sd3_1_173 r0 *1 0,0
Xsg13cmos5l_dlygate4sd3_1_173 \$20208 VPWR VGND \$6410 sg13cmos5l_dlygate4sd3_1
* cell instance sg13cmos5l_dlygate4sd3_1_174 r0 *1 0,0
Xsg13cmos5l_dlygate4sd3_1_174 \$3892 VPWR VGND \$4809 sg13cmos5l_dlygate4sd3_1
* cell instance sg13cmos5l_dlygate4sd3_1_175 r0 *1 0,0
Xsg13cmos5l_dlygate4sd3_1_175 \$3805 VPWR VGND \$3648 sg13cmos5l_dlygate4sd3_1
* cell instance sg13cmos5l_dlygate4sd3_1_176 r0 *1 0,0
Xsg13cmos5l_dlygate4sd3_1_176 \$847 VPWR VGND \$976 sg13cmos5l_dlygate4sd3_1
* cell instance sg13cmos5l_dlygate4sd3_1_177 r0 *1 0,0
Xsg13cmos5l_dlygate4sd3_1_177 \$567 VPWR VGND \$565 sg13cmos5l_dlygate4sd3_1
* cell instance sg13cmos5l_dlygate4sd3_1_178 r0 *1 0,0
Xsg13cmos5l_dlygate4sd3_1_178 \$4444 VPWR VGND \$4441 sg13cmos5l_dlygate4sd3_1
* cell instance sg13cmos5l_dlygate4sd3_1_179 r0 *1 0,0
Xsg13cmos5l_dlygate4sd3_1_179 \$571 VPWR VGND \$705 sg13cmos5l_dlygate4sd3_1
* cell instance sg13cmos5l_dlygate4sd3_1_180 r0 *1 0,0
Xsg13cmos5l_dlygate4sd3_1_180 \$853 VPWR VGND \$453 sg13cmos5l_dlygate4sd3_1
* cell instance sg13cmos5l_dlygate4sd3_1_181 r0 *1 0,0
Xsg13cmos5l_dlygate4sd3_1_181 \$13875 VPWR VGND \$20210 sg13cmos5l_dlygate4sd3_1
* cell instance sg13cmos5l_dlygate4sd3_1_182 r0 *1 0,0
Xsg13cmos5l_dlygate4sd3_1_182 \$3132 VPWR VGND \$3309 sg13cmos5l_dlygate4sd3_1
* cell instance sg13cmos5l_dlygate4sd3_1_183 r0 *1 0,0
Xsg13cmos5l_dlygate4sd3_1_183 \$337 VPWR VGND \$187 sg13cmos5l_dlygate4sd3_1
* cell instance sg13cmos5l_dlygate4sd3_1_184 r0 *1 0,0
Xsg13cmos5l_dlygate4sd3_1_184 \$3991 VPWR VGND \$3820 sg13cmos5l_dlygate4sd3_1
* cell instance sg13cmos5l_dlygate4sd3_1_185 r0 *1 0,0
Xsg13cmos5l_dlygate4sd3_1_185 \$461 VPWR VGND \$459 sg13cmos5l_dlygate4sd3_1
* cell instance sg13cmos5l_dlygate4sd3_1_186 r0 *1 0,0
Xsg13cmos5l_dlygate4sd3_1_186 \$3651 VPWR VGND \$4132 sg13cmos5l_dlygate4sd3_1
* cell instance sg13cmos5l_dlygate4sd3_1_187 r0 *1 0,0
Xsg13cmos5l_dlygate4sd3_1_187 \$198 VPWR VGND \$139 sg13cmos5l_dlygate4sd3_1
* cell instance sg13cmos5l_dlygate4sd3_1_188 r0 *1 0,0
Xsg13cmos5l_dlygate4sd3_1_188 \$3498 VPWR VGND \$3323 sg13cmos5l_dlygate4sd3_1
* cell instance sg13cmos5l_dlygate4sd3_1_189 r0 *1 0,0
Xsg13cmos5l_dlygate4sd3_1_189 \$467 VPWR VGND \$203 sg13cmos5l_dlygate4sd3_1
* cell instance sg13cmos5l_dlygate4sd3_1_190 r0 *1 0,0
Xsg13cmos5l_dlygate4sd3_1_190 \$469 VPWR VGND \$471 sg13cmos5l_dlygate4sd3_1
* cell instance sg13cmos5l_dlygate4sd3_1_191 r0 *1 0,0
Xsg13cmos5l_dlygate4sd3_1_191 \$5836 VPWR VGND \$5839 sg13cmos5l_dlygate4sd3_1
* cell instance sg13cmos5l_dlygate4sd3_1_192 r0 *1 0,0
Xsg13cmos5l_dlygate4sd3_1_192 \$213 VPWR VGND \$142 sg13cmos5l_dlygate4sd3_1
* cell instance sg13cmos5l_dlygate4sd3_1_193 r0 *1 0,0
Xsg13cmos5l_dlygate4sd3_1_193 \$518 VPWR VGND \$588 sg13cmos5l_dlygate4sd3_1
* cell instance sg13cmos5l_dlygate4sd3_1_194 r0 *1 0,0
Xsg13cmos5l_dlygate4sd3_1_194 \$20235 VPWR VGND \$20239 sg13cmos5l_dlygate4sd3_1
* cell instance sg13cmos5l_dlygate4sd3_1_195 r0 *1 0,0
Xsg13cmos5l_dlygate4sd3_1_195 \$3511 VPWR VGND \$3324 sg13cmos5l_dlygate4sd3_1
* cell instance sg13cmos5l_dlygate4sd3_1_196 r0 *1 0,0
Xsg13cmos5l_dlygate4sd3_1_196 \$3147 VPWR VGND \$3326 sg13cmos5l_dlygate4sd3_1
* cell instance sg13cmos5l_dlygate4sd3_1_197 r0 *1 0,0
Xsg13cmos5l_dlygate4sd3_1_197 \$483 VPWR VGND \$355 sg13cmos5l_dlygate4sd3_1
* cell instance sg13cmos5l_dlygate4sd3_1_198 r0 *1 0,0
Xsg13cmos5l_dlygate4sd3_1_198 \$7867 VPWR VGND \$6504 sg13cmos5l_dlygate4sd3_1
* cell instance sg13cmos5l_dlygate4sd3_1_199 r0 *1 0,0
Xsg13cmos5l_dlygate4sd3_1_199 \$8500 VPWR VGND \$6411 sg13cmos5l_dlygate4sd3_1
* cell instance sg13cmos5l_dlygate4sd3_1_200 r0 *1 0,0
Xsg13cmos5l_dlygate4sd3_1_200 \$8797 VPWR VGND \$6503 sg13cmos5l_dlygate4sd3_1
* cell instance sg13cmos5l_dlygate4sd3_1_201 r0 *1 0,0
Xsg13cmos5l_dlygate4sd3_1_201 \$9240 VPWR VGND \$6547 sg13cmos5l_dlygate4sd3_1
* cell instance sg13cmos5l_dlygate4sd3_1_202 r0 *1 0,0
Xsg13cmos5l_dlygate4sd3_1_202 \$217 VPWR VGND \$6004 sg13cmos5l_dlygate4sd3_1
* cell instance sg13cmos5l_dlygate4sd3_1_203 r0 *1 0,0
Xsg13cmos5l_dlygate4sd3_1_203 \$4774 VPWR VGND \$5377 sg13cmos5l_dlygate4sd3_1
* cell instance sg13cmos5l_dlygate4sd3_1_204 r0 *1 0,0
Xsg13cmos5l_dlygate4sd3_1_204 \$6500 VPWR VGND \$5703 sg13cmos5l_dlygate4sd3_1
* cell instance sg13cmos5l_dlygate4sd3_1_205 r0 *1 0,0
Xsg13cmos5l_dlygate4sd3_1_205 \$20058 VPWR VGND \$19892 sg13cmos5l_dlygate4sd3_1
* cell instance sg13cmos5l_dlygate4sd3_1_206 r0 *1 0,0
Xsg13cmos5l_dlygate4sd3_1_206 \$20058 VPWR VGND \$19893 sg13cmos5l_dlygate4sd3_1
* cell instance sg13cmos5l_dlygate4sd3_1_207 r0 *1 0,0
Xsg13cmos5l_dlygate4sd3_1_207 \$1124 VPWR VGND \$993 sg13cmos5l_dlygate4sd3_1
* cell instance sg13cmos5l_dlygate4sd3_1_208 r0 *1 0,0
Xsg13cmos5l_dlygate4sd3_1_208 \$486 VPWR VGND \$480 sg13cmos5l_dlygate4sd3_1
* cell instance sg13cmos5l_dlygate4sd3_1_209 r0 *1 0,0
Xsg13cmos5l_dlygate4sd3_1_209 \$8501 VPWR VGND \$6619 sg13cmos5l_dlygate4sd3_1
* cell instance sg13cmos5l_dlygate4sd3_1_210 r0 *1 0,0
Xsg13cmos5l_dlygate4sd3_1_210 \$785 VPWR VGND \$873 sg13cmos5l_dlygate4sd3_1
* cell instance sg13cmos5l_dlygate4sd3_1_211 r0 *1 0,0
Xsg13cmos5l_dlygate4sd3_1_211 \$15212 VPWR VGND \$14611 sg13cmos5l_dlygate4sd3_1
* cell instance sg13cmos5l_dlygate4sd3_1_212 r0 *1 0,0
Xsg13cmos5l_dlygate4sd3_1_212 \$3336 VPWR VGND \$3516 sg13cmos5l_dlygate4sd3_1
* cell instance sg13cmos5l_dlygate4sd3_1_213 r0 *1 0,0
Xsg13cmos5l_dlygate4sd3_1_213 \$17337 VPWR VGND \$17833 sg13cmos5l_dlygate4sd3_1
* cell instance sg13cmos5l_dlygate4sd3_1_214 r0 *1 0,0
Xsg13cmos5l_dlygate4sd3_1_214 \$399 VPWR VGND \$358 sg13cmos5l_dlygate4sd3_1
* cell instance sg13cmos5l_dlygate4sd3_1_215 r0 *1 0,0
Xsg13cmos5l_dlygate4sd3_1_215 \$3895 VPWR VGND \$3578 sg13cmos5l_dlygate4sd3_1
* cell instance sg13cmos5l_dlygate4sd3_1_216 r0 *1 0,0
Xsg13cmos5l_dlygate4sd3_1_216 \$8799 VPWR VGND \$8236 sg13cmos5l_dlygate4sd3_1
* cell instance sg13cmos5l_dlygate4sd3_1_217 r0 *1 0,0
Xsg13cmos5l_dlygate4sd3_1_217 \$15719 VPWR VGND \$15718 sg13cmos5l_dlygate4sd3_1
* cell instance sg13cmos5l_dlygate4sd3_1_218 r0 *1 0,0
Xsg13cmos5l_dlygate4sd3_1_218 \$19561 VPWR VGND \$19562 sg13cmos5l_dlygate4sd3_1
* cell instance sg13cmos5l_dlygate4sd3_1_219 r0 *1 0,0
Xsg13cmos5l_dlygate4sd3_1_219 \$20240 VPWR VGND \$20108 sg13cmos5l_dlygate4sd3_1
* cell instance sg13cmos5l_dlygate4sd3_1_220 r0 *1 0,0
Xsg13cmos5l_dlygate4sd3_1_220 \$8223 VPWR VGND \$9788 sg13cmos5l_dlygate4sd3_1
* cell instance sg13cmos5l_dlygate4sd3_1_221 r0 *1 0,0
Xsg13cmos5l_dlygate4sd3_1_221 \$8237 VPWR VGND \$7989 sg13cmos5l_dlygate4sd3_1
* cell instance sg13cmos5l_dlygate4sd3_1_222 r0 *1 0,0
Xsg13cmos5l_dlygate4sd3_1_222 \$6407 VPWR VGND \$10928 sg13cmos5l_dlygate4sd3_1
* cell instance sg13cmos5l_dlygate4sd3_1_223 r0 *1 0,0
Xsg13cmos5l_dlygate4sd3_1_223 \$1607 VPWR VGND \$1611 sg13cmos5l_dlygate4sd3_1
* cell instance sg13cmos5l_dlygate4sd3_1_224 r0 *1 0,0
Xsg13cmos5l_dlygate4sd3_1_224 \$8224 VPWR VGND \$7991 sg13cmos5l_dlygate4sd3_1
* cell instance sg13cmos5l_dlygate4sd3_1_225 r0 *1 0,0
Xsg13cmos5l_dlygate4sd3_1_225 \$17304 VPWR VGND \$16847 sg13cmos5l_dlygate4sd3_1
* cell instance sg13cmos5l_dlygate4sd3_1_226 r0 *1 0,0
Xsg13cmos5l_dlygate4sd3_1_226 \$8222 VPWR VGND \$14190 sg13cmos5l_dlygate4sd3_1
* cell instance sg13cmos5l_dlygate4sd3_1_227 r0 *1 0,0
Xsg13cmos5l_dlygate4sd3_1_227 \$2988 VPWR VGND \$3156 sg13cmos5l_dlygate4sd3_1
* cell instance sg13cmos5l_dlygate4sd3_1_228 r0 *1 0,0
Xsg13cmos5l_dlygate4sd3_1_228 \$8802 VPWR VGND \$8502 sg13cmos5l_dlygate4sd3_1
* cell instance sg13cmos5l_dlygate4sd3_1_229 r0 *1 0,0
Xsg13cmos5l_dlygate4sd3_1_229 \$3851 VPWR VGND \$3717 sg13cmos5l_dlygate4sd3_1
* cell instance sg13cmos5l_dlygate4sd3_1_230 r0 *1 0,0
Xsg13cmos5l_dlygate4sd3_1_230 \$6302 VPWR VGND \$6427 sg13cmos5l_dlygate4sd3_1
* cell instance sg13cmos5l_dlygate4sd3_1_231 r0 *1 0,0
Xsg13cmos5l_dlygate4sd3_1_231 \$17840 VPWR VGND \$17835 sg13cmos5l_dlygate4sd3_1
* cell instance sg13cmos5l_dlygate4sd3_1_232 r0 *1 0,0
Xsg13cmos5l_dlygate4sd3_1_232 \$17838 VPWR VGND \$19563 sg13cmos5l_dlygate4sd3_1
* cell instance sg13cmos5l_dlygate4sd3_1_233 r0 *1 0,0
Xsg13cmos5l_dlygate4sd3_1_233 \$7773 VPWR VGND \$7658 sg13cmos5l_dlygate4sd3_1
* cell instance sg13cmos5l_dlygate4sd3_1_234 r0 *1 0,0
Xsg13cmos5l_dlygate4sd3_1_234 \$8800 VPWR VGND \$8801 sg13cmos5l_dlygate4sd3_1
* cell instance sg13cmos5l_dlygate4sd3_1_235 r0 *1 0,0
Xsg13cmos5l_dlygate4sd3_1_235 \$6352 VPWR VGND \$10930 sg13cmos5l_dlygate4sd3_1
* cell instance sg13cmos5l_dlygate4sd3_1_236 r0 *1 0,0
Xsg13cmos5l_dlygate4sd3_1_236 \$242 VPWR VGND \$495 sg13cmos5l_dlygate4sd3_1
* cell instance sg13cmos5l_dlygate4sd3_1_237 r0 *1 0,0
Xsg13cmos5l_dlygate4sd3_1_237 \$3381 VPWR VGND \$3346 sg13cmos5l_dlygate4sd3_1
* cell instance sg13cmos5l_dlygate4sd3_1_238 r0 *1 0,0
Xsg13cmos5l_dlygate4sd3_1_238 \$6546 VPWR VGND \$9626 sg13cmos5l_dlygate4sd3_1
* cell instance sg13cmos5l_dlygate4sd3_1_239 r0 *1 0,0
Xsg13cmos5l_dlygate4sd3_1_239 \$6508 VPWR VGND \$6582 sg13cmos5l_dlygate4sd3_1
* cell instance sg13cmos5l_dlygate4sd3_1_240 r0 *1 0,0
Xsg13cmos5l_dlygate4sd3_1_240 \$1620 VPWR VGND \$1739 sg13cmos5l_dlygate4sd3_1
* cell instance sg13cmos5l_dlygate4sd3_1_241 r0 *1 0,0
Xsg13cmos5l_dlygate4sd3_1_241 \$5857 VPWR VGND \$5858 sg13cmos5l_dlygate4sd3_1
* cell instance sg13cmos5l_dlygate4sd3_1_242 r0 *1 0,0
Xsg13cmos5l_dlygate4sd3_1_242 \$1004 VPWR VGND \$1128 sg13cmos5l_dlygate4sd3_1
* cell instance sg13cmos5l_dlygate4sd3_1_243 r0 *1 0,0
Xsg13cmos5l_dlygate4sd3_1_243 \$1617 VPWR VGND \$1614 sg13cmos5l_dlygate4sd3_1
* cell instance sg13cmos5l_dlygate4sd3_1_244 r0 *1 0,0
Xsg13cmos5l_dlygate4sd3_1_244 \$6488 VPWR VGND \$9368 sg13cmos5l_dlygate4sd3_1
* cell instance sg13cmos5l_dlygate4sd3_1_245 r0 *1 0,0
Xsg13cmos5l_dlygate4sd3_1_245 \$8780 VPWR VGND \$7994 sg13cmos5l_dlygate4sd3_1
* cell instance sg13cmos5l_dlygate4sd3_1_246 r0 *1 0,0
Xsg13cmos5l_dlygate4sd3_1_246 \$748 VPWR VGND \$609 sg13cmos5l_dlygate4sd3_1
* cell instance sg13cmos5l_dlygate4sd3_1_247 r0 *1 0,0
Xsg13cmos5l_dlygate4sd3_1_247 \$8805 VPWR VGND \$8504 sg13cmos5l_dlygate4sd3_1
* cell instance sg13cmos5l_dlygate4sd3_1_248 r0 *1 0,0
Xsg13cmos5l_dlygate4sd3_1_248 \$7532 VPWR VGND \$7780 sg13cmos5l_dlygate4sd3_1
* cell instance sg13cmos5l_dlygate4sd3_1_249 r0 *1 0,0
Xsg13cmos5l_dlygate4sd3_1_249 \$5434 VPWR VGND \$5435 sg13cmos5l_dlygate4sd3_1
* cell instance sg13cmos5l_dlygate4sd3_1_250 r0 *1 0,0
Xsg13cmos5l_dlygate4sd3_1_250 \$1960 VPWR VGND \$1841 sg13cmos5l_dlygate4sd3_1
* cell instance sg13cmos5l_dlygate4sd3_1_251 r0 *1 0,0
Xsg13cmos5l_dlygate4sd3_1_251 \$6780 VPWR VGND \$6854 sg13cmos5l_dlygate4sd3_1
* cell instance sg13cmos5l_dlygate4sd3_1_252 r0 *1 0,0
Xsg13cmos5l_dlygate4sd3_1_252 \$8804 VPWR VGND \$9369 sg13cmos5l_dlygate4sd3_1
* cell instance sg13cmos5l_dlygate4sd3_1_253 r0 *1 0,0
Xsg13cmos5l_dlygate4sd3_1_253 \$8803 VPWR VGND \$8510 sg13cmos5l_dlygate4sd3_1
* cell instance sg13cmos5l_dlygate4sd3_1_254 r0 *1 0,0
Xsg13cmos5l_dlygate4sd3_1_254 \$8487 VPWR VGND \$7993 sg13cmos5l_dlygate4sd3_1
* cell instance sg13cmos5l_dlygate4sd3_1_255 r0 *1 0,0
Xsg13cmos5l_dlygate4sd3_1_255 \$953 VPWR VGND \$13474 sg13cmos5l_dlygate4sd3_1
* cell instance sg13cmos5l_dlygate4sd3_1_256 r0 *1 0,0
Xsg13cmos5l_dlygate4sd3_1_256 \$19410 VPWR VGND \$19565 sg13cmos5l_dlygate4sd3_1
* cell instance sg13cmos5l_dlygate4sd3_1_257 r0 *1 0,0
Xsg13cmos5l_dlygate4sd3_1_257 \$1958 VPWR VGND \$2183 sg13cmos5l_dlygate4sd3_1
* cell instance sg13cmos5l_dlygate4sd3_1_258 r0 *1 0,0
Xsg13cmos5l_dlygate4sd3_1_258 \$3683 VPWR VGND \$3858 sg13cmos5l_dlygate4sd3_1
* cell instance sg13cmos5l_dlygate4sd3_1_259 r0 *1 0,0
Xsg13cmos5l_dlygate4sd3_1_259 \$2464 VPWR VGND \$2778 sg13cmos5l_dlygate4sd3_1
* cell instance sg13cmos5l_dlygate4sd3_1_260 r0 *1 0,0
Xsg13cmos5l_dlygate4sd3_1_260 \$16668 VPWR VGND \$17339 sg13cmos5l_dlygate4sd3_1
* cell instance sg13cmos5l_dlygate4sd3_1_261 r0 *1 0,0
Xsg13cmos5l_dlygate4sd3_1_261 \$1615 VPWR VGND \$1626 sg13cmos5l_dlygate4sd3_1
* cell instance sg13cmos5l_dlygate4sd3_1_262 r0 *1 0,0
Xsg13cmos5l_dlygate4sd3_1_262 \$243 VPWR VGND \$247 sg13cmos5l_dlygate4sd3_1
* cell instance sg13cmos5l_dlygate4sd3_1_263 r0 *1 0,0
Xsg13cmos5l_dlygate4sd3_1_263 \$18235 VPWR VGND \$17844 sg13cmos5l_dlygate4sd3_1
* cell instance sg13cmos5l_dlygate4sd3_1_264 r0 *1 0,0
Xsg13cmos5l_dlygate4sd3_1_264 \$625 VPWR VGND \$612 sg13cmos5l_dlygate4sd3_1
* cell instance sg13cmos5l_dlygate4sd3_1_265 r0 *1 0,0
Xsg13cmos5l_dlygate4sd3_1_265 \$2314 VPWR VGND \$2365 sg13cmos5l_dlygate4sd3_1
* cell instance sg13cmos5l_dlygate4sd3_1_266 r0 *1 0,0
Xsg13cmos5l_dlygate4sd3_1_266 \$15538 VPWR VGND \$14613 sg13cmos5l_dlygate4sd3_1
* cell instance sg13cmos5l_dlygate4sd3_1_267 r0 *1 0,0
Xsg13cmos5l_dlygate4sd3_1_267 \$18963 VPWR VGND \$19564 sg13cmos5l_dlygate4sd3_1
* cell instance sg13cmos5l_dlygate4sd3_1_268 r0 *1 0,0
Xsg13cmos5l_dlygate4sd3_1_268 \$886 VPWR VGND \$887 sg13cmos5l_dlygate4sd3_1
* cell instance sg13cmos5l_dlygate4sd3_1_269 r0 *1 0,0
Xsg13cmos5l_dlygate4sd3_1_269 \$4829 VPWR VGND \$6306 sg13cmos5l_dlygate4sd3_1
* cell instance sg13cmos5l_dlygate4sd3_1_270 r0 *1 0,0
Xsg13cmos5l_dlygate4sd3_1_270 \$8507 VPWR VGND \$7871 sg13cmos5l_dlygate4sd3_1
* cell instance sg13cmos5l_dlygate4sd3_1_271 r0 *1 0,0
Xsg13cmos5l_dlygate4sd3_1_271 \$504 VPWR VGND \$501 sg13cmos5l_dlygate4sd3_1
* cell instance sg13cmos5l_dlygate4sd3_1_272 r0 *1 0,0
Xsg13cmos5l_dlygate4sd3_1_272 \$923 VPWR VGND \$885 sg13cmos5l_dlygate4sd3_1
* cell instance sg13cmos5l_dlygate4sd3_1_273 r0 *1 0,0
Xsg13cmos5l_dlygate4sd3_1_273 \$1388 VPWR VGND \$1387 sg13cmos5l_dlygate4sd3_1
* cell instance sg13cmos5l_dlygate4sd3_1_274 r0 *1 0,0
Xsg13cmos5l_dlygate4sd3_1_274 \$5446 VPWR VGND \$5234 sg13cmos5l_dlygate4sd3_1
* cell instance sg13cmos5l_dlygate4sd3_1_275 r0 *1 0,0
Xsg13cmos5l_dlygate4sd3_1_275 \$7967 VPWR VGND \$7873 sg13cmos5l_dlygate4sd3_1
* cell instance sg13cmos5l_dlygate4sd3_1_276 r0 *1 0,0
Xsg13cmos5l_dlygate4sd3_1_276 \$9790 VPWR VGND \$9627 sg13cmos5l_dlygate4sd3_1
* cell instance sg13cmos5l_dlygate4sd3_1_277 r0 *1 0,0
Xsg13cmos5l_dlygate4sd3_1_277 \$8782 VPWR VGND \$8511 sg13cmos5l_dlygate4sd3_1
* cell instance sg13cmos5l_dlygate4sd3_1_278 r0 *1 0,0
Xsg13cmos5l_dlygate4sd3_1_278 \$6787 VPWR VGND \$6579 sg13cmos5l_dlygate4sd3_1
* cell instance sg13cmos5l_dlygate4sd3_1_279 r0 *1 0,0
Xsg13cmos5l_dlygate4sd3_1_279 \$7971 VPWR VGND \$7872 sg13cmos5l_dlygate4sd3_1
* cell instance sg13cmos5l_dlygate4sd3_1_280 r0 *1 0,0
Xsg13cmos5l_dlygate4sd3_1_280 \$8806 VPWR VGND \$9373 sg13cmos5l_dlygate4sd3_1
* cell instance sg13cmos5l_dlygate4sd3_1_281 r0 *1 0,0
Xsg13cmos5l_dlygate4sd3_1_281 \$8783 VPWR VGND \$8512 sg13cmos5l_dlygate4sd3_1
* cell instance sg13cmos5l_dlygate4sd3_1_282 r0 *1 0,0
Xsg13cmos5l_dlygate4sd3_1_282 \$2326 VPWR VGND \$2469 sg13cmos5l_dlygate4sd3_1
* cell instance sg13cmos5l_dlygate4sd3_1_283 r0 *1 0,0
Xsg13cmos5l_dlygate4sd3_1_283 \$8014 VPWR VGND \$8238 sg13cmos5l_dlygate4sd3_1
* cell instance sg13cmos5l_dlygate4sd3_1_284 r0 *1 0,0
Xsg13cmos5l_dlygate4sd3_1_284 \$17849 VPWR VGND \$17845 sg13cmos5l_dlygate4sd3_1
* cell instance sg13cmos5l_dlygate4sd3_1_285 r0 *1 0,0
Xsg13cmos5l_dlygate4sd3_1_285 \$6792 VPWR VGND \$7084 sg13cmos5l_dlygate4sd3_1
* cell instance sg13cmos5l_dlygate4sd3_1_286 r0 *1 0,0
Xsg13cmos5l_dlygate4sd3_1_286 \$15217 VPWR VGND \$15215 sg13cmos5l_dlygate4sd3_1
* cell instance sg13cmos5l_dlygate4sd3_1_287 r0 *1 0,0
Xsg13cmos5l_dlygate4sd3_1_287 \$16673 VPWR VGND \$16325 sg13cmos5l_dlygate4sd3_1
* cell instance sg13cmos5l_dlygate4sd3_1_288 r0 *1 0,0
Xsg13cmos5l_dlygate4sd3_1_288 \$2473 VPWR VGND \$2368 sg13cmos5l_dlygate4sd3_1
* cell instance sg13cmos5l_dlygate4sd3_1_289 r0 *1 0,0
Xsg13cmos5l_dlygate4sd3_1_289 \$7668 VPWR VGND \$7542 sg13cmos5l_dlygate4sd3_1
* cell instance sg13cmos5l_dlygate4sd3_1_290 r0 *1 0,0
Xsg13cmos5l_dlygate4sd3_1_290 \$17848 VPWR VGND \$18921 sg13cmos5l_dlygate4sd3_1
* cell instance sg13cmos5l_dlygate4sd3_1_291 r0 *1 0,0
Xsg13cmos5l_dlygate4sd3_1_291 \$2200 VPWR VGND \$2206 sg13cmos5l_dlygate4sd3_1
* cell instance sg13cmos5l_dlygate4sd3_1_292 r0 *1 0,0
Xsg13cmos5l_dlygate4sd3_1_292 \$15547 VPWR VGND \$15056 sg13cmos5l_dlygate4sd3_1
* cell instance sg13cmos5l_dlygate4sd3_1_293 r0 *1 0,0
Xsg13cmos5l_dlygate4sd3_1_293 \$1982 VPWR VGND \$1855 sg13cmos5l_dlygate4sd3_1
* cell instance sg13cmos5l_dlygate4sd3_1_294 r0 *1 0,0
Xsg13cmos5l_dlygate4sd3_1_294 \$5228 VPWR VGND \$5865 sg13cmos5l_dlygate4sd3_1
* cell instance sg13cmos5l_dlygate4sd3_1_295 r0 *1 0,0
Xsg13cmos5l_dlygate4sd3_1_295 \$8239 VPWR VGND \$7992 sg13cmos5l_dlygate4sd3_1
* cell instance sg13cmos5l_dlygate4sd3_1_296 r0 *1 0,0
Xsg13cmos5l_dlygate4sd3_1_296 \$8811 VPWR VGND \$8503 sg13cmos5l_dlygate4sd3_1
* cell instance sg13cmos5l_dlygate4sd3_1_297 r0 *1 0,0
Xsg13cmos5l_dlygate4sd3_1_297 \$3170 VPWR VGND \$2945 sg13cmos5l_dlygate4sd3_1
* cell instance sg13cmos5l_dlygate4sd3_1_298 r0 *1 0,0
Xsg13cmos5l_dlygate4sd3_1_298 \$626 VPWR VGND \$762 sg13cmos5l_dlygate4sd3_1
* cell instance sg13cmos5l_dlygate4sd3_1_299 r0 *1 0,0
Xsg13cmos5l_dlygate4sd3_1_299 \$8807 VPWR VGND \$8514 sg13cmos5l_dlygate4sd3_1
* cell instance sg13cmos5l_dlygate4sd3_1_300 r0 *1 0,0
Xsg13cmos5l_dlygate4sd3_1_300 \$2336 VPWR VGND \$2501 sg13cmos5l_dlygate4sd3_1
* cell instance sg13cmos5l_dlygate4sd3_1_301 r0 *1 0,0
Xsg13cmos5l_dlygate4sd3_1_301 \$6861 VPWR VGND \$6524 sg13cmos5l_dlygate4sd3_1
* cell instance sg13cmos5l_dlygate4sd3_1_302 r0 *1 0,0
Xsg13cmos5l_dlygate4sd3_1_302 \$8785 VPWR VGND \$8809 sg13cmos5l_dlygate4sd3_1
* cell instance sg13cmos5l_dlygate4sd3_1_303 r0 *1 0,0
Xsg13cmos5l_dlygate4sd3_1_303 \$15214 VPWR VGND \$15675 sg13cmos5l_dlygate4sd3_1
* cell instance sg13cmos5l_dlygate4sd3_1_304 r0 *1 0,0
Xsg13cmos5l_dlygate4sd3_1_304 \$16208 VPWR VGND \$16367 sg13cmos5l_dlygate4sd3_1
* cell instance sg13cmos5l_dlygate4sd3_1_305 r0 *1 0,0
Xsg13cmos5l_dlygate4sd3_1_305 \$8808 VPWR VGND \$8513 sg13cmos5l_dlygate4sd3_1
* cell instance sg13cmos5l_dlygate4sd3_1_306 r0 *1 0,0
Xsg13cmos5l_dlygate4sd3_1_306 \$16323 VPWR VGND \$17852 sg13cmos5l_dlygate4sd3_1
* cell instance sg13cmos5l_dlygate4sd3_1_307 r0 *1 0,0
Xsg13cmos5l_dlygate4sd3_1_307 \$4033 VPWR VGND \$3879 sg13cmos5l_dlygate4sd3_1
* cell instance sg13cmos5l_dlygate4sd3_1_308 r0 *1 0,0
Xsg13cmos5l_dlygate4sd3_1_308 \$763 VPWR VGND \$644 sg13cmos5l_dlygate4sd3_1
* cell instance sg13cmos5l_dlygate4sd3_1_309 r0 *1 0,0
Xsg13cmos5l_dlygate4sd3_1_309 \$1988 VPWR VGND \$1786 sg13cmos5l_dlygate4sd3_1
* cell instance sg13cmos5l_dlygate4sd3_1_310 r0 *1 0,0
Xsg13cmos5l_dlygate4sd3_1_310 \$7789 VPWR VGND \$6860 sg13cmos5l_dlygate4sd3_1
* cell instance sg13cmos5l_dlygate4sd3_1_311 r0 *1 0,0
Xsg13cmos5l_dlygate4sd3_1_311 \$15216 VPWR VGND \$16326 sg13cmos5l_dlygate4sd3_1
* cell instance sg13cmos5l_dlygate4sd3_1_312 r0 *1 0,0
Xsg13cmos5l_dlygate4sd3_1_312 \$1280 VPWR VGND \$1290 sg13cmos5l_dlygate4sd3_1
* cell instance sg13cmos5l_dlygate4sd3_1_313 r0 *1 0,0
Xsg13cmos5l_dlygate4sd3_1_313 \$2093 VPWR VGND \$2105 sg13cmos5l_dlygate4sd3_1
* cell instance sg13cmos5l_dlygate4sd3_1_314 r0 *1 0,0
Xsg13cmos5l_dlygate4sd3_1_314 \$6062 VPWR VGND \$6072 sg13cmos5l_dlygate4sd3_1
* cell instance sg13cmos5l_dlygate4sd3_1_315 r0 *1 0,0
Xsg13cmos5l_dlygate4sd3_1_315 \$4645 VPWR VGND \$4471 sg13cmos5l_dlygate4sd3_1
* cell instance sg13cmos5l_dlygate4sd3_1_316 r0 *1 0,0
Xsg13cmos5l_dlygate4sd3_1_316 \$6598 VPWR VGND \$6551 sg13cmos5l_dlygate4sd3_1
* cell instance sg13cmos5l_dlygate4sd3_1_317 r0 *1 0,0
Xsg13cmos5l_dlygate4sd3_1_317 \$2782 VPWR VGND \$2633 sg13cmos5l_dlygate4sd3_1
* cell instance sg13cmos5l_dlygate4sd3_1_318 r0 *1 0,0
Xsg13cmos5l_dlygate4sd3_1_318 \$5012 VPWR VGND \$5241 sg13cmos5l_dlygate4sd3_1
* cell instance sg13cmos5l_dlygate4sd3_1_319 r0 *1 0,0
Xsg13cmos5l_dlygate4sd3_1_319 \$3889 VPWR VGND \$4028 sg13cmos5l_dlygate4sd3_1
* cell instance sg13cmos5l_dlygate4sd3_1_320 r0 *1 0,0
Xsg13cmos5l_dlygate4sd3_1_320 \$14521 VPWR VGND \$14619 sg13cmos5l_dlygate4sd3_1
* cell instance sg13cmos5l_dlygate4sd3_1_321 r0 *1 0,0
Xsg13cmos5l_dlygate4sd3_1_321 \$8240 VPWR VGND \$7998 sg13cmos5l_dlygate4sd3_1
* cell instance sg13cmos5l_dlygate4sd3_1_322 r0 *1 0,0
Xsg13cmos5l_dlygate4sd3_1_322 \$6336 VPWR VGND \$6321 sg13cmos5l_dlygate4sd3_1
* cell instance sg13cmos5l_dlygate4sd3_1_323 r0 *1 0,0
Xsg13cmos5l_dlygate4sd3_1_323 \$1282 VPWR VGND \$1524 sg13cmos5l_dlygate4sd3_1
* cell instance sg13cmos5l_dlygate4sd3_1_324 r0 *1 0,0
Xsg13cmos5l_dlygate4sd3_1_324 \$1976 VPWR VGND \$1987 sg13cmos5l_dlygate4sd3_1
* cell instance sg13cmos5l_dlygate4sd3_1_325 r0 *1 0,0
Xsg13cmos5l_dlygate4sd3_1_325 \$2952 VPWR VGND \$3183 sg13cmos5l_dlygate4sd3_1
* cell instance sg13cmos5l_dlygate4sd3_1_326 r0 *1 0,0
Xsg13cmos5l_dlygate4sd3_1_326 \$1765 VPWR VGND \$1768 sg13cmos5l_dlygate4sd3_1
* cell instance sg13cmos5l_dlygate4sd3_1_327 r0 *1 0,0
Xsg13cmos5l_dlygate4sd3_1_327 \$8227 VPWR VGND \$8241 sg13cmos5l_dlygate4sd3_1
* cell instance sg13cmos5l_dlygate4sd3_1_328 r0 *1 0,0
Xsg13cmos5l_dlygate4sd3_1_328 \$1025 VPWR VGND \$924 sg13cmos5l_dlygate4sd3_1
* cell instance sg13cmos5l_dlygate4sd3_1_329 r0 *1 0,0
Xsg13cmos5l_dlygate4sd3_1_329 \$5253 VPWR VGND \$5237 sg13cmos5l_dlygate4sd3_1
* cell instance sg13cmos5l_dlygate4sd3_1_330 r0 *1 0,0
Xsg13cmos5l_dlygate4sd3_1_330 \$8226 VPWR VGND \$11411 sg13cmos5l_dlygate4sd3_1
* cell instance sg13cmos5l_dlygate4sd3_1_331 r0 *1 0,0
Xsg13cmos5l_dlygate4sd3_1_331 \$3695 VPWR VGND \$3694 sg13cmos5l_dlygate4sd3_1
* cell instance sg13cmos5l_dlygate4sd3_1_332 r0 *1 0,0
Xsg13cmos5l_dlygate4sd3_1_332 \$8787 VPWR VGND \$8515 sg13cmos5l_dlygate4sd3_1
* cell instance sg13cmos5l_dlygate4sd3_1_333 r0 *1 0,0
Xsg13cmos5l_dlygate4sd3_1_333 \$8812 VPWR VGND \$9205 sg13cmos5l_dlygate4sd3_1
* cell instance sg13cmos5l_dlygate4sd3_1_334 r0 *1 0,0
Xsg13cmos5l_dlygate4sd3_1_334 \$8228 VPWR VGND \$8242 sg13cmos5l_dlygate4sd3_1
* cell instance sg13cmos5l_dlygate4sd3_1_335 r0 *1 0,0
Xsg13cmos5l_dlygate4sd3_1_335 \$6862 VPWR VGND \$7092 sg13cmos5l_dlygate4sd3_1
* cell instance sg13cmos5l_dlygate4sd3_1_336 r0 *1 0,0
Xsg13cmos5l_dlygate4sd3_1_336 \$898 VPWR VGND \$1147 sg13cmos5l_dlygate4sd3_1
* cell instance sg13cmos5l_dlygate4sd3_1_337 r0 *1 0,0
Xsg13cmos5l_dlygate4sd3_1_337 \$8788 VPWR VGND \$8516 sg13cmos5l_dlygate4sd3_1
* cell instance sg13cmos5l_dlygate4sd3_1_338 r0 *1 0,0
Xsg13cmos5l_dlygate4sd3_1_338 \$8229 VPWR VGND \$8400 sg13cmos5l_dlygate4sd3_1
* cell instance sg13cmos5l_dlygate4sd3_1_339 r0 *1 0,0
Xsg13cmos5l_dlygate4sd3_1_339 \$1279 VPWR VGND \$1635 sg13cmos5l_dlygate4sd3_1
* cell instance sg13cmos5l_dlygate4sd3_1_340 r0 *1 0,0
Xsg13cmos5l_dlygate4sd3_1_340 \$2344 VPWR VGND \$2343 sg13cmos5l_dlygate4sd3_1
* cell instance sg13cmos5l_dlygate4sd3_1_341 r0 *1 0,0
Xsg13cmos5l_dlygate4sd3_1_341 \$4317 VPWR VGND \$4650 sg13cmos5l_dlygate4sd3_1
* cell instance sg13cmos5l_dlygate4sd3_1_342 r0 *1 0,0
Xsg13cmos5l_dlygate4sd3_1_342 \$6445 VPWR VGND \$6450 sg13cmos5l_dlygate4sd3_1
* cell instance sg13cmos5l_fill_1_0 r0 *1 0,0
Xsg13cmos5l_fill_1_0 VPWR VGND sg13cmos5l_fill_1
* cell instance sg13cmos5l_fill_1_1 r0 *1 0,0
Xsg13cmos5l_fill_1_1 VPWR VGND sg13cmos5l_fill_1
* cell instance sg13cmos5l_fill_1_2 r0 *1 0,0
Xsg13cmos5l_fill_1_2 VPWR VGND sg13cmos5l_fill_1
* cell instance sg13cmos5l_fill_1_3 r0 *1 0,0
Xsg13cmos5l_fill_1_3 VPWR VGND sg13cmos5l_fill_1
* cell instance sg13cmos5l_fill_1_4 r0 *1 0,0
Xsg13cmos5l_fill_1_4 VPWR VGND sg13cmos5l_fill_1
* cell instance sg13cmos5l_fill_1_5 r0 *1 0,0
Xsg13cmos5l_fill_1_5 VPWR VGND sg13cmos5l_fill_1
* cell instance sg13cmos5l_fill_1_6 r0 *1 0,0
Xsg13cmos5l_fill_1_6 VPWR VGND sg13cmos5l_fill_1
* cell instance sg13cmos5l_fill_1_7 r0 *1 0,0
Xsg13cmos5l_fill_1_7 VPWR VGND sg13cmos5l_fill_1
* cell instance sg13cmos5l_fill_1_8 r0 *1 0,0
Xsg13cmos5l_fill_1_8 VPWR VGND sg13cmos5l_fill_1
* cell instance sg13cmos5l_fill_1_9 r0 *1 0,0
Xsg13cmos5l_fill_1_9 VPWR VGND sg13cmos5l_fill_1
* cell instance sg13cmos5l_fill_1_10 r0 *1 0,0
Xsg13cmos5l_fill_1_10 VPWR VGND sg13cmos5l_fill_1
* cell instance sg13cmos5l_fill_1_11 r0 *1 0,0
Xsg13cmos5l_fill_1_11 VPWR VGND sg13cmos5l_fill_1
* cell instance sg13cmos5l_fill_1_12 r0 *1 0,0
Xsg13cmos5l_fill_1_12 VPWR VGND sg13cmos5l_fill_1
* cell instance sg13cmos5l_fill_1_13 r0 *1 0,0
Xsg13cmos5l_fill_1_13 VPWR VGND sg13cmos5l_fill_1
* cell instance sg13cmos5l_fill_1_14 r0 *1 0,0
Xsg13cmos5l_fill_1_14 VPWR VGND sg13cmos5l_fill_1
* cell instance sg13cmos5l_fill_1_15 r0 *1 0,0
Xsg13cmos5l_fill_1_15 VPWR VGND sg13cmos5l_fill_1
* cell instance sg13cmos5l_fill_1_16 r0 *1 0,0
Xsg13cmos5l_fill_1_16 VPWR VGND sg13cmos5l_fill_1
* cell instance sg13cmos5l_fill_1_17 r0 *1 0,0
Xsg13cmos5l_fill_1_17 VPWR VGND sg13cmos5l_fill_1
* cell instance sg13cmos5l_fill_1_18 r0 *1 0,0
Xsg13cmos5l_fill_1_18 VPWR VGND sg13cmos5l_fill_1
* cell instance sg13cmos5l_fill_1_19 r0 *1 0,0
Xsg13cmos5l_fill_1_19 VPWR VGND sg13cmos5l_fill_1
* cell instance sg13cmos5l_fill_1_20 r0 *1 0,0
Xsg13cmos5l_fill_1_20 VPWR VGND sg13cmos5l_fill_1
* cell instance sg13cmos5l_fill_1_21 r0 *1 0,0
Xsg13cmos5l_fill_1_21 VPWR VGND sg13cmos5l_fill_1
* cell instance sg13cmos5l_fill_1_22 r0 *1 0,0
Xsg13cmos5l_fill_1_22 VPWR VGND sg13cmos5l_fill_1
* cell instance sg13cmos5l_fill_1_23 r0 *1 0,0
Xsg13cmos5l_fill_1_23 VPWR VGND sg13cmos5l_fill_1
* cell instance sg13cmos5l_fill_1_24 r0 *1 0,0
Xsg13cmos5l_fill_1_24 VPWR VGND sg13cmos5l_fill_1
* cell instance sg13cmos5l_fill_1_25 r0 *1 0,0
Xsg13cmos5l_fill_1_25 VPWR VGND sg13cmos5l_fill_1
* cell instance sg13cmos5l_fill_1_26 r0 *1 0,0
Xsg13cmos5l_fill_1_26 VPWR VGND sg13cmos5l_fill_1
* cell instance sg13cmos5l_fill_1_27 r0 *1 0,0
Xsg13cmos5l_fill_1_27 VPWR VGND sg13cmos5l_fill_1
* cell instance sg13cmos5l_fill_1_28 r0 *1 0,0
Xsg13cmos5l_fill_1_28 VPWR VGND sg13cmos5l_fill_1
* cell instance sg13cmos5l_fill_1_29 r0 *1 0,0
Xsg13cmos5l_fill_1_29 VPWR VGND sg13cmos5l_fill_1
* cell instance sg13cmos5l_fill_1_30 r0 *1 0,0
Xsg13cmos5l_fill_1_30 VPWR VGND sg13cmos5l_fill_1
* cell instance sg13cmos5l_fill_1_31 r0 *1 0,0
Xsg13cmos5l_fill_1_31 VPWR VGND sg13cmos5l_fill_1
* cell instance sg13cmos5l_fill_1_32 r0 *1 0,0
Xsg13cmos5l_fill_1_32 VPWR VGND sg13cmos5l_fill_1
* cell instance sg13cmos5l_fill_1_33 r0 *1 0,0
Xsg13cmos5l_fill_1_33 VPWR VGND sg13cmos5l_fill_1
* cell instance sg13cmos5l_fill_1_34 r0 *1 0,0
Xsg13cmos5l_fill_1_34 VPWR VGND sg13cmos5l_fill_1
* cell instance sg13cmos5l_fill_1_35 r0 *1 0,0
Xsg13cmos5l_fill_1_35 VPWR VGND sg13cmos5l_fill_1
* cell instance sg13cmos5l_fill_1_36 r0 *1 0,0
Xsg13cmos5l_fill_1_36 VPWR VGND sg13cmos5l_fill_1
* cell instance sg13cmos5l_fill_1_37 r0 *1 0,0
Xsg13cmos5l_fill_1_37 VPWR VGND sg13cmos5l_fill_1
* cell instance sg13cmos5l_fill_1_38 r0 *1 0,0
Xsg13cmos5l_fill_1_38 VPWR VGND sg13cmos5l_fill_1
* cell instance sg13cmos5l_fill_1_39 r0 *1 0,0
Xsg13cmos5l_fill_1_39 VPWR VGND sg13cmos5l_fill_1
* cell instance sg13cmos5l_fill_1_40 r0 *1 0,0
Xsg13cmos5l_fill_1_40 VPWR VGND sg13cmos5l_fill_1
* cell instance sg13cmos5l_fill_1_41 r0 *1 0,0
Xsg13cmos5l_fill_1_41 VPWR VGND sg13cmos5l_fill_1
* cell instance sg13cmos5l_fill_1_42 r0 *1 0,0
Xsg13cmos5l_fill_1_42 VPWR VGND sg13cmos5l_fill_1
* cell instance sg13cmos5l_fill_1_43 r0 *1 0,0
Xsg13cmos5l_fill_1_43 VPWR VGND sg13cmos5l_fill_1
* cell instance sg13cmos5l_fill_1_44 r0 *1 0,0
Xsg13cmos5l_fill_1_44 VPWR VGND sg13cmos5l_fill_1
* cell instance sg13cmos5l_fill_1_45 r0 *1 0,0
Xsg13cmos5l_fill_1_45 VPWR VGND sg13cmos5l_fill_1
* cell instance sg13cmos5l_fill_1_46 r0 *1 0,0
Xsg13cmos5l_fill_1_46 VPWR VGND sg13cmos5l_fill_1
* cell instance sg13cmos5l_fill_1_47 r0 *1 0,0
Xsg13cmos5l_fill_1_47 VPWR VGND sg13cmos5l_fill_1
* cell instance sg13cmos5l_fill_1_48 r0 *1 0,0
Xsg13cmos5l_fill_1_48 VPWR VGND sg13cmos5l_fill_1
* cell instance sg13cmos5l_fill_1_49 r0 *1 0,0
Xsg13cmos5l_fill_1_49 VPWR VGND sg13cmos5l_fill_1
* cell instance sg13cmos5l_fill_1_50 r0 *1 0,0
Xsg13cmos5l_fill_1_50 VPWR VGND sg13cmos5l_fill_1
* cell instance sg13cmos5l_fill_1_51 r0 *1 0,0
Xsg13cmos5l_fill_1_51 VPWR VGND sg13cmos5l_fill_1
* cell instance sg13cmos5l_fill_1_52 r0 *1 0,0
Xsg13cmos5l_fill_1_52 VPWR VGND sg13cmos5l_fill_1
* cell instance sg13cmos5l_fill_1_53 r0 *1 0,0
Xsg13cmos5l_fill_1_53 VPWR VGND sg13cmos5l_fill_1
* cell instance sg13cmos5l_fill_1_54 r0 *1 0,0
Xsg13cmos5l_fill_1_54 VPWR VGND sg13cmos5l_fill_1
* cell instance sg13cmos5l_fill_1_55 r0 *1 0,0
Xsg13cmos5l_fill_1_55 VPWR VGND sg13cmos5l_fill_1
* cell instance sg13cmos5l_fill_1_56 r0 *1 0,0
Xsg13cmos5l_fill_1_56 VPWR VGND sg13cmos5l_fill_1
* cell instance sg13cmos5l_fill_1_57 r0 *1 0,0
Xsg13cmos5l_fill_1_57 VPWR VGND sg13cmos5l_fill_1
* cell instance sg13cmos5l_fill_1_58 r0 *1 0,0
Xsg13cmos5l_fill_1_58 VPWR VGND sg13cmos5l_fill_1
* cell instance sg13cmos5l_fill_1_59 r0 *1 0,0
Xsg13cmos5l_fill_1_59 VPWR VGND sg13cmos5l_fill_1
* cell instance sg13cmos5l_fill_1_60 r0 *1 0,0
Xsg13cmos5l_fill_1_60 VPWR VGND sg13cmos5l_fill_1
* cell instance sg13cmos5l_fill_1_61 r0 *1 0,0
Xsg13cmos5l_fill_1_61 VPWR VGND sg13cmos5l_fill_1
* cell instance sg13cmos5l_fill_1_62 r0 *1 0,0
Xsg13cmos5l_fill_1_62 VPWR VGND sg13cmos5l_fill_1
* cell instance sg13cmos5l_fill_1_63 r0 *1 0,0
Xsg13cmos5l_fill_1_63 VPWR VGND sg13cmos5l_fill_1
* cell instance sg13cmos5l_fill_1_64 r0 *1 0,0
Xsg13cmos5l_fill_1_64 VPWR VGND sg13cmos5l_fill_1
* cell instance sg13cmos5l_fill_1_65 r0 *1 0,0
Xsg13cmos5l_fill_1_65 VPWR VGND sg13cmos5l_fill_1
* cell instance sg13cmos5l_fill_1_66 r0 *1 0,0
Xsg13cmos5l_fill_1_66 VPWR VGND sg13cmos5l_fill_1
* cell instance sg13cmos5l_fill_1_67 r0 *1 0,0
Xsg13cmos5l_fill_1_67 VPWR VGND sg13cmos5l_fill_1
* cell instance sg13cmos5l_fill_1_68 r0 *1 0,0
Xsg13cmos5l_fill_1_68 VPWR VGND sg13cmos5l_fill_1
* cell instance sg13cmos5l_fill_1_69 r0 *1 0,0
Xsg13cmos5l_fill_1_69 VPWR VGND sg13cmos5l_fill_1
* cell instance sg13cmos5l_fill_1_70 r0 *1 0,0
Xsg13cmos5l_fill_1_70 VPWR VGND sg13cmos5l_fill_1
* cell instance sg13cmos5l_fill_1_71 r0 *1 0,0
Xsg13cmos5l_fill_1_71 VPWR VGND sg13cmos5l_fill_1
* cell instance sg13cmos5l_fill_1_72 r0 *1 0,0
Xsg13cmos5l_fill_1_72 VPWR VGND sg13cmos5l_fill_1
* cell instance sg13cmos5l_fill_1_73 r0 *1 0,0
Xsg13cmos5l_fill_1_73 VPWR VGND sg13cmos5l_fill_1
* cell instance sg13cmos5l_fill_1_74 r0 *1 0,0
Xsg13cmos5l_fill_1_74 VPWR VGND sg13cmos5l_fill_1
* cell instance sg13cmos5l_fill_1_75 r0 *1 0,0
Xsg13cmos5l_fill_1_75 VPWR VGND sg13cmos5l_fill_1
* cell instance sg13cmos5l_fill_1_76 r0 *1 0,0
Xsg13cmos5l_fill_1_76 VPWR VGND sg13cmos5l_fill_1
* cell instance sg13cmos5l_fill_1_77 r0 *1 0,0
Xsg13cmos5l_fill_1_77 VPWR VGND sg13cmos5l_fill_1
* cell instance sg13cmos5l_fill_1_78 r0 *1 0,0
Xsg13cmos5l_fill_1_78 VPWR VGND sg13cmos5l_fill_1
* cell instance sg13cmos5l_fill_1_79 r0 *1 0,0
Xsg13cmos5l_fill_1_79 VPWR VGND sg13cmos5l_fill_1
* cell instance sg13cmos5l_fill_1_80 r0 *1 0,0
Xsg13cmos5l_fill_1_80 VPWR VGND sg13cmos5l_fill_1
* cell instance sg13cmos5l_fill_1_81 r0 *1 0,0
Xsg13cmos5l_fill_1_81 VPWR VGND sg13cmos5l_fill_1
* cell instance sg13cmos5l_fill_1_82 r0 *1 0,0
Xsg13cmos5l_fill_1_82 VPWR VGND sg13cmos5l_fill_1
* cell instance sg13cmos5l_fill_1_83 r0 *1 0,0
Xsg13cmos5l_fill_1_83 VPWR VGND sg13cmos5l_fill_1
* cell instance sg13cmos5l_fill_1_84 r0 *1 0,0
Xsg13cmos5l_fill_1_84 VPWR VGND sg13cmos5l_fill_1
* cell instance sg13cmos5l_fill_1_85 r0 *1 0,0
Xsg13cmos5l_fill_1_85 VPWR VGND sg13cmos5l_fill_1
* cell instance sg13cmos5l_fill_1_86 r0 *1 0,0
Xsg13cmos5l_fill_1_86 VPWR VGND sg13cmos5l_fill_1
* cell instance sg13cmos5l_fill_1_87 r0 *1 0,0
Xsg13cmos5l_fill_1_87 VPWR VGND sg13cmos5l_fill_1
* cell instance sg13cmos5l_fill_1_88 r0 *1 0,0
Xsg13cmos5l_fill_1_88 VPWR VGND sg13cmos5l_fill_1
* cell instance sg13cmos5l_fill_1_89 r0 *1 0,0
Xsg13cmos5l_fill_1_89 VPWR VGND sg13cmos5l_fill_1
* cell instance sg13cmos5l_fill_1_90 r0 *1 0,0
Xsg13cmos5l_fill_1_90 VPWR VGND sg13cmos5l_fill_1
* cell instance sg13cmos5l_fill_1_91 r0 *1 0,0
Xsg13cmos5l_fill_1_91 VPWR VGND sg13cmos5l_fill_1
* cell instance sg13cmos5l_fill_1_92 r0 *1 0,0
Xsg13cmos5l_fill_1_92 VPWR VGND sg13cmos5l_fill_1
* cell instance sg13cmos5l_fill_1_93 r0 *1 0,0
Xsg13cmos5l_fill_1_93 VPWR VGND sg13cmos5l_fill_1
* cell instance sg13cmos5l_fill_1_94 r0 *1 0,0
Xsg13cmos5l_fill_1_94 VPWR VGND sg13cmos5l_fill_1
* cell instance sg13cmos5l_fill_1_95 r0 *1 0,0
Xsg13cmos5l_fill_1_95 VPWR VGND sg13cmos5l_fill_1
* cell instance sg13cmos5l_fill_1_96 r0 *1 0,0
Xsg13cmos5l_fill_1_96 VPWR VGND sg13cmos5l_fill_1
* cell instance sg13cmos5l_fill_1_97 r0 *1 0,0
Xsg13cmos5l_fill_1_97 VPWR VGND sg13cmos5l_fill_1
* cell instance sg13cmos5l_fill_1_98 r0 *1 0,0
Xsg13cmos5l_fill_1_98 VPWR VGND sg13cmos5l_fill_1
* cell instance sg13cmos5l_fill_1_99 r0 *1 0,0
Xsg13cmos5l_fill_1_99 VPWR VGND sg13cmos5l_fill_1
* cell instance sg13cmos5l_fill_1_100 r0 *1 0,0
Xsg13cmos5l_fill_1_100 VPWR VGND sg13cmos5l_fill_1
* cell instance sg13cmos5l_fill_1_101 r0 *1 0,0
Xsg13cmos5l_fill_1_101 VPWR VGND sg13cmos5l_fill_1
* cell instance sg13cmos5l_fill_1_102 r0 *1 0,0
Xsg13cmos5l_fill_1_102 VPWR VGND sg13cmos5l_fill_1
* cell instance sg13cmos5l_fill_1_103 r0 *1 0,0
Xsg13cmos5l_fill_1_103 VPWR VGND sg13cmos5l_fill_1
* cell instance sg13cmos5l_fill_1_104 r0 *1 0,0
Xsg13cmos5l_fill_1_104 VPWR VGND sg13cmos5l_fill_1
* cell instance sg13cmos5l_fill_1_105 r0 *1 0,0
Xsg13cmos5l_fill_1_105 VPWR VGND sg13cmos5l_fill_1
* cell instance sg13cmos5l_fill_1_106 r0 *1 0,0
Xsg13cmos5l_fill_1_106 VPWR VGND sg13cmos5l_fill_1
* cell instance sg13cmos5l_fill_1_107 r0 *1 0,0
Xsg13cmos5l_fill_1_107 VPWR VGND sg13cmos5l_fill_1
* cell instance sg13cmos5l_fill_1_108 r0 *1 0,0
Xsg13cmos5l_fill_1_108 VPWR VGND sg13cmos5l_fill_1
* cell instance sg13cmos5l_fill_1_109 r0 *1 0,0
Xsg13cmos5l_fill_1_109 VPWR VGND sg13cmos5l_fill_1
* cell instance sg13cmos5l_fill_1_110 r0 *1 0,0
Xsg13cmos5l_fill_1_110 VPWR VGND sg13cmos5l_fill_1
* cell instance sg13cmos5l_fill_1_111 r0 *1 0,0
Xsg13cmos5l_fill_1_111 VPWR VGND sg13cmos5l_fill_1
* cell instance sg13cmos5l_fill_1_112 r0 *1 0,0
Xsg13cmos5l_fill_1_112 VPWR VGND sg13cmos5l_fill_1
* cell instance sg13cmos5l_fill_1_113 r0 *1 0,0
Xsg13cmos5l_fill_1_113 VPWR VGND sg13cmos5l_fill_1
* cell instance sg13cmos5l_fill_1_114 r0 *1 0,0
Xsg13cmos5l_fill_1_114 VPWR VGND sg13cmos5l_fill_1
* cell instance sg13cmos5l_fill_1_115 r0 *1 0,0
Xsg13cmos5l_fill_1_115 VPWR VGND sg13cmos5l_fill_1
* cell instance sg13cmos5l_fill_1_116 r0 *1 0,0
Xsg13cmos5l_fill_1_116 VPWR VGND sg13cmos5l_fill_1
* cell instance sg13cmos5l_fill_1_117 r0 *1 0,0
Xsg13cmos5l_fill_1_117 VPWR VGND sg13cmos5l_fill_1
* cell instance sg13cmos5l_fill_1_118 r0 *1 0,0
Xsg13cmos5l_fill_1_118 VPWR VGND sg13cmos5l_fill_1
* cell instance sg13cmos5l_fill_1_119 r0 *1 0,0
Xsg13cmos5l_fill_1_119 VPWR VGND sg13cmos5l_fill_1
* cell instance sg13cmos5l_fill_1_120 r0 *1 0,0
Xsg13cmos5l_fill_1_120 VPWR VGND sg13cmos5l_fill_1
* cell instance sg13cmos5l_fill_1_121 r0 *1 0,0
Xsg13cmos5l_fill_1_121 VPWR VGND sg13cmos5l_fill_1
* cell instance sg13cmos5l_fill_1_122 r0 *1 0,0
Xsg13cmos5l_fill_1_122 VPWR VGND sg13cmos5l_fill_1
* cell instance sg13cmos5l_fill_1_123 r0 *1 0,0
Xsg13cmos5l_fill_1_123 VPWR VGND sg13cmos5l_fill_1
* cell instance sg13cmos5l_fill_1_124 r0 *1 0,0
Xsg13cmos5l_fill_1_124 VPWR VGND sg13cmos5l_fill_1
* cell instance sg13cmos5l_fill_1_125 r0 *1 0,0
Xsg13cmos5l_fill_1_125 VPWR VGND sg13cmos5l_fill_1
* cell instance sg13cmos5l_fill_1_126 r0 *1 0,0
Xsg13cmos5l_fill_1_126 VPWR VGND sg13cmos5l_fill_1
* cell instance sg13cmos5l_fill_1_127 r0 *1 0,0
Xsg13cmos5l_fill_1_127 VPWR VGND sg13cmos5l_fill_1
* cell instance sg13cmos5l_fill_1_128 r0 *1 0,0
Xsg13cmos5l_fill_1_128 VPWR VGND sg13cmos5l_fill_1
* cell instance sg13cmos5l_fill_1_129 r0 *1 0,0
Xsg13cmos5l_fill_1_129 VPWR VGND sg13cmos5l_fill_1
* cell instance sg13cmos5l_fill_1_130 r0 *1 0,0
Xsg13cmos5l_fill_1_130 VPWR VGND sg13cmos5l_fill_1
* cell instance sg13cmos5l_fill_1_131 r0 *1 0,0
Xsg13cmos5l_fill_1_131 VPWR VGND sg13cmos5l_fill_1
* cell instance sg13cmos5l_fill_1_132 r0 *1 0,0
Xsg13cmos5l_fill_1_132 VPWR VGND sg13cmos5l_fill_1
* cell instance sg13cmos5l_fill_1_133 r0 *1 0,0
Xsg13cmos5l_fill_1_133 VPWR VGND sg13cmos5l_fill_1
* cell instance sg13cmos5l_fill_1_134 r0 *1 0,0
Xsg13cmos5l_fill_1_134 VPWR VGND sg13cmos5l_fill_1
* cell instance sg13cmos5l_fill_1_135 r0 *1 0,0
Xsg13cmos5l_fill_1_135 VPWR VGND sg13cmos5l_fill_1
* cell instance sg13cmos5l_fill_1_136 r0 *1 0,0
Xsg13cmos5l_fill_1_136 VPWR VGND sg13cmos5l_fill_1
* cell instance sg13cmos5l_fill_1_137 r0 *1 0,0
Xsg13cmos5l_fill_1_137 VPWR VGND sg13cmos5l_fill_1
* cell instance sg13cmos5l_fill_1_138 r0 *1 0,0
Xsg13cmos5l_fill_1_138 VPWR VGND sg13cmos5l_fill_1
* cell instance sg13cmos5l_fill_1_139 r0 *1 0,0
Xsg13cmos5l_fill_1_139 VPWR VGND sg13cmos5l_fill_1
* cell instance sg13cmos5l_fill_1_140 r0 *1 0,0
Xsg13cmos5l_fill_1_140 VPWR VGND sg13cmos5l_fill_1
* cell instance sg13cmos5l_fill_1_141 r0 *1 0,0
Xsg13cmos5l_fill_1_141 VPWR VGND sg13cmos5l_fill_1
* cell instance sg13cmos5l_fill_1_142 r0 *1 0,0
Xsg13cmos5l_fill_1_142 VPWR VGND sg13cmos5l_fill_1
* cell instance sg13cmos5l_fill_1_143 r0 *1 0,0
Xsg13cmos5l_fill_1_143 VPWR VGND sg13cmos5l_fill_1
* cell instance sg13cmos5l_fill_1_144 r0 *1 0,0
Xsg13cmos5l_fill_1_144 VPWR VGND sg13cmos5l_fill_1
* cell instance sg13cmos5l_fill_1_145 r0 *1 0,0
Xsg13cmos5l_fill_1_145 VPWR VGND sg13cmos5l_fill_1
* cell instance sg13cmos5l_fill_1_146 r0 *1 0,0
Xsg13cmos5l_fill_1_146 VPWR VGND sg13cmos5l_fill_1
* cell instance sg13cmos5l_fill_1_147 r0 *1 0,0
Xsg13cmos5l_fill_1_147 VPWR VGND sg13cmos5l_fill_1
* cell instance sg13cmos5l_fill_1_148 r0 *1 0,0
Xsg13cmos5l_fill_1_148 VPWR VGND sg13cmos5l_fill_1
* cell instance sg13cmos5l_fill_1_149 r0 *1 0,0
Xsg13cmos5l_fill_1_149 VPWR VGND sg13cmos5l_fill_1
* cell instance sg13cmos5l_fill_1_150 r0 *1 0,0
Xsg13cmos5l_fill_1_150 VPWR VGND sg13cmos5l_fill_1
* cell instance sg13cmos5l_fill_1_151 r0 *1 0,0
Xsg13cmos5l_fill_1_151 VPWR VGND sg13cmos5l_fill_1
* cell instance sg13cmos5l_fill_1_152 r0 *1 0,0
Xsg13cmos5l_fill_1_152 VPWR VGND sg13cmos5l_fill_1
* cell instance sg13cmos5l_fill_1_153 r0 *1 0,0
Xsg13cmos5l_fill_1_153 VPWR VGND sg13cmos5l_fill_1
* cell instance sg13cmos5l_fill_1_154 r0 *1 0,0
Xsg13cmos5l_fill_1_154 VPWR VGND sg13cmos5l_fill_1
* cell instance sg13cmos5l_fill_1_155 r0 *1 0,0
Xsg13cmos5l_fill_1_155 VPWR VGND sg13cmos5l_fill_1
* cell instance sg13cmos5l_fill_1_156 r0 *1 0,0
Xsg13cmos5l_fill_1_156 VPWR VGND sg13cmos5l_fill_1
* cell instance sg13cmos5l_fill_1_157 r0 *1 0,0
Xsg13cmos5l_fill_1_157 VPWR VGND sg13cmos5l_fill_1
* cell instance sg13cmos5l_fill_1_158 r0 *1 0,0
Xsg13cmos5l_fill_1_158 VPWR VGND sg13cmos5l_fill_1
* cell instance sg13cmos5l_fill_1_159 r0 *1 0,0
Xsg13cmos5l_fill_1_159 VPWR VGND sg13cmos5l_fill_1
* cell instance sg13cmos5l_fill_1_160 r0 *1 0,0
Xsg13cmos5l_fill_1_160 VPWR VGND sg13cmos5l_fill_1
* cell instance sg13cmos5l_fill_1_161 r0 *1 0,0
Xsg13cmos5l_fill_1_161 VPWR VGND sg13cmos5l_fill_1
* cell instance sg13cmos5l_fill_1_162 r0 *1 0,0
Xsg13cmos5l_fill_1_162 VPWR VGND sg13cmos5l_fill_1
* cell instance sg13cmos5l_fill_1_163 r0 *1 0,0
Xsg13cmos5l_fill_1_163 VPWR VGND sg13cmos5l_fill_1
* cell instance sg13cmos5l_fill_1_164 r0 *1 0,0
Xsg13cmos5l_fill_1_164 VPWR VGND sg13cmos5l_fill_1
* cell instance sg13cmos5l_fill_1_165 r0 *1 0,0
Xsg13cmos5l_fill_1_165 VPWR VGND sg13cmos5l_fill_1
* cell instance sg13cmos5l_fill_1_166 r0 *1 0,0
Xsg13cmos5l_fill_1_166 VPWR VGND sg13cmos5l_fill_1
* cell instance sg13cmos5l_fill_1_167 r0 *1 0,0
Xsg13cmos5l_fill_1_167 VPWR VGND sg13cmos5l_fill_1
* cell instance sg13cmos5l_fill_1_168 r0 *1 0,0
Xsg13cmos5l_fill_1_168 VPWR VGND sg13cmos5l_fill_1
* cell instance sg13cmos5l_fill_1_169 r0 *1 0,0
Xsg13cmos5l_fill_1_169 VPWR VGND sg13cmos5l_fill_1
* cell instance sg13cmos5l_fill_1_170 r0 *1 0,0
Xsg13cmos5l_fill_1_170 VPWR VGND sg13cmos5l_fill_1
* cell instance sg13cmos5l_fill_1_171 r0 *1 0,0
Xsg13cmos5l_fill_1_171 VPWR VGND sg13cmos5l_fill_1
* cell instance sg13cmos5l_fill_1_172 r0 *1 0,0
Xsg13cmos5l_fill_1_172 VPWR VGND sg13cmos5l_fill_1
* cell instance sg13cmos5l_fill_1_173 r0 *1 0,0
Xsg13cmos5l_fill_1_173 VPWR VGND sg13cmos5l_fill_1
* cell instance sg13cmos5l_fill_1_174 r0 *1 0,0
Xsg13cmos5l_fill_1_174 VPWR VGND sg13cmos5l_fill_1
* cell instance sg13cmos5l_fill_1_175 r0 *1 0,0
Xsg13cmos5l_fill_1_175 VPWR VGND sg13cmos5l_fill_1
* cell instance sg13cmos5l_fill_1_176 r0 *1 0,0
Xsg13cmos5l_fill_1_176 VPWR VGND sg13cmos5l_fill_1
* cell instance sg13cmos5l_fill_1_177 r0 *1 0,0
Xsg13cmos5l_fill_1_177 VPWR VGND sg13cmos5l_fill_1
* cell instance sg13cmos5l_fill_1_178 r0 *1 0,0
Xsg13cmos5l_fill_1_178 VPWR VGND sg13cmos5l_fill_1
* cell instance sg13cmos5l_fill_1_179 r0 *1 0,0
Xsg13cmos5l_fill_1_179 VPWR VGND sg13cmos5l_fill_1
* cell instance sg13cmos5l_fill_1_180 r0 *1 0,0
Xsg13cmos5l_fill_1_180 VPWR VGND sg13cmos5l_fill_1
* cell instance sg13cmos5l_fill_1_181 r0 *1 0,0
Xsg13cmos5l_fill_1_181 VPWR VGND sg13cmos5l_fill_1
* cell instance sg13cmos5l_fill_1_182 r0 *1 0,0
Xsg13cmos5l_fill_1_182 VPWR VGND sg13cmos5l_fill_1
* cell instance sg13cmos5l_fill_1_183 r0 *1 0,0
Xsg13cmos5l_fill_1_183 VPWR VGND sg13cmos5l_fill_1
* cell instance sg13cmos5l_fill_1_184 r0 *1 0,0
Xsg13cmos5l_fill_1_184 VPWR VGND sg13cmos5l_fill_1
* cell instance sg13cmos5l_fill_1_185 r0 *1 0,0
Xsg13cmos5l_fill_1_185 VPWR VGND sg13cmos5l_fill_1
* cell instance sg13cmos5l_fill_1_186 r0 *1 0,0
Xsg13cmos5l_fill_1_186 VPWR VGND sg13cmos5l_fill_1
* cell instance sg13cmos5l_fill_1_187 r0 *1 0,0
Xsg13cmos5l_fill_1_187 VPWR VGND sg13cmos5l_fill_1
* cell instance sg13cmos5l_fill_1_188 r0 *1 0,0
Xsg13cmos5l_fill_1_188 VPWR VGND sg13cmos5l_fill_1
* cell instance sg13cmos5l_fill_1_189 r0 *1 0,0
Xsg13cmos5l_fill_1_189 VPWR VGND sg13cmos5l_fill_1
* cell instance sg13cmos5l_fill_1_190 r0 *1 0,0
Xsg13cmos5l_fill_1_190 VPWR VGND sg13cmos5l_fill_1
* cell instance sg13cmos5l_fill_1_191 r0 *1 0,0
Xsg13cmos5l_fill_1_191 VPWR VGND sg13cmos5l_fill_1
* cell instance sg13cmos5l_fill_1_192 r0 *1 0,0
Xsg13cmos5l_fill_1_192 VPWR VGND sg13cmos5l_fill_1
* cell instance sg13cmos5l_fill_1_193 r0 *1 0,0
Xsg13cmos5l_fill_1_193 VPWR VGND sg13cmos5l_fill_1
* cell instance sg13cmos5l_fill_1_194 r0 *1 0,0
Xsg13cmos5l_fill_1_194 VPWR VGND sg13cmos5l_fill_1
* cell instance sg13cmos5l_fill_1_195 r0 *1 0,0
Xsg13cmos5l_fill_1_195 VPWR VGND sg13cmos5l_fill_1
* cell instance sg13cmos5l_fill_1_196 r0 *1 0,0
Xsg13cmos5l_fill_1_196 VPWR VGND sg13cmos5l_fill_1
* cell instance sg13cmos5l_fill_1_197 r0 *1 0,0
Xsg13cmos5l_fill_1_197 VPWR VGND sg13cmos5l_fill_1
* cell instance sg13cmos5l_fill_1_198 r0 *1 0,0
Xsg13cmos5l_fill_1_198 VPWR VGND sg13cmos5l_fill_1
* cell instance sg13cmos5l_fill_1_199 r0 *1 0,0
Xsg13cmos5l_fill_1_199 VPWR VGND sg13cmos5l_fill_1
* cell instance sg13cmos5l_fill_1_200 r0 *1 0,0
Xsg13cmos5l_fill_1_200 VPWR VGND sg13cmos5l_fill_1
* cell instance sg13cmos5l_fill_1_201 r0 *1 0,0
Xsg13cmos5l_fill_1_201 VPWR VGND sg13cmos5l_fill_1
* cell instance sg13cmos5l_fill_1_202 r0 *1 0,0
Xsg13cmos5l_fill_1_202 VPWR VGND sg13cmos5l_fill_1
* cell instance sg13cmos5l_fill_1_203 r0 *1 0,0
Xsg13cmos5l_fill_1_203 VPWR VGND sg13cmos5l_fill_1
* cell instance sg13cmos5l_fill_1_204 r0 *1 0,0
Xsg13cmos5l_fill_1_204 VPWR VGND sg13cmos5l_fill_1
* cell instance sg13cmos5l_fill_1_205 r0 *1 0,0
Xsg13cmos5l_fill_1_205 VPWR VGND sg13cmos5l_fill_1
* cell instance sg13cmos5l_fill_1_206 r0 *1 0,0
Xsg13cmos5l_fill_1_206 VPWR VGND sg13cmos5l_fill_1
* cell instance sg13cmos5l_fill_1_207 r0 *1 0,0
Xsg13cmos5l_fill_1_207 VPWR VGND sg13cmos5l_fill_1
* cell instance sg13cmos5l_fill_1_208 r0 *1 0,0
Xsg13cmos5l_fill_1_208 VPWR VGND sg13cmos5l_fill_1
* cell instance sg13cmos5l_fill_1_209 r0 *1 0,0
Xsg13cmos5l_fill_1_209 VPWR VGND sg13cmos5l_fill_1
* cell instance sg13cmos5l_fill_1_210 r0 *1 0,0
Xsg13cmos5l_fill_1_210 VPWR VGND sg13cmos5l_fill_1
* cell instance sg13cmos5l_fill_1_211 r0 *1 0,0
Xsg13cmos5l_fill_1_211 VPWR VGND sg13cmos5l_fill_1
* cell instance sg13cmos5l_fill_1_212 r0 *1 0,0
Xsg13cmos5l_fill_1_212 VPWR VGND sg13cmos5l_fill_1
* cell instance sg13cmos5l_fill_1_213 r0 *1 0,0
Xsg13cmos5l_fill_1_213 VPWR VGND sg13cmos5l_fill_1
* cell instance sg13cmos5l_fill_1_214 r0 *1 0,0
Xsg13cmos5l_fill_1_214 VPWR VGND sg13cmos5l_fill_1
* cell instance sg13cmos5l_fill_1_215 r0 *1 0,0
Xsg13cmos5l_fill_1_215 VPWR VGND sg13cmos5l_fill_1
* cell instance sg13cmos5l_fill_1_216 r0 *1 0,0
Xsg13cmos5l_fill_1_216 VPWR VGND sg13cmos5l_fill_1
* cell instance sg13cmos5l_fill_1_217 r0 *1 0,0
Xsg13cmos5l_fill_1_217 VPWR VGND sg13cmos5l_fill_1
* cell instance sg13cmos5l_fill_1_218 r0 *1 0,0
Xsg13cmos5l_fill_1_218 VPWR VGND sg13cmos5l_fill_1
* cell instance sg13cmos5l_fill_1_219 r0 *1 0,0
Xsg13cmos5l_fill_1_219 VPWR VGND sg13cmos5l_fill_1
* cell instance sg13cmos5l_fill_1_220 r0 *1 0,0
Xsg13cmos5l_fill_1_220 VPWR VGND sg13cmos5l_fill_1
* cell instance sg13cmos5l_fill_1_221 r0 *1 0,0
Xsg13cmos5l_fill_1_221 VPWR VGND sg13cmos5l_fill_1
* cell instance sg13cmos5l_fill_1_222 r0 *1 0,0
Xsg13cmos5l_fill_1_222 VPWR VGND sg13cmos5l_fill_1
* cell instance sg13cmos5l_fill_1_223 r0 *1 0,0
Xsg13cmos5l_fill_1_223 VPWR VGND sg13cmos5l_fill_1
* cell instance sg13cmos5l_fill_1_224 r0 *1 0,0
Xsg13cmos5l_fill_1_224 VPWR VGND sg13cmos5l_fill_1
* cell instance sg13cmos5l_fill_1_225 r0 *1 0,0
Xsg13cmos5l_fill_1_225 VPWR VGND sg13cmos5l_fill_1
* cell instance sg13cmos5l_fill_1_226 r0 *1 0,0
Xsg13cmos5l_fill_1_226 VPWR VGND sg13cmos5l_fill_1
* cell instance sg13cmos5l_fill_1_227 r0 *1 0,0
Xsg13cmos5l_fill_1_227 VPWR VGND sg13cmos5l_fill_1
* cell instance sg13cmos5l_fill_1_228 r0 *1 0,0
Xsg13cmos5l_fill_1_228 VPWR VGND sg13cmos5l_fill_1
* cell instance sg13cmos5l_fill_1_229 r0 *1 0,0
Xsg13cmos5l_fill_1_229 VPWR VGND sg13cmos5l_fill_1
* cell instance sg13cmos5l_fill_1_230 r0 *1 0,0
Xsg13cmos5l_fill_1_230 VPWR VGND sg13cmos5l_fill_1
* cell instance sg13cmos5l_fill_1_231 r0 *1 0,0
Xsg13cmos5l_fill_1_231 VPWR VGND sg13cmos5l_fill_1
* cell instance sg13cmos5l_fill_1_232 r0 *1 0,0
Xsg13cmos5l_fill_1_232 VPWR VGND sg13cmos5l_fill_1
* cell instance sg13cmos5l_fill_1_233 r0 *1 0,0
Xsg13cmos5l_fill_1_233 VPWR VGND sg13cmos5l_fill_1
* cell instance sg13cmos5l_fill_1_234 r0 *1 0,0
Xsg13cmos5l_fill_1_234 VPWR VGND sg13cmos5l_fill_1
* cell instance sg13cmos5l_fill_1_235 r0 *1 0,0
Xsg13cmos5l_fill_1_235 VPWR VGND sg13cmos5l_fill_1
* cell instance sg13cmos5l_fill_1_236 r0 *1 0,0
Xsg13cmos5l_fill_1_236 VPWR VGND sg13cmos5l_fill_1
* cell instance sg13cmos5l_fill_1_237 r0 *1 0,0
Xsg13cmos5l_fill_1_237 VPWR VGND sg13cmos5l_fill_1
* cell instance sg13cmos5l_fill_1_238 r0 *1 0,0
Xsg13cmos5l_fill_1_238 VPWR VGND sg13cmos5l_fill_1
* cell instance sg13cmos5l_fill_1_239 r0 *1 0,0
Xsg13cmos5l_fill_1_239 VPWR VGND sg13cmos5l_fill_1
* cell instance sg13cmos5l_fill_1_240 r0 *1 0,0
Xsg13cmos5l_fill_1_240 VPWR VGND sg13cmos5l_fill_1
* cell instance sg13cmos5l_fill_1_241 r0 *1 0,0
Xsg13cmos5l_fill_1_241 VPWR VGND sg13cmos5l_fill_1
* cell instance sg13cmos5l_fill_1_242 r0 *1 0,0
Xsg13cmos5l_fill_1_242 VPWR VGND sg13cmos5l_fill_1
* cell instance sg13cmos5l_fill_1_243 r0 *1 0,0
Xsg13cmos5l_fill_1_243 VPWR VGND sg13cmos5l_fill_1
* cell instance sg13cmos5l_fill_1_244 r0 *1 0,0
Xsg13cmos5l_fill_1_244 VPWR VGND sg13cmos5l_fill_1
* cell instance sg13cmos5l_fill_1_245 r0 *1 0,0
Xsg13cmos5l_fill_1_245 VPWR VGND sg13cmos5l_fill_1
* cell instance sg13cmos5l_fill_1_246 r0 *1 0,0
Xsg13cmos5l_fill_1_246 VPWR VGND sg13cmos5l_fill_1
* cell instance sg13cmos5l_fill_1_247 r0 *1 0,0
Xsg13cmos5l_fill_1_247 VPWR VGND sg13cmos5l_fill_1
* cell instance sg13cmos5l_fill_1_248 r0 *1 0,0
Xsg13cmos5l_fill_1_248 VPWR VGND sg13cmos5l_fill_1
* cell instance sg13cmos5l_fill_1_249 r0 *1 0,0
Xsg13cmos5l_fill_1_249 VPWR VGND sg13cmos5l_fill_1
* cell instance sg13cmos5l_fill_1_250 r0 *1 0,0
Xsg13cmos5l_fill_1_250 VPWR VGND sg13cmos5l_fill_1
* cell instance sg13cmos5l_fill_1_251 r0 *1 0,0
Xsg13cmos5l_fill_1_251 VPWR VGND sg13cmos5l_fill_1
* cell instance sg13cmos5l_fill_1_252 r0 *1 0,0
Xsg13cmos5l_fill_1_252 VPWR VGND sg13cmos5l_fill_1
* cell instance sg13cmos5l_fill_1_253 r0 *1 0,0
Xsg13cmos5l_fill_1_253 VPWR VGND sg13cmos5l_fill_1
* cell instance sg13cmos5l_fill_1_254 r0 *1 0,0
Xsg13cmos5l_fill_1_254 VPWR VGND sg13cmos5l_fill_1
* cell instance sg13cmos5l_fill_1_255 r0 *1 0,0
Xsg13cmos5l_fill_1_255 VPWR VGND sg13cmos5l_fill_1
* cell instance sg13cmos5l_fill_1_256 r0 *1 0,0
Xsg13cmos5l_fill_1_256 VPWR VGND sg13cmos5l_fill_1
* cell instance sg13cmos5l_fill_1_257 r0 *1 0,0
Xsg13cmos5l_fill_1_257 VPWR VGND sg13cmos5l_fill_1
* cell instance sg13cmos5l_fill_1_258 r0 *1 0,0
Xsg13cmos5l_fill_1_258 VPWR VGND sg13cmos5l_fill_1
* cell instance sg13cmos5l_fill_1_259 r0 *1 0,0
Xsg13cmos5l_fill_1_259 VPWR VGND sg13cmos5l_fill_1
* cell instance sg13cmos5l_fill_1_260 r0 *1 0,0
Xsg13cmos5l_fill_1_260 VPWR VGND sg13cmos5l_fill_1
* cell instance sg13cmos5l_fill_1_261 r0 *1 0,0
Xsg13cmos5l_fill_1_261 VPWR VGND sg13cmos5l_fill_1
* cell instance sg13cmos5l_fill_1_262 r0 *1 0,0
Xsg13cmos5l_fill_1_262 VPWR VGND sg13cmos5l_fill_1
* cell instance sg13cmos5l_fill_1_263 r0 *1 0,0
Xsg13cmos5l_fill_1_263 VPWR VGND sg13cmos5l_fill_1
* cell instance sg13cmos5l_fill_1_264 r0 *1 0,0
Xsg13cmos5l_fill_1_264 VPWR VGND sg13cmos5l_fill_1
* cell instance sg13cmos5l_fill_1_265 r0 *1 0,0
Xsg13cmos5l_fill_1_265 VPWR VGND sg13cmos5l_fill_1
* cell instance sg13cmos5l_fill_1_266 r0 *1 0,0
Xsg13cmos5l_fill_1_266 VPWR VGND sg13cmos5l_fill_1
* cell instance sg13cmos5l_fill_1_267 r0 *1 0,0
Xsg13cmos5l_fill_1_267 VPWR VGND sg13cmos5l_fill_1
* cell instance sg13cmos5l_fill_1_268 r0 *1 0,0
Xsg13cmos5l_fill_1_268 VPWR VGND sg13cmos5l_fill_1
* cell instance sg13cmos5l_fill_1_269 r0 *1 0,0
Xsg13cmos5l_fill_1_269 VPWR VGND sg13cmos5l_fill_1
* cell instance sg13cmos5l_fill_1_270 r0 *1 0,0
Xsg13cmos5l_fill_1_270 VPWR VGND sg13cmos5l_fill_1
* cell instance sg13cmos5l_fill_1_271 r0 *1 0,0
Xsg13cmos5l_fill_1_271 VPWR VGND sg13cmos5l_fill_1
* cell instance sg13cmos5l_fill_1_272 r0 *1 0,0
Xsg13cmos5l_fill_1_272 VPWR VGND sg13cmos5l_fill_1
* cell instance sg13cmos5l_fill_1_273 r0 *1 0,0
Xsg13cmos5l_fill_1_273 VPWR VGND sg13cmos5l_fill_1
* cell instance sg13cmos5l_fill_1_274 r0 *1 0,0
Xsg13cmos5l_fill_1_274 VPWR VGND sg13cmos5l_fill_1
* cell instance sg13cmos5l_fill_1_275 r0 *1 0,0
Xsg13cmos5l_fill_1_275 VPWR VGND sg13cmos5l_fill_1
* cell instance sg13cmos5l_fill_1_276 r0 *1 0,0
Xsg13cmos5l_fill_1_276 VPWR VGND sg13cmos5l_fill_1
* cell instance sg13cmos5l_fill_1_277 r0 *1 0,0
Xsg13cmos5l_fill_1_277 VPWR VGND sg13cmos5l_fill_1
* cell instance sg13cmos5l_fill_1_278 r0 *1 0,0
Xsg13cmos5l_fill_1_278 VPWR VGND sg13cmos5l_fill_1
* cell instance sg13cmos5l_fill_1_279 r0 *1 0,0
Xsg13cmos5l_fill_1_279 VPWR VGND sg13cmos5l_fill_1
* cell instance sg13cmos5l_fill_1_280 r0 *1 0,0
Xsg13cmos5l_fill_1_280 VPWR VGND sg13cmos5l_fill_1
* cell instance sg13cmos5l_fill_1_281 r0 *1 0,0
Xsg13cmos5l_fill_1_281 VPWR VGND sg13cmos5l_fill_1
* cell instance sg13cmos5l_fill_1_282 r0 *1 0,0
Xsg13cmos5l_fill_1_282 VPWR VGND sg13cmos5l_fill_1
* cell instance sg13cmos5l_fill_1_283 r0 *1 0,0
Xsg13cmos5l_fill_1_283 VPWR VGND sg13cmos5l_fill_1
* cell instance sg13cmos5l_fill_1_284 r0 *1 0,0
Xsg13cmos5l_fill_1_284 VPWR VGND sg13cmos5l_fill_1
* cell instance sg13cmos5l_fill_1_285 r0 *1 0,0
Xsg13cmos5l_fill_1_285 VPWR VGND sg13cmos5l_fill_1
* cell instance sg13cmos5l_fill_1_286 r0 *1 0,0
Xsg13cmos5l_fill_1_286 VPWR VGND sg13cmos5l_fill_1
* cell instance sg13cmos5l_fill_1_287 r0 *1 0,0
Xsg13cmos5l_fill_1_287 VPWR VGND sg13cmos5l_fill_1
* cell instance sg13cmos5l_fill_1_288 r0 *1 0,0
Xsg13cmos5l_fill_1_288 VPWR VGND sg13cmos5l_fill_1
* cell instance sg13cmos5l_fill_1_289 r0 *1 0,0
Xsg13cmos5l_fill_1_289 VPWR VGND sg13cmos5l_fill_1
* cell instance sg13cmos5l_fill_1_290 r0 *1 0,0
Xsg13cmos5l_fill_1_290 VPWR VGND sg13cmos5l_fill_1
* cell instance sg13cmos5l_fill_1_291 r0 *1 0,0
Xsg13cmos5l_fill_1_291 VPWR VGND sg13cmos5l_fill_1
* cell instance sg13cmos5l_fill_1_292 r0 *1 0,0
Xsg13cmos5l_fill_1_292 VPWR VGND sg13cmos5l_fill_1
* cell instance sg13cmos5l_fill_1_293 r0 *1 0,0
Xsg13cmos5l_fill_1_293 VPWR VGND sg13cmos5l_fill_1
* cell instance sg13cmos5l_fill_1_294 r0 *1 0,0
Xsg13cmos5l_fill_1_294 VPWR VGND sg13cmos5l_fill_1
* cell instance sg13cmos5l_fill_1_295 r0 *1 0,0
Xsg13cmos5l_fill_1_295 VPWR VGND sg13cmos5l_fill_1
* cell instance sg13cmos5l_fill_1_296 r0 *1 0,0
Xsg13cmos5l_fill_1_296 VPWR VGND sg13cmos5l_fill_1
* cell instance sg13cmos5l_fill_1_297 r0 *1 0,0
Xsg13cmos5l_fill_1_297 VPWR VGND sg13cmos5l_fill_1
* cell instance sg13cmos5l_fill_1_298 r0 *1 0,0
Xsg13cmos5l_fill_1_298 VPWR VGND sg13cmos5l_fill_1
* cell instance sg13cmos5l_fill_1_299 r0 *1 0,0
Xsg13cmos5l_fill_1_299 VPWR VGND sg13cmos5l_fill_1
* cell instance sg13cmos5l_fill_1_300 r0 *1 0,0
Xsg13cmos5l_fill_1_300 VPWR VGND sg13cmos5l_fill_1
* cell instance sg13cmos5l_fill_1_301 r0 *1 0,0
Xsg13cmos5l_fill_1_301 VPWR VGND sg13cmos5l_fill_1
* cell instance sg13cmos5l_fill_1_302 r0 *1 0,0
Xsg13cmos5l_fill_1_302 VPWR VGND sg13cmos5l_fill_1
* cell instance sg13cmos5l_fill_1_303 r0 *1 0,0
Xsg13cmos5l_fill_1_303 VPWR VGND sg13cmos5l_fill_1
* cell instance sg13cmos5l_fill_1_304 r0 *1 0,0
Xsg13cmos5l_fill_1_304 VPWR VGND sg13cmos5l_fill_1
* cell instance sg13cmos5l_fill_1_305 r0 *1 0,0
Xsg13cmos5l_fill_1_305 VPWR VGND sg13cmos5l_fill_1
* cell instance sg13cmos5l_fill_1_306 r0 *1 0,0
Xsg13cmos5l_fill_1_306 VPWR VGND sg13cmos5l_fill_1
* cell instance sg13cmos5l_fill_1_307 r0 *1 0,0
Xsg13cmos5l_fill_1_307 VPWR VGND sg13cmos5l_fill_1
* cell instance sg13cmos5l_fill_1_308 r0 *1 0,0
Xsg13cmos5l_fill_1_308 VPWR VGND sg13cmos5l_fill_1
* cell instance sg13cmos5l_fill_1_309 r0 *1 0,0
Xsg13cmos5l_fill_1_309 VPWR VGND sg13cmos5l_fill_1
* cell instance sg13cmos5l_fill_1_310 r0 *1 0,0
Xsg13cmos5l_fill_1_310 VPWR VGND sg13cmos5l_fill_1
* cell instance sg13cmos5l_fill_1_311 r0 *1 0,0
Xsg13cmos5l_fill_1_311 VPWR VGND sg13cmos5l_fill_1
* cell instance sg13cmos5l_fill_1_312 r0 *1 0,0
Xsg13cmos5l_fill_1_312 VPWR VGND sg13cmos5l_fill_1
* cell instance sg13cmos5l_fill_1_313 r0 *1 0,0
Xsg13cmos5l_fill_1_313 VPWR VGND sg13cmos5l_fill_1
* cell instance sg13cmos5l_fill_1_314 r0 *1 0,0
Xsg13cmos5l_fill_1_314 VPWR VGND sg13cmos5l_fill_1
* cell instance sg13cmos5l_fill_1_315 r0 *1 0,0
Xsg13cmos5l_fill_1_315 VPWR VGND sg13cmos5l_fill_1
* cell instance sg13cmos5l_fill_1_316 r0 *1 0,0
Xsg13cmos5l_fill_1_316 VPWR VGND sg13cmos5l_fill_1
* cell instance sg13cmos5l_fill_1_317 r0 *1 0,0
Xsg13cmos5l_fill_1_317 VPWR VGND sg13cmos5l_fill_1
* cell instance sg13cmos5l_fill_1_318 r0 *1 0,0
Xsg13cmos5l_fill_1_318 VPWR VGND sg13cmos5l_fill_1
* cell instance sg13cmos5l_fill_1_319 r0 *1 0,0
Xsg13cmos5l_fill_1_319 VPWR VGND sg13cmos5l_fill_1
* cell instance sg13cmos5l_fill_1_320 r0 *1 0,0
Xsg13cmos5l_fill_1_320 VPWR VGND sg13cmos5l_fill_1
* cell instance sg13cmos5l_fill_1_321 r0 *1 0,0
Xsg13cmos5l_fill_1_321 VPWR VGND sg13cmos5l_fill_1
* cell instance sg13cmos5l_fill_1_322 r0 *1 0,0
Xsg13cmos5l_fill_1_322 VPWR VGND sg13cmos5l_fill_1
* cell instance sg13cmos5l_fill_1_323 r0 *1 0,0
Xsg13cmos5l_fill_1_323 VPWR VGND sg13cmos5l_fill_1
* cell instance sg13cmos5l_fill_1_324 r0 *1 0,0
Xsg13cmos5l_fill_1_324 VPWR VGND sg13cmos5l_fill_1
* cell instance sg13cmos5l_fill_1_325 r0 *1 0,0
Xsg13cmos5l_fill_1_325 VPWR VGND sg13cmos5l_fill_1
* cell instance sg13cmos5l_fill_1_326 r0 *1 0,0
Xsg13cmos5l_fill_1_326 VPWR VGND sg13cmos5l_fill_1
* cell instance sg13cmos5l_fill_1_327 r0 *1 0,0
Xsg13cmos5l_fill_1_327 VPWR VGND sg13cmos5l_fill_1
* cell instance sg13cmos5l_fill_1_328 r0 *1 0,0
Xsg13cmos5l_fill_1_328 VPWR VGND sg13cmos5l_fill_1
* cell instance sg13cmos5l_fill_1_329 r0 *1 0,0
Xsg13cmos5l_fill_1_329 VPWR VGND sg13cmos5l_fill_1
* cell instance sg13cmos5l_fill_1_330 r0 *1 0,0
Xsg13cmos5l_fill_1_330 VPWR VGND sg13cmos5l_fill_1
* cell instance sg13cmos5l_fill_1_331 r0 *1 0,0
Xsg13cmos5l_fill_1_331 VPWR VGND sg13cmos5l_fill_1
* cell instance sg13cmos5l_fill_1_332 r0 *1 0,0
Xsg13cmos5l_fill_1_332 VPWR VGND sg13cmos5l_fill_1
* cell instance sg13cmos5l_fill_1_333 r0 *1 0,0
Xsg13cmos5l_fill_1_333 VPWR VGND sg13cmos5l_fill_1
* cell instance sg13cmos5l_fill_1_334 r0 *1 0,0
Xsg13cmos5l_fill_1_334 VPWR VGND sg13cmos5l_fill_1
* cell instance sg13cmos5l_fill_1_335 r0 *1 0,0
Xsg13cmos5l_fill_1_335 VPWR VGND sg13cmos5l_fill_1
* cell instance sg13cmos5l_fill_1_336 r0 *1 0,0
Xsg13cmos5l_fill_1_336 VPWR VGND sg13cmos5l_fill_1
* cell instance sg13cmos5l_fill_1_337 r0 *1 0,0
Xsg13cmos5l_fill_1_337 VPWR VGND sg13cmos5l_fill_1
* cell instance sg13cmos5l_fill_1_338 r0 *1 0,0
Xsg13cmos5l_fill_1_338 VPWR VGND sg13cmos5l_fill_1
* cell instance sg13cmos5l_fill_1_339 r0 *1 0,0
Xsg13cmos5l_fill_1_339 VPWR VGND sg13cmos5l_fill_1
* cell instance sg13cmos5l_fill_1_340 r0 *1 0,0
Xsg13cmos5l_fill_1_340 VPWR VGND sg13cmos5l_fill_1
* cell instance sg13cmos5l_fill_1_341 r0 *1 0,0
Xsg13cmos5l_fill_1_341 VPWR VGND sg13cmos5l_fill_1
* cell instance sg13cmos5l_fill_1_342 r0 *1 0,0
Xsg13cmos5l_fill_1_342 VPWR VGND sg13cmos5l_fill_1
* cell instance sg13cmos5l_fill_1_343 r0 *1 0,0
Xsg13cmos5l_fill_1_343 VPWR VGND sg13cmos5l_fill_1
* cell instance sg13cmos5l_fill_1_344 r0 *1 0,0
Xsg13cmos5l_fill_1_344 VPWR VGND sg13cmos5l_fill_1
* cell instance sg13cmos5l_fill_1_345 r0 *1 0,0
Xsg13cmos5l_fill_1_345 VPWR VGND sg13cmos5l_fill_1
* cell instance sg13cmos5l_fill_1_346 r0 *1 0,0
Xsg13cmos5l_fill_1_346 VPWR VGND sg13cmos5l_fill_1
* cell instance sg13cmos5l_fill_1_347 r0 *1 0,0
Xsg13cmos5l_fill_1_347 VPWR VGND sg13cmos5l_fill_1
* cell instance sg13cmos5l_fill_1_348 r0 *1 0,0
Xsg13cmos5l_fill_1_348 VPWR VGND sg13cmos5l_fill_1
* cell instance sg13cmos5l_fill_1_349 r0 *1 0,0
Xsg13cmos5l_fill_1_349 VPWR VGND sg13cmos5l_fill_1
* cell instance sg13cmos5l_fill_1_350 r0 *1 0,0
Xsg13cmos5l_fill_1_350 VPWR VGND sg13cmos5l_fill_1
* cell instance sg13cmos5l_fill_1_351 r0 *1 0,0
Xsg13cmos5l_fill_1_351 VPWR VGND sg13cmos5l_fill_1
* cell instance sg13cmos5l_fill_1_352 r0 *1 0,0
Xsg13cmos5l_fill_1_352 VPWR VGND sg13cmos5l_fill_1
* cell instance sg13cmos5l_fill_1_353 r0 *1 0,0
Xsg13cmos5l_fill_1_353 VPWR VGND sg13cmos5l_fill_1
* cell instance sg13cmos5l_fill_1_354 r0 *1 0,0
Xsg13cmos5l_fill_1_354 VPWR VGND sg13cmos5l_fill_1
* cell instance sg13cmos5l_fill_1_355 r0 *1 0,0
Xsg13cmos5l_fill_1_355 VPWR VGND sg13cmos5l_fill_1
* cell instance sg13cmos5l_fill_1_356 r0 *1 0,0
Xsg13cmos5l_fill_1_356 VPWR VGND sg13cmos5l_fill_1
* cell instance sg13cmos5l_fill_1_357 r0 *1 0,0
Xsg13cmos5l_fill_1_357 VPWR VGND sg13cmos5l_fill_1
* cell instance sg13cmos5l_fill_1_358 r0 *1 0,0
Xsg13cmos5l_fill_1_358 VPWR VGND sg13cmos5l_fill_1
* cell instance sg13cmos5l_fill_1_359 r0 *1 0,0
Xsg13cmos5l_fill_1_359 VPWR VGND sg13cmos5l_fill_1
* cell instance sg13cmos5l_fill_1_360 r0 *1 0,0
Xsg13cmos5l_fill_1_360 VPWR VGND sg13cmos5l_fill_1
* cell instance sg13cmos5l_fill_1_361 r0 *1 0,0
Xsg13cmos5l_fill_1_361 VPWR VGND sg13cmos5l_fill_1
* cell instance sg13cmos5l_fill_1_362 r0 *1 0,0
Xsg13cmos5l_fill_1_362 VPWR VGND sg13cmos5l_fill_1
* cell instance sg13cmos5l_fill_1_363 r0 *1 0,0
Xsg13cmos5l_fill_1_363 VPWR VGND sg13cmos5l_fill_1
* cell instance sg13cmos5l_fill_1_364 r0 *1 0,0
Xsg13cmos5l_fill_1_364 VPWR VGND sg13cmos5l_fill_1
* cell instance sg13cmos5l_fill_1_365 r0 *1 0,0
Xsg13cmos5l_fill_1_365 VPWR VGND sg13cmos5l_fill_1
* cell instance sg13cmos5l_fill_1_366 r0 *1 0,0
Xsg13cmos5l_fill_1_366 VPWR VGND sg13cmos5l_fill_1
* cell instance sg13cmos5l_fill_1_367 r0 *1 0,0
Xsg13cmos5l_fill_1_367 VPWR VGND sg13cmos5l_fill_1
* cell instance sg13cmos5l_fill_1_368 r0 *1 0,0
Xsg13cmos5l_fill_1_368 VPWR VGND sg13cmos5l_fill_1
* cell instance sg13cmos5l_fill_1_369 r0 *1 0,0
Xsg13cmos5l_fill_1_369 VPWR VGND sg13cmos5l_fill_1
* cell instance sg13cmos5l_fill_1_370 r0 *1 0,0
Xsg13cmos5l_fill_1_370 VPWR VGND sg13cmos5l_fill_1
* cell instance sg13cmos5l_fill_1_371 r0 *1 0,0
Xsg13cmos5l_fill_1_371 VPWR VGND sg13cmos5l_fill_1
* cell instance sg13cmos5l_fill_1_372 r0 *1 0,0
Xsg13cmos5l_fill_1_372 VPWR VGND sg13cmos5l_fill_1
* cell instance sg13cmos5l_fill_1_373 r0 *1 0,0
Xsg13cmos5l_fill_1_373 VPWR VGND sg13cmos5l_fill_1
* cell instance sg13cmos5l_fill_1_374 r0 *1 0,0
Xsg13cmos5l_fill_1_374 VPWR VGND sg13cmos5l_fill_1
* cell instance sg13cmos5l_fill_1_375 r0 *1 0,0
Xsg13cmos5l_fill_1_375 VPWR VGND sg13cmos5l_fill_1
* cell instance sg13cmos5l_fill_1_376 r0 *1 0,0
Xsg13cmos5l_fill_1_376 VPWR VGND sg13cmos5l_fill_1
* cell instance sg13cmos5l_fill_1_377 r0 *1 0,0
Xsg13cmos5l_fill_1_377 VPWR VGND sg13cmos5l_fill_1
* cell instance sg13cmos5l_fill_1_378 r0 *1 0,0
Xsg13cmos5l_fill_1_378 VPWR VGND sg13cmos5l_fill_1
* cell instance sg13cmos5l_fill_1_379 r0 *1 0,0
Xsg13cmos5l_fill_1_379 VPWR VGND sg13cmos5l_fill_1
* cell instance sg13cmos5l_fill_1_380 r0 *1 0,0
Xsg13cmos5l_fill_1_380 VPWR VGND sg13cmos5l_fill_1
* cell instance sg13cmos5l_fill_1_381 r0 *1 0,0
Xsg13cmos5l_fill_1_381 VPWR VGND sg13cmos5l_fill_1
* cell instance sg13cmos5l_fill_1_382 r0 *1 0,0
Xsg13cmos5l_fill_1_382 VPWR VGND sg13cmos5l_fill_1
* cell instance sg13cmos5l_fill_1_383 r0 *1 0,0
Xsg13cmos5l_fill_1_383 VPWR VGND sg13cmos5l_fill_1
* cell instance sg13cmos5l_fill_1_384 r0 *1 0,0
Xsg13cmos5l_fill_1_384 VPWR VGND sg13cmos5l_fill_1
* cell instance sg13cmos5l_fill_1_385 r0 *1 0,0
Xsg13cmos5l_fill_1_385 VPWR VGND sg13cmos5l_fill_1
* cell instance sg13cmos5l_fill_1_386 r0 *1 0,0
Xsg13cmos5l_fill_1_386 VPWR VGND sg13cmos5l_fill_1
* cell instance sg13cmos5l_fill_1_387 r0 *1 0,0
Xsg13cmos5l_fill_1_387 VPWR VGND sg13cmos5l_fill_1
* cell instance sg13cmos5l_fill_1_388 r0 *1 0,0
Xsg13cmos5l_fill_1_388 VPWR VGND sg13cmos5l_fill_1
* cell instance sg13cmos5l_fill_1_389 r0 *1 0,0
Xsg13cmos5l_fill_1_389 VPWR VGND sg13cmos5l_fill_1
* cell instance sg13cmos5l_fill_1_390 r0 *1 0,0
Xsg13cmos5l_fill_1_390 VPWR VGND sg13cmos5l_fill_1
* cell instance sg13cmos5l_fill_1_391 r0 *1 0,0
Xsg13cmos5l_fill_1_391 VPWR VGND sg13cmos5l_fill_1
* cell instance sg13cmos5l_fill_1_392 r0 *1 0,0
Xsg13cmos5l_fill_1_392 VPWR VGND sg13cmos5l_fill_1
* cell instance sg13cmos5l_fill_1_393 r0 *1 0,0
Xsg13cmos5l_fill_1_393 VPWR VGND sg13cmos5l_fill_1
* cell instance sg13cmos5l_fill_1_394 r0 *1 0,0
Xsg13cmos5l_fill_1_394 VPWR VGND sg13cmos5l_fill_1
* cell instance sg13cmos5l_fill_1_395 r0 *1 0,0
Xsg13cmos5l_fill_1_395 VPWR VGND sg13cmos5l_fill_1
* cell instance sg13cmos5l_fill_1_396 r0 *1 0,0
Xsg13cmos5l_fill_1_396 VPWR VGND sg13cmos5l_fill_1
* cell instance sg13cmos5l_fill_1_397 r0 *1 0,0
Xsg13cmos5l_fill_1_397 VPWR VGND sg13cmos5l_fill_1
* cell instance sg13cmos5l_fill_1_398 r0 *1 0,0
Xsg13cmos5l_fill_1_398 VPWR VGND sg13cmos5l_fill_1
* cell instance sg13cmos5l_fill_1_399 r0 *1 0,0
Xsg13cmos5l_fill_1_399 VPWR VGND sg13cmos5l_fill_1
* cell instance sg13cmos5l_fill_1_400 r0 *1 0,0
Xsg13cmos5l_fill_1_400 VPWR VGND sg13cmos5l_fill_1
* cell instance sg13cmos5l_fill_1_401 r0 *1 0,0
Xsg13cmos5l_fill_1_401 VPWR VGND sg13cmos5l_fill_1
* cell instance sg13cmos5l_fill_1_402 r0 *1 0,0
Xsg13cmos5l_fill_1_402 VPWR VGND sg13cmos5l_fill_1
* cell instance sg13cmos5l_fill_1_403 r0 *1 0,0
Xsg13cmos5l_fill_1_403 VPWR VGND sg13cmos5l_fill_1
* cell instance sg13cmos5l_fill_1_404 r0 *1 0,0
Xsg13cmos5l_fill_1_404 VPWR VGND sg13cmos5l_fill_1
* cell instance sg13cmos5l_fill_1_405 r0 *1 0,0
Xsg13cmos5l_fill_1_405 VPWR VGND sg13cmos5l_fill_1
* cell instance sg13cmos5l_fill_1_406 r0 *1 0,0
Xsg13cmos5l_fill_1_406 VPWR VGND sg13cmos5l_fill_1
* cell instance sg13cmos5l_fill_1_407 r0 *1 0,0
Xsg13cmos5l_fill_1_407 VPWR VGND sg13cmos5l_fill_1
* cell instance sg13cmos5l_fill_1_408 r0 *1 0,0
Xsg13cmos5l_fill_1_408 VPWR VGND sg13cmos5l_fill_1
* cell instance sg13cmos5l_fill_1_409 r0 *1 0,0
Xsg13cmos5l_fill_1_409 VPWR VGND sg13cmos5l_fill_1
* cell instance sg13cmos5l_fill_1_410 r0 *1 0,0
Xsg13cmos5l_fill_1_410 VPWR VGND sg13cmos5l_fill_1
* cell instance sg13cmos5l_fill_1_411 r0 *1 0,0
Xsg13cmos5l_fill_1_411 VPWR VGND sg13cmos5l_fill_1
* cell instance sg13cmos5l_fill_1_412 r0 *1 0,0
Xsg13cmos5l_fill_1_412 VPWR VGND sg13cmos5l_fill_1
* cell instance sg13cmos5l_fill_1_413 r0 *1 0,0
Xsg13cmos5l_fill_1_413 VPWR VGND sg13cmos5l_fill_1
* cell instance sg13cmos5l_fill_1_414 r0 *1 0,0
Xsg13cmos5l_fill_1_414 VPWR VGND sg13cmos5l_fill_1
* cell instance sg13cmos5l_fill_1_415 r0 *1 0,0
Xsg13cmos5l_fill_1_415 VPWR VGND sg13cmos5l_fill_1
* cell instance sg13cmos5l_fill_1_416 r0 *1 0,0
Xsg13cmos5l_fill_1_416 VPWR VGND sg13cmos5l_fill_1
* cell instance sg13cmos5l_fill_1_417 r0 *1 0,0
Xsg13cmos5l_fill_1_417 VPWR VGND sg13cmos5l_fill_1
* cell instance sg13cmos5l_fill_1_418 r0 *1 0,0
Xsg13cmos5l_fill_1_418 VPWR VGND sg13cmos5l_fill_1
* cell instance sg13cmos5l_fill_1_419 r0 *1 0,0
Xsg13cmos5l_fill_1_419 VPWR VGND sg13cmos5l_fill_1
* cell instance sg13cmos5l_fill_1_420 r0 *1 0,0
Xsg13cmos5l_fill_1_420 VPWR VGND sg13cmos5l_fill_1
* cell instance sg13cmos5l_fill_1_421 r0 *1 0,0
Xsg13cmos5l_fill_1_421 VPWR VGND sg13cmos5l_fill_1
* cell instance sg13cmos5l_fill_1_422 r0 *1 0,0
Xsg13cmos5l_fill_1_422 VPWR VGND sg13cmos5l_fill_1
* cell instance sg13cmos5l_fill_1_423 r0 *1 0,0
Xsg13cmos5l_fill_1_423 VPWR VGND sg13cmos5l_fill_1
* cell instance sg13cmos5l_fill_1_424 r0 *1 0,0
Xsg13cmos5l_fill_1_424 VPWR VGND sg13cmos5l_fill_1
* cell instance sg13cmos5l_fill_1_425 r0 *1 0,0
Xsg13cmos5l_fill_1_425 VPWR VGND sg13cmos5l_fill_1
* cell instance sg13cmos5l_fill_1_426 r0 *1 0,0
Xsg13cmos5l_fill_1_426 VPWR VGND sg13cmos5l_fill_1
* cell instance sg13cmos5l_fill_1_427 r0 *1 0,0
Xsg13cmos5l_fill_1_427 VPWR VGND sg13cmos5l_fill_1
* cell instance sg13cmos5l_fill_1_428 r0 *1 0,0
Xsg13cmos5l_fill_1_428 VPWR VGND sg13cmos5l_fill_1
* cell instance sg13cmos5l_fill_1_429 r0 *1 0,0
Xsg13cmos5l_fill_1_429 VPWR VGND sg13cmos5l_fill_1
* cell instance sg13cmos5l_fill_1_430 r0 *1 0,0
Xsg13cmos5l_fill_1_430 VPWR VGND sg13cmos5l_fill_1
* cell instance sg13cmos5l_fill_1_431 r0 *1 0,0
Xsg13cmos5l_fill_1_431 VPWR VGND sg13cmos5l_fill_1
* cell instance sg13cmos5l_fill_1_432 r0 *1 0,0
Xsg13cmos5l_fill_1_432 VPWR VGND sg13cmos5l_fill_1
* cell instance sg13cmos5l_fill_1_433 r0 *1 0,0
Xsg13cmos5l_fill_1_433 VPWR VGND sg13cmos5l_fill_1
* cell instance sg13cmos5l_fill_1_434 r0 *1 0,0
Xsg13cmos5l_fill_1_434 VPWR VGND sg13cmos5l_fill_1
* cell instance sg13cmos5l_fill_1_435 r0 *1 0,0
Xsg13cmos5l_fill_1_435 VPWR VGND sg13cmos5l_fill_1
* cell instance sg13cmos5l_fill_1_436 r0 *1 0,0
Xsg13cmos5l_fill_1_436 VPWR VGND sg13cmos5l_fill_1
* cell instance sg13cmos5l_fill_1_437 r0 *1 0,0
Xsg13cmos5l_fill_1_437 VPWR VGND sg13cmos5l_fill_1
* cell instance sg13cmos5l_fill_1_438 r0 *1 0,0
Xsg13cmos5l_fill_1_438 VPWR VGND sg13cmos5l_fill_1
* cell instance sg13cmos5l_fill_1_439 r0 *1 0,0
Xsg13cmos5l_fill_1_439 VPWR VGND sg13cmos5l_fill_1
* cell instance sg13cmos5l_fill_1_440 r0 *1 0,0
Xsg13cmos5l_fill_1_440 VPWR VGND sg13cmos5l_fill_1
* cell instance sg13cmos5l_fill_1_441 r0 *1 0,0
Xsg13cmos5l_fill_1_441 VPWR VGND sg13cmos5l_fill_1
* cell instance sg13cmos5l_fill_1_442 r0 *1 0,0
Xsg13cmos5l_fill_1_442 VPWR VGND sg13cmos5l_fill_1
* cell instance sg13cmos5l_fill_1_443 r0 *1 0,0
Xsg13cmos5l_fill_1_443 VPWR VGND sg13cmos5l_fill_1
* cell instance sg13cmos5l_fill_1_444 r0 *1 0,0
Xsg13cmos5l_fill_1_444 VPWR VGND sg13cmos5l_fill_1
* cell instance sg13cmos5l_fill_1_445 r0 *1 0,0
Xsg13cmos5l_fill_1_445 VPWR VGND sg13cmos5l_fill_1
* cell instance sg13cmos5l_fill_1_446 r0 *1 0,0
Xsg13cmos5l_fill_1_446 VPWR VGND sg13cmos5l_fill_1
* cell instance sg13cmos5l_fill_1_447 r0 *1 0,0
Xsg13cmos5l_fill_1_447 VPWR VGND sg13cmos5l_fill_1
* cell instance sg13cmos5l_fill_1_448 r0 *1 0,0
Xsg13cmos5l_fill_1_448 VPWR VGND sg13cmos5l_fill_1
* cell instance sg13cmos5l_fill_1_449 r0 *1 0,0
Xsg13cmos5l_fill_1_449 VPWR VGND sg13cmos5l_fill_1
* cell instance sg13cmos5l_fill_1_450 r0 *1 0,0
Xsg13cmos5l_fill_1_450 VPWR VGND sg13cmos5l_fill_1
* cell instance sg13cmos5l_fill_1_451 r0 *1 0,0
Xsg13cmos5l_fill_1_451 VPWR VGND sg13cmos5l_fill_1
* cell instance sg13cmos5l_fill_1_452 r0 *1 0,0
Xsg13cmos5l_fill_1_452 VPWR VGND sg13cmos5l_fill_1
* cell instance sg13cmos5l_fill_1_453 r0 *1 0,0
Xsg13cmos5l_fill_1_453 VPWR VGND sg13cmos5l_fill_1
* cell instance sg13cmos5l_fill_1_454 r0 *1 0,0
Xsg13cmos5l_fill_1_454 VPWR VGND sg13cmos5l_fill_1
* cell instance sg13cmos5l_fill_1_455 r0 *1 0,0
Xsg13cmos5l_fill_1_455 VPWR VGND sg13cmos5l_fill_1
* cell instance sg13cmos5l_fill_1_456 r0 *1 0,0
Xsg13cmos5l_fill_1_456 VPWR VGND sg13cmos5l_fill_1
* cell instance sg13cmos5l_fill_1_457 r0 *1 0,0
Xsg13cmos5l_fill_1_457 VPWR VGND sg13cmos5l_fill_1
* cell instance sg13cmos5l_fill_1_458 r0 *1 0,0
Xsg13cmos5l_fill_1_458 VPWR VGND sg13cmos5l_fill_1
* cell instance sg13cmos5l_fill_1_459 r0 *1 0,0
Xsg13cmos5l_fill_1_459 VPWR VGND sg13cmos5l_fill_1
* cell instance sg13cmos5l_fill_1_460 r0 *1 0,0
Xsg13cmos5l_fill_1_460 VPWR VGND sg13cmos5l_fill_1
* cell instance sg13cmos5l_fill_1_461 r0 *1 0,0
Xsg13cmos5l_fill_1_461 VPWR VGND sg13cmos5l_fill_1
* cell instance sg13cmos5l_fill_1_462 r0 *1 0,0
Xsg13cmos5l_fill_1_462 VPWR VGND sg13cmos5l_fill_1
* cell instance sg13cmos5l_fill_1_463 r0 *1 0,0
Xsg13cmos5l_fill_1_463 VPWR VGND sg13cmos5l_fill_1
* cell instance sg13cmos5l_fill_1_464 r0 *1 0,0
Xsg13cmos5l_fill_1_464 VPWR VGND sg13cmos5l_fill_1
* cell instance sg13cmos5l_fill_1_465 r0 *1 0,0
Xsg13cmos5l_fill_1_465 VPWR VGND sg13cmos5l_fill_1
* cell instance sg13cmos5l_fill_1_466 r0 *1 0,0
Xsg13cmos5l_fill_1_466 VPWR VGND sg13cmos5l_fill_1
* cell instance sg13cmos5l_fill_1_467 r0 *1 0,0
Xsg13cmos5l_fill_1_467 VPWR VGND sg13cmos5l_fill_1
* cell instance sg13cmos5l_fill_1_468 r0 *1 0,0
Xsg13cmos5l_fill_1_468 VPWR VGND sg13cmos5l_fill_1
* cell instance sg13cmos5l_fill_1_469 r0 *1 0,0
Xsg13cmos5l_fill_1_469 VPWR VGND sg13cmos5l_fill_1
* cell instance sg13cmos5l_fill_1_470 r0 *1 0,0
Xsg13cmos5l_fill_1_470 VPWR VGND sg13cmos5l_fill_1
* cell instance sg13cmos5l_fill_1_471 r0 *1 0,0
Xsg13cmos5l_fill_1_471 VPWR VGND sg13cmos5l_fill_1
* cell instance sg13cmos5l_fill_1_472 r0 *1 0,0
Xsg13cmos5l_fill_1_472 VPWR VGND sg13cmos5l_fill_1
* cell instance sg13cmos5l_fill_1_473 r0 *1 0,0
Xsg13cmos5l_fill_1_473 VPWR VGND sg13cmos5l_fill_1
* cell instance sg13cmos5l_fill_1_474 r0 *1 0,0
Xsg13cmos5l_fill_1_474 VPWR VGND sg13cmos5l_fill_1
* cell instance sg13cmos5l_fill_1_475 r0 *1 0,0
Xsg13cmos5l_fill_1_475 VPWR VGND sg13cmos5l_fill_1
* cell instance sg13cmos5l_fill_1_476 r0 *1 0,0
Xsg13cmos5l_fill_1_476 VPWR VGND sg13cmos5l_fill_1
* cell instance sg13cmos5l_fill_1_477 r0 *1 0,0
Xsg13cmos5l_fill_1_477 VPWR VGND sg13cmos5l_fill_1
* cell instance sg13cmos5l_fill_1_478 r0 *1 0,0
Xsg13cmos5l_fill_1_478 VPWR VGND sg13cmos5l_fill_1
* cell instance sg13cmos5l_fill_1_479 r0 *1 0,0
Xsg13cmos5l_fill_1_479 VPWR VGND sg13cmos5l_fill_1
* cell instance sg13cmos5l_fill_1_480 r0 *1 0,0
Xsg13cmos5l_fill_1_480 VPWR VGND sg13cmos5l_fill_1
* cell instance sg13cmos5l_fill_1_481 r0 *1 0,0
Xsg13cmos5l_fill_1_481 VPWR VGND sg13cmos5l_fill_1
* cell instance sg13cmos5l_fill_1_482 r0 *1 0,0
Xsg13cmos5l_fill_1_482 VPWR VGND sg13cmos5l_fill_1
* cell instance sg13cmos5l_fill_1_483 r0 *1 0,0
Xsg13cmos5l_fill_1_483 VPWR VGND sg13cmos5l_fill_1
* cell instance sg13cmos5l_fill_1_484 r0 *1 0,0
Xsg13cmos5l_fill_1_484 VPWR VGND sg13cmos5l_fill_1
* cell instance sg13cmos5l_fill_1_485 r0 *1 0,0
Xsg13cmos5l_fill_1_485 VPWR VGND sg13cmos5l_fill_1
* cell instance sg13cmos5l_fill_1_486 r0 *1 0,0
Xsg13cmos5l_fill_1_486 VPWR VGND sg13cmos5l_fill_1
* cell instance sg13cmos5l_fill_1_487 r0 *1 0,0
Xsg13cmos5l_fill_1_487 VPWR VGND sg13cmos5l_fill_1
* cell instance sg13cmos5l_fill_1_488 r0 *1 0,0
Xsg13cmos5l_fill_1_488 VPWR VGND sg13cmos5l_fill_1
* cell instance sg13cmos5l_fill_1_489 r0 *1 0,0
Xsg13cmos5l_fill_1_489 VPWR VGND sg13cmos5l_fill_1
* cell instance sg13cmos5l_fill_1_490 r0 *1 0,0
Xsg13cmos5l_fill_1_490 VPWR VGND sg13cmos5l_fill_1
* cell instance sg13cmos5l_fill_1_491 r0 *1 0,0
Xsg13cmos5l_fill_1_491 VPWR VGND sg13cmos5l_fill_1
* cell instance sg13cmos5l_fill_1_492 r0 *1 0,0
Xsg13cmos5l_fill_1_492 VPWR VGND sg13cmos5l_fill_1
* cell instance sg13cmos5l_fill_1_493 r0 *1 0,0
Xsg13cmos5l_fill_1_493 VPWR VGND sg13cmos5l_fill_1
* cell instance sg13cmos5l_fill_1_494 r0 *1 0,0
Xsg13cmos5l_fill_1_494 VPWR VGND sg13cmos5l_fill_1
* cell instance sg13cmos5l_fill_1_495 r0 *1 0,0
Xsg13cmos5l_fill_1_495 VPWR VGND sg13cmos5l_fill_1
* cell instance sg13cmos5l_fill_1_496 r0 *1 0,0
Xsg13cmos5l_fill_1_496 VPWR VGND sg13cmos5l_fill_1
* cell instance sg13cmos5l_fill_1_497 r0 *1 0,0
Xsg13cmos5l_fill_1_497 VPWR VGND sg13cmos5l_fill_1
* cell instance sg13cmos5l_fill_1_498 r0 *1 0,0
Xsg13cmos5l_fill_1_498 VPWR VGND sg13cmos5l_fill_1
* cell instance sg13cmos5l_fill_1_499 r0 *1 0,0
Xsg13cmos5l_fill_1_499 VPWR VGND sg13cmos5l_fill_1
* cell instance sg13cmos5l_fill_1_500 r0 *1 0,0
Xsg13cmos5l_fill_1_500 VPWR VGND sg13cmos5l_fill_1
* cell instance sg13cmos5l_fill_1_501 r0 *1 0,0
Xsg13cmos5l_fill_1_501 VPWR VGND sg13cmos5l_fill_1
* cell instance sg13cmos5l_fill_1_502 r0 *1 0,0
Xsg13cmos5l_fill_1_502 VPWR VGND sg13cmos5l_fill_1
* cell instance sg13cmos5l_fill_1_503 r0 *1 0,0
Xsg13cmos5l_fill_1_503 VPWR VGND sg13cmos5l_fill_1
* cell instance sg13cmos5l_fill_1_504 r0 *1 0,0
Xsg13cmos5l_fill_1_504 VPWR VGND sg13cmos5l_fill_1
* cell instance sg13cmos5l_fill_1_505 r0 *1 0,0
Xsg13cmos5l_fill_1_505 VPWR VGND sg13cmos5l_fill_1
* cell instance sg13cmos5l_fill_1_506 r0 *1 0,0
Xsg13cmos5l_fill_1_506 VPWR VGND sg13cmos5l_fill_1
* cell instance sg13cmos5l_fill_1_507 r0 *1 0,0
Xsg13cmos5l_fill_1_507 VPWR VGND sg13cmos5l_fill_1
* cell instance sg13cmos5l_fill_1_508 r0 *1 0,0
Xsg13cmos5l_fill_1_508 VPWR VGND sg13cmos5l_fill_1
* cell instance sg13cmos5l_fill_1_509 r0 *1 0,0
Xsg13cmos5l_fill_1_509 VPWR VGND sg13cmos5l_fill_1
* cell instance sg13cmos5l_fill_1_510 r0 *1 0,0
Xsg13cmos5l_fill_1_510 VPWR VGND sg13cmos5l_fill_1
* cell instance sg13cmos5l_fill_1_511 r0 *1 0,0
Xsg13cmos5l_fill_1_511 VPWR VGND sg13cmos5l_fill_1
* cell instance sg13cmos5l_fill_1_512 r0 *1 0,0
Xsg13cmos5l_fill_1_512 VPWR VGND sg13cmos5l_fill_1
* cell instance sg13cmos5l_fill_1_513 r0 *1 0,0
Xsg13cmos5l_fill_1_513 VPWR VGND sg13cmos5l_fill_1
* cell instance sg13cmos5l_fill_1_514 r0 *1 0,0
Xsg13cmos5l_fill_1_514 VPWR VGND sg13cmos5l_fill_1
* cell instance sg13cmos5l_fill_1_515 r0 *1 0,0
Xsg13cmos5l_fill_1_515 VPWR VGND sg13cmos5l_fill_1
* cell instance sg13cmos5l_fill_1_516 r0 *1 0,0
Xsg13cmos5l_fill_1_516 VPWR VGND sg13cmos5l_fill_1
* cell instance sg13cmos5l_fill_1_517 r0 *1 0,0
Xsg13cmos5l_fill_1_517 VPWR VGND sg13cmos5l_fill_1
* cell instance sg13cmos5l_fill_1_518 r0 *1 0,0
Xsg13cmos5l_fill_1_518 VPWR VGND sg13cmos5l_fill_1
* cell instance sg13cmos5l_fill_1_519 r0 *1 0,0
Xsg13cmos5l_fill_1_519 VPWR VGND sg13cmos5l_fill_1
* cell instance sg13cmos5l_fill_1_520 r0 *1 0,0
Xsg13cmos5l_fill_1_520 VPWR VGND sg13cmos5l_fill_1
* cell instance sg13cmos5l_fill_1_521 r0 *1 0,0
Xsg13cmos5l_fill_1_521 VPWR VGND sg13cmos5l_fill_1
* cell instance sg13cmos5l_fill_1_522 r0 *1 0,0
Xsg13cmos5l_fill_1_522 VPWR VGND sg13cmos5l_fill_1
* cell instance sg13cmos5l_fill_1_523 r0 *1 0,0
Xsg13cmos5l_fill_1_523 VPWR VGND sg13cmos5l_fill_1
* cell instance sg13cmos5l_fill_1_524 r0 *1 0,0
Xsg13cmos5l_fill_1_524 VPWR VGND sg13cmos5l_fill_1
* cell instance sg13cmos5l_fill_1_525 r0 *1 0,0
Xsg13cmos5l_fill_1_525 VPWR VGND sg13cmos5l_fill_1
* cell instance sg13cmos5l_fill_1_526 r0 *1 0,0
Xsg13cmos5l_fill_1_526 VPWR VGND sg13cmos5l_fill_1
* cell instance sg13cmos5l_fill_1_527 r0 *1 0,0
Xsg13cmos5l_fill_1_527 VPWR VGND sg13cmos5l_fill_1
* cell instance sg13cmos5l_fill_1_528 r0 *1 0,0
Xsg13cmos5l_fill_1_528 VPWR VGND sg13cmos5l_fill_1
* cell instance sg13cmos5l_fill_1_529 r0 *1 0,0
Xsg13cmos5l_fill_1_529 VPWR VGND sg13cmos5l_fill_1
* cell instance sg13cmos5l_fill_1_530 r0 *1 0,0
Xsg13cmos5l_fill_1_530 VPWR VGND sg13cmos5l_fill_1
* cell instance sg13cmos5l_fill_1_531 r0 *1 0,0
Xsg13cmos5l_fill_1_531 VPWR VGND sg13cmos5l_fill_1
* cell instance sg13cmos5l_fill_1_532 r0 *1 0,0
Xsg13cmos5l_fill_1_532 VPWR VGND sg13cmos5l_fill_1
* cell instance sg13cmos5l_fill_1_533 r0 *1 0,0
Xsg13cmos5l_fill_1_533 VPWR VGND sg13cmos5l_fill_1
* cell instance sg13cmos5l_fill_1_534 r0 *1 0,0
Xsg13cmos5l_fill_1_534 VPWR VGND sg13cmos5l_fill_1
* cell instance sg13cmos5l_fill_1_535 r0 *1 0,0
Xsg13cmos5l_fill_1_535 VPWR VGND sg13cmos5l_fill_1
* cell instance sg13cmos5l_fill_1_536 r0 *1 0,0
Xsg13cmos5l_fill_1_536 VPWR VGND sg13cmos5l_fill_1
* cell instance sg13cmos5l_fill_1_537 r0 *1 0,0
Xsg13cmos5l_fill_1_537 VPWR VGND sg13cmos5l_fill_1
* cell instance sg13cmos5l_fill_1_538 r0 *1 0,0
Xsg13cmos5l_fill_1_538 VPWR VGND sg13cmos5l_fill_1
* cell instance sg13cmos5l_fill_1_539 r0 *1 0,0
Xsg13cmos5l_fill_1_539 VPWR VGND sg13cmos5l_fill_1
* cell instance sg13cmos5l_fill_1_540 r0 *1 0,0
Xsg13cmos5l_fill_1_540 VPWR VGND sg13cmos5l_fill_1
* cell instance sg13cmos5l_fill_1_541 r0 *1 0,0
Xsg13cmos5l_fill_1_541 VPWR VGND sg13cmos5l_fill_1
* cell instance sg13cmos5l_fill_1_542 r0 *1 0,0
Xsg13cmos5l_fill_1_542 VPWR VGND sg13cmos5l_fill_1
* cell instance sg13cmos5l_fill_1_543 r0 *1 0,0
Xsg13cmos5l_fill_1_543 VPWR VGND sg13cmos5l_fill_1
* cell instance sg13cmos5l_fill_1_544 r0 *1 0,0
Xsg13cmos5l_fill_1_544 VPWR VGND sg13cmos5l_fill_1
* cell instance sg13cmos5l_fill_1_545 r0 *1 0,0
Xsg13cmos5l_fill_1_545 VPWR VGND sg13cmos5l_fill_1
* cell instance sg13cmos5l_fill_1_546 r0 *1 0,0
Xsg13cmos5l_fill_1_546 VPWR VGND sg13cmos5l_fill_1
* cell instance sg13cmos5l_fill_1_547 r0 *1 0,0
Xsg13cmos5l_fill_1_547 VPWR VGND sg13cmos5l_fill_1
* cell instance sg13cmos5l_fill_1_548 r0 *1 0,0
Xsg13cmos5l_fill_1_548 VPWR VGND sg13cmos5l_fill_1
* cell instance sg13cmos5l_fill_1_549 r0 *1 0,0
Xsg13cmos5l_fill_1_549 VPWR VGND sg13cmos5l_fill_1
* cell instance sg13cmos5l_fill_1_550 r0 *1 0,0
Xsg13cmos5l_fill_1_550 VPWR VGND sg13cmos5l_fill_1
* cell instance sg13cmos5l_fill_1_551 r0 *1 0,0
Xsg13cmos5l_fill_1_551 VPWR VGND sg13cmos5l_fill_1
* cell instance sg13cmos5l_fill_1_552 r0 *1 0,0
Xsg13cmos5l_fill_1_552 VPWR VGND sg13cmos5l_fill_1
* cell instance sg13cmos5l_fill_1_553 r0 *1 0,0
Xsg13cmos5l_fill_1_553 VPWR VGND sg13cmos5l_fill_1
* cell instance sg13cmos5l_fill_1_554 r0 *1 0,0
Xsg13cmos5l_fill_1_554 VPWR VGND sg13cmos5l_fill_1
* cell instance sg13cmos5l_fill_1_555 r0 *1 0,0
Xsg13cmos5l_fill_1_555 VPWR VGND sg13cmos5l_fill_1
* cell instance sg13cmos5l_fill_1_556 r0 *1 0,0
Xsg13cmos5l_fill_1_556 VPWR VGND sg13cmos5l_fill_1
* cell instance sg13cmos5l_fill_1_557 r0 *1 0,0
Xsg13cmos5l_fill_1_557 VPWR VGND sg13cmos5l_fill_1
* cell instance sg13cmos5l_fill_1_558 r0 *1 0,0
Xsg13cmos5l_fill_1_558 VPWR VGND sg13cmos5l_fill_1
* cell instance sg13cmos5l_fill_1_559 r0 *1 0,0
Xsg13cmos5l_fill_1_559 VPWR VGND sg13cmos5l_fill_1
* cell instance sg13cmos5l_fill_1_560 r0 *1 0,0
Xsg13cmos5l_fill_1_560 VPWR VGND sg13cmos5l_fill_1
* cell instance sg13cmos5l_fill_1_561 r0 *1 0,0
Xsg13cmos5l_fill_1_561 VPWR VGND sg13cmos5l_fill_1
* cell instance sg13cmos5l_fill_1_562 r0 *1 0,0
Xsg13cmos5l_fill_1_562 VPWR VGND sg13cmos5l_fill_1
* cell instance sg13cmos5l_fill_1_563 r0 *1 0,0
Xsg13cmos5l_fill_1_563 VPWR VGND sg13cmos5l_fill_1
* cell instance sg13cmos5l_fill_1_564 r0 *1 0,0
Xsg13cmos5l_fill_1_564 VPWR VGND sg13cmos5l_fill_1
* cell instance sg13cmos5l_fill_1_565 r0 *1 0,0
Xsg13cmos5l_fill_1_565 VPWR VGND sg13cmos5l_fill_1
* cell instance sg13cmos5l_fill_1_566 r0 *1 0,0
Xsg13cmos5l_fill_1_566 VPWR VGND sg13cmos5l_fill_1
* cell instance sg13cmos5l_fill_1_567 r0 *1 0,0
Xsg13cmos5l_fill_1_567 VPWR VGND sg13cmos5l_fill_1
* cell instance sg13cmos5l_fill_1_568 r0 *1 0,0
Xsg13cmos5l_fill_1_568 VPWR VGND sg13cmos5l_fill_1
* cell instance sg13cmos5l_fill_1_569 r0 *1 0,0
Xsg13cmos5l_fill_1_569 VPWR VGND sg13cmos5l_fill_1
* cell instance sg13cmos5l_fill_1_570 r0 *1 0,0
Xsg13cmos5l_fill_1_570 VPWR VGND sg13cmos5l_fill_1
* cell instance sg13cmos5l_fill_1_571 r0 *1 0,0
Xsg13cmos5l_fill_1_571 VPWR VGND sg13cmos5l_fill_1
* cell instance sg13cmos5l_fill_1_572 r0 *1 0,0
Xsg13cmos5l_fill_1_572 VPWR VGND sg13cmos5l_fill_1
* cell instance sg13cmos5l_fill_1_573 r0 *1 0,0
Xsg13cmos5l_fill_1_573 VPWR VGND sg13cmos5l_fill_1
* cell instance sg13cmos5l_fill_1_574 r0 *1 0,0
Xsg13cmos5l_fill_1_574 VPWR VGND sg13cmos5l_fill_1
* cell instance sg13cmos5l_fill_1_575 r0 *1 0,0
Xsg13cmos5l_fill_1_575 VPWR VGND sg13cmos5l_fill_1
* cell instance sg13cmos5l_fill_1_576 r0 *1 0,0
Xsg13cmos5l_fill_1_576 VPWR VGND sg13cmos5l_fill_1
* cell instance sg13cmos5l_fill_1_577 r0 *1 0,0
Xsg13cmos5l_fill_1_577 VPWR VGND sg13cmos5l_fill_1
* cell instance sg13cmos5l_fill_1_578 r0 *1 0,0
Xsg13cmos5l_fill_1_578 VPWR VGND sg13cmos5l_fill_1
* cell instance sg13cmos5l_fill_1_579 r0 *1 0,0
Xsg13cmos5l_fill_1_579 VPWR VGND sg13cmos5l_fill_1
* cell instance sg13cmos5l_fill_1_580 r0 *1 0,0
Xsg13cmos5l_fill_1_580 VPWR VGND sg13cmos5l_fill_1
* cell instance sg13cmos5l_fill_1_581 r0 *1 0,0
Xsg13cmos5l_fill_1_581 VPWR VGND sg13cmos5l_fill_1
* cell instance sg13cmos5l_fill_1_582 r0 *1 0,0
Xsg13cmos5l_fill_1_582 VPWR VGND sg13cmos5l_fill_1
* cell instance sg13cmos5l_fill_1_583 r0 *1 0,0
Xsg13cmos5l_fill_1_583 VPWR VGND sg13cmos5l_fill_1
* cell instance sg13cmos5l_fill_1_584 r0 *1 0,0
Xsg13cmos5l_fill_1_584 VPWR VGND sg13cmos5l_fill_1
* cell instance sg13cmos5l_fill_1_585 r0 *1 0,0
Xsg13cmos5l_fill_1_585 VPWR VGND sg13cmos5l_fill_1
* cell instance sg13cmos5l_fill_1_586 r0 *1 0,0
Xsg13cmos5l_fill_1_586 VPWR VGND sg13cmos5l_fill_1
* cell instance sg13cmos5l_fill_1_587 r0 *1 0,0
Xsg13cmos5l_fill_1_587 VPWR VGND sg13cmos5l_fill_1
* cell instance sg13cmos5l_fill_1_588 r0 *1 0,0
Xsg13cmos5l_fill_1_588 VPWR VGND sg13cmos5l_fill_1
* cell instance sg13cmos5l_fill_1_589 r0 *1 0,0
Xsg13cmos5l_fill_1_589 VPWR VGND sg13cmos5l_fill_1
* cell instance sg13cmos5l_fill_1_590 r0 *1 0,0
Xsg13cmos5l_fill_1_590 VPWR VGND sg13cmos5l_fill_1
* cell instance sg13cmos5l_fill_1_591 r0 *1 0,0
Xsg13cmos5l_fill_1_591 VPWR VGND sg13cmos5l_fill_1
* cell instance sg13cmos5l_fill_1_592 r0 *1 0,0
Xsg13cmos5l_fill_1_592 VPWR VGND sg13cmos5l_fill_1
* cell instance sg13cmos5l_fill_1_593 r0 *1 0,0
Xsg13cmos5l_fill_1_593 VPWR VGND sg13cmos5l_fill_1
* cell instance sg13cmos5l_fill_1_594 r0 *1 0,0
Xsg13cmos5l_fill_1_594 VPWR VGND sg13cmos5l_fill_1
* cell instance sg13cmos5l_fill_1_595 r0 *1 0,0
Xsg13cmos5l_fill_1_595 VPWR VGND sg13cmos5l_fill_1
* cell instance sg13cmos5l_fill_1_596 r0 *1 0,0
Xsg13cmos5l_fill_1_596 VPWR VGND sg13cmos5l_fill_1
* cell instance sg13cmos5l_fill_1_597 r0 *1 0,0
Xsg13cmos5l_fill_1_597 VPWR VGND sg13cmos5l_fill_1
* cell instance sg13cmos5l_fill_1_598 r0 *1 0,0
Xsg13cmos5l_fill_1_598 VPWR VGND sg13cmos5l_fill_1
* cell instance sg13cmos5l_fill_1_599 r0 *1 0,0
Xsg13cmos5l_fill_1_599 VPWR VGND sg13cmos5l_fill_1
* cell instance sg13cmos5l_fill_1_600 r0 *1 0,0
Xsg13cmos5l_fill_1_600 VPWR VGND sg13cmos5l_fill_1
* cell instance sg13cmos5l_fill_1_601 r0 *1 0,0
Xsg13cmos5l_fill_1_601 VPWR VGND sg13cmos5l_fill_1
* cell instance sg13cmos5l_fill_1_602 r0 *1 0,0
Xsg13cmos5l_fill_1_602 VPWR VGND sg13cmos5l_fill_1
* cell instance sg13cmos5l_fill_1_603 r0 *1 0,0
Xsg13cmos5l_fill_1_603 VPWR VGND sg13cmos5l_fill_1
* cell instance sg13cmos5l_fill_1_604 r0 *1 0,0
Xsg13cmos5l_fill_1_604 VPWR VGND sg13cmos5l_fill_1
* cell instance sg13cmos5l_fill_1_605 r0 *1 0,0
Xsg13cmos5l_fill_1_605 VPWR VGND sg13cmos5l_fill_1
* cell instance sg13cmos5l_fill_1_606 r0 *1 0,0
Xsg13cmos5l_fill_1_606 VPWR VGND sg13cmos5l_fill_1
* cell instance sg13cmos5l_fill_1_607 r0 *1 0,0
Xsg13cmos5l_fill_1_607 VPWR VGND sg13cmos5l_fill_1
* cell instance sg13cmos5l_fill_1_608 r0 *1 0,0
Xsg13cmos5l_fill_1_608 VPWR VGND sg13cmos5l_fill_1
* cell instance sg13cmos5l_fill_1_609 r0 *1 0,0
Xsg13cmos5l_fill_1_609 VPWR VGND sg13cmos5l_fill_1
* cell instance sg13cmos5l_fill_1_610 r0 *1 0,0
Xsg13cmos5l_fill_1_610 VPWR VGND sg13cmos5l_fill_1
* cell instance sg13cmos5l_fill_1_611 r0 *1 0,0
Xsg13cmos5l_fill_1_611 VPWR VGND sg13cmos5l_fill_1
* cell instance sg13cmos5l_fill_1_612 r0 *1 0,0
Xsg13cmos5l_fill_1_612 VPWR VGND sg13cmos5l_fill_1
* cell instance sg13cmos5l_fill_1_613 r0 *1 0,0
Xsg13cmos5l_fill_1_613 VPWR VGND sg13cmos5l_fill_1
* cell instance sg13cmos5l_fill_1_614 r0 *1 0,0
Xsg13cmos5l_fill_1_614 VPWR VGND sg13cmos5l_fill_1
* cell instance sg13cmos5l_fill_1_615 r0 *1 0,0
Xsg13cmos5l_fill_1_615 VPWR VGND sg13cmos5l_fill_1
* cell instance sg13cmos5l_fill_1_616 r0 *1 0,0
Xsg13cmos5l_fill_1_616 VPWR VGND sg13cmos5l_fill_1
* cell instance sg13cmos5l_fill_1_617 r0 *1 0,0
Xsg13cmos5l_fill_1_617 VPWR VGND sg13cmos5l_fill_1
* cell instance sg13cmos5l_fill_1_618 r0 *1 0,0
Xsg13cmos5l_fill_1_618 VPWR VGND sg13cmos5l_fill_1
* cell instance sg13cmos5l_fill_1_619 r0 *1 0,0
Xsg13cmos5l_fill_1_619 VPWR VGND sg13cmos5l_fill_1
* cell instance sg13cmos5l_fill_1_620 r0 *1 0,0
Xsg13cmos5l_fill_1_620 VPWR VGND sg13cmos5l_fill_1
* cell instance sg13cmos5l_fill_1_621 r0 *1 0,0
Xsg13cmos5l_fill_1_621 VPWR VGND sg13cmos5l_fill_1
* cell instance sg13cmos5l_fill_1_622 r0 *1 0,0
Xsg13cmos5l_fill_1_622 VPWR VGND sg13cmos5l_fill_1
* cell instance sg13cmos5l_fill_1_623 r0 *1 0,0
Xsg13cmos5l_fill_1_623 VPWR VGND sg13cmos5l_fill_1
* cell instance sg13cmos5l_fill_1_624 r0 *1 0,0
Xsg13cmos5l_fill_1_624 VPWR VGND sg13cmos5l_fill_1
* cell instance sg13cmos5l_fill_1_625 r0 *1 0,0
Xsg13cmos5l_fill_1_625 VPWR VGND sg13cmos5l_fill_1
* cell instance sg13cmos5l_fill_1_626 r0 *1 0,0
Xsg13cmos5l_fill_1_626 VPWR VGND sg13cmos5l_fill_1
* cell instance sg13cmos5l_fill_1_627 r0 *1 0,0
Xsg13cmos5l_fill_1_627 VPWR VGND sg13cmos5l_fill_1
* cell instance sg13cmos5l_fill_1_628 r0 *1 0,0
Xsg13cmos5l_fill_1_628 VPWR VGND sg13cmos5l_fill_1
* cell instance sg13cmos5l_fill_1_629 r0 *1 0,0
Xsg13cmos5l_fill_1_629 VPWR VGND sg13cmos5l_fill_1
* cell instance sg13cmos5l_fill_1_630 r0 *1 0,0
Xsg13cmos5l_fill_1_630 VPWR VGND sg13cmos5l_fill_1
* cell instance sg13cmos5l_fill_1_631 r0 *1 0,0
Xsg13cmos5l_fill_1_631 VPWR VGND sg13cmos5l_fill_1
* cell instance sg13cmos5l_fill_1_632 r0 *1 0,0
Xsg13cmos5l_fill_1_632 VPWR VGND sg13cmos5l_fill_1
* cell instance sg13cmos5l_fill_1_633 r0 *1 0,0
Xsg13cmos5l_fill_1_633 VPWR VGND sg13cmos5l_fill_1
* cell instance sg13cmos5l_fill_1_634 r0 *1 0,0
Xsg13cmos5l_fill_1_634 VPWR VGND sg13cmos5l_fill_1
* cell instance sg13cmos5l_fill_1_635 r0 *1 0,0
Xsg13cmos5l_fill_1_635 VPWR VGND sg13cmos5l_fill_1
* cell instance sg13cmos5l_fill_1_636 r0 *1 0,0
Xsg13cmos5l_fill_1_636 VPWR VGND sg13cmos5l_fill_1
* cell instance sg13cmos5l_fill_1_637 r0 *1 0,0
Xsg13cmos5l_fill_1_637 VPWR VGND sg13cmos5l_fill_1
* cell instance sg13cmos5l_fill_1_638 r0 *1 0,0
Xsg13cmos5l_fill_1_638 VPWR VGND sg13cmos5l_fill_1
* cell instance sg13cmos5l_fill_1_639 r0 *1 0,0
Xsg13cmos5l_fill_1_639 VPWR VGND sg13cmos5l_fill_1
* cell instance sg13cmos5l_fill_1_640 r0 *1 0,0
Xsg13cmos5l_fill_1_640 VPWR VGND sg13cmos5l_fill_1
* cell instance sg13cmos5l_fill_1_641 r0 *1 0,0
Xsg13cmos5l_fill_1_641 VPWR VGND sg13cmos5l_fill_1
* cell instance sg13cmos5l_fill_1_642 r0 *1 0,0
Xsg13cmos5l_fill_1_642 VPWR VGND sg13cmos5l_fill_1
* cell instance sg13cmos5l_fill_1_643 r0 *1 0,0
Xsg13cmos5l_fill_1_643 VPWR VGND sg13cmos5l_fill_1
* cell instance sg13cmos5l_fill_1_644 r0 *1 0,0
Xsg13cmos5l_fill_1_644 VPWR VGND sg13cmos5l_fill_1
* cell instance sg13cmos5l_fill_1_645 r0 *1 0,0
Xsg13cmos5l_fill_1_645 VPWR VGND sg13cmos5l_fill_1
* cell instance sg13cmos5l_fill_1_646 r0 *1 0,0
Xsg13cmos5l_fill_1_646 VPWR VGND sg13cmos5l_fill_1
* cell instance sg13cmos5l_fill_1_647 r0 *1 0,0
Xsg13cmos5l_fill_1_647 VPWR VGND sg13cmos5l_fill_1
* cell instance sg13cmos5l_fill_1_648 r0 *1 0,0
Xsg13cmos5l_fill_1_648 VPWR VGND sg13cmos5l_fill_1
* cell instance sg13cmos5l_fill_1_649 r0 *1 0,0
Xsg13cmos5l_fill_1_649 VPWR VGND sg13cmos5l_fill_1
* cell instance sg13cmos5l_fill_1_650 r0 *1 0,0
Xsg13cmos5l_fill_1_650 VPWR VGND sg13cmos5l_fill_1
* cell instance sg13cmos5l_fill_1_651 r0 *1 0,0
Xsg13cmos5l_fill_1_651 VPWR VGND sg13cmos5l_fill_1
* cell instance sg13cmos5l_fill_1_652 r0 *1 0,0
Xsg13cmos5l_fill_1_652 VPWR VGND sg13cmos5l_fill_1
* cell instance sg13cmos5l_fill_1_653 r0 *1 0,0
Xsg13cmos5l_fill_1_653 VPWR VGND sg13cmos5l_fill_1
* cell instance sg13cmos5l_fill_1_654 r0 *1 0,0
Xsg13cmos5l_fill_1_654 VPWR VGND sg13cmos5l_fill_1
* cell instance sg13cmos5l_fill_1_655 r0 *1 0,0
Xsg13cmos5l_fill_1_655 VPWR VGND sg13cmos5l_fill_1
* cell instance sg13cmos5l_fill_1_656 r0 *1 0,0
Xsg13cmos5l_fill_1_656 VPWR VGND sg13cmos5l_fill_1
* cell instance sg13cmos5l_fill_1_657 r0 *1 0,0
Xsg13cmos5l_fill_1_657 VPWR VGND sg13cmos5l_fill_1
* cell instance sg13cmos5l_fill_1_658 r0 *1 0,0
Xsg13cmos5l_fill_1_658 VPWR VGND sg13cmos5l_fill_1
* cell instance sg13cmos5l_fill_1_659 r0 *1 0,0
Xsg13cmos5l_fill_1_659 VPWR VGND sg13cmos5l_fill_1
* cell instance sg13cmos5l_fill_1_660 r0 *1 0,0
Xsg13cmos5l_fill_1_660 VPWR VGND sg13cmos5l_fill_1
* cell instance sg13cmos5l_fill_1_661 r0 *1 0,0
Xsg13cmos5l_fill_1_661 VPWR VGND sg13cmos5l_fill_1
* cell instance sg13cmos5l_fill_1_662 r0 *1 0,0
Xsg13cmos5l_fill_1_662 VPWR VGND sg13cmos5l_fill_1
* cell instance sg13cmos5l_fill_1_663 r0 *1 0,0
Xsg13cmos5l_fill_1_663 VPWR VGND sg13cmos5l_fill_1
* cell instance sg13cmos5l_fill_1_664 r0 *1 0,0
Xsg13cmos5l_fill_1_664 VPWR VGND sg13cmos5l_fill_1
* cell instance sg13cmos5l_fill_1_665 r0 *1 0,0
Xsg13cmos5l_fill_1_665 VPWR VGND sg13cmos5l_fill_1
* cell instance sg13cmos5l_fill_1_666 r0 *1 0,0
Xsg13cmos5l_fill_1_666 VPWR VGND sg13cmos5l_fill_1
* cell instance sg13cmos5l_fill_1_667 r0 *1 0,0
Xsg13cmos5l_fill_1_667 VPWR VGND sg13cmos5l_fill_1
* cell instance sg13cmos5l_fill_1_668 r0 *1 0,0
Xsg13cmos5l_fill_1_668 VPWR VGND sg13cmos5l_fill_1
* cell instance sg13cmos5l_fill_1_669 r0 *1 0,0
Xsg13cmos5l_fill_1_669 VPWR VGND sg13cmos5l_fill_1
* cell instance sg13cmos5l_fill_1_670 r0 *1 0,0
Xsg13cmos5l_fill_1_670 VPWR VGND sg13cmos5l_fill_1
* cell instance sg13cmos5l_fill_1_671 r0 *1 0,0
Xsg13cmos5l_fill_1_671 VPWR VGND sg13cmos5l_fill_1
* cell instance sg13cmos5l_fill_1_672 r0 *1 0,0
Xsg13cmos5l_fill_1_672 VPWR VGND sg13cmos5l_fill_1
* cell instance sg13cmos5l_fill_1_673 r0 *1 0,0
Xsg13cmos5l_fill_1_673 VPWR VGND sg13cmos5l_fill_1
* cell instance sg13cmos5l_fill_1_674 r0 *1 0,0
Xsg13cmos5l_fill_1_674 VPWR VGND sg13cmos5l_fill_1
* cell instance sg13cmos5l_fill_1_675 r0 *1 0,0
Xsg13cmos5l_fill_1_675 VPWR VGND sg13cmos5l_fill_1
* cell instance sg13cmos5l_fill_1_676 r0 *1 0,0
Xsg13cmos5l_fill_1_676 VPWR VGND sg13cmos5l_fill_1
* cell instance sg13cmos5l_fill_1_677 r0 *1 0,0
Xsg13cmos5l_fill_1_677 VPWR VGND sg13cmos5l_fill_1
* cell instance sg13cmos5l_fill_1_678 r0 *1 0,0
Xsg13cmos5l_fill_1_678 VPWR VGND sg13cmos5l_fill_1
* cell instance sg13cmos5l_fill_1_679 r0 *1 0,0
Xsg13cmos5l_fill_1_679 VPWR VGND sg13cmos5l_fill_1
* cell instance sg13cmos5l_fill_1_680 r0 *1 0,0
Xsg13cmos5l_fill_1_680 VPWR VGND sg13cmos5l_fill_1
* cell instance sg13cmos5l_fill_1_681 r0 *1 0,0
Xsg13cmos5l_fill_1_681 VPWR VGND sg13cmos5l_fill_1
* cell instance sg13cmos5l_fill_1_682 r0 *1 0,0
Xsg13cmos5l_fill_1_682 VPWR VGND sg13cmos5l_fill_1
* cell instance sg13cmos5l_fill_1_683 r0 *1 0,0
Xsg13cmos5l_fill_1_683 VPWR VGND sg13cmos5l_fill_1
* cell instance sg13cmos5l_fill_1_684 r0 *1 0,0
Xsg13cmos5l_fill_1_684 VPWR VGND sg13cmos5l_fill_1
* cell instance sg13cmos5l_fill_1_685 r0 *1 0,0
Xsg13cmos5l_fill_1_685 VPWR VGND sg13cmos5l_fill_1
* cell instance sg13cmos5l_fill_1_686 r0 *1 0,0
Xsg13cmos5l_fill_1_686 VPWR VGND sg13cmos5l_fill_1
* cell instance sg13cmos5l_fill_1_687 r0 *1 0,0
Xsg13cmos5l_fill_1_687 VPWR VGND sg13cmos5l_fill_1
* cell instance sg13cmos5l_fill_1_688 r0 *1 0,0
Xsg13cmos5l_fill_1_688 VPWR VGND sg13cmos5l_fill_1
* cell instance sg13cmos5l_fill_1_689 r0 *1 0,0
Xsg13cmos5l_fill_1_689 VPWR VGND sg13cmos5l_fill_1
* cell instance sg13cmos5l_fill_1_690 r0 *1 0,0
Xsg13cmos5l_fill_1_690 VPWR VGND sg13cmos5l_fill_1
* cell instance sg13cmos5l_fill_1_691 r0 *1 0,0
Xsg13cmos5l_fill_1_691 VPWR VGND sg13cmos5l_fill_1
* cell instance sg13cmos5l_fill_1_692 r0 *1 0,0
Xsg13cmos5l_fill_1_692 VPWR VGND sg13cmos5l_fill_1
* cell instance sg13cmos5l_fill_1_693 r0 *1 0,0
Xsg13cmos5l_fill_1_693 VPWR VGND sg13cmos5l_fill_1
* cell instance sg13cmos5l_fill_1_694 r0 *1 0,0
Xsg13cmos5l_fill_1_694 VPWR VGND sg13cmos5l_fill_1
* cell instance sg13cmos5l_fill_1_695 r0 *1 0,0
Xsg13cmos5l_fill_1_695 VPWR VGND sg13cmos5l_fill_1
* cell instance sg13cmos5l_fill_1_696 r0 *1 0,0
Xsg13cmos5l_fill_1_696 VPWR VGND sg13cmos5l_fill_1
* cell instance sg13cmos5l_fill_1_697 r0 *1 0,0
Xsg13cmos5l_fill_1_697 VPWR VGND sg13cmos5l_fill_1
* cell instance sg13cmos5l_fill_1_698 r0 *1 0,0
Xsg13cmos5l_fill_1_698 VPWR VGND sg13cmos5l_fill_1
* cell instance sg13cmos5l_fill_1_699 r0 *1 0,0
Xsg13cmos5l_fill_1_699 VPWR VGND sg13cmos5l_fill_1
* cell instance sg13cmos5l_fill_1_700 r0 *1 0,0
Xsg13cmos5l_fill_1_700 VPWR VGND sg13cmos5l_fill_1
* cell instance sg13cmos5l_fill_1_701 r0 *1 0,0
Xsg13cmos5l_fill_1_701 VPWR VGND sg13cmos5l_fill_1
* cell instance sg13cmos5l_fill_1_702 r0 *1 0,0
Xsg13cmos5l_fill_1_702 VPWR VGND sg13cmos5l_fill_1
* cell instance sg13cmos5l_fill_1_703 r0 *1 0,0
Xsg13cmos5l_fill_1_703 VPWR VGND sg13cmos5l_fill_1
* cell instance sg13cmos5l_fill_1_704 r0 *1 0,0
Xsg13cmos5l_fill_1_704 VPWR VGND sg13cmos5l_fill_1
* cell instance sg13cmos5l_fill_1_705 r0 *1 0,0
Xsg13cmos5l_fill_1_705 VPWR VGND sg13cmos5l_fill_1
* cell instance sg13cmos5l_fill_1_706 r0 *1 0,0
Xsg13cmos5l_fill_1_706 VPWR VGND sg13cmos5l_fill_1
* cell instance sg13cmos5l_fill_1_707 r0 *1 0,0
Xsg13cmos5l_fill_1_707 VPWR VGND sg13cmos5l_fill_1
* cell instance sg13cmos5l_fill_1_708 r0 *1 0,0
Xsg13cmos5l_fill_1_708 VPWR VGND sg13cmos5l_fill_1
* cell instance sg13cmos5l_fill_1_709 r0 *1 0,0
Xsg13cmos5l_fill_1_709 VPWR VGND sg13cmos5l_fill_1
* cell instance sg13cmos5l_fill_1_710 r0 *1 0,0
Xsg13cmos5l_fill_1_710 VPWR VGND sg13cmos5l_fill_1
* cell instance sg13cmos5l_fill_1_711 r0 *1 0,0
Xsg13cmos5l_fill_1_711 VPWR VGND sg13cmos5l_fill_1
* cell instance sg13cmos5l_fill_1_712 r0 *1 0,0
Xsg13cmos5l_fill_1_712 VPWR VGND sg13cmos5l_fill_1
* cell instance sg13cmos5l_fill_1_713 r0 *1 0,0
Xsg13cmos5l_fill_1_713 VPWR VGND sg13cmos5l_fill_1
* cell instance sg13cmos5l_fill_1_714 r0 *1 0,0
Xsg13cmos5l_fill_1_714 VPWR VGND sg13cmos5l_fill_1
* cell instance sg13cmos5l_fill_1_715 r0 *1 0,0
Xsg13cmos5l_fill_1_715 VPWR VGND sg13cmos5l_fill_1
* cell instance sg13cmos5l_fill_1_716 r0 *1 0,0
Xsg13cmos5l_fill_1_716 VPWR VGND sg13cmos5l_fill_1
* cell instance sg13cmos5l_fill_1_717 r0 *1 0,0
Xsg13cmos5l_fill_1_717 VPWR VGND sg13cmos5l_fill_1
* cell instance sg13cmos5l_fill_1_718 r0 *1 0,0
Xsg13cmos5l_fill_1_718 VPWR VGND sg13cmos5l_fill_1
* cell instance sg13cmos5l_fill_1_719 r0 *1 0,0
Xsg13cmos5l_fill_1_719 VPWR VGND sg13cmos5l_fill_1
* cell instance sg13cmos5l_fill_1_720 r0 *1 0,0
Xsg13cmos5l_fill_1_720 VPWR VGND sg13cmos5l_fill_1
* cell instance sg13cmos5l_fill_1_721 r0 *1 0,0
Xsg13cmos5l_fill_1_721 VPWR VGND sg13cmos5l_fill_1
* cell instance sg13cmos5l_fill_1_722 r0 *1 0,0
Xsg13cmos5l_fill_1_722 VPWR VGND sg13cmos5l_fill_1
* cell instance sg13cmos5l_fill_1_723 r0 *1 0,0
Xsg13cmos5l_fill_1_723 VPWR VGND sg13cmos5l_fill_1
* cell instance sg13cmos5l_fill_1_724 r0 *1 0,0
Xsg13cmos5l_fill_1_724 VPWR VGND sg13cmos5l_fill_1
* cell instance sg13cmos5l_fill_1_725 r0 *1 0,0
Xsg13cmos5l_fill_1_725 VPWR VGND sg13cmos5l_fill_1
* cell instance sg13cmos5l_fill_1_726 r0 *1 0,0
Xsg13cmos5l_fill_1_726 VPWR VGND sg13cmos5l_fill_1
* cell instance sg13cmos5l_fill_1_727 r0 *1 0,0
Xsg13cmos5l_fill_1_727 VPWR VGND sg13cmos5l_fill_1
* cell instance sg13cmos5l_fill_1_728 r0 *1 0,0
Xsg13cmos5l_fill_1_728 VPWR VGND sg13cmos5l_fill_1
* cell instance sg13cmos5l_fill_1_729 r0 *1 0,0
Xsg13cmos5l_fill_1_729 VPWR VGND sg13cmos5l_fill_1
* cell instance sg13cmos5l_fill_1_730 r0 *1 0,0
Xsg13cmos5l_fill_1_730 VPWR VGND sg13cmos5l_fill_1
* cell instance sg13cmos5l_fill_1_731 r0 *1 0,0
Xsg13cmos5l_fill_1_731 VPWR VGND sg13cmos5l_fill_1
* cell instance sg13cmos5l_fill_1_732 r0 *1 0,0
Xsg13cmos5l_fill_1_732 VPWR VGND sg13cmos5l_fill_1
* cell instance sg13cmos5l_fill_1_733 r0 *1 0,0
Xsg13cmos5l_fill_1_733 VPWR VGND sg13cmos5l_fill_1
* cell instance sg13cmos5l_fill_1_734 r0 *1 0,0
Xsg13cmos5l_fill_1_734 VPWR VGND sg13cmos5l_fill_1
* cell instance sg13cmos5l_fill_1_735 r0 *1 0,0
Xsg13cmos5l_fill_1_735 VPWR VGND sg13cmos5l_fill_1
* cell instance sg13cmos5l_fill_1_736 r0 *1 0,0
Xsg13cmos5l_fill_1_736 VPWR VGND sg13cmos5l_fill_1
* cell instance sg13cmos5l_fill_1_737 r0 *1 0,0
Xsg13cmos5l_fill_1_737 VPWR VGND sg13cmos5l_fill_1
* cell instance sg13cmos5l_fill_1_738 r0 *1 0,0
Xsg13cmos5l_fill_1_738 VPWR VGND sg13cmos5l_fill_1
* cell instance sg13cmos5l_fill_1_739 r0 *1 0,0
Xsg13cmos5l_fill_1_739 VPWR VGND sg13cmos5l_fill_1
* cell instance sg13cmos5l_fill_1_740 r0 *1 0,0
Xsg13cmos5l_fill_1_740 VPWR VGND sg13cmos5l_fill_1
* cell instance sg13cmos5l_fill_1_741 r0 *1 0,0
Xsg13cmos5l_fill_1_741 VPWR VGND sg13cmos5l_fill_1
* cell instance sg13cmos5l_fill_1_742 r0 *1 0,0
Xsg13cmos5l_fill_1_742 VPWR VGND sg13cmos5l_fill_1
* cell instance sg13cmos5l_fill_1_743 r0 *1 0,0
Xsg13cmos5l_fill_1_743 VPWR VGND sg13cmos5l_fill_1
* cell instance sg13cmos5l_fill_1_744 r0 *1 0,0
Xsg13cmos5l_fill_1_744 VPWR VGND sg13cmos5l_fill_1
* cell instance sg13cmos5l_fill_1_745 r0 *1 0,0
Xsg13cmos5l_fill_1_745 VPWR VGND sg13cmos5l_fill_1
* cell instance sg13cmos5l_fill_1_746 r0 *1 0,0
Xsg13cmos5l_fill_1_746 VPWR VGND sg13cmos5l_fill_1
* cell instance sg13cmos5l_fill_1_747 r0 *1 0,0
Xsg13cmos5l_fill_1_747 VPWR VGND sg13cmos5l_fill_1
* cell instance sg13cmos5l_fill_1_748 r0 *1 0,0
Xsg13cmos5l_fill_1_748 VPWR VGND sg13cmos5l_fill_1
* cell instance sg13cmos5l_fill_1_749 r0 *1 0,0
Xsg13cmos5l_fill_1_749 VPWR VGND sg13cmos5l_fill_1
* cell instance sg13cmos5l_fill_1_750 r0 *1 0,0
Xsg13cmos5l_fill_1_750 VPWR VGND sg13cmos5l_fill_1
* cell instance sg13cmos5l_fill_1_751 r0 *1 0,0
Xsg13cmos5l_fill_1_751 VPWR VGND sg13cmos5l_fill_1
* cell instance sg13cmos5l_fill_1_752 r0 *1 0,0
Xsg13cmos5l_fill_1_752 VPWR VGND sg13cmos5l_fill_1
* cell instance sg13cmos5l_fill_1_753 r0 *1 0,0
Xsg13cmos5l_fill_1_753 VPWR VGND sg13cmos5l_fill_1
* cell instance sg13cmos5l_fill_1_754 r0 *1 0,0
Xsg13cmos5l_fill_1_754 VPWR VGND sg13cmos5l_fill_1
* cell instance sg13cmos5l_fill_1_755 r0 *1 0,0
Xsg13cmos5l_fill_1_755 VPWR VGND sg13cmos5l_fill_1
* cell instance sg13cmos5l_fill_1_756 r0 *1 0,0
Xsg13cmos5l_fill_1_756 VPWR VGND sg13cmos5l_fill_1
* cell instance sg13cmos5l_fill_1_757 r0 *1 0,0
Xsg13cmos5l_fill_1_757 VPWR VGND sg13cmos5l_fill_1
* cell instance sg13cmos5l_fill_1_758 r0 *1 0,0
Xsg13cmos5l_fill_1_758 VPWR VGND sg13cmos5l_fill_1
* cell instance sg13cmos5l_fill_1_759 r0 *1 0,0
Xsg13cmos5l_fill_1_759 VPWR VGND sg13cmos5l_fill_1
* cell instance sg13cmos5l_fill_1_760 r0 *1 0,0
Xsg13cmos5l_fill_1_760 VPWR VGND sg13cmos5l_fill_1
* cell instance sg13cmos5l_fill_1_761 r0 *1 0,0
Xsg13cmos5l_fill_1_761 VPWR VGND sg13cmos5l_fill_1
* cell instance sg13cmos5l_fill_1_762 r0 *1 0,0
Xsg13cmos5l_fill_1_762 VPWR VGND sg13cmos5l_fill_1
* cell instance sg13cmos5l_fill_1_763 r0 *1 0,0
Xsg13cmos5l_fill_1_763 VPWR VGND sg13cmos5l_fill_1
* cell instance sg13cmos5l_fill_1_764 r0 *1 0,0
Xsg13cmos5l_fill_1_764 VPWR VGND sg13cmos5l_fill_1
* cell instance sg13cmos5l_fill_1_765 r0 *1 0,0
Xsg13cmos5l_fill_1_765 VPWR VGND sg13cmos5l_fill_1
* cell instance sg13cmos5l_fill_1_766 r0 *1 0,0
Xsg13cmos5l_fill_1_766 VPWR VGND sg13cmos5l_fill_1
* cell instance sg13cmos5l_fill_1_767 r0 *1 0,0
Xsg13cmos5l_fill_1_767 VPWR VGND sg13cmos5l_fill_1
* cell instance sg13cmos5l_fill_1_768 r0 *1 0,0
Xsg13cmos5l_fill_1_768 VPWR VGND sg13cmos5l_fill_1
* cell instance sg13cmos5l_fill_1_769 r0 *1 0,0
Xsg13cmos5l_fill_1_769 VPWR VGND sg13cmos5l_fill_1
* cell instance sg13cmos5l_fill_1_770 r0 *1 0,0
Xsg13cmos5l_fill_1_770 VPWR VGND sg13cmos5l_fill_1
* cell instance sg13cmos5l_fill_1_771 r0 *1 0,0
Xsg13cmos5l_fill_1_771 VPWR VGND sg13cmos5l_fill_1
* cell instance sg13cmos5l_fill_1_772 r0 *1 0,0
Xsg13cmos5l_fill_1_772 VPWR VGND sg13cmos5l_fill_1
* cell instance sg13cmos5l_fill_1_773 r0 *1 0,0
Xsg13cmos5l_fill_1_773 VPWR VGND sg13cmos5l_fill_1
* cell instance sg13cmos5l_fill_1_774 r0 *1 0,0
Xsg13cmos5l_fill_1_774 VPWR VGND sg13cmos5l_fill_1
* cell instance sg13cmos5l_fill_1_775 r0 *1 0,0
Xsg13cmos5l_fill_1_775 VPWR VGND sg13cmos5l_fill_1
* cell instance sg13cmos5l_fill_1_776 r0 *1 0,0
Xsg13cmos5l_fill_1_776 VPWR VGND sg13cmos5l_fill_1
* cell instance sg13cmos5l_fill_1_777 r0 *1 0,0
Xsg13cmos5l_fill_1_777 VPWR VGND sg13cmos5l_fill_1
* cell instance sg13cmos5l_fill_1_778 r0 *1 0,0
Xsg13cmos5l_fill_1_778 VPWR VGND sg13cmos5l_fill_1
* cell instance sg13cmos5l_fill_1_779 r0 *1 0,0
Xsg13cmos5l_fill_1_779 VPWR VGND sg13cmos5l_fill_1
* cell instance sg13cmos5l_fill_1_780 r0 *1 0,0
Xsg13cmos5l_fill_1_780 VPWR VGND sg13cmos5l_fill_1
* cell instance sg13cmos5l_fill_1_781 r0 *1 0,0
Xsg13cmos5l_fill_1_781 VPWR VGND sg13cmos5l_fill_1
* cell instance sg13cmos5l_fill_1_782 r0 *1 0,0
Xsg13cmos5l_fill_1_782 VPWR VGND sg13cmos5l_fill_1
* cell instance sg13cmos5l_fill_1_783 r0 *1 0,0
Xsg13cmos5l_fill_1_783 VPWR VGND sg13cmos5l_fill_1
* cell instance sg13cmos5l_fill_1_784 r0 *1 0,0
Xsg13cmos5l_fill_1_784 VPWR VGND sg13cmos5l_fill_1
* cell instance sg13cmos5l_fill_1_785 r0 *1 0,0
Xsg13cmos5l_fill_1_785 VPWR VGND sg13cmos5l_fill_1
* cell instance sg13cmos5l_fill_1_786 r0 *1 0,0
Xsg13cmos5l_fill_1_786 VPWR VGND sg13cmos5l_fill_1
* cell instance sg13cmos5l_fill_1_787 r0 *1 0,0
Xsg13cmos5l_fill_1_787 VPWR VGND sg13cmos5l_fill_1
* cell instance sg13cmos5l_fill_1_788 r0 *1 0,0
Xsg13cmos5l_fill_1_788 VPWR VGND sg13cmos5l_fill_1
* cell instance sg13cmos5l_fill_1_789 r0 *1 0,0
Xsg13cmos5l_fill_1_789 VPWR VGND sg13cmos5l_fill_1
* cell instance sg13cmos5l_fill_1_790 r0 *1 0,0
Xsg13cmos5l_fill_1_790 VPWR VGND sg13cmos5l_fill_1
* cell instance sg13cmos5l_fill_1_791 r0 *1 0,0
Xsg13cmos5l_fill_1_791 VPWR VGND sg13cmos5l_fill_1
* cell instance sg13cmos5l_fill_1_792 r0 *1 0,0
Xsg13cmos5l_fill_1_792 VPWR VGND sg13cmos5l_fill_1
* cell instance sg13cmos5l_fill_1_793 r0 *1 0,0
Xsg13cmos5l_fill_1_793 VPWR VGND sg13cmos5l_fill_1
* cell instance sg13cmos5l_fill_1_794 r0 *1 0,0
Xsg13cmos5l_fill_1_794 VPWR VGND sg13cmos5l_fill_1
* cell instance sg13cmos5l_fill_1_795 r0 *1 0,0
Xsg13cmos5l_fill_1_795 VPWR VGND sg13cmos5l_fill_1
* cell instance sg13cmos5l_fill_1_796 r0 *1 0,0
Xsg13cmos5l_fill_1_796 VPWR VGND sg13cmos5l_fill_1
* cell instance sg13cmos5l_fill_1_797 r0 *1 0,0
Xsg13cmos5l_fill_1_797 VPWR VGND sg13cmos5l_fill_1
* cell instance sg13cmos5l_fill_1_798 r0 *1 0,0
Xsg13cmos5l_fill_1_798 VPWR VGND sg13cmos5l_fill_1
* cell instance sg13cmos5l_fill_1_799 r0 *1 0,0
Xsg13cmos5l_fill_1_799 VPWR VGND sg13cmos5l_fill_1
* cell instance sg13cmos5l_fill_1_800 r0 *1 0,0
Xsg13cmos5l_fill_1_800 VPWR VGND sg13cmos5l_fill_1
* cell instance sg13cmos5l_fill_1_801 r0 *1 0,0
Xsg13cmos5l_fill_1_801 VPWR VGND sg13cmos5l_fill_1
* cell instance sg13cmos5l_fill_1_802 r0 *1 0,0
Xsg13cmos5l_fill_1_802 VPWR VGND sg13cmos5l_fill_1
* cell instance sg13cmos5l_fill_1_803 r0 *1 0,0
Xsg13cmos5l_fill_1_803 VPWR VGND sg13cmos5l_fill_1
* cell instance sg13cmos5l_fill_1_804 r0 *1 0,0
Xsg13cmos5l_fill_1_804 VPWR VGND sg13cmos5l_fill_1
* cell instance sg13cmos5l_fill_1_805 r0 *1 0,0
Xsg13cmos5l_fill_1_805 VPWR VGND sg13cmos5l_fill_1
* cell instance sg13cmos5l_fill_1_806 r0 *1 0,0
Xsg13cmos5l_fill_1_806 VPWR VGND sg13cmos5l_fill_1
* cell instance sg13cmos5l_fill_1_807 r0 *1 0,0
Xsg13cmos5l_fill_1_807 VPWR VGND sg13cmos5l_fill_1
* cell instance sg13cmos5l_fill_1_808 r0 *1 0,0
Xsg13cmos5l_fill_1_808 VPWR VGND sg13cmos5l_fill_1
* cell instance sg13cmos5l_fill_1_809 r0 *1 0,0
Xsg13cmos5l_fill_1_809 VPWR VGND sg13cmos5l_fill_1
* cell instance sg13cmos5l_fill_1_810 r0 *1 0,0
Xsg13cmos5l_fill_1_810 VPWR VGND sg13cmos5l_fill_1
* cell instance sg13cmos5l_fill_1_811 r0 *1 0,0
Xsg13cmos5l_fill_1_811 VPWR VGND sg13cmos5l_fill_1
* cell instance sg13cmos5l_fill_1_812 r0 *1 0,0
Xsg13cmos5l_fill_1_812 VPWR VGND sg13cmos5l_fill_1
* cell instance sg13cmos5l_fill_1_813 r0 *1 0,0
Xsg13cmos5l_fill_1_813 VPWR VGND sg13cmos5l_fill_1
* cell instance sg13cmos5l_fill_1_814 r0 *1 0,0
Xsg13cmos5l_fill_1_814 VPWR VGND sg13cmos5l_fill_1
* cell instance sg13cmos5l_fill_1_815 r0 *1 0,0
Xsg13cmos5l_fill_1_815 VPWR VGND sg13cmos5l_fill_1
* cell instance sg13cmos5l_fill_1_816 r0 *1 0,0
Xsg13cmos5l_fill_1_816 VPWR VGND sg13cmos5l_fill_1
* cell instance sg13cmos5l_fill_1_817 r0 *1 0,0
Xsg13cmos5l_fill_1_817 VPWR VGND sg13cmos5l_fill_1
* cell instance sg13cmos5l_fill_1_818 r0 *1 0,0
Xsg13cmos5l_fill_1_818 VPWR VGND sg13cmos5l_fill_1
* cell instance sg13cmos5l_fill_1_819 r0 *1 0,0
Xsg13cmos5l_fill_1_819 VPWR VGND sg13cmos5l_fill_1
* cell instance sg13cmos5l_fill_1_820 r0 *1 0,0
Xsg13cmos5l_fill_1_820 VPWR VGND sg13cmos5l_fill_1
* cell instance sg13cmos5l_fill_1_821 r0 *1 0,0
Xsg13cmos5l_fill_1_821 VPWR VGND sg13cmos5l_fill_1
* cell instance sg13cmos5l_fill_1_822 r0 *1 0,0
Xsg13cmos5l_fill_1_822 VPWR VGND sg13cmos5l_fill_1
* cell instance sg13cmos5l_fill_1_823 r0 *1 0,0
Xsg13cmos5l_fill_1_823 VPWR VGND sg13cmos5l_fill_1
* cell instance sg13cmos5l_fill_1_824 r0 *1 0,0
Xsg13cmos5l_fill_1_824 VPWR VGND sg13cmos5l_fill_1
* cell instance sg13cmos5l_fill_1_825 r0 *1 0,0
Xsg13cmos5l_fill_1_825 VPWR VGND sg13cmos5l_fill_1
* cell instance sg13cmos5l_fill_1_826 r0 *1 0,0
Xsg13cmos5l_fill_1_826 VPWR VGND sg13cmos5l_fill_1
* cell instance sg13cmos5l_fill_1_827 r0 *1 0,0
Xsg13cmos5l_fill_1_827 VPWR VGND sg13cmos5l_fill_1
* cell instance sg13cmos5l_fill_1_828 r0 *1 0,0
Xsg13cmos5l_fill_1_828 VPWR VGND sg13cmos5l_fill_1
* cell instance sg13cmos5l_fill_1_829 r0 *1 0,0
Xsg13cmos5l_fill_1_829 VPWR VGND sg13cmos5l_fill_1
* cell instance sg13cmos5l_fill_1_830 r0 *1 0,0
Xsg13cmos5l_fill_1_830 VPWR VGND sg13cmos5l_fill_1
* cell instance sg13cmos5l_fill_1_831 r0 *1 0,0
Xsg13cmos5l_fill_1_831 VPWR VGND sg13cmos5l_fill_1
* cell instance sg13cmos5l_fill_1_832 r0 *1 0,0
Xsg13cmos5l_fill_1_832 VPWR VGND sg13cmos5l_fill_1
* cell instance sg13cmos5l_fill_1_833 r0 *1 0,0
Xsg13cmos5l_fill_1_833 VPWR VGND sg13cmos5l_fill_1
* cell instance sg13cmos5l_fill_1_834 r0 *1 0,0
Xsg13cmos5l_fill_1_834 VPWR VGND sg13cmos5l_fill_1
* cell instance sg13cmos5l_fill_1_835 r0 *1 0,0
Xsg13cmos5l_fill_1_835 VPWR VGND sg13cmos5l_fill_1
* cell instance sg13cmos5l_fill_1_836 r0 *1 0,0
Xsg13cmos5l_fill_1_836 VPWR VGND sg13cmos5l_fill_1
* cell instance sg13cmos5l_fill_1_837 r0 *1 0,0
Xsg13cmos5l_fill_1_837 VPWR VGND sg13cmos5l_fill_1
* cell instance sg13cmos5l_fill_1_838 r0 *1 0,0
Xsg13cmos5l_fill_1_838 VPWR VGND sg13cmos5l_fill_1
* cell instance sg13cmos5l_fill_1_839 r0 *1 0,0
Xsg13cmos5l_fill_1_839 VPWR VGND sg13cmos5l_fill_1
* cell instance sg13cmos5l_fill_1_840 r0 *1 0,0
Xsg13cmos5l_fill_1_840 VPWR VGND sg13cmos5l_fill_1
* cell instance sg13cmos5l_fill_1_841 r0 *1 0,0
Xsg13cmos5l_fill_1_841 VPWR VGND sg13cmos5l_fill_1
* cell instance sg13cmos5l_fill_1_842 r0 *1 0,0
Xsg13cmos5l_fill_1_842 VPWR VGND sg13cmos5l_fill_1
* cell instance sg13cmos5l_fill_1_843 r0 *1 0,0
Xsg13cmos5l_fill_1_843 VPWR VGND sg13cmos5l_fill_1
* cell instance sg13cmos5l_fill_1_844 r0 *1 0,0
Xsg13cmos5l_fill_1_844 VPWR VGND sg13cmos5l_fill_1
* cell instance sg13cmos5l_fill_1_845 r0 *1 0,0
Xsg13cmos5l_fill_1_845 VPWR VGND sg13cmos5l_fill_1
* cell instance sg13cmos5l_fill_1_846 r0 *1 0,0
Xsg13cmos5l_fill_1_846 VPWR VGND sg13cmos5l_fill_1
* cell instance sg13cmos5l_fill_1_847 r0 *1 0,0
Xsg13cmos5l_fill_1_847 VPWR VGND sg13cmos5l_fill_1
* cell instance sg13cmos5l_fill_1_848 r0 *1 0,0
Xsg13cmos5l_fill_1_848 VPWR VGND sg13cmos5l_fill_1
* cell instance sg13cmos5l_fill_1_849 r0 *1 0,0
Xsg13cmos5l_fill_1_849 VPWR VGND sg13cmos5l_fill_1
* cell instance sg13cmos5l_fill_1_850 r0 *1 0,0
Xsg13cmos5l_fill_1_850 VPWR VGND sg13cmos5l_fill_1
* cell instance sg13cmos5l_fill_1_851 r0 *1 0,0
Xsg13cmos5l_fill_1_851 VPWR VGND sg13cmos5l_fill_1
* cell instance sg13cmos5l_fill_1_852 r0 *1 0,0
Xsg13cmos5l_fill_1_852 VPWR VGND sg13cmos5l_fill_1
* cell instance sg13cmos5l_fill_1_853 r0 *1 0,0
Xsg13cmos5l_fill_1_853 VPWR VGND sg13cmos5l_fill_1
* cell instance sg13cmos5l_fill_1_854 r0 *1 0,0
Xsg13cmos5l_fill_1_854 VPWR VGND sg13cmos5l_fill_1
* cell instance sg13cmos5l_fill_1_855 r0 *1 0,0
Xsg13cmos5l_fill_1_855 VPWR VGND sg13cmos5l_fill_1
* cell instance sg13cmos5l_fill_1_856 r0 *1 0,0
Xsg13cmos5l_fill_1_856 VPWR VGND sg13cmos5l_fill_1
* cell instance sg13cmos5l_fill_1_857 r0 *1 0,0
Xsg13cmos5l_fill_1_857 VPWR VGND sg13cmos5l_fill_1
* cell instance sg13cmos5l_fill_1_858 r0 *1 0,0
Xsg13cmos5l_fill_1_858 VPWR VGND sg13cmos5l_fill_1
* cell instance sg13cmos5l_fill_1_859 r0 *1 0,0
Xsg13cmos5l_fill_1_859 VPWR VGND sg13cmos5l_fill_1
* cell instance sg13cmos5l_fill_1_860 r0 *1 0,0
Xsg13cmos5l_fill_1_860 VPWR VGND sg13cmos5l_fill_1
* cell instance sg13cmos5l_fill_1_861 r0 *1 0,0
Xsg13cmos5l_fill_1_861 VPWR VGND sg13cmos5l_fill_1
* cell instance sg13cmos5l_fill_1_862 r0 *1 0,0
Xsg13cmos5l_fill_1_862 VPWR VGND sg13cmos5l_fill_1
* cell instance sg13cmos5l_fill_1_863 r0 *1 0,0
Xsg13cmos5l_fill_1_863 VPWR VGND sg13cmos5l_fill_1
* cell instance sg13cmos5l_fill_1_864 r0 *1 0,0
Xsg13cmos5l_fill_1_864 VPWR VGND sg13cmos5l_fill_1
* cell instance sg13cmos5l_fill_1_865 r0 *1 0,0
Xsg13cmos5l_fill_1_865 VPWR VGND sg13cmos5l_fill_1
* cell instance sg13cmos5l_fill_1_866 r0 *1 0,0
Xsg13cmos5l_fill_1_866 VPWR VGND sg13cmos5l_fill_1
* cell instance sg13cmos5l_fill_1_867 r0 *1 0,0
Xsg13cmos5l_fill_1_867 VPWR VGND sg13cmos5l_fill_1
* cell instance sg13cmos5l_fill_1_868 r0 *1 0,0
Xsg13cmos5l_fill_1_868 VPWR VGND sg13cmos5l_fill_1
* cell instance sg13cmos5l_fill_1_869 r0 *1 0,0
Xsg13cmos5l_fill_1_869 VPWR VGND sg13cmos5l_fill_1
* cell instance sg13cmos5l_fill_1_870 r0 *1 0,0
Xsg13cmos5l_fill_1_870 VPWR VGND sg13cmos5l_fill_1
* cell instance sg13cmos5l_fill_1_871 r0 *1 0,0
Xsg13cmos5l_fill_1_871 VPWR VGND sg13cmos5l_fill_1
* cell instance sg13cmos5l_fill_1_872 r0 *1 0,0
Xsg13cmos5l_fill_1_872 VPWR VGND sg13cmos5l_fill_1
* cell instance sg13cmos5l_fill_1_873 r0 *1 0,0
Xsg13cmos5l_fill_1_873 VPWR VGND sg13cmos5l_fill_1
* cell instance sg13cmos5l_fill_1_874 r0 *1 0,0
Xsg13cmos5l_fill_1_874 VPWR VGND sg13cmos5l_fill_1
* cell instance sg13cmos5l_fill_1_875 r0 *1 0,0
Xsg13cmos5l_fill_1_875 VPWR VGND sg13cmos5l_fill_1
* cell instance sg13cmos5l_fill_1_876 r0 *1 0,0
Xsg13cmos5l_fill_1_876 VPWR VGND sg13cmos5l_fill_1
* cell instance sg13cmos5l_fill_1_877 r0 *1 0,0
Xsg13cmos5l_fill_1_877 VPWR VGND sg13cmos5l_fill_1
* cell instance sg13cmos5l_fill_1_878 r0 *1 0,0
Xsg13cmos5l_fill_1_878 VPWR VGND sg13cmos5l_fill_1
* cell instance sg13cmos5l_fill_1_879 r0 *1 0,0
Xsg13cmos5l_fill_1_879 VPWR VGND sg13cmos5l_fill_1
* cell instance sg13cmos5l_fill_1_880 r0 *1 0,0
Xsg13cmos5l_fill_1_880 VPWR VGND sg13cmos5l_fill_1
* cell instance sg13cmos5l_fill_1_881 r0 *1 0,0
Xsg13cmos5l_fill_1_881 VPWR VGND sg13cmos5l_fill_1
* cell instance sg13cmos5l_fill_1_882 r0 *1 0,0
Xsg13cmos5l_fill_1_882 VPWR VGND sg13cmos5l_fill_1
* cell instance sg13cmos5l_fill_1_883 r0 *1 0,0
Xsg13cmos5l_fill_1_883 VPWR VGND sg13cmos5l_fill_1
* cell instance sg13cmos5l_fill_1_884 r0 *1 0,0
Xsg13cmos5l_fill_1_884 VPWR VGND sg13cmos5l_fill_1
* cell instance sg13cmos5l_fill_2_0 r0 *1 0,0
Xsg13cmos5l_fill_2_0 VPWR VGND sg13cmos5l_fill_2
* cell instance sg13cmos5l_fill_2_1 r0 *1 0,0
Xsg13cmos5l_fill_2_1 VPWR VGND sg13cmos5l_fill_2
* cell instance sg13cmos5l_fill_2_2 r0 *1 0,0
Xsg13cmos5l_fill_2_2 VPWR VGND sg13cmos5l_fill_2
* cell instance sg13cmos5l_fill_2_3 r0 *1 0,0
Xsg13cmos5l_fill_2_3 VPWR VGND sg13cmos5l_fill_2
* cell instance sg13cmos5l_fill_2_4 r0 *1 0,0
Xsg13cmos5l_fill_2_4 VPWR VGND sg13cmos5l_fill_2
* cell instance sg13cmos5l_fill_2_5 r0 *1 0,0
Xsg13cmos5l_fill_2_5 VPWR VGND sg13cmos5l_fill_2
* cell instance sg13cmos5l_fill_2_6 r0 *1 0,0
Xsg13cmos5l_fill_2_6 VPWR VGND sg13cmos5l_fill_2
* cell instance sg13cmos5l_fill_2_7 r0 *1 0,0
Xsg13cmos5l_fill_2_7 VPWR VGND sg13cmos5l_fill_2
* cell instance sg13cmos5l_fill_2_8 r0 *1 0,0
Xsg13cmos5l_fill_2_8 VPWR VGND sg13cmos5l_fill_2
* cell instance sg13cmos5l_fill_2_9 r0 *1 0,0
Xsg13cmos5l_fill_2_9 VPWR VGND sg13cmos5l_fill_2
* cell instance sg13cmos5l_fill_2_10 r0 *1 0,0
Xsg13cmos5l_fill_2_10 VPWR VGND sg13cmos5l_fill_2
* cell instance sg13cmos5l_fill_2_11 r0 *1 0,0
Xsg13cmos5l_fill_2_11 VPWR VGND sg13cmos5l_fill_2
* cell instance sg13cmos5l_fill_2_12 r0 *1 0,0
Xsg13cmos5l_fill_2_12 VPWR VGND sg13cmos5l_fill_2
* cell instance sg13cmos5l_fill_2_13 r0 *1 0,0
Xsg13cmos5l_fill_2_13 VPWR VGND sg13cmos5l_fill_2
* cell instance sg13cmos5l_fill_2_14 r0 *1 0,0
Xsg13cmos5l_fill_2_14 VPWR VGND sg13cmos5l_fill_2
* cell instance sg13cmos5l_fill_2_15 r0 *1 0,0
Xsg13cmos5l_fill_2_15 VPWR VGND sg13cmos5l_fill_2
* cell instance sg13cmos5l_fill_2_16 r0 *1 0,0
Xsg13cmos5l_fill_2_16 VPWR VGND sg13cmos5l_fill_2
* cell instance sg13cmos5l_fill_2_17 r0 *1 0,0
Xsg13cmos5l_fill_2_17 VPWR VGND sg13cmos5l_fill_2
* cell instance sg13cmos5l_fill_2_18 r0 *1 0,0
Xsg13cmos5l_fill_2_18 VPWR VGND sg13cmos5l_fill_2
* cell instance sg13cmos5l_fill_2_19 r0 *1 0,0
Xsg13cmos5l_fill_2_19 VPWR VGND sg13cmos5l_fill_2
* cell instance sg13cmos5l_fill_2_20 r0 *1 0,0
Xsg13cmos5l_fill_2_20 VPWR VGND sg13cmos5l_fill_2
* cell instance sg13cmos5l_fill_2_21 r0 *1 0,0
Xsg13cmos5l_fill_2_21 VPWR VGND sg13cmos5l_fill_2
* cell instance sg13cmos5l_fill_2_22 r0 *1 0,0
Xsg13cmos5l_fill_2_22 VPWR VGND sg13cmos5l_fill_2
* cell instance sg13cmos5l_fill_2_23 r0 *1 0,0
Xsg13cmos5l_fill_2_23 VPWR VGND sg13cmos5l_fill_2
* cell instance sg13cmos5l_fill_2_24 r0 *1 0,0
Xsg13cmos5l_fill_2_24 VPWR VGND sg13cmos5l_fill_2
* cell instance sg13cmos5l_fill_2_25 r0 *1 0,0
Xsg13cmos5l_fill_2_25 VPWR VGND sg13cmos5l_fill_2
* cell instance sg13cmos5l_fill_2_26 r0 *1 0,0
Xsg13cmos5l_fill_2_26 VPWR VGND sg13cmos5l_fill_2
* cell instance sg13cmos5l_fill_2_27 r0 *1 0,0
Xsg13cmos5l_fill_2_27 VPWR VGND sg13cmos5l_fill_2
* cell instance sg13cmos5l_fill_2_28 r0 *1 0,0
Xsg13cmos5l_fill_2_28 VPWR VGND sg13cmos5l_fill_2
* cell instance sg13cmos5l_fill_2_29 r0 *1 0,0
Xsg13cmos5l_fill_2_29 VPWR VGND sg13cmos5l_fill_2
* cell instance sg13cmos5l_fill_2_30 r0 *1 0,0
Xsg13cmos5l_fill_2_30 VPWR VGND sg13cmos5l_fill_2
* cell instance sg13cmos5l_fill_2_31 r0 *1 0,0
Xsg13cmos5l_fill_2_31 VPWR VGND sg13cmos5l_fill_2
* cell instance sg13cmos5l_fill_2_32 r0 *1 0,0
Xsg13cmos5l_fill_2_32 VPWR VGND sg13cmos5l_fill_2
* cell instance sg13cmos5l_fill_2_33 r0 *1 0,0
Xsg13cmos5l_fill_2_33 VPWR VGND sg13cmos5l_fill_2
* cell instance sg13cmos5l_fill_2_34 r0 *1 0,0
Xsg13cmos5l_fill_2_34 VPWR VGND sg13cmos5l_fill_2
* cell instance sg13cmos5l_fill_2_35 r0 *1 0,0
Xsg13cmos5l_fill_2_35 VPWR VGND sg13cmos5l_fill_2
* cell instance sg13cmos5l_fill_2_36 r0 *1 0,0
Xsg13cmos5l_fill_2_36 VPWR VGND sg13cmos5l_fill_2
* cell instance sg13cmos5l_fill_2_37 r0 *1 0,0
Xsg13cmos5l_fill_2_37 VPWR VGND sg13cmos5l_fill_2
* cell instance sg13cmos5l_fill_2_38 r0 *1 0,0
Xsg13cmos5l_fill_2_38 VPWR VGND sg13cmos5l_fill_2
* cell instance sg13cmos5l_fill_2_39 r0 *1 0,0
Xsg13cmos5l_fill_2_39 VPWR VGND sg13cmos5l_fill_2
* cell instance sg13cmos5l_fill_2_40 r0 *1 0,0
Xsg13cmos5l_fill_2_40 VPWR VGND sg13cmos5l_fill_2
* cell instance sg13cmos5l_fill_2_41 r0 *1 0,0
Xsg13cmos5l_fill_2_41 VPWR VGND sg13cmos5l_fill_2
* cell instance sg13cmos5l_fill_2_42 r0 *1 0,0
Xsg13cmos5l_fill_2_42 VPWR VGND sg13cmos5l_fill_2
* cell instance sg13cmos5l_fill_2_43 r0 *1 0,0
Xsg13cmos5l_fill_2_43 VPWR VGND sg13cmos5l_fill_2
* cell instance sg13cmos5l_fill_2_44 r0 *1 0,0
Xsg13cmos5l_fill_2_44 VPWR VGND sg13cmos5l_fill_2
* cell instance sg13cmos5l_fill_2_45 r0 *1 0,0
Xsg13cmos5l_fill_2_45 VPWR VGND sg13cmos5l_fill_2
* cell instance sg13cmos5l_fill_2_46 r0 *1 0,0
Xsg13cmos5l_fill_2_46 VPWR VGND sg13cmos5l_fill_2
* cell instance sg13cmos5l_fill_2_47 r0 *1 0,0
Xsg13cmos5l_fill_2_47 VPWR VGND sg13cmos5l_fill_2
* cell instance sg13cmos5l_fill_2_48 r0 *1 0,0
Xsg13cmos5l_fill_2_48 VPWR VGND sg13cmos5l_fill_2
* cell instance sg13cmos5l_fill_2_49 r0 *1 0,0
Xsg13cmos5l_fill_2_49 VPWR VGND sg13cmos5l_fill_2
* cell instance sg13cmos5l_fill_2_50 r0 *1 0,0
Xsg13cmos5l_fill_2_50 VPWR VGND sg13cmos5l_fill_2
* cell instance sg13cmos5l_fill_2_51 r0 *1 0,0
Xsg13cmos5l_fill_2_51 VPWR VGND sg13cmos5l_fill_2
* cell instance sg13cmos5l_fill_2_52 r0 *1 0,0
Xsg13cmos5l_fill_2_52 VPWR VGND sg13cmos5l_fill_2
* cell instance sg13cmos5l_fill_2_53 r0 *1 0,0
Xsg13cmos5l_fill_2_53 VPWR VGND sg13cmos5l_fill_2
* cell instance sg13cmos5l_fill_2_54 r0 *1 0,0
Xsg13cmos5l_fill_2_54 VPWR VGND sg13cmos5l_fill_2
* cell instance sg13cmos5l_fill_2_55 r0 *1 0,0
Xsg13cmos5l_fill_2_55 VPWR VGND sg13cmos5l_fill_2
* cell instance sg13cmos5l_fill_2_56 r0 *1 0,0
Xsg13cmos5l_fill_2_56 VPWR VGND sg13cmos5l_fill_2
* cell instance sg13cmos5l_fill_2_57 r0 *1 0,0
Xsg13cmos5l_fill_2_57 VPWR VGND sg13cmos5l_fill_2
* cell instance sg13cmos5l_fill_2_58 r0 *1 0,0
Xsg13cmos5l_fill_2_58 VPWR VGND sg13cmos5l_fill_2
* cell instance sg13cmos5l_fill_2_59 r0 *1 0,0
Xsg13cmos5l_fill_2_59 VPWR VGND sg13cmos5l_fill_2
* cell instance sg13cmos5l_fill_2_60 r0 *1 0,0
Xsg13cmos5l_fill_2_60 VPWR VGND sg13cmos5l_fill_2
* cell instance sg13cmos5l_fill_2_61 r0 *1 0,0
Xsg13cmos5l_fill_2_61 VPWR VGND sg13cmos5l_fill_2
* cell instance sg13cmos5l_fill_2_62 r0 *1 0,0
Xsg13cmos5l_fill_2_62 VPWR VGND sg13cmos5l_fill_2
* cell instance sg13cmos5l_fill_2_63 r0 *1 0,0
Xsg13cmos5l_fill_2_63 VPWR VGND sg13cmos5l_fill_2
* cell instance sg13cmos5l_fill_2_64 r0 *1 0,0
Xsg13cmos5l_fill_2_64 VPWR VGND sg13cmos5l_fill_2
* cell instance sg13cmos5l_fill_2_65 r0 *1 0,0
Xsg13cmos5l_fill_2_65 VPWR VGND sg13cmos5l_fill_2
* cell instance sg13cmos5l_fill_2_66 r0 *1 0,0
Xsg13cmos5l_fill_2_66 VPWR VGND sg13cmos5l_fill_2
* cell instance sg13cmos5l_fill_2_67 r0 *1 0,0
Xsg13cmos5l_fill_2_67 VPWR VGND sg13cmos5l_fill_2
* cell instance sg13cmos5l_fill_2_68 r0 *1 0,0
Xsg13cmos5l_fill_2_68 VPWR VGND sg13cmos5l_fill_2
* cell instance sg13cmos5l_fill_2_69 r0 *1 0,0
Xsg13cmos5l_fill_2_69 VPWR VGND sg13cmos5l_fill_2
* cell instance sg13cmos5l_fill_2_70 r0 *1 0,0
Xsg13cmos5l_fill_2_70 VPWR VGND sg13cmos5l_fill_2
* cell instance sg13cmos5l_fill_2_71 r0 *1 0,0
Xsg13cmos5l_fill_2_71 VPWR VGND sg13cmos5l_fill_2
* cell instance sg13cmos5l_fill_2_72 r0 *1 0,0
Xsg13cmos5l_fill_2_72 VPWR VGND sg13cmos5l_fill_2
* cell instance sg13cmos5l_fill_2_73 r0 *1 0,0
Xsg13cmos5l_fill_2_73 VPWR VGND sg13cmos5l_fill_2
* cell instance sg13cmos5l_fill_2_74 r0 *1 0,0
Xsg13cmos5l_fill_2_74 VPWR VGND sg13cmos5l_fill_2
* cell instance sg13cmos5l_fill_2_75 r0 *1 0,0
Xsg13cmos5l_fill_2_75 VPWR VGND sg13cmos5l_fill_2
* cell instance sg13cmos5l_fill_2_76 r0 *1 0,0
Xsg13cmos5l_fill_2_76 VPWR VGND sg13cmos5l_fill_2
* cell instance sg13cmos5l_fill_2_77 r0 *1 0,0
Xsg13cmos5l_fill_2_77 VPWR VGND sg13cmos5l_fill_2
* cell instance sg13cmos5l_fill_2_78 r0 *1 0,0
Xsg13cmos5l_fill_2_78 VPWR VGND sg13cmos5l_fill_2
* cell instance sg13cmos5l_fill_2_79 r0 *1 0,0
Xsg13cmos5l_fill_2_79 VPWR VGND sg13cmos5l_fill_2
* cell instance sg13cmos5l_fill_2_80 r0 *1 0,0
Xsg13cmos5l_fill_2_80 VPWR VGND sg13cmos5l_fill_2
* cell instance sg13cmos5l_fill_2_81 r0 *1 0,0
Xsg13cmos5l_fill_2_81 VPWR VGND sg13cmos5l_fill_2
* cell instance sg13cmos5l_fill_2_82 r0 *1 0,0
Xsg13cmos5l_fill_2_82 VPWR VGND sg13cmos5l_fill_2
* cell instance sg13cmos5l_fill_2_83 r0 *1 0,0
Xsg13cmos5l_fill_2_83 VPWR VGND sg13cmos5l_fill_2
* cell instance sg13cmos5l_fill_2_84 r0 *1 0,0
Xsg13cmos5l_fill_2_84 VPWR VGND sg13cmos5l_fill_2
* cell instance sg13cmos5l_fill_2_85 r0 *1 0,0
Xsg13cmos5l_fill_2_85 VPWR VGND sg13cmos5l_fill_2
* cell instance sg13cmos5l_fill_2_86 r0 *1 0,0
Xsg13cmos5l_fill_2_86 VPWR VGND sg13cmos5l_fill_2
* cell instance sg13cmos5l_fill_2_87 r0 *1 0,0
Xsg13cmos5l_fill_2_87 VPWR VGND sg13cmos5l_fill_2
* cell instance sg13cmos5l_fill_2_88 r0 *1 0,0
Xsg13cmos5l_fill_2_88 VPWR VGND sg13cmos5l_fill_2
* cell instance sg13cmos5l_fill_2_89 r0 *1 0,0
Xsg13cmos5l_fill_2_89 VPWR VGND sg13cmos5l_fill_2
* cell instance sg13cmos5l_fill_2_90 r0 *1 0,0
Xsg13cmos5l_fill_2_90 VPWR VGND sg13cmos5l_fill_2
* cell instance sg13cmos5l_fill_2_91 r0 *1 0,0
Xsg13cmos5l_fill_2_91 VPWR VGND sg13cmos5l_fill_2
* cell instance sg13cmos5l_fill_2_92 r0 *1 0,0
Xsg13cmos5l_fill_2_92 VPWR VGND sg13cmos5l_fill_2
* cell instance sg13cmos5l_fill_2_93 r0 *1 0,0
Xsg13cmos5l_fill_2_93 VPWR VGND sg13cmos5l_fill_2
* cell instance sg13cmos5l_fill_2_94 r0 *1 0,0
Xsg13cmos5l_fill_2_94 VPWR VGND sg13cmos5l_fill_2
* cell instance sg13cmos5l_fill_2_95 r0 *1 0,0
Xsg13cmos5l_fill_2_95 VPWR VGND sg13cmos5l_fill_2
* cell instance sg13cmos5l_fill_2_96 r0 *1 0,0
Xsg13cmos5l_fill_2_96 VPWR VGND sg13cmos5l_fill_2
* cell instance sg13cmos5l_fill_2_97 r0 *1 0,0
Xsg13cmos5l_fill_2_97 VPWR VGND sg13cmos5l_fill_2
* cell instance sg13cmos5l_fill_2_98 r0 *1 0,0
Xsg13cmos5l_fill_2_98 VPWR VGND sg13cmos5l_fill_2
* cell instance sg13cmos5l_fill_2_99 r0 *1 0,0
Xsg13cmos5l_fill_2_99 VPWR VGND sg13cmos5l_fill_2
* cell instance sg13cmos5l_fill_2_100 r0 *1 0,0
Xsg13cmos5l_fill_2_100 VPWR VGND sg13cmos5l_fill_2
* cell instance sg13cmos5l_fill_2_101 r0 *1 0,0
Xsg13cmos5l_fill_2_101 VPWR VGND sg13cmos5l_fill_2
* cell instance sg13cmos5l_fill_2_102 r0 *1 0,0
Xsg13cmos5l_fill_2_102 VPWR VGND sg13cmos5l_fill_2
* cell instance sg13cmos5l_fill_2_103 r0 *1 0,0
Xsg13cmos5l_fill_2_103 VPWR VGND sg13cmos5l_fill_2
* cell instance sg13cmos5l_fill_2_104 r0 *1 0,0
Xsg13cmos5l_fill_2_104 VPWR VGND sg13cmos5l_fill_2
* cell instance sg13cmos5l_fill_2_105 r0 *1 0,0
Xsg13cmos5l_fill_2_105 VPWR VGND sg13cmos5l_fill_2
* cell instance sg13cmos5l_fill_2_106 r0 *1 0,0
Xsg13cmos5l_fill_2_106 VPWR VGND sg13cmos5l_fill_2
* cell instance sg13cmos5l_fill_2_107 r0 *1 0,0
Xsg13cmos5l_fill_2_107 VPWR VGND sg13cmos5l_fill_2
* cell instance sg13cmos5l_fill_2_108 r0 *1 0,0
Xsg13cmos5l_fill_2_108 VPWR VGND sg13cmos5l_fill_2
* cell instance sg13cmos5l_fill_2_109 r0 *1 0,0
Xsg13cmos5l_fill_2_109 VPWR VGND sg13cmos5l_fill_2
* cell instance sg13cmos5l_fill_2_110 r0 *1 0,0
Xsg13cmos5l_fill_2_110 VPWR VGND sg13cmos5l_fill_2
* cell instance sg13cmos5l_fill_2_111 r0 *1 0,0
Xsg13cmos5l_fill_2_111 VPWR VGND sg13cmos5l_fill_2
* cell instance sg13cmos5l_fill_2_112 r0 *1 0,0
Xsg13cmos5l_fill_2_112 VPWR VGND sg13cmos5l_fill_2
* cell instance sg13cmos5l_fill_2_113 r0 *1 0,0
Xsg13cmos5l_fill_2_113 VPWR VGND sg13cmos5l_fill_2
* cell instance sg13cmos5l_fill_2_114 r0 *1 0,0
Xsg13cmos5l_fill_2_114 VPWR VGND sg13cmos5l_fill_2
* cell instance sg13cmos5l_fill_2_115 r0 *1 0,0
Xsg13cmos5l_fill_2_115 VPWR VGND sg13cmos5l_fill_2
* cell instance sg13cmos5l_fill_2_116 r0 *1 0,0
Xsg13cmos5l_fill_2_116 VPWR VGND sg13cmos5l_fill_2
* cell instance sg13cmos5l_fill_2_117 r0 *1 0,0
Xsg13cmos5l_fill_2_117 VPWR VGND sg13cmos5l_fill_2
* cell instance sg13cmos5l_fill_2_118 r0 *1 0,0
Xsg13cmos5l_fill_2_118 VPWR VGND sg13cmos5l_fill_2
* cell instance sg13cmos5l_fill_2_119 r0 *1 0,0
Xsg13cmos5l_fill_2_119 VPWR VGND sg13cmos5l_fill_2
* cell instance sg13cmos5l_fill_2_120 r0 *1 0,0
Xsg13cmos5l_fill_2_120 VPWR VGND sg13cmos5l_fill_2
* cell instance sg13cmos5l_fill_2_121 r0 *1 0,0
Xsg13cmos5l_fill_2_121 VPWR VGND sg13cmos5l_fill_2
* cell instance sg13cmos5l_fill_2_122 r0 *1 0,0
Xsg13cmos5l_fill_2_122 VPWR VGND sg13cmos5l_fill_2
* cell instance sg13cmos5l_fill_2_123 r0 *1 0,0
Xsg13cmos5l_fill_2_123 VPWR VGND sg13cmos5l_fill_2
* cell instance sg13cmos5l_fill_2_124 r0 *1 0,0
Xsg13cmos5l_fill_2_124 VPWR VGND sg13cmos5l_fill_2
* cell instance sg13cmos5l_fill_2_125 r0 *1 0,0
Xsg13cmos5l_fill_2_125 VPWR VGND sg13cmos5l_fill_2
* cell instance sg13cmos5l_fill_2_126 r0 *1 0,0
Xsg13cmos5l_fill_2_126 VPWR VGND sg13cmos5l_fill_2
* cell instance sg13cmos5l_fill_2_127 r0 *1 0,0
Xsg13cmos5l_fill_2_127 VPWR VGND sg13cmos5l_fill_2
* cell instance sg13cmos5l_fill_2_128 r0 *1 0,0
Xsg13cmos5l_fill_2_128 VPWR VGND sg13cmos5l_fill_2
* cell instance sg13cmos5l_fill_2_129 r0 *1 0,0
Xsg13cmos5l_fill_2_129 VPWR VGND sg13cmos5l_fill_2
* cell instance sg13cmos5l_fill_2_130 r0 *1 0,0
Xsg13cmos5l_fill_2_130 VPWR VGND sg13cmos5l_fill_2
* cell instance sg13cmos5l_fill_2_131 r0 *1 0,0
Xsg13cmos5l_fill_2_131 VPWR VGND sg13cmos5l_fill_2
* cell instance sg13cmos5l_fill_2_132 r0 *1 0,0
Xsg13cmos5l_fill_2_132 VPWR VGND sg13cmos5l_fill_2
* cell instance sg13cmos5l_fill_2_133 r0 *1 0,0
Xsg13cmos5l_fill_2_133 VPWR VGND sg13cmos5l_fill_2
* cell instance sg13cmos5l_fill_2_134 r0 *1 0,0
Xsg13cmos5l_fill_2_134 VPWR VGND sg13cmos5l_fill_2
* cell instance sg13cmos5l_fill_2_135 r0 *1 0,0
Xsg13cmos5l_fill_2_135 VPWR VGND sg13cmos5l_fill_2
* cell instance sg13cmos5l_fill_2_136 r0 *1 0,0
Xsg13cmos5l_fill_2_136 VPWR VGND sg13cmos5l_fill_2
* cell instance sg13cmos5l_fill_2_137 r0 *1 0,0
Xsg13cmos5l_fill_2_137 VPWR VGND sg13cmos5l_fill_2
* cell instance sg13cmos5l_fill_2_138 r0 *1 0,0
Xsg13cmos5l_fill_2_138 VPWR VGND sg13cmos5l_fill_2
* cell instance sg13cmos5l_fill_2_139 r0 *1 0,0
Xsg13cmos5l_fill_2_139 VPWR VGND sg13cmos5l_fill_2
* cell instance sg13cmos5l_fill_2_140 r0 *1 0,0
Xsg13cmos5l_fill_2_140 VPWR VGND sg13cmos5l_fill_2
* cell instance sg13cmos5l_fill_2_141 r0 *1 0,0
Xsg13cmos5l_fill_2_141 VPWR VGND sg13cmos5l_fill_2
* cell instance sg13cmos5l_fill_2_142 r0 *1 0,0
Xsg13cmos5l_fill_2_142 VPWR VGND sg13cmos5l_fill_2
* cell instance sg13cmos5l_fill_2_143 r0 *1 0,0
Xsg13cmos5l_fill_2_143 VPWR VGND sg13cmos5l_fill_2
* cell instance sg13cmos5l_fill_2_144 r0 *1 0,0
Xsg13cmos5l_fill_2_144 VPWR VGND sg13cmos5l_fill_2
* cell instance sg13cmos5l_fill_2_145 r0 *1 0,0
Xsg13cmos5l_fill_2_145 VPWR VGND sg13cmos5l_fill_2
* cell instance sg13cmos5l_fill_2_146 r0 *1 0,0
Xsg13cmos5l_fill_2_146 VPWR VGND sg13cmos5l_fill_2
* cell instance sg13cmos5l_fill_2_147 r0 *1 0,0
Xsg13cmos5l_fill_2_147 VPWR VGND sg13cmos5l_fill_2
* cell instance sg13cmos5l_fill_2_148 r0 *1 0,0
Xsg13cmos5l_fill_2_148 VPWR VGND sg13cmos5l_fill_2
* cell instance sg13cmos5l_fill_2_149 r0 *1 0,0
Xsg13cmos5l_fill_2_149 VPWR VGND sg13cmos5l_fill_2
* cell instance sg13cmos5l_fill_2_150 r0 *1 0,0
Xsg13cmos5l_fill_2_150 VPWR VGND sg13cmos5l_fill_2
* cell instance sg13cmos5l_fill_2_151 r0 *1 0,0
Xsg13cmos5l_fill_2_151 VPWR VGND sg13cmos5l_fill_2
* cell instance sg13cmos5l_fill_2_152 r0 *1 0,0
Xsg13cmos5l_fill_2_152 VPWR VGND sg13cmos5l_fill_2
* cell instance sg13cmos5l_fill_2_153 r0 *1 0,0
Xsg13cmos5l_fill_2_153 VPWR VGND sg13cmos5l_fill_2
* cell instance sg13cmos5l_fill_2_154 r0 *1 0,0
Xsg13cmos5l_fill_2_154 VPWR VGND sg13cmos5l_fill_2
* cell instance sg13cmos5l_fill_2_155 r0 *1 0,0
Xsg13cmos5l_fill_2_155 VPWR VGND sg13cmos5l_fill_2
* cell instance sg13cmos5l_fill_2_156 r0 *1 0,0
Xsg13cmos5l_fill_2_156 VPWR VGND sg13cmos5l_fill_2
* cell instance sg13cmos5l_fill_2_157 r0 *1 0,0
Xsg13cmos5l_fill_2_157 VPWR VGND sg13cmos5l_fill_2
* cell instance sg13cmos5l_fill_2_158 r0 *1 0,0
Xsg13cmos5l_fill_2_158 VPWR VGND sg13cmos5l_fill_2
* cell instance sg13cmos5l_fill_2_159 r0 *1 0,0
Xsg13cmos5l_fill_2_159 VPWR VGND sg13cmos5l_fill_2
* cell instance sg13cmos5l_fill_2_160 r0 *1 0,0
Xsg13cmos5l_fill_2_160 VPWR VGND sg13cmos5l_fill_2
* cell instance sg13cmos5l_fill_2_161 r0 *1 0,0
Xsg13cmos5l_fill_2_161 VPWR VGND sg13cmos5l_fill_2
* cell instance sg13cmos5l_fill_2_162 r0 *1 0,0
Xsg13cmos5l_fill_2_162 VPWR VGND sg13cmos5l_fill_2
* cell instance sg13cmos5l_fill_2_163 r0 *1 0,0
Xsg13cmos5l_fill_2_163 VPWR VGND sg13cmos5l_fill_2
* cell instance sg13cmos5l_fill_2_164 r0 *1 0,0
Xsg13cmos5l_fill_2_164 VPWR VGND sg13cmos5l_fill_2
* cell instance sg13cmos5l_fill_2_165 r0 *1 0,0
Xsg13cmos5l_fill_2_165 VPWR VGND sg13cmos5l_fill_2
* cell instance sg13cmos5l_fill_2_166 r0 *1 0,0
Xsg13cmos5l_fill_2_166 VPWR VGND sg13cmos5l_fill_2
* cell instance sg13cmos5l_fill_2_167 r0 *1 0,0
Xsg13cmos5l_fill_2_167 VPWR VGND sg13cmos5l_fill_2
* cell instance sg13cmos5l_fill_2_168 r0 *1 0,0
Xsg13cmos5l_fill_2_168 VPWR VGND sg13cmos5l_fill_2
* cell instance sg13cmos5l_fill_2_169 r0 *1 0,0
Xsg13cmos5l_fill_2_169 VPWR VGND sg13cmos5l_fill_2
* cell instance sg13cmos5l_fill_2_170 r0 *1 0,0
Xsg13cmos5l_fill_2_170 VPWR VGND sg13cmos5l_fill_2
* cell instance sg13cmos5l_fill_2_171 r0 *1 0,0
Xsg13cmos5l_fill_2_171 VPWR VGND sg13cmos5l_fill_2
* cell instance sg13cmos5l_fill_2_172 r0 *1 0,0
Xsg13cmos5l_fill_2_172 VPWR VGND sg13cmos5l_fill_2
* cell instance sg13cmos5l_fill_2_173 r0 *1 0,0
Xsg13cmos5l_fill_2_173 VPWR VGND sg13cmos5l_fill_2
* cell instance sg13cmos5l_fill_2_174 r0 *1 0,0
Xsg13cmos5l_fill_2_174 VPWR VGND sg13cmos5l_fill_2
* cell instance sg13cmos5l_fill_2_175 r0 *1 0,0
Xsg13cmos5l_fill_2_175 VPWR VGND sg13cmos5l_fill_2
* cell instance sg13cmos5l_fill_2_176 r0 *1 0,0
Xsg13cmos5l_fill_2_176 VPWR VGND sg13cmos5l_fill_2
* cell instance sg13cmos5l_fill_2_177 r0 *1 0,0
Xsg13cmos5l_fill_2_177 VPWR VGND sg13cmos5l_fill_2
* cell instance sg13cmos5l_fill_2_178 r0 *1 0,0
Xsg13cmos5l_fill_2_178 VPWR VGND sg13cmos5l_fill_2
* cell instance sg13cmos5l_fill_2_179 r0 *1 0,0
Xsg13cmos5l_fill_2_179 VPWR VGND sg13cmos5l_fill_2
* cell instance sg13cmos5l_fill_2_180 r0 *1 0,0
Xsg13cmos5l_fill_2_180 VPWR VGND sg13cmos5l_fill_2
* cell instance sg13cmos5l_fill_2_181 r0 *1 0,0
Xsg13cmos5l_fill_2_181 VPWR VGND sg13cmos5l_fill_2
* cell instance sg13cmos5l_fill_2_182 r0 *1 0,0
Xsg13cmos5l_fill_2_182 VPWR VGND sg13cmos5l_fill_2
* cell instance sg13cmos5l_fill_2_183 r0 *1 0,0
Xsg13cmos5l_fill_2_183 VPWR VGND sg13cmos5l_fill_2
* cell instance sg13cmos5l_fill_2_184 r0 *1 0,0
Xsg13cmos5l_fill_2_184 VPWR VGND sg13cmos5l_fill_2
* cell instance sg13cmos5l_fill_2_185 r0 *1 0,0
Xsg13cmos5l_fill_2_185 VPWR VGND sg13cmos5l_fill_2
* cell instance sg13cmos5l_fill_2_186 r0 *1 0,0
Xsg13cmos5l_fill_2_186 VPWR VGND sg13cmos5l_fill_2
* cell instance sg13cmos5l_fill_2_187 r0 *1 0,0
Xsg13cmos5l_fill_2_187 VPWR VGND sg13cmos5l_fill_2
* cell instance sg13cmos5l_fill_2_188 r0 *1 0,0
Xsg13cmos5l_fill_2_188 VPWR VGND sg13cmos5l_fill_2
* cell instance sg13cmos5l_fill_2_189 r0 *1 0,0
Xsg13cmos5l_fill_2_189 VPWR VGND sg13cmos5l_fill_2
* cell instance sg13cmos5l_fill_2_190 r0 *1 0,0
Xsg13cmos5l_fill_2_190 VPWR VGND sg13cmos5l_fill_2
* cell instance sg13cmos5l_fill_2_191 r0 *1 0,0
Xsg13cmos5l_fill_2_191 VPWR VGND sg13cmos5l_fill_2
* cell instance sg13cmos5l_fill_2_192 r0 *1 0,0
Xsg13cmos5l_fill_2_192 VPWR VGND sg13cmos5l_fill_2
* cell instance sg13cmos5l_fill_2_193 r0 *1 0,0
Xsg13cmos5l_fill_2_193 VPWR VGND sg13cmos5l_fill_2
* cell instance sg13cmos5l_fill_2_194 r0 *1 0,0
Xsg13cmos5l_fill_2_194 VPWR VGND sg13cmos5l_fill_2
* cell instance sg13cmos5l_fill_2_195 r0 *1 0,0
Xsg13cmos5l_fill_2_195 VPWR VGND sg13cmos5l_fill_2
* cell instance sg13cmos5l_fill_2_196 r0 *1 0,0
Xsg13cmos5l_fill_2_196 VPWR VGND sg13cmos5l_fill_2
* cell instance sg13cmos5l_fill_2_197 r0 *1 0,0
Xsg13cmos5l_fill_2_197 VPWR VGND sg13cmos5l_fill_2
* cell instance sg13cmos5l_fill_2_198 r0 *1 0,0
Xsg13cmos5l_fill_2_198 VPWR VGND sg13cmos5l_fill_2
* cell instance sg13cmos5l_fill_2_199 r0 *1 0,0
Xsg13cmos5l_fill_2_199 VPWR VGND sg13cmos5l_fill_2
* cell instance sg13cmos5l_fill_2_200 r0 *1 0,0
Xsg13cmos5l_fill_2_200 VPWR VGND sg13cmos5l_fill_2
* cell instance sg13cmos5l_fill_2_201 r0 *1 0,0
Xsg13cmos5l_fill_2_201 VPWR VGND sg13cmos5l_fill_2
* cell instance sg13cmos5l_fill_2_202 r0 *1 0,0
Xsg13cmos5l_fill_2_202 VPWR VGND sg13cmos5l_fill_2
* cell instance sg13cmos5l_fill_2_203 r0 *1 0,0
Xsg13cmos5l_fill_2_203 VPWR VGND sg13cmos5l_fill_2
* cell instance sg13cmos5l_fill_2_204 r0 *1 0,0
Xsg13cmos5l_fill_2_204 VPWR VGND sg13cmos5l_fill_2
* cell instance sg13cmos5l_fill_2_205 r0 *1 0,0
Xsg13cmos5l_fill_2_205 VPWR VGND sg13cmos5l_fill_2
* cell instance sg13cmos5l_fill_2_206 r0 *1 0,0
Xsg13cmos5l_fill_2_206 VPWR VGND sg13cmos5l_fill_2
* cell instance sg13cmos5l_fill_2_207 r0 *1 0,0
Xsg13cmos5l_fill_2_207 VPWR VGND sg13cmos5l_fill_2
* cell instance sg13cmos5l_fill_2_208 r0 *1 0,0
Xsg13cmos5l_fill_2_208 VPWR VGND sg13cmos5l_fill_2
* cell instance sg13cmos5l_fill_2_209 r0 *1 0,0
Xsg13cmos5l_fill_2_209 VPWR VGND sg13cmos5l_fill_2
* cell instance sg13cmos5l_fill_2_210 r0 *1 0,0
Xsg13cmos5l_fill_2_210 VPWR VGND sg13cmos5l_fill_2
* cell instance sg13cmos5l_fill_2_211 r0 *1 0,0
Xsg13cmos5l_fill_2_211 VPWR VGND sg13cmos5l_fill_2
* cell instance sg13cmos5l_fill_2_212 r0 *1 0,0
Xsg13cmos5l_fill_2_212 VPWR VGND sg13cmos5l_fill_2
* cell instance sg13cmos5l_fill_2_213 r0 *1 0,0
Xsg13cmos5l_fill_2_213 VPWR VGND sg13cmos5l_fill_2
* cell instance sg13cmos5l_fill_2_214 r0 *1 0,0
Xsg13cmos5l_fill_2_214 VPWR VGND sg13cmos5l_fill_2
* cell instance sg13cmos5l_fill_2_215 r0 *1 0,0
Xsg13cmos5l_fill_2_215 VPWR VGND sg13cmos5l_fill_2
* cell instance sg13cmos5l_fill_2_216 r0 *1 0,0
Xsg13cmos5l_fill_2_216 VPWR VGND sg13cmos5l_fill_2
* cell instance sg13cmos5l_fill_2_217 r0 *1 0,0
Xsg13cmos5l_fill_2_217 VPWR VGND sg13cmos5l_fill_2
* cell instance sg13cmos5l_fill_2_218 r0 *1 0,0
Xsg13cmos5l_fill_2_218 VPWR VGND sg13cmos5l_fill_2
* cell instance sg13cmos5l_fill_2_219 r0 *1 0,0
Xsg13cmos5l_fill_2_219 VPWR VGND sg13cmos5l_fill_2
* cell instance sg13cmos5l_fill_2_220 r0 *1 0,0
Xsg13cmos5l_fill_2_220 VPWR VGND sg13cmos5l_fill_2
* cell instance sg13cmos5l_fill_2_221 r0 *1 0,0
Xsg13cmos5l_fill_2_221 VPWR VGND sg13cmos5l_fill_2
* cell instance sg13cmos5l_fill_2_222 r0 *1 0,0
Xsg13cmos5l_fill_2_222 VPWR VGND sg13cmos5l_fill_2
* cell instance sg13cmos5l_fill_2_223 r0 *1 0,0
Xsg13cmos5l_fill_2_223 VPWR VGND sg13cmos5l_fill_2
* cell instance sg13cmos5l_fill_2_224 r0 *1 0,0
Xsg13cmos5l_fill_2_224 VPWR VGND sg13cmos5l_fill_2
* cell instance sg13cmos5l_fill_2_225 r0 *1 0,0
Xsg13cmos5l_fill_2_225 VPWR VGND sg13cmos5l_fill_2
* cell instance sg13cmos5l_fill_2_226 r0 *1 0,0
Xsg13cmos5l_fill_2_226 VPWR VGND sg13cmos5l_fill_2
* cell instance sg13cmos5l_fill_2_227 r0 *1 0,0
Xsg13cmos5l_fill_2_227 VPWR VGND sg13cmos5l_fill_2
* cell instance sg13cmos5l_fill_2_228 r0 *1 0,0
Xsg13cmos5l_fill_2_228 VPWR VGND sg13cmos5l_fill_2
* cell instance sg13cmos5l_fill_2_229 r0 *1 0,0
Xsg13cmos5l_fill_2_229 VPWR VGND sg13cmos5l_fill_2
* cell instance sg13cmos5l_fill_2_230 r0 *1 0,0
Xsg13cmos5l_fill_2_230 VPWR VGND sg13cmos5l_fill_2
* cell instance sg13cmos5l_fill_2_231 r0 *1 0,0
Xsg13cmos5l_fill_2_231 VPWR VGND sg13cmos5l_fill_2
* cell instance sg13cmos5l_fill_2_232 r0 *1 0,0
Xsg13cmos5l_fill_2_232 VPWR VGND sg13cmos5l_fill_2
* cell instance sg13cmos5l_fill_2_233 r0 *1 0,0
Xsg13cmos5l_fill_2_233 VPWR VGND sg13cmos5l_fill_2
* cell instance sg13cmos5l_fill_2_234 r0 *1 0,0
Xsg13cmos5l_fill_2_234 VPWR VGND sg13cmos5l_fill_2
* cell instance sg13cmos5l_fill_2_235 r0 *1 0,0
Xsg13cmos5l_fill_2_235 VPWR VGND sg13cmos5l_fill_2
* cell instance sg13cmos5l_fill_2_236 r0 *1 0,0
Xsg13cmos5l_fill_2_236 VPWR VGND sg13cmos5l_fill_2
* cell instance sg13cmos5l_fill_2_237 r0 *1 0,0
Xsg13cmos5l_fill_2_237 VPWR VGND sg13cmos5l_fill_2
* cell instance sg13cmos5l_fill_2_238 r0 *1 0,0
Xsg13cmos5l_fill_2_238 VPWR VGND sg13cmos5l_fill_2
* cell instance sg13cmos5l_fill_2_239 r0 *1 0,0
Xsg13cmos5l_fill_2_239 VPWR VGND sg13cmos5l_fill_2
* cell instance sg13cmos5l_fill_2_240 r0 *1 0,0
Xsg13cmos5l_fill_2_240 VPWR VGND sg13cmos5l_fill_2
* cell instance sg13cmos5l_fill_2_241 r0 *1 0,0
Xsg13cmos5l_fill_2_241 VPWR VGND sg13cmos5l_fill_2
* cell instance sg13cmos5l_fill_2_242 r0 *1 0,0
Xsg13cmos5l_fill_2_242 VPWR VGND sg13cmos5l_fill_2
* cell instance sg13cmos5l_fill_2_243 r0 *1 0,0
Xsg13cmos5l_fill_2_243 VPWR VGND sg13cmos5l_fill_2
* cell instance sg13cmos5l_fill_2_244 r0 *1 0,0
Xsg13cmos5l_fill_2_244 VPWR VGND sg13cmos5l_fill_2
* cell instance sg13cmos5l_fill_2_245 r0 *1 0,0
Xsg13cmos5l_fill_2_245 VPWR VGND sg13cmos5l_fill_2
* cell instance sg13cmos5l_fill_2_246 r0 *1 0,0
Xsg13cmos5l_fill_2_246 VPWR VGND sg13cmos5l_fill_2
* cell instance sg13cmos5l_fill_2_247 r0 *1 0,0
Xsg13cmos5l_fill_2_247 VPWR VGND sg13cmos5l_fill_2
* cell instance sg13cmos5l_fill_2_248 r0 *1 0,0
Xsg13cmos5l_fill_2_248 VPWR VGND sg13cmos5l_fill_2
* cell instance sg13cmos5l_fill_2_249 r0 *1 0,0
Xsg13cmos5l_fill_2_249 VPWR VGND sg13cmos5l_fill_2
* cell instance sg13cmos5l_fill_2_250 r0 *1 0,0
Xsg13cmos5l_fill_2_250 VPWR VGND sg13cmos5l_fill_2
* cell instance sg13cmos5l_fill_2_251 r0 *1 0,0
Xsg13cmos5l_fill_2_251 VPWR VGND sg13cmos5l_fill_2
* cell instance sg13cmos5l_fill_2_252 r0 *1 0,0
Xsg13cmos5l_fill_2_252 VPWR VGND sg13cmos5l_fill_2
* cell instance sg13cmos5l_fill_2_253 r0 *1 0,0
Xsg13cmos5l_fill_2_253 VPWR VGND sg13cmos5l_fill_2
* cell instance sg13cmos5l_fill_2_254 r0 *1 0,0
Xsg13cmos5l_fill_2_254 VPWR VGND sg13cmos5l_fill_2
* cell instance sg13cmos5l_fill_2_255 r0 *1 0,0
Xsg13cmos5l_fill_2_255 VPWR VGND sg13cmos5l_fill_2
* cell instance sg13cmos5l_fill_2_256 r0 *1 0,0
Xsg13cmos5l_fill_2_256 VPWR VGND sg13cmos5l_fill_2
* cell instance sg13cmos5l_fill_2_257 r0 *1 0,0
Xsg13cmos5l_fill_2_257 VPWR VGND sg13cmos5l_fill_2
* cell instance sg13cmos5l_fill_2_258 r0 *1 0,0
Xsg13cmos5l_fill_2_258 VPWR VGND sg13cmos5l_fill_2
* cell instance sg13cmos5l_fill_2_259 r0 *1 0,0
Xsg13cmos5l_fill_2_259 VPWR VGND sg13cmos5l_fill_2
* cell instance sg13cmos5l_fill_2_260 r0 *1 0,0
Xsg13cmos5l_fill_2_260 VPWR VGND sg13cmos5l_fill_2
* cell instance sg13cmos5l_fill_2_261 r0 *1 0,0
Xsg13cmos5l_fill_2_261 VPWR VGND sg13cmos5l_fill_2
* cell instance sg13cmos5l_fill_2_262 r0 *1 0,0
Xsg13cmos5l_fill_2_262 VPWR VGND sg13cmos5l_fill_2
* cell instance sg13cmos5l_fill_2_263 r0 *1 0,0
Xsg13cmos5l_fill_2_263 VPWR VGND sg13cmos5l_fill_2
* cell instance sg13cmos5l_fill_2_264 r0 *1 0,0
Xsg13cmos5l_fill_2_264 VPWR VGND sg13cmos5l_fill_2
* cell instance sg13cmos5l_fill_2_265 r0 *1 0,0
Xsg13cmos5l_fill_2_265 VPWR VGND sg13cmos5l_fill_2
* cell instance sg13cmos5l_fill_2_266 r0 *1 0,0
Xsg13cmos5l_fill_2_266 VPWR VGND sg13cmos5l_fill_2
* cell instance sg13cmos5l_fill_2_267 r0 *1 0,0
Xsg13cmos5l_fill_2_267 VPWR VGND sg13cmos5l_fill_2
* cell instance sg13cmos5l_fill_2_268 r0 *1 0,0
Xsg13cmos5l_fill_2_268 VPWR VGND sg13cmos5l_fill_2
* cell instance sg13cmos5l_fill_2_269 r0 *1 0,0
Xsg13cmos5l_fill_2_269 VPWR VGND sg13cmos5l_fill_2
* cell instance sg13cmos5l_fill_2_270 r0 *1 0,0
Xsg13cmos5l_fill_2_270 VPWR VGND sg13cmos5l_fill_2
* cell instance sg13cmos5l_fill_2_271 r0 *1 0,0
Xsg13cmos5l_fill_2_271 VPWR VGND sg13cmos5l_fill_2
* cell instance sg13cmos5l_fill_2_272 r0 *1 0,0
Xsg13cmos5l_fill_2_272 VPWR VGND sg13cmos5l_fill_2
* cell instance sg13cmos5l_fill_2_273 r0 *1 0,0
Xsg13cmos5l_fill_2_273 VPWR VGND sg13cmos5l_fill_2
* cell instance sg13cmos5l_fill_2_274 r0 *1 0,0
Xsg13cmos5l_fill_2_274 VPWR VGND sg13cmos5l_fill_2
* cell instance sg13cmos5l_fill_2_275 r0 *1 0,0
Xsg13cmos5l_fill_2_275 VPWR VGND sg13cmos5l_fill_2
* cell instance sg13cmos5l_fill_2_276 r0 *1 0,0
Xsg13cmos5l_fill_2_276 VPWR VGND sg13cmos5l_fill_2
* cell instance sg13cmos5l_fill_2_277 r0 *1 0,0
Xsg13cmos5l_fill_2_277 VPWR VGND sg13cmos5l_fill_2
* cell instance sg13cmos5l_fill_2_278 r0 *1 0,0
Xsg13cmos5l_fill_2_278 VPWR VGND sg13cmos5l_fill_2
* cell instance sg13cmos5l_fill_2_279 r0 *1 0,0
Xsg13cmos5l_fill_2_279 VPWR VGND sg13cmos5l_fill_2
* cell instance sg13cmos5l_fill_2_280 r0 *1 0,0
Xsg13cmos5l_fill_2_280 VPWR VGND sg13cmos5l_fill_2
* cell instance sg13cmos5l_fill_2_281 r0 *1 0,0
Xsg13cmos5l_fill_2_281 VPWR VGND sg13cmos5l_fill_2
* cell instance sg13cmos5l_fill_2_282 r0 *1 0,0
Xsg13cmos5l_fill_2_282 VPWR VGND sg13cmos5l_fill_2
* cell instance sg13cmos5l_fill_2_283 r0 *1 0,0
Xsg13cmos5l_fill_2_283 VPWR VGND sg13cmos5l_fill_2
* cell instance sg13cmos5l_fill_2_284 r0 *1 0,0
Xsg13cmos5l_fill_2_284 VPWR VGND sg13cmos5l_fill_2
* cell instance sg13cmos5l_fill_2_285 r0 *1 0,0
Xsg13cmos5l_fill_2_285 VPWR VGND sg13cmos5l_fill_2
* cell instance sg13cmos5l_fill_2_286 r0 *1 0,0
Xsg13cmos5l_fill_2_286 VPWR VGND sg13cmos5l_fill_2
* cell instance sg13cmos5l_fill_2_287 r0 *1 0,0
Xsg13cmos5l_fill_2_287 VPWR VGND sg13cmos5l_fill_2
* cell instance sg13cmos5l_fill_2_288 r0 *1 0,0
Xsg13cmos5l_fill_2_288 VPWR VGND sg13cmos5l_fill_2
* cell instance sg13cmos5l_fill_2_289 r0 *1 0,0
Xsg13cmos5l_fill_2_289 VPWR VGND sg13cmos5l_fill_2
* cell instance sg13cmos5l_fill_2_290 r0 *1 0,0
Xsg13cmos5l_fill_2_290 VPWR VGND sg13cmos5l_fill_2
* cell instance sg13cmos5l_fill_2_291 r0 *1 0,0
Xsg13cmos5l_fill_2_291 VPWR VGND sg13cmos5l_fill_2
* cell instance sg13cmos5l_fill_2_292 r0 *1 0,0
Xsg13cmos5l_fill_2_292 VPWR VGND sg13cmos5l_fill_2
* cell instance sg13cmos5l_fill_2_293 r0 *1 0,0
Xsg13cmos5l_fill_2_293 VPWR VGND sg13cmos5l_fill_2
* cell instance sg13cmos5l_fill_2_294 r0 *1 0,0
Xsg13cmos5l_fill_2_294 VPWR VGND sg13cmos5l_fill_2
* cell instance sg13cmos5l_fill_2_295 r0 *1 0,0
Xsg13cmos5l_fill_2_295 VPWR VGND sg13cmos5l_fill_2
* cell instance sg13cmos5l_fill_2_296 r0 *1 0,0
Xsg13cmos5l_fill_2_296 VPWR VGND sg13cmos5l_fill_2
* cell instance sg13cmos5l_fill_2_297 r0 *1 0,0
Xsg13cmos5l_fill_2_297 VPWR VGND sg13cmos5l_fill_2
* cell instance sg13cmos5l_fill_2_298 r0 *1 0,0
Xsg13cmos5l_fill_2_298 VPWR VGND sg13cmos5l_fill_2
* cell instance sg13cmos5l_fill_2_299 r0 *1 0,0
Xsg13cmos5l_fill_2_299 VPWR VGND sg13cmos5l_fill_2
* cell instance sg13cmos5l_fill_2_300 r0 *1 0,0
Xsg13cmos5l_fill_2_300 VPWR VGND sg13cmos5l_fill_2
* cell instance sg13cmos5l_fill_2_301 r0 *1 0,0
Xsg13cmos5l_fill_2_301 VPWR VGND sg13cmos5l_fill_2
* cell instance sg13cmos5l_fill_2_302 r0 *1 0,0
Xsg13cmos5l_fill_2_302 VPWR VGND sg13cmos5l_fill_2
* cell instance sg13cmos5l_fill_2_303 r0 *1 0,0
Xsg13cmos5l_fill_2_303 VPWR VGND sg13cmos5l_fill_2
* cell instance sg13cmos5l_fill_2_304 r0 *1 0,0
Xsg13cmos5l_fill_2_304 VPWR VGND sg13cmos5l_fill_2
* cell instance sg13cmos5l_fill_2_305 r0 *1 0,0
Xsg13cmos5l_fill_2_305 VPWR VGND sg13cmos5l_fill_2
* cell instance sg13cmos5l_fill_2_306 r0 *1 0,0
Xsg13cmos5l_fill_2_306 VPWR VGND sg13cmos5l_fill_2
* cell instance sg13cmos5l_fill_2_307 r0 *1 0,0
Xsg13cmos5l_fill_2_307 VPWR VGND sg13cmos5l_fill_2
* cell instance sg13cmos5l_fill_2_308 r0 *1 0,0
Xsg13cmos5l_fill_2_308 VPWR VGND sg13cmos5l_fill_2
* cell instance sg13cmos5l_fill_2_309 r0 *1 0,0
Xsg13cmos5l_fill_2_309 VPWR VGND sg13cmos5l_fill_2
* cell instance sg13cmos5l_fill_2_310 r0 *1 0,0
Xsg13cmos5l_fill_2_310 VPWR VGND sg13cmos5l_fill_2
* cell instance sg13cmos5l_fill_2_311 r0 *1 0,0
Xsg13cmos5l_fill_2_311 VPWR VGND sg13cmos5l_fill_2
* cell instance sg13cmos5l_fill_2_312 r0 *1 0,0
Xsg13cmos5l_fill_2_312 VPWR VGND sg13cmos5l_fill_2
* cell instance sg13cmos5l_fill_2_313 r0 *1 0,0
Xsg13cmos5l_fill_2_313 VPWR VGND sg13cmos5l_fill_2
* cell instance sg13cmos5l_fill_2_314 r0 *1 0,0
Xsg13cmos5l_fill_2_314 VPWR VGND sg13cmos5l_fill_2
* cell instance sg13cmos5l_fill_2_315 r0 *1 0,0
Xsg13cmos5l_fill_2_315 VPWR VGND sg13cmos5l_fill_2
* cell instance sg13cmos5l_fill_2_316 r0 *1 0,0
Xsg13cmos5l_fill_2_316 VPWR VGND sg13cmos5l_fill_2
* cell instance sg13cmos5l_fill_2_317 r0 *1 0,0
Xsg13cmos5l_fill_2_317 VPWR VGND sg13cmos5l_fill_2
* cell instance sg13cmos5l_fill_2_318 r0 *1 0,0
Xsg13cmos5l_fill_2_318 VPWR VGND sg13cmos5l_fill_2
* cell instance sg13cmos5l_fill_2_319 r0 *1 0,0
Xsg13cmos5l_fill_2_319 VPWR VGND sg13cmos5l_fill_2
* cell instance sg13cmos5l_fill_2_320 r0 *1 0,0
Xsg13cmos5l_fill_2_320 VPWR VGND sg13cmos5l_fill_2
* cell instance sg13cmos5l_fill_2_321 r0 *1 0,0
Xsg13cmos5l_fill_2_321 VPWR VGND sg13cmos5l_fill_2
* cell instance sg13cmos5l_fill_2_322 r0 *1 0,0
Xsg13cmos5l_fill_2_322 VPWR VGND sg13cmos5l_fill_2
* cell instance sg13cmos5l_fill_2_323 r0 *1 0,0
Xsg13cmos5l_fill_2_323 VPWR VGND sg13cmos5l_fill_2
* cell instance sg13cmos5l_fill_2_324 r0 *1 0,0
Xsg13cmos5l_fill_2_324 VPWR VGND sg13cmos5l_fill_2
* cell instance sg13cmos5l_fill_2_325 r0 *1 0,0
Xsg13cmos5l_fill_2_325 VPWR VGND sg13cmos5l_fill_2
* cell instance sg13cmos5l_fill_2_326 r0 *1 0,0
Xsg13cmos5l_fill_2_326 VPWR VGND sg13cmos5l_fill_2
* cell instance sg13cmos5l_fill_2_327 r0 *1 0,0
Xsg13cmos5l_fill_2_327 VPWR VGND sg13cmos5l_fill_2
* cell instance sg13cmos5l_fill_2_328 r0 *1 0,0
Xsg13cmos5l_fill_2_328 VPWR VGND sg13cmos5l_fill_2
* cell instance sg13cmos5l_fill_2_329 r0 *1 0,0
Xsg13cmos5l_fill_2_329 VPWR VGND sg13cmos5l_fill_2
* cell instance sg13cmos5l_fill_2_330 r0 *1 0,0
Xsg13cmos5l_fill_2_330 VPWR VGND sg13cmos5l_fill_2
* cell instance sg13cmos5l_fill_2_331 r0 *1 0,0
Xsg13cmos5l_fill_2_331 VPWR VGND sg13cmos5l_fill_2
* cell instance sg13cmos5l_fill_2_332 r0 *1 0,0
Xsg13cmos5l_fill_2_332 VPWR VGND sg13cmos5l_fill_2
* cell instance sg13cmos5l_fill_2_333 r0 *1 0,0
Xsg13cmos5l_fill_2_333 VPWR VGND sg13cmos5l_fill_2
* cell instance sg13cmos5l_fill_2_334 r0 *1 0,0
Xsg13cmos5l_fill_2_334 VPWR VGND sg13cmos5l_fill_2
* cell instance sg13cmos5l_fill_2_335 r0 *1 0,0
Xsg13cmos5l_fill_2_335 VPWR VGND sg13cmos5l_fill_2
* cell instance sg13cmos5l_fill_2_336 r0 *1 0,0
Xsg13cmos5l_fill_2_336 VPWR VGND sg13cmos5l_fill_2
* cell instance sg13cmos5l_fill_2_337 r0 *1 0,0
Xsg13cmos5l_fill_2_337 VPWR VGND sg13cmos5l_fill_2
* cell instance sg13cmos5l_fill_2_338 r0 *1 0,0
Xsg13cmos5l_fill_2_338 VPWR VGND sg13cmos5l_fill_2
* cell instance sg13cmos5l_fill_2_339 r0 *1 0,0
Xsg13cmos5l_fill_2_339 VPWR VGND sg13cmos5l_fill_2
* cell instance sg13cmos5l_fill_2_340 r0 *1 0,0
Xsg13cmos5l_fill_2_340 VPWR VGND sg13cmos5l_fill_2
* cell instance sg13cmos5l_fill_2_341 r0 *1 0,0
Xsg13cmos5l_fill_2_341 VPWR VGND sg13cmos5l_fill_2
* cell instance sg13cmos5l_fill_2_342 r0 *1 0,0
Xsg13cmos5l_fill_2_342 VPWR VGND sg13cmos5l_fill_2
* cell instance sg13cmos5l_fill_2_343 r0 *1 0,0
Xsg13cmos5l_fill_2_343 VPWR VGND sg13cmos5l_fill_2
* cell instance sg13cmos5l_fill_2_344 r0 *1 0,0
Xsg13cmos5l_fill_2_344 VPWR VGND sg13cmos5l_fill_2
* cell instance sg13cmos5l_fill_2_345 r0 *1 0,0
Xsg13cmos5l_fill_2_345 VPWR VGND sg13cmos5l_fill_2
* cell instance sg13cmos5l_fill_2_346 r0 *1 0,0
Xsg13cmos5l_fill_2_346 VPWR VGND sg13cmos5l_fill_2
* cell instance sg13cmos5l_fill_2_347 r0 *1 0,0
Xsg13cmos5l_fill_2_347 VPWR VGND sg13cmos5l_fill_2
* cell instance sg13cmos5l_fill_2_348 r0 *1 0,0
Xsg13cmos5l_fill_2_348 VPWR VGND sg13cmos5l_fill_2
* cell instance sg13cmos5l_fill_2_349 r0 *1 0,0
Xsg13cmos5l_fill_2_349 VPWR VGND sg13cmos5l_fill_2
* cell instance sg13cmos5l_fill_2_350 r0 *1 0,0
Xsg13cmos5l_fill_2_350 VPWR VGND sg13cmos5l_fill_2
* cell instance sg13cmos5l_fill_2_351 r0 *1 0,0
Xsg13cmos5l_fill_2_351 VPWR VGND sg13cmos5l_fill_2
* cell instance sg13cmos5l_fill_2_352 r0 *1 0,0
Xsg13cmos5l_fill_2_352 VPWR VGND sg13cmos5l_fill_2
* cell instance sg13cmos5l_fill_2_353 r0 *1 0,0
Xsg13cmos5l_fill_2_353 VPWR VGND sg13cmos5l_fill_2
* cell instance sg13cmos5l_fill_2_354 r0 *1 0,0
Xsg13cmos5l_fill_2_354 VPWR VGND sg13cmos5l_fill_2
* cell instance sg13cmos5l_fill_2_355 r0 *1 0,0
Xsg13cmos5l_fill_2_355 VPWR VGND sg13cmos5l_fill_2
* cell instance sg13cmos5l_fill_2_356 r0 *1 0,0
Xsg13cmos5l_fill_2_356 VPWR VGND sg13cmos5l_fill_2
* cell instance sg13cmos5l_fill_2_357 r0 *1 0,0
Xsg13cmos5l_fill_2_357 VPWR VGND sg13cmos5l_fill_2
* cell instance sg13cmos5l_fill_2_358 r0 *1 0,0
Xsg13cmos5l_fill_2_358 VPWR VGND sg13cmos5l_fill_2
* cell instance sg13cmos5l_fill_2_359 r0 *1 0,0
Xsg13cmos5l_fill_2_359 VPWR VGND sg13cmos5l_fill_2
* cell instance sg13cmos5l_fill_2_360 r0 *1 0,0
Xsg13cmos5l_fill_2_360 VPWR VGND sg13cmos5l_fill_2
* cell instance sg13cmos5l_fill_2_361 r0 *1 0,0
Xsg13cmos5l_fill_2_361 VPWR VGND sg13cmos5l_fill_2
* cell instance sg13cmos5l_fill_2_362 r0 *1 0,0
Xsg13cmos5l_fill_2_362 VPWR VGND sg13cmos5l_fill_2
* cell instance sg13cmos5l_fill_2_363 r0 *1 0,0
Xsg13cmos5l_fill_2_363 VPWR VGND sg13cmos5l_fill_2
* cell instance sg13cmos5l_fill_2_364 r0 *1 0,0
Xsg13cmos5l_fill_2_364 VPWR VGND sg13cmos5l_fill_2
* cell instance sg13cmos5l_fill_2_365 r0 *1 0,0
Xsg13cmos5l_fill_2_365 VPWR VGND sg13cmos5l_fill_2
* cell instance sg13cmos5l_fill_2_366 r0 *1 0,0
Xsg13cmos5l_fill_2_366 VPWR VGND sg13cmos5l_fill_2
* cell instance sg13cmos5l_fill_2_367 r0 *1 0,0
Xsg13cmos5l_fill_2_367 VPWR VGND sg13cmos5l_fill_2
* cell instance sg13cmos5l_fill_2_368 r0 *1 0,0
Xsg13cmos5l_fill_2_368 VPWR VGND sg13cmos5l_fill_2
* cell instance sg13cmos5l_fill_2_369 r0 *1 0,0
Xsg13cmos5l_fill_2_369 VPWR VGND sg13cmos5l_fill_2
* cell instance sg13cmos5l_fill_2_370 r0 *1 0,0
Xsg13cmos5l_fill_2_370 VPWR VGND sg13cmos5l_fill_2
* cell instance sg13cmos5l_fill_2_371 r0 *1 0,0
Xsg13cmos5l_fill_2_371 VPWR VGND sg13cmos5l_fill_2
* cell instance sg13cmos5l_fill_2_372 r0 *1 0,0
Xsg13cmos5l_fill_2_372 VPWR VGND sg13cmos5l_fill_2
* cell instance sg13cmos5l_fill_2_373 r0 *1 0,0
Xsg13cmos5l_fill_2_373 VPWR VGND sg13cmos5l_fill_2
* cell instance sg13cmos5l_fill_2_374 r0 *1 0,0
Xsg13cmos5l_fill_2_374 VPWR VGND sg13cmos5l_fill_2
* cell instance sg13cmos5l_fill_2_375 r0 *1 0,0
Xsg13cmos5l_fill_2_375 VPWR VGND sg13cmos5l_fill_2
* cell instance sg13cmos5l_fill_2_376 r0 *1 0,0
Xsg13cmos5l_fill_2_376 VPWR VGND sg13cmos5l_fill_2
* cell instance sg13cmos5l_fill_2_377 r0 *1 0,0
Xsg13cmos5l_fill_2_377 VPWR VGND sg13cmos5l_fill_2
* cell instance sg13cmos5l_fill_2_378 r0 *1 0,0
Xsg13cmos5l_fill_2_378 VPWR VGND sg13cmos5l_fill_2
* cell instance sg13cmos5l_fill_2_379 r0 *1 0,0
Xsg13cmos5l_fill_2_379 VPWR VGND sg13cmos5l_fill_2
* cell instance sg13cmos5l_fill_2_380 r0 *1 0,0
Xsg13cmos5l_fill_2_380 VPWR VGND sg13cmos5l_fill_2
* cell instance sg13cmos5l_fill_2_381 r0 *1 0,0
Xsg13cmos5l_fill_2_381 VPWR VGND sg13cmos5l_fill_2
* cell instance sg13cmos5l_fill_2_382 r0 *1 0,0
Xsg13cmos5l_fill_2_382 VPWR VGND sg13cmos5l_fill_2
* cell instance sg13cmos5l_fill_2_383 r0 *1 0,0
Xsg13cmos5l_fill_2_383 VPWR VGND sg13cmos5l_fill_2
* cell instance sg13cmos5l_fill_2_384 r0 *1 0,0
Xsg13cmos5l_fill_2_384 VPWR VGND sg13cmos5l_fill_2
* cell instance sg13cmos5l_fill_2_385 r0 *1 0,0
Xsg13cmos5l_fill_2_385 VPWR VGND sg13cmos5l_fill_2
* cell instance sg13cmos5l_fill_2_386 r0 *1 0,0
Xsg13cmos5l_fill_2_386 VPWR VGND sg13cmos5l_fill_2
* cell instance sg13cmos5l_fill_2_387 r0 *1 0,0
Xsg13cmos5l_fill_2_387 VPWR VGND sg13cmos5l_fill_2
* cell instance sg13cmos5l_fill_2_388 r0 *1 0,0
Xsg13cmos5l_fill_2_388 VPWR VGND sg13cmos5l_fill_2
* cell instance sg13cmos5l_fill_2_389 r0 *1 0,0
Xsg13cmos5l_fill_2_389 VPWR VGND sg13cmos5l_fill_2
* cell instance sg13cmos5l_fill_2_390 r0 *1 0,0
Xsg13cmos5l_fill_2_390 VPWR VGND sg13cmos5l_fill_2
* cell instance sg13cmos5l_fill_2_391 r0 *1 0,0
Xsg13cmos5l_fill_2_391 VPWR VGND sg13cmos5l_fill_2
* cell instance sg13cmos5l_fill_2_392 r0 *1 0,0
Xsg13cmos5l_fill_2_392 VPWR VGND sg13cmos5l_fill_2
* cell instance sg13cmos5l_fill_2_393 r0 *1 0,0
Xsg13cmos5l_fill_2_393 VPWR VGND sg13cmos5l_fill_2
* cell instance sg13cmos5l_fill_2_394 r0 *1 0,0
Xsg13cmos5l_fill_2_394 VPWR VGND sg13cmos5l_fill_2
* cell instance sg13cmos5l_fill_2_395 r0 *1 0,0
Xsg13cmos5l_fill_2_395 VPWR VGND sg13cmos5l_fill_2
* cell instance sg13cmos5l_fill_2_396 r0 *1 0,0
Xsg13cmos5l_fill_2_396 VPWR VGND sg13cmos5l_fill_2
* cell instance sg13cmos5l_fill_2_397 r0 *1 0,0
Xsg13cmos5l_fill_2_397 VPWR VGND sg13cmos5l_fill_2
* cell instance sg13cmos5l_fill_2_398 r0 *1 0,0
Xsg13cmos5l_fill_2_398 VPWR VGND sg13cmos5l_fill_2
* cell instance sg13cmos5l_fill_2_399 r0 *1 0,0
Xsg13cmos5l_fill_2_399 VPWR VGND sg13cmos5l_fill_2
* cell instance sg13cmos5l_fill_2_400 r0 *1 0,0
Xsg13cmos5l_fill_2_400 VPWR VGND sg13cmos5l_fill_2
* cell instance sg13cmos5l_fill_2_401 r0 *1 0,0
Xsg13cmos5l_fill_2_401 VPWR VGND sg13cmos5l_fill_2
* cell instance sg13cmos5l_fill_2_402 r0 *1 0,0
Xsg13cmos5l_fill_2_402 VPWR VGND sg13cmos5l_fill_2
* cell instance sg13cmos5l_fill_2_403 r0 *1 0,0
Xsg13cmos5l_fill_2_403 VPWR VGND sg13cmos5l_fill_2
* cell instance sg13cmos5l_fill_2_404 r0 *1 0,0
Xsg13cmos5l_fill_2_404 VPWR VGND sg13cmos5l_fill_2
* cell instance sg13cmos5l_fill_2_405 r0 *1 0,0
Xsg13cmos5l_fill_2_405 VPWR VGND sg13cmos5l_fill_2
* cell instance sg13cmos5l_fill_2_406 r0 *1 0,0
Xsg13cmos5l_fill_2_406 VPWR VGND sg13cmos5l_fill_2
* cell instance sg13cmos5l_fill_2_407 r0 *1 0,0
Xsg13cmos5l_fill_2_407 VPWR VGND sg13cmos5l_fill_2
* cell instance sg13cmos5l_fill_2_408 r0 *1 0,0
Xsg13cmos5l_fill_2_408 VPWR VGND sg13cmos5l_fill_2
* cell instance sg13cmos5l_fill_2_409 r0 *1 0,0
Xsg13cmos5l_fill_2_409 VPWR VGND sg13cmos5l_fill_2
* cell instance sg13cmos5l_fill_2_410 r0 *1 0,0
Xsg13cmos5l_fill_2_410 VPWR VGND sg13cmos5l_fill_2
* cell instance sg13cmos5l_fill_2_411 r0 *1 0,0
Xsg13cmos5l_fill_2_411 VPWR VGND sg13cmos5l_fill_2
* cell instance sg13cmos5l_fill_2_412 r0 *1 0,0
Xsg13cmos5l_fill_2_412 VPWR VGND sg13cmos5l_fill_2
* cell instance sg13cmos5l_fill_2_413 r0 *1 0,0
Xsg13cmos5l_fill_2_413 VPWR VGND sg13cmos5l_fill_2
* cell instance sg13cmos5l_fill_2_414 r0 *1 0,0
Xsg13cmos5l_fill_2_414 VPWR VGND sg13cmos5l_fill_2
* cell instance sg13cmos5l_fill_2_415 r0 *1 0,0
Xsg13cmos5l_fill_2_415 VPWR VGND sg13cmos5l_fill_2
* cell instance sg13cmos5l_fill_2_416 r0 *1 0,0
Xsg13cmos5l_fill_2_416 VPWR VGND sg13cmos5l_fill_2
* cell instance sg13cmos5l_fill_2_417 r0 *1 0,0
Xsg13cmos5l_fill_2_417 VPWR VGND sg13cmos5l_fill_2
* cell instance sg13cmos5l_fill_2_418 r0 *1 0,0
Xsg13cmos5l_fill_2_418 VPWR VGND sg13cmos5l_fill_2
* cell instance sg13cmos5l_fill_2_419 r0 *1 0,0
Xsg13cmos5l_fill_2_419 VPWR VGND sg13cmos5l_fill_2
* cell instance sg13cmos5l_fill_2_420 r0 *1 0,0
Xsg13cmos5l_fill_2_420 VPWR VGND sg13cmos5l_fill_2
* cell instance sg13cmos5l_fill_2_421 r0 *1 0,0
Xsg13cmos5l_fill_2_421 VPWR VGND sg13cmos5l_fill_2
* cell instance sg13cmos5l_fill_2_422 r0 *1 0,0
Xsg13cmos5l_fill_2_422 VPWR VGND sg13cmos5l_fill_2
* cell instance sg13cmos5l_fill_2_423 r0 *1 0,0
Xsg13cmos5l_fill_2_423 VPWR VGND sg13cmos5l_fill_2
* cell instance sg13cmos5l_fill_2_424 r0 *1 0,0
Xsg13cmos5l_fill_2_424 VPWR VGND sg13cmos5l_fill_2
* cell instance sg13cmos5l_fill_2_425 r0 *1 0,0
Xsg13cmos5l_fill_2_425 VPWR VGND sg13cmos5l_fill_2
* cell instance sg13cmos5l_fill_2_426 r0 *1 0,0
Xsg13cmos5l_fill_2_426 VPWR VGND sg13cmos5l_fill_2
* cell instance sg13cmos5l_fill_2_427 r0 *1 0,0
Xsg13cmos5l_fill_2_427 VPWR VGND sg13cmos5l_fill_2
* cell instance sg13cmos5l_fill_2_428 r0 *1 0,0
Xsg13cmos5l_fill_2_428 VPWR VGND sg13cmos5l_fill_2
* cell instance sg13cmos5l_fill_2_429 r0 *1 0,0
Xsg13cmos5l_fill_2_429 VPWR VGND sg13cmos5l_fill_2
* cell instance sg13cmos5l_fill_2_430 r0 *1 0,0
Xsg13cmos5l_fill_2_430 VPWR VGND sg13cmos5l_fill_2
* cell instance sg13cmos5l_fill_2_431 r0 *1 0,0
Xsg13cmos5l_fill_2_431 VPWR VGND sg13cmos5l_fill_2
* cell instance sg13cmos5l_fill_2_432 r0 *1 0,0
Xsg13cmos5l_fill_2_432 VPWR VGND sg13cmos5l_fill_2
* cell instance sg13cmos5l_fill_2_433 r0 *1 0,0
Xsg13cmos5l_fill_2_433 VPWR VGND sg13cmos5l_fill_2
* cell instance sg13cmos5l_fill_2_434 r0 *1 0,0
Xsg13cmos5l_fill_2_434 VPWR VGND sg13cmos5l_fill_2
* cell instance sg13cmos5l_fill_2_435 r0 *1 0,0
Xsg13cmos5l_fill_2_435 VPWR VGND sg13cmos5l_fill_2
* cell instance sg13cmos5l_fill_2_436 r0 *1 0,0
Xsg13cmos5l_fill_2_436 VPWR VGND sg13cmos5l_fill_2
* cell instance sg13cmos5l_fill_2_437 r0 *1 0,0
Xsg13cmos5l_fill_2_437 VPWR VGND sg13cmos5l_fill_2
* cell instance sg13cmos5l_fill_2_438 r0 *1 0,0
Xsg13cmos5l_fill_2_438 VPWR VGND sg13cmos5l_fill_2
* cell instance sg13cmos5l_fill_2_439 r0 *1 0,0
Xsg13cmos5l_fill_2_439 VPWR VGND sg13cmos5l_fill_2
* cell instance sg13cmos5l_fill_2_440 r0 *1 0,0
Xsg13cmos5l_fill_2_440 VPWR VGND sg13cmos5l_fill_2
* cell instance sg13cmos5l_fill_2_441 r0 *1 0,0
Xsg13cmos5l_fill_2_441 VPWR VGND sg13cmos5l_fill_2
* cell instance sg13cmos5l_fill_2_442 r0 *1 0,0
Xsg13cmos5l_fill_2_442 VPWR VGND sg13cmos5l_fill_2
* cell instance sg13cmos5l_fill_2_443 r0 *1 0,0
Xsg13cmos5l_fill_2_443 VPWR VGND sg13cmos5l_fill_2
* cell instance sg13cmos5l_fill_2_444 r0 *1 0,0
Xsg13cmos5l_fill_2_444 VPWR VGND sg13cmos5l_fill_2
* cell instance sg13cmos5l_fill_2_445 r0 *1 0,0
Xsg13cmos5l_fill_2_445 VPWR VGND sg13cmos5l_fill_2
* cell instance sg13cmos5l_fill_2_446 r0 *1 0,0
Xsg13cmos5l_fill_2_446 VPWR VGND sg13cmos5l_fill_2
* cell instance sg13cmos5l_fill_2_447 r0 *1 0,0
Xsg13cmos5l_fill_2_447 VPWR VGND sg13cmos5l_fill_2
* cell instance sg13cmos5l_fill_2_448 r0 *1 0,0
Xsg13cmos5l_fill_2_448 VPWR VGND sg13cmos5l_fill_2
* cell instance sg13cmos5l_fill_2_449 r0 *1 0,0
Xsg13cmos5l_fill_2_449 VPWR VGND sg13cmos5l_fill_2
* cell instance sg13cmos5l_fill_2_450 r0 *1 0,0
Xsg13cmos5l_fill_2_450 VPWR VGND sg13cmos5l_fill_2
* cell instance sg13cmos5l_fill_2_451 r0 *1 0,0
Xsg13cmos5l_fill_2_451 VPWR VGND sg13cmos5l_fill_2
* cell instance sg13cmos5l_fill_2_452 r0 *1 0,0
Xsg13cmos5l_fill_2_452 VPWR VGND sg13cmos5l_fill_2
* cell instance sg13cmos5l_fill_2_453 r0 *1 0,0
Xsg13cmos5l_fill_2_453 VPWR VGND sg13cmos5l_fill_2
* cell instance sg13cmos5l_fill_2_454 r0 *1 0,0
Xsg13cmos5l_fill_2_454 VPWR VGND sg13cmos5l_fill_2
* cell instance sg13cmos5l_fill_2_455 r0 *1 0,0
Xsg13cmos5l_fill_2_455 VPWR VGND sg13cmos5l_fill_2
* cell instance sg13cmos5l_fill_2_456 r0 *1 0,0
Xsg13cmos5l_fill_2_456 VPWR VGND sg13cmos5l_fill_2
* cell instance sg13cmos5l_fill_2_457 r0 *1 0,0
Xsg13cmos5l_fill_2_457 VPWR VGND sg13cmos5l_fill_2
* cell instance sg13cmos5l_fill_2_458 r0 *1 0,0
Xsg13cmos5l_fill_2_458 VPWR VGND sg13cmos5l_fill_2
* cell instance sg13cmos5l_fill_2_459 r0 *1 0,0
Xsg13cmos5l_fill_2_459 VPWR VGND sg13cmos5l_fill_2
* cell instance sg13cmos5l_fill_2_460 r0 *1 0,0
Xsg13cmos5l_fill_2_460 VPWR VGND sg13cmos5l_fill_2
* cell instance sg13cmos5l_fill_2_461 r0 *1 0,0
Xsg13cmos5l_fill_2_461 VPWR VGND sg13cmos5l_fill_2
* cell instance sg13cmos5l_fill_2_462 r0 *1 0,0
Xsg13cmos5l_fill_2_462 VPWR VGND sg13cmos5l_fill_2
* cell instance sg13cmos5l_fill_2_463 r0 *1 0,0
Xsg13cmos5l_fill_2_463 VPWR VGND sg13cmos5l_fill_2
* cell instance sg13cmos5l_fill_2_464 r0 *1 0,0
Xsg13cmos5l_fill_2_464 VPWR VGND sg13cmos5l_fill_2
* cell instance sg13cmos5l_fill_2_465 r0 *1 0,0
Xsg13cmos5l_fill_2_465 VPWR VGND sg13cmos5l_fill_2
* cell instance sg13cmos5l_fill_2_466 r0 *1 0,0
Xsg13cmos5l_fill_2_466 VPWR VGND sg13cmos5l_fill_2
* cell instance sg13cmos5l_fill_2_467 r0 *1 0,0
Xsg13cmos5l_fill_2_467 VPWR VGND sg13cmos5l_fill_2
* cell instance sg13cmos5l_fill_2_468 r0 *1 0,0
Xsg13cmos5l_fill_2_468 VPWR VGND sg13cmos5l_fill_2
* cell instance sg13cmos5l_fill_2_469 r0 *1 0,0
Xsg13cmos5l_fill_2_469 VPWR VGND sg13cmos5l_fill_2
* cell instance sg13cmos5l_fill_2_470 r0 *1 0,0
Xsg13cmos5l_fill_2_470 VPWR VGND sg13cmos5l_fill_2
* cell instance sg13cmos5l_fill_2_471 r0 *1 0,0
Xsg13cmos5l_fill_2_471 VPWR VGND sg13cmos5l_fill_2
* cell instance sg13cmos5l_fill_2_472 r0 *1 0,0
Xsg13cmos5l_fill_2_472 VPWR VGND sg13cmos5l_fill_2
* cell instance sg13cmos5l_fill_2_473 r0 *1 0,0
Xsg13cmos5l_fill_2_473 VPWR VGND sg13cmos5l_fill_2
* cell instance sg13cmos5l_fill_2_474 r0 *1 0,0
Xsg13cmos5l_fill_2_474 VPWR VGND sg13cmos5l_fill_2
* cell instance sg13cmos5l_fill_2_475 r0 *1 0,0
Xsg13cmos5l_fill_2_475 VPWR VGND sg13cmos5l_fill_2
* cell instance sg13cmos5l_fill_2_476 r0 *1 0,0
Xsg13cmos5l_fill_2_476 VPWR VGND sg13cmos5l_fill_2
* cell instance sg13cmos5l_fill_2_477 r0 *1 0,0
Xsg13cmos5l_fill_2_477 VPWR VGND sg13cmos5l_fill_2
* cell instance sg13cmos5l_fill_2_478 r0 *1 0,0
Xsg13cmos5l_fill_2_478 VPWR VGND sg13cmos5l_fill_2
* cell instance sg13cmos5l_fill_2_479 r0 *1 0,0
Xsg13cmos5l_fill_2_479 VPWR VGND sg13cmos5l_fill_2
* cell instance sg13cmos5l_fill_2_480 r0 *1 0,0
Xsg13cmos5l_fill_2_480 VPWR VGND sg13cmos5l_fill_2
* cell instance sg13cmos5l_fill_2_481 r0 *1 0,0
Xsg13cmos5l_fill_2_481 VPWR VGND sg13cmos5l_fill_2
* cell instance sg13cmos5l_fill_2_482 r0 *1 0,0
Xsg13cmos5l_fill_2_482 VPWR VGND sg13cmos5l_fill_2
* cell instance sg13cmos5l_fill_2_483 r0 *1 0,0
Xsg13cmos5l_fill_2_483 VPWR VGND sg13cmos5l_fill_2
* cell instance sg13cmos5l_fill_2_484 r0 *1 0,0
Xsg13cmos5l_fill_2_484 VPWR VGND sg13cmos5l_fill_2
* cell instance sg13cmos5l_fill_2_485 r0 *1 0,0
Xsg13cmos5l_fill_2_485 VPWR VGND sg13cmos5l_fill_2
* cell instance sg13cmos5l_fill_2_486 r0 *1 0,0
Xsg13cmos5l_fill_2_486 VPWR VGND sg13cmos5l_fill_2
* cell instance sg13cmos5l_fill_2_487 r0 *1 0,0
Xsg13cmos5l_fill_2_487 VPWR VGND sg13cmos5l_fill_2
* cell instance sg13cmos5l_fill_2_488 r0 *1 0,0
Xsg13cmos5l_fill_2_488 VPWR VGND sg13cmos5l_fill_2
* cell instance sg13cmos5l_fill_2_489 r0 *1 0,0
Xsg13cmos5l_fill_2_489 VPWR VGND sg13cmos5l_fill_2
* cell instance sg13cmos5l_fill_2_490 r0 *1 0,0
Xsg13cmos5l_fill_2_490 VPWR VGND sg13cmos5l_fill_2
* cell instance sg13cmos5l_fill_2_491 r0 *1 0,0
Xsg13cmos5l_fill_2_491 VPWR VGND sg13cmos5l_fill_2
* cell instance sg13cmos5l_fill_2_492 r0 *1 0,0
Xsg13cmos5l_fill_2_492 VPWR VGND sg13cmos5l_fill_2
* cell instance sg13cmos5l_fill_2_493 r0 *1 0,0
Xsg13cmos5l_fill_2_493 VPWR VGND sg13cmos5l_fill_2
* cell instance sg13cmos5l_fill_2_494 r0 *1 0,0
Xsg13cmos5l_fill_2_494 VPWR VGND sg13cmos5l_fill_2
* cell instance sg13cmos5l_fill_2_495 r0 *1 0,0
Xsg13cmos5l_fill_2_495 VPWR VGND sg13cmos5l_fill_2
* cell instance sg13cmos5l_fill_2_496 r0 *1 0,0
Xsg13cmos5l_fill_2_496 VPWR VGND sg13cmos5l_fill_2
* cell instance sg13cmos5l_fill_2_497 r0 *1 0,0
Xsg13cmos5l_fill_2_497 VPWR VGND sg13cmos5l_fill_2
* cell instance sg13cmos5l_fill_2_498 r0 *1 0,0
Xsg13cmos5l_fill_2_498 VPWR VGND sg13cmos5l_fill_2
* cell instance sg13cmos5l_fill_2_499 r0 *1 0,0
Xsg13cmos5l_fill_2_499 VPWR VGND sg13cmos5l_fill_2
* cell instance sg13cmos5l_fill_2_500 r0 *1 0,0
Xsg13cmos5l_fill_2_500 VPWR VGND sg13cmos5l_fill_2
* cell instance sg13cmos5l_fill_2_501 r0 *1 0,0
Xsg13cmos5l_fill_2_501 VPWR VGND sg13cmos5l_fill_2
* cell instance sg13cmos5l_fill_2_502 r0 *1 0,0
Xsg13cmos5l_fill_2_502 VPWR VGND sg13cmos5l_fill_2
* cell instance sg13cmos5l_fill_2_503 r0 *1 0,0
Xsg13cmos5l_fill_2_503 VPWR VGND sg13cmos5l_fill_2
* cell instance sg13cmos5l_fill_2_504 r0 *1 0,0
Xsg13cmos5l_fill_2_504 VPWR VGND sg13cmos5l_fill_2
* cell instance sg13cmos5l_fill_2_505 r0 *1 0,0
Xsg13cmos5l_fill_2_505 VPWR VGND sg13cmos5l_fill_2
* cell instance sg13cmos5l_fill_2_506 r0 *1 0,0
Xsg13cmos5l_fill_2_506 VPWR VGND sg13cmos5l_fill_2
* cell instance sg13cmos5l_fill_2_507 r0 *1 0,0
Xsg13cmos5l_fill_2_507 VPWR VGND sg13cmos5l_fill_2
* cell instance sg13cmos5l_fill_2_508 r0 *1 0,0
Xsg13cmos5l_fill_2_508 VPWR VGND sg13cmos5l_fill_2
* cell instance sg13cmos5l_fill_2_509 r0 *1 0,0
Xsg13cmos5l_fill_2_509 VPWR VGND sg13cmos5l_fill_2
* cell instance sg13cmos5l_fill_2_510 r0 *1 0,0
Xsg13cmos5l_fill_2_510 VPWR VGND sg13cmos5l_fill_2
* cell instance sg13cmos5l_fill_2_511 r0 *1 0,0
Xsg13cmos5l_fill_2_511 VPWR VGND sg13cmos5l_fill_2
* cell instance sg13cmos5l_fill_2_512 r0 *1 0,0
Xsg13cmos5l_fill_2_512 VPWR VGND sg13cmos5l_fill_2
* cell instance sg13cmos5l_fill_2_513 r0 *1 0,0
Xsg13cmos5l_fill_2_513 VPWR VGND sg13cmos5l_fill_2
* cell instance sg13cmos5l_fill_2_514 r0 *1 0,0
Xsg13cmos5l_fill_2_514 VPWR VGND sg13cmos5l_fill_2
* cell instance sg13cmos5l_fill_2_515 r0 *1 0,0
Xsg13cmos5l_fill_2_515 VPWR VGND sg13cmos5l_fill_2
* cell instance sg13cmos5l_fill_2_516 r0 *1 0,0
Xsg13cmos5l_fill_2_516 VPWR VGND sg13cmos5l_fill_2
* cell instance sg13cmos5l_fill_2_517 r0 *1 0,0
Xsg13cmos5l_fill_2_517 VPWR VGND sg13cmos5l_fill_2
* cell instance sg13cmos5l_fill_2_518 r0 *1 0,0
Xsg13cmos5l_fill_2_518 VPWR VGND sg13cmos5l_fill_2
* cell instance sg13cmos5l_fill_2_519 r0 *1 0,0
Xsg13cmos5l_fill_2_519 VPWR VGND sg13cmos5l_fill_2
* cell instance sg13cmos5l_fill_2_520 r0 *1 0,0
Xsg13cmos5l_fill_2_520 VPWR VGND sg13cmos5l_fill_2
* cell instance sg13cmos5l_fill_2_521 r0 *1 0,0
Xsg13cmos5l_fill_2_521 VPWR VGND sg13cmos5l_fill_2
* cell instance sg13cmos5l_fill_2_522 r0 *1 0,0
Xsg13cmos5l_fill_2_522 VPWR VGND sg13cmos5l_fill_2
* cell instance sg13cmos5l_fill_2_523 r0 *1 0,0
Xsg13cmos5l_fill_2_523 VPWR VGND sg13cmos5l_fill_2
* cell instance sg13cmos5l_fill_2_524 r0 *1 0,0
Xsg13cmos5l_fill_2_524 VPWR VGND sg13cmos5l_fill_2
* cell instance sg13cmos5l_fill_2_525 r0 *1 0,0
Xsg13cmos5l_fill_2_525 VPWR VGND sg13cmos5l_fill_2
* cell instance sg13cmos5l_fill_2_526 r0 *1 0,0
Xsg13cmos5l_fill_2_526 VPWR VGND sg13cmos5l_fill_2
* cell instance sg13cmos5l_fill_2_527 r0 *1 0,0
Xsg13cmos5l_fill_2_527 VPWR VGND sg13cmos5l_fill_2
* cell instance sg13cmos5l_fill_2_528 r0 *1 0,0
Xsg13cmos5l_fill_2_528 VPWR VGND sg13cmos5l_fill_2
* cell instance sg13cmos5l_fill_2_529 r0 *1 0,0
Xsg13cmos5l_fill_2_529 VPWR VGND sg13cmos5l_fill_2
* cell instance sg13cmos5l_fill_2_530 r0 *1 0,0
Xsg13cmos5l_fill_2_530 VPWR VGND sg13cmos5l_fill_2
* cell instance sg13cmos5l_fill_2_531 r0 *1 0,0
Xsg13cmos5l_fill_2_531 VPWR VGND sg13cmos5l_fill_2
* cell instance sg13cmos5l_fill_2_532 r0 *1 0,0
Xsg13cmos5l_fill_2_532 VPWR VGND sg13cmos5l_fill_2
* cell instance sg13cmos5l_fill_2_533 r0 *1 0,0
Xsg13cmos5l_fill_2_533 VPWR VGND sg13cmos5l_fill_2
* cell instance sg13cmos5l_fill_2_534 r0 *1 0,0
Xsg13cmos5l_fill_2_534 VPWR VGND sg13cmos5l_fill_2
* cell instance sg13cmos5l_fill_2_535 r0 *1 0,0
Xsg13cmos5l_fill_2_535 VPWR VGND sg13cmos5l_fill_2
* cell instance sg13cmos5l_fill_2_536 r0 *1 0,0
Xsg13cmos5l_fill_2_536 VPWR VGND sg13cmos5l_fill_2
* cell instance sg13cmos5l_fill_2_537 r0 *1 0,0
Xsg13cmos5l_fill_2_537 VPWR VGND sg13cmos5l_fill_2
* cell instance sg13cmos5l_fill_2_538 r0 *1 0,0
Xsg13cmos5l_fill_2_538 VPWR VGND sg13cmos5l_fill_2
* cell instance sg13cmos5l_fill_2_539 r0 *1 0,0
Xsg13cmos5l_fill_2_539 VPWR VGND sg13cmos5l_fill_2
* cell instance sg13cmos5l_fill_2_540 r0 *1 0,0
Xsg13cmos5l_fill_2_540 VPWR VGND sg13cmos5l_fill_2
* cell instance sg13cmos5l_fill_2_541 r0 *1 0,0
Xsg13cmos5l_fill_2_541 VPWR VGND sg13cmos5l_fill_2
* cell instance sg13cmos5l_fill_2_542 r0 *1 0,0
Xsg13cmos5l_fill_2_542 VPWR VGND sg13cmos5l_fill_2
* cell instance sg13cmos5l_fill_2_543 r0 *1 0,0
Xsg13cmos5l_fill_2_543 VPWR VGND sg13cmos5l_fill_2
* cell instance sg13cmos5l_fill_2_544 r0 *1 0,0
Xsg13cmos5l_fill_2_544 VPWR VGND sg13cmos5l_fill_2
* cell instance sg13cmos5l_fill_2_545 r0 *1 0,0
Xsg13cmos5l_fill_2_545 VPWR VGND sg13cmos5l_fill_2
* cell instance sg13cmos5l_fill_2_546 r0 *1 0,0
Xsg13cmos5l_fill_2_546 VPWR VGND sg13cmos5l_fill_2
* cell instance sg13cmos5l_fill_2_547 r0 *1 0,0
Xsg13cmos5l_fill_2_547 VPWR VGND sg13cmos5l_fill_2
* cell instance sg13cmos5l_fill_2_548 r0 *1 0,0
Xsg13cmos5l_fill_2_548 VPWR VGND sg13cmos5l_fill_2
* cell instance sg13cmos5l_fill_2_549 r0 *1 0,0
Xsg13cmos5l_fill_2_549 VPWR VGND sg13cmos5l_fill_2
* cell instance sg13cmos5l_fill_2_550 r0 *1 0,0
Xsg13cmos5l_fill_2_550 VPWR VGND sg13cmos5l_fill_2
* cell instance sg13cmos5l_fill_2_551 r0 *1 0,0
Xsg13cmos5l_fill_2_551 VPWR VGND sg13cmos5l_fill_2
* cell instance sg13cmos5l_fill_2_552 r0 *1 0,0
Xsg13cmos5l_fill_2_552 VPWR VGND sg13cmos5l_fill_2
* cell instance sg13cmos5l_fill_2_553 r0 *1 0,0
Xsg13cmos5l_fill_2_553 VPWR VGND sg13cmos5l_fill_2
* cell instance sg13cmos5l_fill_2_554 r0 *1 0,0
Xsg13cmos5l_fill_2_554 VPWR VGND sg13cmos5l_fill_2
* cell instance sg13cmos5l_fill_2_555 r0 *1 0,0
Xsg13cmos5l_fill_2_555 VPWR VGND sg13cmos5l_fill_2
* cell instance sg13cmos5l_fill_2_556 r0 *1 0,0
Xsg13cmos5l_fill_2_556 VPWR VGND sg13cmos5l_fill_2
* cell instance sg13cmos5l_fill_2_557 r0 *1 0,0
Xsg13cmos5l_fill_2_557 VPWR VGND sg13cmos5l_fill_2
* cell instance sg13cmos5l_fill_2_558 r0 *1 0,0
Xsg13cmos5l_fill_2_558 VPWR VGND sg13cmos5l_fill_2
* cell instance sg13cmos5l_fill_2_559 r0 *1 0,0
Xsg13cmos5l_fill_2_559 VPWR VGND sg13cmos5l_fill_2
* cell instance sg13cmos5l_fill_2_560 r0 *1 0,0
Xsg13cmos5l_fill_2_560 VPWR VGND sg13cmos5l_fill_2
* cell instance sg13cmos5l_fill_2_561 r0 *1 0,0
Xsg13cmos5l_fill_2_561 VPWR VGND sg13cmos5l_fill_2
* cell instance sg13cmos5l_fill_2_562 r0 *1 0,0
Xsg13cmos5l_fill_2_562 VPWR VGND sg13cmos5l_fill_2
* cell instance sg13cmos5l_fill_2_563 r0 *1 0,0
Xsg13cmos5l_fill_2_563 VPWR VGND sg13cmos5l_fill_2
* cell instance sg13cmos5l_fill_2_564 r0 *1 0,0
Xsg13cmos5l_fill_2_564 VPWR VGND sg13cmos5l_fill_2
* cell instance sg13cmos5l_fill_2_565 r0 *1 0,0
Xsg13cmos5l_fill_2_565 VPWR VGND sg13cmos5l_fill_2
* cell instance sg13cmos5l_fill_2_566 r0 *1 0,0
Xsg13cmos5l_fill_2_566 VPWR VGND sg13cmos5l_fill_2
* cell instance sg13cmos5l_fill_2_567 r0 *1 0,0
Xsg13cmos5l_fill_2_567 VPWR VGND sg13cmos5l_fill_2
* cell instance sg13cmos5l_fill_2_568 r0 *1 0,0
Xsg13cmos5l_fill_2_568 VPWR VGND sg13cmos5l_fill_2
* cell instance sg13cmos5l_fill_2_569 r0 *1 0,0
Xsg13cmos5l_fill_2_569 VPWR VGND sg13cmos5l_fill_2
* cell instance sg13cmos5l_fill_2_570 r0 *1 0,0
Xsg13cmos5l_fill_2_570 VPWR VGND sg13cmos5l_fill_2
* cell instance sg13cmos5l_fill_2_571 r0 *1 0,0
Xsg13cmos5l_fill_2_571 VPWR VGND sg13cmos5l_fill_2
* cell instance sg13cmos5l_fill_2_572 r0 *1 0,0
Xsg13cmos5l_fill_2_572 VPWR VGND sg13cmos5l_fill_2
* cell instance sg13cmos5l_fill_2_573 r0 *1 0,0
Xsg13cmos5l_fill_2_573 VPWR VGND sg13cmos5l_fill_2
* cell instance sg13cmos5l_fill_2_574 r0 *1 0,0
Xsg13cmos5l_fill_2_574 VPWR VGND sg13cmos5l_fill_2
* cell instance sg13cmos5l_fill_2_575 r0 *1 0,0
Xsg13cmos5l_fill_2_575 VPWR VGND sg13cmos5l_fill_2
* cell instance sg13cmos5l_fill_2_576 r0 *1 0,0
Xsg13cmos5l_fill_2_576 VPWR VGND sg13cmos5l_fill_2
* cell instance sg13cmos5l_fill_2_577 r0 *1 0,0
Xsg13cmos5l_fill_2_577 VPWR VGND sg13cmos5l_fill_2
* cell instance sg13cmos5l_fill_2_578 r0 *1 0,0
Xsg13cmos5l_fill_2_578 VPWR VGND sg13cmos5l_fill_2
* cell instance sg13cmos5l_fill_2_579 r0 *1 0,0
Xsg13cmos5l_fill_2_579 VPWR VGND sg13cmos5l_fill_2
* cell instance sg13cmos5l_fill_2_580 r0 *1 0,0
Xsg13cmos5l_fill_2_580 VPWR VGND sg13cmos5l_fill_2
* cell instance sg13cmos5l_fill_2_581 r0 *1 0,0
Xsg13cmos5l_fill_2_581 VPWR VGND sg13cmos5l_fill_2
* cell instance sg13cmos5l_fill_2_582 r0 *1 0,0
Xsg13cmos5l_fill_2_582 VPWR VGND sg13cmos5l_fill_2
* cell instance sg13cmos5l_fill_2_583 r0 *1 0,0
Xsg13cmos5l_fill_2_583 VPWR VGND sg13cmos5l_fill_2
* cell instance sg13cmos5l_fill_2_584 r0 *1 0,0
Xsg13cmos5l_fill_2_584 VPWR VGND sg13cmos5l_fill_2
* cell instance sg13cmos5l_fill_2_585 r0 *1 0,0
Xsg13cmos5l_fill_2_585 VPWR VGND sg13cmos5l_fill_2
* cell instance sg13cmos5l_fill_2_586 r0 *1 0,0
Xsg13cmos5l_fill_2_586 VPWR VGND sg13cmos5l_fill_2
* cell instance sg13cmos5l_fill_2_587 r0 *1 0,0
Xsg13cmos5l_fill_2_587 VPWR VGND sg13cmos5l_fill_2
* cell instance sg13cmos5l_fill_2_588 r0 *1 0,0
Xsg13cmos5l_fill_2_588 VPWR VGND sg13cmos5l_fill_2
* cell instance sg13cmos5l_fill_2_589 r0 *1 0,0
Xsg13cmos5l_fill_2_589 VPWR VGND sg13cmos5l_fill_2
* cell instance sg13cmos5l_fill_2_590 r0 *1 0,0
Xsg13cmos5l_fill_2_590 VPWR VGND sg13cmos5l_fill_2
* cell instance sg13cmos5l_fill_2_591 r0 *1 0,0
Xsg13cmos5l_fill_2_591 VPWR VGND sg13cmos5l_fill_2
* cell instance sg13cmos5l_fill_2_592 r0 *1 0,0
Xsg13cmos5l_fill_2_592 VPWR VGND sg13cmos5l_fill_2
* cell instance sg13cmos5l_fill_2_593 r0 *1 0,0
Xsg13cmos5l_fill_2_593 VPWR VGND sg13cmos5l_fill_2
* cell instance sg13cmos5l_fill_2_594 r0 *1 0,0
Xsg13cmos5l_fill_2_594 VPWR VGND sg13cmos5l_fill_2
* cell instance sg13cmos5l_fill_2_595 r0 *1 0,0
Xsg13cmos5l_fill_2_595 VPWR VGND sg13cmos5l_fill_2
* cell instance sg13cmos5l_fill_2_596 r0 *1 0,0
Xsg13cmos5l_fill_2_596 VPWR VGND sg13cmos5l_fill_2
* cell instance sg13cmos5l_fill_2_597 r0 *1 0,0
Xsg13cmos5l_fill_2_597 VPWR VGND sg13cmos5l_fill_2
* cell instance sg13cmos5l_fill_2_598 r0 *1 0,0
Xsg13cmos5l_fill_2_598 VPWR VGND sg13cmos5l_fill_2
* cell instance sg13cmos5l_fill_2_599 r0 *1 0,0
Xsg13cmos5l_fill_2_599 VPWR VGND sg13cmos5l_fill_2
* cell instance sg13cmos5l_fill_2_600 r0 *1 0,0
Xsg13cmos5l_fill_2_600 VPWR VGND sg13cmos5l_fill_2
* cell instance sg13cmos5l_fill_2_601 r0 *1 0,0
Xsg13cmos5l_fill_2_601 VPWR VGND sg13cmos5l_fill_2
* cell instance sg13cmos5l_fill_2_602 r0 *1 0,0
Xsg13cmos5l_fill_2_602 VPWR VGND sg13cmos5l_fill_2
* cell instance sg13cmos5l_fill_2_603 r0 *1 0,0
Xsg13cmos5l_fill_2_603 VPWR VGND sg13cmos5l_fill_2
* cell instance sg13cmos5l_fill_2_604 r0 *1 0,0
Xsg13cmos5l_fill_2_604 VPWR VGND sg13cmos5l_fill_2
* cell instance sg13cmos5l_fill_2_605 r0 *1 0,0
Xsg13cmos5l_fill_2_605 VPWR VGND sg13cmos5l_fill_2
* cell instance sg13cmos5l_fill_2_606 r0 *1 0,0
Xsg13cmos5l_fill_2_606 VPWR VGND sg13cmos5l_fill_2
* cell instance sg13cmos5l_fill_2_607 r0 *1 0,0
Xsg13cmos5l_fill_2_607 VPWR VGND sg13cmos5l_fill_2
* cell instance sg13cmos5l_fill_2_608 r0 *1 0,0
Xsg13cmos5l_fill_2_608 VPWR VGND sg13cmos5l_fill_2
* cell instance sg13cmos5l_fill_2_609 r0 *1 0,0
Xsg13cmos5l_fill_2_609 VPWR VGND sg13cmos5l_fill_2
* cell instance sg13cmos5l_fill_2_610 r0 *1 0,0
Xsg13cmos5l_fill_2_610 VPWR VGND sg13cmos5l_fill_2
* cell instance sg13cmos5l_fill_2_611 r0 *1 0,0
Xsg13cmos5l_fill_2_611 VPWR VGND sg13cmos5l_fill_2
* cell instance sg13cmos5l_fill_2_612 r0 *1 0,0
Xsg13cmos5l_fill_2_612 VPWR VGND sg13cmos5l_fill_2
* cell instance sg13cmos5l_fill_2_613 r0 *1 0,0
Xsg13cmos5l_fill_2_613 VPWR VGND sg13cmos5l_fill_2
* cell instance sg13cmos5l_fill_2_614 r0 *1 0,0
Xsg13cmos5l_fill_2_614 VPWR VGND sg13cmos5l_fill_2
* cell instance sg13cmos5l_fill_2_615 r0 *1 0,0
Xsg13cmos5l_fill_2_615 VPWR VGND sg13cmos5l_fill_2
* cell instance sg13cmos5l_fill_2_616 r0 *1 0,0
Xsg13cmos5l_fill_2_616 VPWR VGND sg13cmos5l_fill_2
* cell instance sg13cmos5l_fill_2_617 r0 *1 0,0
Xsg13cmos5l_fill_2_617 VPWR VGND sg13cmos5l_fill_2
* cell instance sg13cmos5l_fill_2_618 r0 *1 0,0
Xsg13cmos5l_fill_2_618 VPWR VGND sg13cmos5l_fill_2
* cell instance sg13cmos5l_fill_2_619 r0 *1 0,0
Xsg13cmos5l_fill_2_619 VPWR VGND sg13cmos5l_fill_2
* cell instance sg13cmos5l_fill_2_620 r0 *1 0,0
Xsg13cmos5l_fill_2_620 VPWR VGND sg13cmos5l_fill_2
* cell instance sg13cmos5l_fill_2_621 r0 *1 0,0
Xsg13cmos5l_fill_2_621 VPWR VGND sg13cmos5l_fill_2
* cell instance sg13cmos5l_fill_2_622 r0 *1 0,0
Xsg13cmos5l_fill_2_622 VPWR VGND sg13cmos5l_fill_2
* cell instance sg13cmos5l_fill_2_623 r0 *1 0,0
Xsg13cmos5l_fill_2_623 VPWR VGND sg13cmos5l_fill_2
* cell instance sg13cmos5l_fill_2_624 r0 *1 0,0
Xsg13cmos5l_fill_2_624 VPWR VGND sg13cmos5l_fill_2
* cell instance sg13cmos5l_fill_2_625 r0 *1 0,0
Xsg13cmos5l_fill_2_625 VPWR VGND sg13cmos5l_fill_2
* cell instance sg13cmos5l_fill_2_626 r0 *1 0,0
Xsg13cmos5l_fill_2_626 VPWR VGND sg13cmos5l_fill_2
* cell instance sg13cmos5l_fill_2_627 r0 *1 0,0
Xsg13cmos5l_fill_2_627 VPWR VGND sg13cmos5l_fill_2
* cell instance sg13cmos5l_fill_2_628 r0 *1 0,0
Xsg13cmos5l_fill_2_628 VPWR VGND sg13cmos5l_fill_2
* cell instance sg13cmos5l_fill_2_629 r0 *1 0,0
Xsg13cmos5l_fill_2_629 VPWR VGND sg13cmos5l_fill_2
* cell instance sg13cmos5l_fill_2_630 r0 *1 0,0
Xsg13cmos5l_fill_2_630 VPWR VGND sg13cmos5l_fill_2
* cell instance sg13cmos5l_fill_2_631 r0 *1 0,0
Xsg13cmos5l_fill_2_631 VPWR VGND sg13cmos5l_fill_2
* cell instance sg13cmos5l_fill_2_632 r0 *1 0,0
Xsg13cmos5l_fill_2_632 VPWR VGND sg13cmos5l_fill_2
* cell instance sg13cmos5l_fill_2_633 r0 *1 0,0
Xsg13cmos5l_fill_2_633 VPWR VGND sg13cmos5l_fill_2
* cell instance sg13cmos5l_fill_2_634 r0 *1 0,0
Xsg13cmos5l_fill_2_634 VPWR VGND sg13cmos5l_fill_2
* cell instance sg13cmos5l_fill_2_635 r0 *1 0,0
Xsg13cmos5l_fill_2_635 VPWR VGND sg13cmos5l_fill_2
* cell instance sg13cmos5l_fill_2_636 r0 *1 0,0
Xsg13cmos5l_fill_2_636 VPWR VGND sg13cmos5l_fill_2
* cell instance sg13cmos5l_fill_2_637 r0 *1 0,0
Xsg13cmos5l_fill_2_637 VPWR VGND sg13cmos5l_fill_2
* cell instance sg13cmos5l_fill_2_638 r0 *1 0,0
Xsg13cmos5l_fill_2_638 VPWR VGND sg13cmos5l_fill_2
* cell instance sg13cmos5l_fill_2_639 r0 *1 0,0
Xsg13cmos5l_fill_2_639 VPWR VGND sg13cmos5l_fill_2
* cell instance sg13cmos5l_fill_2_640 r0 *1 0,0
Xsg13cmos5l_fill_2_640 VPWR VGND sg13cmos5l_fill_2
* cell instance sg13cmos5l_fill_2_641 r0 *1 0,0
Xsg13cmos5l_fill_2_641 VPWR VGND sg13cmos5l_fill_2
* cell instance sg13cmos5l_fill_2_642 r0 *1 0,0
Xsg13cmos5l_fill_2_642 VPWR VGND sg13cmos5l_fill_2
* cell instance sg13cmos5l_fill_2_643 r0 *1 0,0
Xsg13cmos5l_fill_2_643 VPWR VGND sg13cmos5l_fill_2
* cell instance sg13cmos5l_fill_2_644 r0 *1 0,0
Xsg13cmos5l_fill_2_644 VPWR VGND sg13cmos5l_fill_2
* cell instance sg13cmos5l_fill_2_645 r0 *1 0,0
Xsg13cmos5l_fill_2_645 VPWR VGND sg13cmos5l_fill_2
* cell instance sg13cmos5l_fill_2_646 r0 *1 0,0
Xsg13cmos5l_fill_2_646 VPWR VGND sg13cmos5l_fill_2
* cell instance sg13cmos5l_fill_2_647 r0 *1 0,0
Xsg13cmos5l_fill_2_647 VPWR VGND sg13cmos5l_fill_2
* cell instance sg13cmos5l_fill_2_648 r0 *1 0,0
Xsg13cmos5l_fill_2_648 VPWR VGND sg13cmos5l_fill_2
* cell instance sg13cmos5l_fill_2_649 r0 *1 0,0
Xsg13cmos5l_fill_2_649 VPWR VGND sg13cmos5l_fill_2
* cell instance sg13cmos5l_fill_2_650 r0 *1 0,0
Xsg13cmos5l_fill_2_650 VPWR VGND sg13cmos5l_fill_2
* cell instance sg13cmos5l_fill_2_651 r0 *1 0,0
Xsg13cmos5l_fill_2_651 VPWR VGND sg13cmos5l_fill_2
* cell instance sg13cmos5l_fill_2_652 r0 *1 0,0
Xsg13cmos5l_fill_2_652 VPWR VGND sg13cmos5l_fill_2
* cell instance sg13cmos5l_fill_2_653 r0 *1 0,0
Xsg13cmos5l_fill_2_653 VPWR VGND sg13cmos5l_fill_2
* cell instance sg13cmos5l_fill_2_654 r0 *1 0,0
Xsg13cmos5l_fill_2_654 VPWR VGND sg13cmos5l_fill_2
* cell instance sg13cmos5l_fill_2_655 r0 *1 0,0
Xsg13cmos5l_fill_2_655 VPWR VGND sg13cmos5l_fill_2
* cell instance sg13cmos5l_fill_2_656 r0 *1 0,0
Xsg13cmos5l_fill_2_656 VPWR VGND sg13cmos5l_fill_2
* cell instance sg13cmos5l_fill_2_657 r0 *1 0,0
Xsg13cmos5l_fill_2_657 VPWR VGND sg13cmos5l_fill_2
* cell instance sg13cmos5l_fill_2_658 r0 *1 0,0
Xsg13cmos5l_fill_2_658 VPWR VGND sg13cmos5l_fill_2
* cell instance sg13cmos5l_fill_2_659 r0 *1 0,0
Xsg13cmos5l_fill_2_659 VPWR VGND sg13cmos5l_fill_2
* cell instance sg13cmos5l_fill_2_660 r0 *1 0,0
Xsg13cmos5l_fill_2_660 VPWR VGND sg13cmos5l_fill_2
* cell instance sg13cmos5l_fill_2_661 r0 *1 0,0
Xsg13cmos5l_fill_2_661 VPWR VGND sg13cmos5l_fill_2
* cell instance sg13cmos5l_fill_2_662 r0 *1 0,0
Xsg13cmos5l_fill_2_662 VPWR VGND sg13cmos5l_fill_2
* cell instance sg13cmos5l_fill_2_663 r0 *1 0,0
Xsg13cmos5l_fill_2_663 VPWR VGND sg13cmos5l_fill_2
* cell instance sg13cmos5l_fill_2_664 r0 *1 0,0
Xsg13cmos5l_fill_2_664 VPWR VGND sg13cmos5l_fill_2
* cell instance sg13cmos5l_fill_2_665 r0 *1 0,0
Xsg13cmos5l_fill_2_665 VPWR VGND sg13cmos5l_fill_2
* cell instance sg13cmos5l_fill_2_666 r0 *1 0,0
Xsg13cmos5l_fill_2_666 VPWR VGND sg13cmos5l_fill_2
* cell instance sg13cmos5l_fill_2_667 r0 *1 0,0
Xsg13cmos5l_fill_2_667 VPWR VGND sg13cmos5l_fill_2
* cell instance sg13cmos5l_fill_2_668 r0 *1 0,0
Xsg13cmos5l_fill_2_668 VPWR VGND sg13cmos5l_fill_2
* cell instance sg13cmos5l_fill_2_669 r0 *1 0,0
Xsg13cmos5l_fill_2_669 VPWR VGND sg13cmos5l_fill_2
* cell instance sg13cmos5l_fill_2_670 r0 *1 0,0
Xsg13cmos5l_fill_2_670 VPWR VGND sg13cmos5l_fill_2
* cell instance sg13cmos5l_fill_2_671 r0 *1 0,0
Xsg13cmos5l_fill_2_671 VPWR VGND sg13cmos5l_fill_2
* cell instance sg13cmos5l_fill_2_672 r0 *1 0,0
Xsg13cmos5l_fill_2_672 VPWR VGND sg13cmos5l_fill_2
* cell instance sg13cmos5l_fill_2_673 r0 *1 0,0
Xsg13cmos5l_fill_2_673 VPWR VGND sg13cmos5l_fill_2
* cell instance sg13cmos5l_fill_2_674 r0 *1 0,0
Xsg13cmos5l_fill_2_674 VPWR VGND sg13cmos5l_fill_2
* cell instance sg13cmos5l_fill_2_675 r0 *1 0,0
Xsg13cmos5l_fill_2_675 VPWR VGND sg13cmos5l_fill_2
* cell instance sg13cmos5l_fill_2_676 r0 *1 0,0
Xsg13cmos5l_fill_2_676 VPWR VGND sg13cmos5l_fill_2
* cell instance sg13cmos5l_fill_2_677 r0 *1 0,0
Xsg13cmos5l_fill_2_677 VPWR VGND sg13cmos5l_fill_2
* cell instance sg13cmos5l_fill_2_678 r0 *1 0,0
Xsg13cmos5l_fill_2_678 VPWR VGND sg13cmos5l_fill_2
* cell instance sg13cmos5l_fill_2_679 r0 *1 0,0
Xsg13cmos5l_fill_2_679 VPWR VGND sg13cmos5l_fill_2
* cell instance sg13cmos5l_fill_2_680 r0 *1 0,0
Xsg13cmos5l_fill_2_680 VPWR VGND sg13cmos5l_fill_2
* cell instance sg13cmos5l_fill_2_681 r0 *1 0,0
Xsg13cmos5l_fill_2_681 VPWR VGND sg13cmos5l_fill_2
* cell instance sg13cmos5l_fill_2_682 r0 *1 0,0
Xsg13cmos5l_fill_2_682 VPWR VGND sg13cmos5l_fill_2
* cell instance sg13cmos5l_fill_2_683 r0 *1 0,0
Xsg13cmos5l_fill_2_683 VPWR VGND sg13cmos5l_fill_2
* cell instance sg13cmos5l_fill_2_684 r0 *1 0,0
Xsg13cmos5l_fill_2_684 VPWR VGND sg13cmos5l_fill_2
* cell instance sg13cmos5l_fill_2_685 r0 *1 0,0
Xsg13cmos5l_fill_2_685 VPWR VGND sg13cmos5l_fill_2
* cell instance sg13cmos5l_fill_2_686 r0 *1 0,0
Xsg13cmos5l_fill_2_686 VPWR VGND sg13cmos5l_fill_2
* cell instance sg13cmos5l_fill_2_687 r0 *1 0,0
Xsg13cmos5l_fill_2_687 VPWR VGND sg13cmos5l_fill_2
* cell instance sg13cmos5l_fill_2_688 r0 *1 0,0
Xsg13cmos5l_fill_2_688 VPWR VGND sg13cmos5l_fill_2
* cell instance sg13cmos5l_fill_2_689 r0 *1 0,0
Xsg13cmos5l_fill_2_689 VPWR VGND sg13cmos5l_fill_2
* cell instance sg13cmos5l_fill_2_690 r0 *1 0,0
Xsg13cmos5l_fill_2_690 VPWR VGND sg13cmos5l_fill_2
* cell instance sg13cmos5l_fill_2_691 r0 *1 0,0
Xsg13cmos5l_fill_2_691 VPWR VGND sg13cmos5l_fill_2
* cell instance sg13cmos5l_fill_2_692 r0 *1 0,0
Xsg13cmos5l_fill_2_692 VPWR VGND sg13cmos5l_fill_2
* cell instance sg13cmos5l_fill_2_693 r0 *1 0,0
Xsg13cmos5l_fill_2_693 VPWR VGND sg13cmos5l_fill_2
* cell instance sg13cmos5l_fill_2_694 r0 *1 0,0
Xsg13cmos5l_fill_2_694 VPWR VGND sg13cmos5l_fill_2
* cell instance sg13cmos5l_fill_2_695 r0 *1 0,0
Xsg13cmos5l_fill_2_695 VPWR VGND sg13cmos5l_fill_2
* cell instance sg13cmos5l_fill_2_696 r0 *1 0,0
Xsg13cmos5l_fill_2_696 VPWR VGND sg13cmos5l_fill_2
* cell instance sg13cmos5l_fill_2_697 r0 *1 0,0
Xsg13cmos5l_fill_2_697 VPWR VGND sg13cmos5l_fill_2
* cell instance sg13cmos5l_fill_2_698 r0 *1 0,0
Xsg13cmos5l_fill_2_698 VPWR VGND sg13cmos5l_fill_2
* cell instance sg13cmos5l_fill_2_699 r0 *1 0,0
Xsg13cmos5l_fill_2_699 VPWR VGND sg13cmos5l_fill_2
* cell instance sg13cmos5l_fill_2_700 r0 *1 0,0
Xsg13cmos5l_fill_2_700 VPWR VGND sg13cmos5l_fill_2
* cell instance sg13cmos5l_fill_2_701 r0 *1 0,0
Xsg13cmos5l_fill_2_701 VPWR VGND sg13cmos5l_fill_2
* cell instance sg13cmos5l_fill_2_702 r0 *1 0,0
Xsg13cmos5l_fill_2_702 VPWR VGND sg13cmos5l_fill_2
* cell instance sg13cmos5l_fill_2_703 r0 *1 0,0
Xsg13cmos5l_fill_2_703 VPWR VGND sg13cmos5l_fill_2
* cell instance sg13cmos5l_fill_2_704 r0 *1 0,0
Xsg13cmos5l_fill_2_704 VPWR VGND sg13cmos5l_fill_2
* cell instance sg13cmos5l_fill_2_705 r0 *1 0,0
Xsg13cmos5l_fill_2_705 VPWR VGND sg13cmos5l_fill_2
* cell instance sg13cmos5l_fill_2_706 r0 *1 0,0
Xsg13cmos5l_fill_2_706 VPWR VGND sg13cmos5l_fill_2
* cell instance sg13cmos5l_fill_2_707 r0 *1 0,0
Xsg13cmos5l_fill_2_707 VPWR VGND sg13cmos5l_fill_2
* cell instance sg13cmos5l_fill_2_708 r0 *1 0,0
Xsg13cmos5l_fill_2_708 VPWR VGND sg13cmos5l_fill_2
* cell instance sg13cmos5l_fill_2_709 r0 *1 0,0
Xsg13cmos5l_fill_2_709 VPWR VGND sg13cmos5l_fill_2
* cell instance sg13cmos5l_fill_2_710 r0 *1 0,0
Xsg13cmos5l_fill_2_710 VPWR VGND sg13cmos5l_fill_2
* cell instance sg13cmos5l_fill_2_711 r0 *1 0,0
Xsg13cmos5l_fill_2_711 VPWR VGND sg13cmos5l_fill_2
* cell instance sg13cmos5l_fill_2_712 r0 *1 0,0
Xsg13cmos5l_fill_2_712 VPWR VGND sg13cmos5l_fill_2
* cell instance sg13cmos5l_fill_2_713 r0 *1 0,0
Xsg13cmos5l_fill_2_713 VPWR VGND sg13cmos5l_fill_2
* cell instance sg13cmos5l_fill_2_714 r0 *1 0,0
Xsg13cmos5l_fill_2_714 VPWR VGND sg13cmos5l_fill_2
* cell instance sg13cmos5l_fill_2_715 r0 *1 0,0
Xsg13cmos5l_fill_2_715 VPWR VGND sg13cmos5l_fill_2
* cell instance sg13cmos5l_fill_2_716 r0 *1 0,0
Xsg13cmos5l_fill_2_716 VPWR VGND sg13cmos5l_fill_2
* cell instance sg13cmos5l_fill_2_717 r0 *1 0,0
Xsg13cmos5l_fill_2_717 VPWR VGND sg13cmos5l_fill_2
* cell instance sg13cmos5l_fill_2_718 r0 *1 0,0
Xsg13cmos5l_fill_2_718 VPWR VGND sg13cmos5l_fill_2
* cell instance sg13cmos5l_fill_2_719 r0 *1 0,0
Xsg13cmos5l_fill_2_719 VPWR VGND sg13cmos5l_fill_2
* cell instance sg13cmos5l_fill_2_720 r0 *1 0,0
Xsg13cmos5l_fill_2_720 VPWR VGND sg13cmos5l_fill_2
* cell instance sg13cmos5l_fill_2_721 r0 *1 0,0
Xsg13cmos5l_fill_2_721 VPWR VGND sg13cmos5l_fill_2
* cell instance sg13cmos5l_fill_2_722 r0 *1 0,0
Xsg13cmos5l_fill_2_722 VPWR VGND sg13cmos5l_fill_2
* cell instance sg13cmos5l_fill_2_723 r0 *1 0,0
Xsg13cmos5l_fill_2_723 VPWR VGND sg13cmos5l_fill_2
* cell instance sg13cmos5l_fill_2_724 r0 *1 0,0
Xsg13cmos5l_fill_2_724 VPWR VGND sg13cmos5l_fill_2
* cell instance sg13cmos5l_fill_2_725 r0 *1 0,0
Xsg13cmos5l_fill_2_725 VPWR VGND sg13cmos5l_fill_2
* cell instance sg13cmos5l_fill_2_726 r0 *1 0,0
Xsg13cmos5l_fill_2_726 VPWR VGND sg13cmos5l_fill_2
* cell instance sg13cmos5l_fill_2_727 r0 *1 0,0
Xsg13cmos5l_fill_2_727 VPWR VGND sg13cmos5l_fill_2
* cell instance sg13cmos5l_fill_2_728 r0 *1 0,0
Xsg13cmos5l_fill_2_728 VPWR VGND sg13cmos5l_fill_2
* cell instance sg13cmos5l_fill_2_729 r0 *1 0,0
Xsg13cmos5l_fill_2_729 VPWR VGND sg13cmos5l_fill_2
* cell instance sg13cmos5l_fill_2_730 r0 *1 0,0
Xsg13cmos5l_fill_2_730 VPWR VGND sg13cmos5l_fill_2
* cell instance sg13cmos5l_fill_2_731 r0 *1 0,0
Xsg13cmos5l_fill_2_731 VPWR VGND sg13cmos5l_fill_2
* cell instance sg13cmos5l_fill_2_732 r0 *1 0,0
Xsg13cmos5l_fill_2_732 VPWR VGND sg13cmos5l_fill_2
* cell instance sg13cmos5l_fill_2_733 r0 *1 0,0
Xsg13cmos5l_fill_2_733 VPWR VGND sg13cmos5l_fill_2
* cell instance sg13cmos5l_fill_2_734 r0 *1 0,0
Xsg13cmos5l_fill_2_734 VPWR VGND sg13cmos5l_fill_2
* cell instance sg13cmos5l_fill_2_735 r0 *1 0,0
Xsg13cmos5l_fill_2_735 VPWR VGND sg13cmos5l_fill_2
* cell instance sg13cmos5l_fill_2_736 r0 *1 0,0
Xsg13cmos5l_fill_2_736 VPWR VGND sg13cmos5l_fill_2
* cell instance sg13cmos5l_fill_2_737 r0 *1 0,0
Xsg13cmos5l_fill_2_737 VPWR VGND sg13cmos5l_fill_2
* cell instance sg13cmos5l_fill_2_738 r0 *1 0,0
Xsg13cmos5l_fill_2_738 VPWR VGND sg13cmos5l_fill_2
* cell instance sg13cmos5l_fill_2_739 r0 *1 0,0
Xsg13cmos5l_fill_2_739 VPWR VGND sg13cmos5l_fill_2
* cell instance sg13cmos5l_fill_2_740 r0 *1 0,0
Xsg13cmos5l_fill_2_740 VPWR VGND sg13cmos5l_fill_2
* cell instance sg13cmos5l_fill_2_741 r0 *1 0,0
Xsg13cmos5l_fill_2_741 VPWR VGND sg13cmos5l_fill_2
* cell instance sg13cmos5l_fill_2_742 r0 *1 0,0
Xsg13cmos5l_fill_2_742 VPWR VGND sg13cmos5l_fill_2
* cell instance sg13cmos5l_fill_2_743 r0 *1 0,0
Xsg13cmos5l_fill_2_743 VPWR VGND sg13cmos5l_fill_2
* cell instance sg13cmos5l_fill_2_744 r0 *1 0,0
Xsg13cmos5l_fill_2_744 VPWR VGND sg13cmos5l_fill_2
* cell instance sg13cmos5l_fill_2_745 r0 *1 0,0
Xsg13cmos5l_fill_2_745 VPWR VGND sg13cmos5l_fill_2
* cell instance sg13cmos5l_fill_2_746 r0 *1 0,0
Xsg13cmos5l_fill_2_746 VPWR VGND sg13cmos5l_fill_2
* cell instance sg13cmos5l_fill_2_747 r0 *1 0,0
Xsg13cmos5l_fill_2_747 VPWR VGND sg13cmos5l_fill_2
* cell instance sg13cmos5l_fill_2_748 r0 *1 0,0
Xsg13cmos5l_fill_2_748 VPWR VGND sg13cmos5l_fill_2
* cell instance sg13cmos5l_fill_2_749 r0 *1 0,0
Xsg13cmos5l_fill_2_749 VPWR VGND sg13cmos5l_fill_2
* cell instance sg13cmos5l_fill_2_750 r0 *1 0,0
Xsg13cmos5l_fill_2_750 VPWR VGND sg13cmos5l_fill_2
* cell instance sg13cmos5l_fill_2_751 r0 *1 0,0
Xsg13cmos5l_fill_2_751 VPWR VGND sg13cmos5l_fill_2
* cell instance sg13cmos5l_fill_2_752 r0 *1 0,0
Xsg13cmos5l_fill_2_752 VPWR VGND sg13cmos5l_fill_2
* cell instance sg13cmos5l_fill_2_753 r0 *1 0,0
Xsg13cmos5l_fill_2_753 VPWR VGND sg13cmos5l_fill_2
* cell instance sg13cmos5l_fill_2_754 r0 *1 0,0
Xsg13cmos5l_fill_2_754 VPWR VGND sg13cmos5l_fill_2
* cell instance sg13cmos5l_fill_2_755 r0 *1 0,0
Xsg13cmos5l_fill_2_755 VPWR VGND sg13cmos5l_fill_2
* cell instance sg13cmos5l_fill_2_756 r0 *1 0,0
Xsg13cmos5l_fill_2_756 VPWR VGND sg13cmos5l_fill_2
* cell instance sg13cmos5l_fill_2_757 r0 *1 0,0
Xsg13cmos5l_fill_2_757 VPWR VGND sg13cmos5l_fill_2
* cell instance sg13cmos5l_fill_2_758 r0 *1 0,0
Xsg13cmos5l_fill_2_758 VPWR VGND sg13cmos5l_fill_2
* cell instance sg13cmos5l_fill_2_759 r0 *1 0,0
Xsg13cmos5l_fill_2_759 VPWR VGND sg13cmos5l_fill_2
* cell instance sg13cmos5l_fill_2_760 r0 *1 0,0
Xsg13cmos5l_fill_2_760 VPWR VGND sg13cmos5l_fill_2
* cell instance sg13cmos5l_fill_2_761 r0 *1 0,0
Xsg13cmos5l_fill_2_761 VPWR VGND sg13cmos5l_fill_2
* cell instance sg13cmos5l_fill_2_762 r0 *1 0,0
Xsg13cmos5l_fill_2_762 VPWR VGND sg13cmos5l_fill_2
* cell instance sg13cmos5l_fill_2_763 r0 *1 0,0
Xsg13cmos5l_fill_2_763 VPWR VGND sg13cmos5l_fill_2
* cell instance sg13cmos5l_fill_2_764 r0 *1 0,0
Xsg13cmos5l_fill_2_764 VPWR VGND sg13cmos5l_fill_2
* cell instance sg13cmos5l_fill_2_765 r0 *1 0,0
Xsg13cmos5l_fill_2_765 VPWR VGND sg13cmos5l_fill_2
* cell instance sg13cmos5l_fill_2_766 r0 *1 0,0
Xsg13cmos5l_fill_2_766 VPWR VGND sg13cmos5l_fill_2
* cell instance sg13cmos5l_fill_2_767 r0 *1 0,0
Xsg13cmos5l_fill_2_767 VPWR VGND sg13cmos5l_fill_2
* cell instance sg13cmos5l_fill_2_768 r0 *1 0,0
Xsg13cmos5l_fill_2_768 VPWR VGND sg13cmos5l_fill_2
* cell instance sg13cmos5l_fill_2_769 r0 *1 0,0
Xsg13cmos5l_fill_2_769 VPWR VGND sg13cmos5l_fill_2
* cell instance sg13cmos5l_fill_2_770 r0 *1 0,0
Xsg13cmos5l_fill_2_770 VPWR VGND sg13cmos5l_fill_2
* cell instance sg13cmos5l_fill_2_771 r0 *1 0,0
Xsg13cmos5l_fill_2_771 VPWR VGND sg13cmos5l_fill_2
* cell instance sg13cmos5l_fill_2_772 r0 *1 0,0
Xsg13cmos5l_fill_2_772 VPWR VGND sg13cmos5l_fill_2
* cell instance sg13cmos5l_fill_2_773 r0 *1 0,0
Xsg13cmos5l_fill_2_773 VPWR VGND sg13cmos5l_fill_2
* cell instance sg13cmos5l_fill_2_774 r0 *1 0,0
Xsg13cmos5l_fill_2_774 VPWR VGND sg13cmos5l_fill_2
* cell instance sg13cmos5l_fill_2_775 r0 *1 0,0
Xsg13cmos5l_fill_2_775 VPWR VGND sg13cmos5l_fill_2
* cell instance sg13cmos5l_fill_2_776 r0 *1 0,0
Xsg13cmos5l_fill_2_776 VPWR VGND sg13cmos5l_fill_2
* cell instance sg13cmos5l_fill_2_777 r0 *1 0,0
Xsg13cmos5l_fill_2_777 VPWR VGND sg13cmos5l_fill_2
* cell instance sg13cmos5l_fill_2_778 r0 *1 0,0
Xsg13cmos5l_fill_2_778 VPWR VGND sg13cmos5l_fill_2
* cell instance sg13cmos5l_fill_2_779 r0 *1 0,0
Xsg13cmos5l_fill_2_779 VPWR VGND sg13cmos5l_fill_2
* cell instance sg13cmos5l_fill_2_780 r0 *1 0,0
Xsg13cmos5l_fill_2_780 VPWR VGND sg13cmos5l_fill_2
* cell instance sg13cmos5l_fill_2_781 r0 *1 0,0
Xsg13cmos5l_fill_2_781 VPWR VGND sg13cmos5l_fill_2
* cell instance sg13cmos5l_fill_2_782 r0 *1 0,0
Xsg13cmos5l_fill_2_782 VPWR VGND sg13cmos5l_fill_2
* cell instance sg13cmos5l_fill_2_783 r0 *1 0,0
Xsg13cmos5l_fill_2_783 VPWR VGND sg13cmos5l_fill_2
* cell instance sg13cmos5l_fill_2_784 r0 *1 0,0
Xsg13cmos5l_fill_2_784 VPWR VGND sg13cmos5l_fill_2
* cell instance sg13cmos5l_fill_2_785 r0 *1 0,0
Xsg13cmos5l_fill_2_785 VPWR VGND sg13cmos5l_fill_2
* cell instance sg13cmos5l_fill_2_786 r0 *1 0,0
Xsg13cmos5l_fill_2_786 VPWR VGND sg13cmos5l_fill_2
* cell instance sg13cmos5l_fill_2_787 r0 *1 0,0
Xsg13cmos5l_fill_2_787 VPWR VGND sg13cmos5l_fill_2
* cell instance sg13cmos5l_fill_2_788 r0 *1 0,0
Xsg13cmos5l_fill_2_788 VPWR VGND sg13cmos5l_fill_2
* cell instance sg13cmos5l_fill_2_789 r0 *1 0,0
Xsg13cmos5l_fill_2_789 VPWR VGND sg13cmos5l_fill_2
* cell instance sg13cmos5l_fill_2_790 r0 *1 0,0
Xsg13cmos5l_fill_2_790 VPWR VGND sg13cmos5l_fill_2
* cell instance sg13cmos5l_fill_2_791 r0 *1 0,0
Xsg13cmos5l_fill_2_791 VPWR VGND sg13cmos5l_fill_2
* cell instance sg13cmos5l_fill_2_792 r0 *1 0,0
Xsg13cmos5l_fill_2_792 VPWR VGND sg13cmos5l_fill_2
* cell instance sg13cmos5l_fill_2_793 r0 *1 0,0
Xsg13cmos5l_fill_2_793 VPWR VGND sg13cmos5l_fill_2
* cell instance sg13cmos5l_fill_2_794 r0 *1 0,0
Xsg13cmos5l_fill_2_794 VPWR VGND sg13cmos5l_fill_2
* cell instance sg13cmos5l_fill_2_795 r0 *1 0,0
Xsg13cmos5l_fill_2_795 VPWR VGND sg13cmos5l_fill_2
* cell instance sg13cmos5l_fill_2_796 r0 *1 0,0
Xsg13cmos5l_fill_2_796 VPWR VGND sg13cmos5l_fill_2
* cell instance sg13cmos5l_fill_2_797 r0 *1 0,0
Xsg13cmos5l_fill_2_797 VPWR VGND sg13cmos5l_fill_2
* cell instance sg13cmos5l_fill_2_798 r0 *1 0,0
Xsg13cmos5l_fill_2_798 VPWR VGND sg13cmos5l_fill_2
* cell instance sg13cmos5l_fill_2_799 r0 *1 0,0
Xsg13cmos5l_fill_2_799 VPWR VGND sg13cmos5l_fill_2
* cell instance sg13cmos5l_fill_2_800 r0 *1 0,0
Xsg13cmos5l_fill_2_800 VPWR VGND sg13cmos5l_fill_2
* cell instance sg13cmos5l_fill_2_801 r0 *1 0,0
Xsg13cmos5l_fill_2_801 VPWR VGND sg13cmos5l_fill_2
* cell instance sg13cmos5l_fill_2_802 r0 *1 0,0
Xsg13cmos5l_fill_2_802 VPWR VGND sg13cmos5l_fill_2
* cell instance sg13cmos5l_fill_2_803 r0 *1 0,0
Xsg13cmos5l_fill_2_803 VPWR VGND sg13cmos5l_fill_2
* cell instance sg13cmos5l_fill_2_804 r0 *1 0,0
Xsg13cmos5l_fill_2_804 VPWR VGND sg13cmos5l_fill_2
* cell instance sg13cmos5l_fill_2_805 r0 *1 0,0
Xsg13cmos5l_fill_2_805 VPWR VGND sg13cmos5l_fill_2
* cell instance sg13cmos5l_fill_2_806 r0 *1 0,0
Xsg13cmos5l_fill_2_806 VPWR VGND sg13cmos5l_fill_2
* cell instance sg13cmos5l_fill_2_807 r0 *1 0,0
Xsg13cmos5l_fill_2_807 VPWR VGND sg13cmos5l_fill_2
* cell instance sg13cmos5l_fill_2_808 r0 *1 0,0
Xsg13cmos5l_fill_2_808 VPWR VGND sg13cmos5l_fill_2
* cell instance sg13cmos5l_fill_2_809 r0 *1 0,0
Xsg13cmos5l_fill_2_809 VPWR VGND sg13cmos5l_fill_2
* cell instance sg13cmos5l_fill_2_810 r0 *1 0,0
Xsg13cmos5l_fill_2_810 VPWR VGND sg13cmos5l_fill_2
* cell instance sg13cmos5l_fill_2_811 r0 *1 0,0
Xsg13cmos5l_fill_2_811 VPWR VGND sg13cmos5l_fill_2
* cell instance sg13cmos5l_fill_2_812 r0 *1 0,0
Xsg13cmos5l_fill_2_812 VPWR VGND sg13cmos5l_fill_2
* cell instance sg13cmos5l_fill_2_813 r0 *1 0,0
Xsg13cmos5l_fill_2_813 VPWR VGND sg13cmos5l_fill_2
* cell instance sg13cmos5l_fill_2_814 r0 *1 0,0
Xsg13cmos5l_fill_2_814 VPWR VGND sg13cmos5l_fill_2
* cell instance sg13cmos5l_fill_2_815 r0 *1 0,0
Xsg13cmos5l_fill_2_815 VPWR VGND sg13cmos5l_fill_2
* cell instance sg13cmos5l_fill_2_816 r0 *1 0,0
Xsg13cmos5l_fill_2_816 VPWR VGND sg13cmos5l_fill_2
* cell instance sg13cmos5l_fill_2_817 r0 *1 0,0
Xsg13cmos5l_fill_2_817 VPWR VGND sg13cmos5l_fill_2
* cell instance sg13cmos5l_fill_2_818 r0 *1 0,0
Xsg13cmos5l_fill_2_818 VPWR VGND sg13cmos5l_fill_2
* cell instance sg13cmos5l_fill_2_819 r0 *1 0,0
Xsg13cmos5l_fill_2_819 VPWR VGND sg13cmos5l_fill_2
* cell instance sg13cmos5l_fill_2_820 r0 *1 0,0
Xsg13cmos5l_fill_2_820 VPWR VGND sg13cmos5l_fill_2
* cell instance sg13cmos5l_fill_2_821 r0 *1 0,0
Xsg13cmos5l_fill_2_821 VPWR VGND sg13cmos5l_fill_2
* cell instance sg13cmos5l_fill_2_822 r0 *1 0,0
Xsg13cmos5l_fill_2_822 VPWR VGND sg13cmos5l_fill_2
* cell instance sg13cmos5l_fill_2_823 r0 *1 0,0
Xsg13cmos5l_fill_2_823 VPWR VGND sg13cmos5l_fill_2
* cell instance sg13cmos5l_fill_2_824 r0 *1 0,0
Xsg13cmos5l_fill_2_824 VPWR VGND sg13cmos5l_fill_2
* cell instance sg13cmos5l_fill_2_825 r0 *1 0,0
Xsg13cmos5l_fill_2_825 VPWR VGND sg13cmos5l_fill_2
* cell instance sg13cmos5l_fill_2_826 r0 *1 0,0
Xsg13cmos5l_fill_2_826 VPWR VGND sg13cmos5l_fill_2
* cell instance sg13cmos5l_fill_2_827 r0 *1 0,0
Xsg13cmos5l_fill_2_827 VPWR VGND sg13cmos5l_fill_2
* cell instance sg13cmos5l_fill_2_828 r0 *1 0,0
Xsg13cmos5l_fill_2_828 VPWR VGND sg13cmos5l_fill_2
* cell instance sg13cmos5l_fill_2_829 r0 *1 0,0
Xsg13cmos5l_fill_2_829 VPWR VGND sg13cmos5l_fill_2
* cell instance sg13cmos5l_fill_2_830 r0 *1 0,0
Xsg13cmos5l_fill_2_830 VPWR VGND sg13cmos5l_fill_2
* cell instance sg13cmos5l_fill_2_831 r0 *1 0,0
Xsg13cmos5l_fill_2_831 VPWR VGND sg13cmos5l_fill_2
* cell instance sg13cmos5l_fill_2_832 r0 *1 0,0
Xsg13cmos5l_fill_2_832 VPWR VGND sg13cmos5l_fill_2
* cell instance sg13cmos5l_fill_2_833 r0 *1 0,0
Xsg13cmos5l_fill_2_833 VPWR VGND sg13cmos5l_fill_2
* cell instance sg13cmos5l_fill_2_834 r0 *1 0,0
Xsg13cmos5l_fill_2_834 VPWR VGND sg13cmos5l_fill_2
* cell instance sg13cmos5l_fill_2_835 r0 *1 0,0
Xsg13cmos5l_fill_2_835 VPWR VGND sg13cmos5l_fill_2
* cell instance sg13cmos5l_fill_2_836 r0 *1 0,0
Xsg13cmos5l_fill_2_836 VPWR VGND sg13cmos5l_fill_2
* cell instance sg13cmos5l_fill_2_837 r0 *1 0,0
Xsg13cmos5l_fill_2_837 VPWR VGND sg13cmos5l_fill_2
* cell instance sg13cmos5l_fill_2_838 r0 *1 0,0
Xsg13cmos5l_fill_2_838 VPWR VGND sg13cmos5l_fill_2
* cell instance sg13cmos5l_fill_2_839 r0 *1 0,0
Xsg13cmos5l_fill_2_839 VPWR VGND sg13cmos5l_fill_2
* cell instance sg13cmos5l_fill_2_840 r0 *1 0,0
Xsg13cmos5l_fill_2_840 VPWR VGND sg13cmos5l_fill_2
* cell instance sg13cmos5l_fill_2_841 r0 *1 0,0
Xsg13cmos5l_fill_2_841 VPWR VGND sg13cmos5l_fill_2
* cell instance sg13cmos5l_fill_2_842 r0 *1 0,0
Xsg13cmos5l_fill_2_842 VPWR VGND sg13cmos5l_fill_2
* cell instance sg13cmos5l_inv_1_0 r0 *1 0,0
Xsg13cmos5l_inv_1_0 \$4190 VPWR VGND \$4191 sg13cmos5l_inv_1
* cell instance sg13cmos5l_inv_1_1 r0 *1 0,0
Xsg13cmos5l_inv_1_1 \$4495 VPWR VGND \$4496 sg13cmos5l_inv_1
* cell instance sg13cmos5l_inv_1_2 r0 *1 0,0
Xsg13cmos5l_inv_1_2 \$4361 VPWR VGND \$4362 sg13cmos5l_inv_1
* cell instance sg13cmos5l_inv_1_3 r0 *1 0,0
Xsg13cmos5l_inv_1_3 \$154 VPWR VGND \$2234 sg13cmos5l_inv_1
* cell instance sg13cmos5l_inv_1_4 r0 *1 0,0
Xsg13cmos5l_inv_1_4 \$3590 VPWR VGND \$3591 sg13cmos5l_inv_1
* cell instance sg13cmos5l_inv_1_5 r0 *1 0,0
Xsg13cmos5l_inv_1_5 \$2383 VPWR VGND \$2505 sg13cmos5l_inv_1
* cell instance sg13cmos5l_inv_1_6 r0 *1 0,0
Xsg13cmos5l_inv_1_6 \$152 VPWR VGND \$1442 sg13cmos5l_inv_1
* cell instance sg13cmos5l_inv_1_7 r0 *1 0,0
Xsg13cmos5l_inv_1_7 \$1433 VPWR VGND \$2109 sg13cmos5l_inv_1
* cell instance sg13cmos5l_inv_1_8 r0 *1 0,0
Xsg13cmos5l_inv_1_8 \$2390 VPWR VGND \$2393 sg13cmos5l_inv_1
* cell instance sg13cmos5l_inv_1_9 r0 *1 0,0
Xsg13cmos5l_inv_1_9 \$8495 VPWR VGND \$8421 sg13cmos5l_inv_1
* cell instance sg13cmos5l_inv_1_10 r0 *1 0,0
Xsg13cmos5l_inv_1_10 \$664 VPWR VGND \$2110 sg13cmos5l_inv_1
* cell instance sg13cmos5l_inv_1_11 r0 *1 0,0
Xsg13cmos5l_inv_1_11 \$4084 VPWR VGND \$3918 sg13cmos5l_inv_1
* cell instance sg13cmos5l_inv_1_12 r0 *1 0,0
Xsg13cmos5l_inv_1_12 \$2111 VPWR VGND \$2112 sg13cmos5l_inv_1
* cell instance sg13cmos5l_inv_1_13 r0 *1 0,0
Xsg13cmos5l_inv_1_13 \$4705 VPWR VGND \$4507 sg13cmos5l_inv_1
* cell instance sg13cmos5l_inv_1_14 r0 *1 0,0
Xsg13cmos5l_inv_1_14 \$11895 VPWR VGND \$13227 sg13cmos5l_inv_1
* cell instance sg13cmos5l_inv_1_15 r0 *1 0,0
Xsg13cmos5l_inv_1_15 \$8791 VPWR VGND \$8537 sg13cmos5l_inv_1
* cell instance sg13cmos5l_inv_1_16 r0 *1 0,0
Xsg13cmos5l_inv_1_16 \$4087 VPWR VGND \$3915 sg13cmos5l_inv_1
* cell instance sg13cmos5l_inv_1_17 r0 *1 0,0
Xsg13cmos5l_inv_1_17 \$6476 VPWR VGND \$6477 sg13cmos5l_inv_1
* cell instance sg13cmos5l_inv_1_18 r0 *1 0,0
Xsg13cmos5l_inv_1_18 \$4376 VPWR VGND \$4373 sg13cmos5l_inv_1
* cell instance sg13cmos5l_inv_1_19 r0 *1 0,0
Xsg13cmos5l_inv_1_19 \$4045 VPWR VGND \$62 sg13cmos5l_inv_1
* cell instance sg13cmos5l_inv_1_20 r0 *1 0,0
Xsg13cmos5l_inv_1_20 \$2670 VPWR VGND \$2516 sg13cmos5l_inv_1
* cell instance sg13cmos5l_inv_1_21 r0 *1 0,0
Xsg13cmos5l_inv_1_21 \$20088 VPWR VGND \$20039 sg13cmos5l_inv_1
* cell instance sg13cmos5l_inv_1_22 r0 *1 0,0
Xsg13cmos5l_inv_1_22 \$3014 VPWR VGND \$3008 sg13cmos5l_inv_1
* cell instance sg13cmos5l_inv_1_23 r0 *1 0,0
Xsg13cmos5l_inv_1_23 \$4210 VPWR VGND \$4209 sg13cmos5l_inv_1
* cell instance sg13cmos5l_inv_1_24 r0 *1 0,0
Xsg13cmos5l_inv_1_24 \$649 VPWR VGND \$1890 sg13cmos5l_inv_1
* cell instance sg13cmos5l_inv_1_25 r0 *1 0,0
Xsg13cmos5l_inv_1_25 \$150 VPWR VGND \$163 sg13cmos5l_inv_1
* cell instance sg13cmos5l_inv_1_26 r0 *1 0,0
Xsg13cmos5l_inv_1_26 \$7815 VPWR VGND \$7724 sg13cmos5l_inv_1
* cell instance sg13cmos5l_inv_1_27 r0 *1 0,0
Xsg13cmos5l_inv_1_27 \$2694 VPWR VGND \$2826 sg13cmos5l_inv_1
* cell instance sg13cmos5l_inv_1_28 r0 *1 0,0
Xsg13cmos5l_inv_1_28 \$3024 VPWR VGND \$2832 sg13cmos5l_inv_1
* cell instance sg13cmos5l_inv_1_29 r0 *1 0,0
Xsg13cmos5l_inv_1_29 \$5079 VPWR VGND \$4902 sg13cmos5l_inv_1
* cell instance sg13cmos5l_inv_1_30 r0 *1 0,0
Xsg13cmos5l_inv_1_30 \$2392 VPWR VGND \$2422 sg13cmos5l_inv_1
* cell instance sg13cmos5l_inv_1_31 r0 *1 0,0
Xsg13cmos5l_inv_1_31 \$19996 VPWR VGND \$19890 sg13cmos5l_inv_1
* cell instance sg13cmos5l_inv_1_32 r0 *1 0,0
Xsg13cmos5l_inv_1_32 \$20152 VPWR VGND \$20151 sg13cmos5l_inv_1
* cell instance sg13cmos5l_inv_1_33 r0 *1 0,0
Xsg13cmos5l_inv_1_33 \$3260 VPWR VGND \$3373 sg13cmos5l_inv_1
* cell instance sg13cmos5l_inv_1_34 r0 *1 0,0
Xsg13cmos5l_inv_1_34 \$4574 VPWR VGND \$4114 sg13cmos5l_inv_1
* cell instance sg13cmos5l_inv_1_35 r0 *1 0,0
Xsg13cmos5l_inv_1_35 \$3959 VPWR VGND \$3791 sg13cmos5l_inv_1
* cell instance sg13cmos5l_inv_1_36 r0 *1 0,0
Xsg13cmos5l_inv_1_36 \$819 VPWR VGND \$1352 sg13cmos5l_inv_1
* cell instance sg13cmos5l_inv_1_37 r0 *1 0,0
Xsg13cmos5l_inv_1_37 \$2744 VPWR VGND \$2745 sg13cmos5l_inv_1
* cell instance sg13cmos5l_inv_1_38 r0 *1 0,0
Xsg13cmos5l_inv_1_38 \$1879 VPWR VGND \$174 sg13cmos5l_inv_1
* cell instance sg13cmos5l_inv_1_39 r0 *1 0,0
Xsg13cmos5l_inv_1_39 \$973 VPWR VGND \$972 sg13cmos5l_inv_1
* cell instance sg13cmos5l_inv_1_40 r0 *1 0,0
Xsg13cmos5l_inv_1_40 \$4004 VPWR VGND \$4274 sg13cmos5l_inv_1
* cell instance sg13cmos5l_inv_1_41 r0 *1 0,0
Xsg13cmos5l_inv_1_41 \$4129 VPWR VGND \$4812 sg13cmos5l_inv_1
* cell instance sg13cmos5l_inv_1_42 r0 *1 0,0
Xsg13cmos5l_inv_1_42 \$1473 VPWR VGND \$1592 sg13cmos5l_inv_1
* cell instance sg13cmos5l_inv_1_43 r0 *1 0,0
Xsg13cmos5l_inv_1_43 \$2295 VPWR VGND \$2107 sg13cmos5l_inv_1
* cell instance sg13cmos5l_inv_1_44 r0 *1 0,0
Xsg13cmos5l_inv_1_44 \$3309 VPWR VGND \$3310 sg13cmos5l_inv_1
* cell instance sg13cmos5l_inv_1_45 r0 *1 0,0
Xsg13cmos5l_inv_1_45 \$2302 VPWR VGND \$2445 sg13cmos5l_inv_1
* cell instance sg13cmos5l_inv_1_46 r0 *1 0,0
Xsg13cmos5l_inv_1_46 \$459 VPWR VGND \$573 sg13cmos5l_inv_1
* cell instance sg13cmos5l_inv_1_47 r0 *1 0,0
Xsg13cmos5l_inv_1_47 \$4132 VPWR VGND \$4000 sg13cmos5l_inv_1
* cell instance sg13cmos5l_inv_1_48 r0 *1 0,0
Xsg13cmos5l_inv_1_48 \$2296 VPWR VGND \$2446 sg13cmos5l_inv_1
* cell instance sg13cmos5l_inv_1_49 r0 *1 0,0
Xsg13cmos5l_inv_1_49 \$139 VPWR VGND \$138 sg13cmos5l_inv_1
* cell instance sg13cmos5l_inv_1_50 r0 *1 0,0
Xsg13cmos5l_inv_1_50 \$142 VPWR VGND \$466 sg13cmos5l_inv_1
* cell instance sg13cmos5l_inv_1_51 r0 *1 0,0
Xsg13cmos5l_inv_1_51 \$588 VPWR VGND \$516 sg13cmos5l_inv_1
* cell instance sg13cmos5l_inv_1_52 r0 *1 0,0
Xsg13cmos5l_inv_1_52 \$20239 VPWR VGND \$20207 sg13cmos5l_inv_1
* cell instance sg13cmos5l_inv_1_53 r0 *1 0,0
Xsg13cmos5l_inv_1_53 \$3324 VPWR VGND \$3499 sg13cmos5l_inv_1
* cell instance sg13cmos5l_inv_1_54 r0 *1 0,0
Xsg13cmos5l_inv_1_54 \$870 VPWR VGND \$986 sg13cmos5l_inv_1
* cell instance sg13cmos5l_inv_1_55 r0 *1 0,0
Xsg13cmos5l_inv_1_55 \$5839 VPWR VGND \$4149 sg13cmos5l_inv_1
* cell instance sg13cmos5l_inv_1_56 r0 *1 0,0
Xsg13cmos5l_inv_1_56 \$1833 VPWR VGND \$1832 sg13cmos5l_inv_1
* cell instance sg13cmos5l_inv_1_57 r0 *1 0,0
Xsg13cmos5l_inv_1_57 \$3578 VPWR VGND \$3654 sg13cmos5l_inv_1
* cell instance sg13cmos5l_inv_1_58 r0 *1 0,0
Xsg13cmos5l_inv_1_58 \$19562 VPWR VGND \$19401 sg13cmos5l_inv_1
* cell instance sg13cmos5l_inv_1_59 r0 *1 0,0
Xsg13cmos5l_inv_1_59 \$3516 VPWR VGND \$3148 sg13cmos5l_inv_1
* cell instance sg13cmos5l_inv_1_60 r0 *1 0,0
Xsg13cmos5l_inv_1_60 \$3156 VPWR VGND \$2922 sg13cmos5l_inv_1
* cell instance sg13cmos5l_inv_1_61 r0 *1 0,0
Xsg13cmos5l_inv_1_61 \$609 VPWR VGND \$605 sg13cmos5l_inv_1
* cell instance sg13cmos5l_inv_1_62 r0 *1 0,0
Xsg13cmos5l_inv_1_62 \$1128 VPWR VGND \$1261 sg13cmos5l_inv_1
* cell instance sg13cmos5l_inv_1_63 r0 *1 0,0
Xsg13cmos5l_inv_1_63 \$6582 VPWR VGND \$6512 sg13cmos5l_inv_1
* cell instance sg13cmos5l_inv_1_64 r0 *1 0,0
Xsg13cmos5l_inv_1_64 \$7658 VPWR VGND \$6513 sg13cmos5l_inv_1
* cell instance sg13cmos5l_inv_1_65 r0 *1 0,0
Xsg13cmos5l_inv_1_65 \$5858 VPWR VGND \$4455 sg13cmos5l_inv_1
* cell instance sg13cmos5l_inv_1_66 r0 *1 0,0
Xsg13cmos5l_inv_1_66 \$1958 VPWR VGND \$2079 sg13cmos5l_inv_1
* cell instance sg13cmos5l_inv_1_67 r0 *1 0,0
Xsg13cmos5l_inv_1_67 \$3346 VPWR VGND \$3347 sg13cmos5l_inv_1
* cell instance sg13cmos5l_inv_1_68 r0 *1 0,0
Xsg13cmos5l_inv_1_68 \$6306 VPWR VGND \$6303 sg13cmos5l_inv_1
* cell instance sg13cmos5l_inv_1_69 r0 *1 0,0
Xsg13cmos5l_inv_1_69 \$3858 VPWR VGND \$3859 sg13cmos5l_inv_1
* cell instance sg13cmos5l_inv_1_70 r0 *1 0,0
Xsg13cmos5l_inv_1_70 \$2778 VPWR VGND \$2609 sg13cmos5l_inv_1
* cell instance sg13cmos5l_inv_1_71 r0 *1 0,0
Xsg13cmos5l_inv_1_71 \$4685 VPWR VGND \$4821 sg13cmos5l_inv_1
* cell instance sg13cmos5l_inv_1_72 r0 *1 0,0
Xsg13cmos5l_inv_1_72 \$5234 VPWR VGND \$5427 sg13cmos5l_inv_1
* cell instance sg13cmos5l_inv_1_73 r0 *1 0,0
Xsg13cmos5l_inv_1_73 \$6579 VPWR VGND \$6550 sg13cmos5l_inv_1
* cell instance sg13cmos5l_inv_1_74 r0 *1 0,0
Xsg13cmos5l_inv_1_74 \$7873 VPWR VGND \$6515 sg13cmos5l_inv_1
* cell instance sg13cmos5l_inv_1_75 r0 *1 0,0
Xsg13cmos5l_inv_1_75 \$1982 VPWR VGND \$1851 sg13cmos5l_inv_1
* cell instance sg13cmos5l_inv_1_76 r0 *1 0,0
Xsg13cmos5l_inv_1_76 \$2469 VPWR VGND \$2316 sg13cmos5l_inv_1
* cell instance sg13cmos5l_inv_1_77 r0 *1 0,0
Xsg13cmos5l_inv_1_77 \$4060 VPWR VGND \$2941 sg13cmos5l_inv_1
* cell instance sg13cmos5l_inv_1_78 r0 *1 0,0
Xsg13cmos5l_inv_1_78 \$5865 VPWR VGND \$5864 sg13cmos5l_inv_1
* cell instance sg13cmos5l_inv_1_79 r0 *1 0,0
Xsg13cmos5l_inv_1_79 \$626 VPWR VGND \$627 sg13cmos5l_inv_1
* cell instance sg13cmos5l_inv_1_80 r0 *1 0,0
Xsg13cmos5l_inv_1_80 \$898 VPWR VGND \$899 sg13cmos5l_inv_1
* cell instance sg13cmos5l_inv_1_81 r0 *1 0,0
Xsg13cmos5l_inv_1_81 \$1388 VPWR VGND \$1518 sg13cmos5l_inv_1
* cell instance sg13cmos5l_inv_1_82 r0 *1 0,0
Xsg13cmos5l_inv_1_82 \$1279 VPWR VGND \$1519 sg13cmos5l_inv_1
* cell instance sg13cmos5l_inv_1_83 r0 *1 0,0
Xsg13cmos5l_inv_1_83 \$5006 VPWR VGND \$5235 sg13cmos5l_inv_1
* cell instance sg13cmos5l_inv_1_84 r0 *1 0,0
Xsg13cmos5l_inv_1_84 \$6524 VPWR VGND \$6589 sg13cmos5l_inv_1
* cell instance sg13cmos5l_inv_1_85 r0 *1 0,0
Xsg13cmos5l_inv_1_85 \$1280 VPWR VGND \$1520 sg13cmos5l_inv_1
* cell instance sg13cmos5l_inv_1_86 r0 *1 0,0
Xsg13cmos5l_inv_1_86 \$763 VPWR VGND \$764 sg13cmos5l_inv_1
* cell instance sg13cmos5l_inv_1_87 r0 *1 0,0
Xsg13cmos5l_inv_1_87 \$11905 VPWR VGND \$15052 sg13cmos5l_inv_1
* cell instance sg13cmos5l_inv_1_88 r0 *1 0,0
Xsg13cmos5l_inv_1_88 \$1282 VPWR VGND \$1521 sg13cmos5l_inv_1
* cell instance sg13cmos5l_inv_1_89 r0 *1 0,0
Xsg13cmos5l_inv_1_89 \$2633 VPWR VGND \$2807 sg13cmos5l_inv_1
* cell instance sg13cmos5l_inv_1_90 r0 *1 0,0
Xsg13cmos5l_inv_1_90 \$2501 VPWR VGND \$2474 sg13cmos5l_inv_1
* cell instance sg13cmos5l_inv_1_91 r0 *1 0,0
Xsg13cmos5l_inv_1_91 \$2945 VPWR VGND \$2946 sg13cmos5l_inv_1
* cell instance sg13cmos5l_inv_1_92 r0 *1 0,0
Xsg13cmos5l_inv_1_92 \$2938 VPWR VGND \$2612 sg13cmos5l_inv_1
* cell instance sg13cmos5l_inv_1_93 r0 *1 0,0
Xsg13cmos5l_inv_1_93 \$4028 VPWR VGND \$4030 sg13cmos5l_inv_1
* cell instance sg13cmos5l_inv_1_94 r0 *1 0,0
Xsg13cmos5l_inv_1_94 \$1025 VPWR VGND \$904 sg13cmos5l_inv_1
* cell instance sg13cmos5l_inv_1_95 r0 *1 0,0
Xsg13cmos5l_inv_1_95 \$6321 VPWR VGND \$4833 sg13cmos5l_inv_1
* cell instance sg13cmos5l_inv_1_96 r0 *1 0,0
Xsg13cmos5l_inv_1_96 \$6860 VPWR VGND \$6522 sg13cmos5l_inv_1
* cell instance sg13cmos5l_inv_1_97 r0 *1 0,0
Xsg13cmos5l_inv_1_97 \$3183 VPWR VGND \$3188 sg13cmos5l_inv_1
* cell instance sg13cmos5l_inv_1_98 r0 *1 0,0
Xsg13cmos5l_inv_1_98 \$5237 VPWR VGND \$4839 sg13cmos5l_inv_1
* cell instance sg13cmos5l_inv_1_99 r0 *1 0,0
Xsg13cmos5l_inv_1_99 \$3694 VPWR VGND \$3659 sg13cmos5l_inv_1
* cell instance sg13cmos5l_inv_1_100 r0 *1 0,0
Xsg13cmos5l_inv_1_100 \$6450 VPWR VGND \$6599 sg13cmos5l_inv_1
* cell instance sg13cmos5l_inv_1_101 r0 *1 0,0
Xsg13cmos5l_inv_1_101 \$7092 VPWR VGND \$6520 sg13cmos5l_inv_1
* cell instance sg13cmos5l_inv_1_102 r0 *1 0,0
Xsg13cmos5l_inv_1_102 \$4650 VPWR VGND \$4638 sg13cmos5l_inv_1
* cell instance sg13cmos5l_inv_1_103 r0 *1 0,0
Xsg13cmos5l_inv_1_103 \$2343 VPWR VGND \$2340 sg13cmos5l_inv_1
* cell instance sg13cmos5l_inv_2_0 r0 *1 0,0
Xsg13cmos5l_inv_2_0 \$16331 VPWR VGND \$19841 sg13cmos5l_inv_2
* cell instance sg13cmos5l_inv_2_1 r0 *1 0,0
Xsg13cmos5l_inv_2_1 \$2229 VPWR VGND \$4099 sg13cmos5l_inv_2
* cell instance sg13cmos5l_inv_2_2 r0 *1 0,0
Xsg13cmos5l_inv_2_2 \$2844 VPWR VGND \$4223 sg13cmos5l_inv_2
* cell instance sg13cmos5l_inv_2_3 r0 *1 0,0
Xsg13cmos5l_inv_2_3 \$2866 VPWR VGND \$3624 sg13cmos5l_inv_2
* cell instance sg13cmos5l_inv_2_4 r0 *1 0,0
Xsg13cmos5l_inv_2_4 \$9016 VPWR VGND \$11712 sg13cmos5l_inv_2
* cell instance sg13cmos5l_inv_4_0 r0 *1 0,0
Xsg13cmos5l_inv_4_0 \$4783 VPWR VGND \$6286 sg13cmos5l_inv_4
* cell instance sg13cmos5l_inv_4_1 r0 *1 0,0
Xsg13cmos5l_inv_4_1 \$3813 VPWR VGND \$4626 sg13cmos5l_inv_4
* cell instance sg13cmos5l_inv_4_2 r0 *1 0,0
Xsg13cmos5l_inv_4_2 \$7090 VPWR VGND \$8488 sg13cmos5l_inv_4
* cell instance sg13cmos5l_inv_8_0 r0 *1 0,0
Xsg13cmos5l_inv_8_0 \$17336 VPWR VGND \$19854 sg13cmos5l_inv_8
* cell instance sg13cmos5l_inv_8_1 r0 *1 0,0
Xsg13cmos5l_inv_8_1 \$1299 VPWR VGND \$2751 sg13cmos5l_inv_8
* cell instance sg13cmos5l_mux2_1_0 r0 *1 0,0
Xsg13cmos5l_mux2_1_0 \$5051 \$5050 \$5047 VPWR VGND \$5017 sg13cmos5l_mux2_1
* cell instance sg13cmos5l_mux2_1_1 r0 *1 0,0
Xsg13cmos5l_mux2_1_1 \$15364 \$14879 \$6502 VPWR VGND \$15365 sg13cmos5l_mux2_1
* cell instance sg13cmos5l_mux2_1_2 r0 *1 0,0
Xsg13cmos5l_mux2_1_2 \$16218 \$15364 \$6502 VPWR VGND \$16010 sg13cmos5l_mux2_1
* cell instance sg13cmos5l_mux2_1_3 r0 *1 0,0
Xsg13cmos5l_mux2_1_3 \$16691 \$16218 \$6502 VPWR VGND \$17332 sg13cmos5l_mux2_1
* cell instance sg13cmos5l_mux2_1_4 r0 *1 0,0
Xsg13cmos5l_mux2_1_4 \$16693 \$16691 \$6502 VPWR VGND \$16653 sg13cmos5l_mux2_1
* cell instance sg13cmos5l_mux2_1_5 r0 *1 0,0
Xsg13cmos5l_mux2_1_5 \$14879 \$15079 \$6502 VPWR VGND \$14542 sg13cmos5l_mux2_1
* cell instance sg13cmos5l_mux2_1_6 r0 *1 0,0
Xsg13cmos5l_mux2_1_6 \$15079 \$15080 \$6502 VPWR VGND \$15564 sg13cmos5l_mux2_1
* cell instance sg13cmos5l_mux2_1_7 r0 *1 0,0
Xsg13cmos5l_mux2_1_7 \$3760 \$6406 \$3622 VPWR VGND \$6484 sg13cmos5l_mux2_1
* cell instance sg13cmos5l_mux2_1_8 r0 *1 0,0
Xsg13cmos5l_mux2_1_8 \$5943 \$5737 \$3622 VPWR VGND \$5930 sg13cmos5l_mux2_1
* cell instance sg13cmos5l_mux2_1_9 r0 *1 0,0
Xsg13cmos5l_mux2_1_9 \$3250 \$5102 \$3622 VPWR VGND \$5256 sg13cmos5l_mux2_1
* cell instance sg13cmos5l_mux2_1_10 r0 *1 0,0
Xsg13cmos5l_mux2_1_10 \$2715 \$5525 \$3622 VPWR VGND \$5526 sg13cmos5l_mux2_1
* cell instance sg13cmos5l_mux2_1_11 r0 *1 0,0
Xsg13cmos5l_mux2_1_11 \$2715 \$2714 \$2717 VPWR VGND \$2719 sg13cmos5l_mux2_1
* cell instance sg13cmos5l_mux2_1_12 r0 *1 0,0
Xsg13cmos5l_mux2_1_12 \$3943 \$3612 \$3941 VPWR VGND \$2643 sg13cmos5l_mux2_1
* cell instance sg13cmos5l_mux2_1_13 r0 *1 0,0
Xsg13cmos5l_mux2_1_13 \$3426 \$5024 \$3622 VPWR VGND \$4922 sg13cmos5l_mux2_1
* cell instance sg13cmos5l_mux2_1_14 r0 *1 0,0
Xsg13cmos5l_mux2_1_14 \$5943 \$2848 \$2717 VPWR VGND \$3420 sg13cmos5l_mux2_1
* cell instance sg13cmos5l_mux2_1_15 r0 *1 0,0
Xsg13cmos5l_mux2_1_15 \$3426 \$3246 \$2717 VPWR VGND \$3427 sg13cmos5l_mux2_1
* cell instance sg13cmos5l_mux2_1_16 r0 *1 0,0
Xsg13cmos5l_mux2_1_16 \$3943 \$5531 \$3622 VPWR VGND \$5532 sg13cmos5l_mux2_1
* cell instance sg13cmos5l_mux2_1_17 r0 *1 0,0
Xsg13cmos5l_mux2_1_17 \$3250 \$3431 \$2717 VPWR VGND \$4222 sg13cmos5l_mux2_1
* cell instance sg13cmos5l_mux2_1_18 r0 *1 0,0
Xsg13cmos5l_mux2_1_18 \$3760 \$2858 \$3941 VPWR VGND \$3708 sg13cmos5l_mux2_1
* cell instance sg13cmos5l_mux2_1_19 r0 *1 0,0
Xsg13cmos5l_mux2_1_19 \$3046 \$4934 \$3622 VPWR VGND \$5110 sg13cmos5l_mux2_1
* cell instance sg13cmos5l_mux2_1_20 r0 *1 0,0
Xsg13cmos5l_mux2_1_20 \$3046 \$2870 \$3043 VPWR VGND \$3009 sg13cmos5l_mux2_1
* cell instance sg13cmos5l_mux2_1_21 r0 *1 0,0
Xsg13cmos5l_mux2_1_21 \$2883 \$2880 \$2219 VPWR VGND \$3026 sg13cmos5l_mux2_1
* cell instance sg13cmos5l_mux2_1_22 r0 *1 0,0
Xsg13cmos5l_mux2_1_22 \$2883 \$5345 \$3442 VPWR VGND \$5342 sg13cmos5l_mux2_1
* cell instance sg13cmos5l_mux2_1_23 r0 *1 0,0
Xsg13cmos5l_mux2_1_23 \$4954 \$4953 \$4242 VPWR VGND \$4957 sg13cmos5l_mux2_1
* cell instance sg13cmos5l_mux2_1_24 r0 *1 0,0
Xsg13cmos5l_mux2_1_24 \$2744 \$2741 \$2219 VPWR VGND \$2076 sg13cmos5l_mux2_1
* cell instance sg13cmos5l_mux2_1_25 r0 *1 0,0
Xsg13cmos5l_mux2_1_25 \$2906 \$2577 \$2754 VPWR VGND \$2907 sg13cmos5l_mux2_1
* cell instance sg13cmos5l_mux2_1_26 r0 *1 0,0
Xsg13cmos5l_mux2_1_26 \$2106 \$2148 \$1929 VPWR VGND \$864 sg13cmos5l_mux2_1
* cell instance sg13cmos5l_mux2_1_27 r0 *1 0,0
Xsg13cmos5l_mux2_1_27 \$2291 \$2755 \$3132 VPWR VGND \$3299 sg13cmos5l_mux2_1
* cell instance sg13cmos5l_mux2_1_28 r0 *1 0,0
Xsg13cmos5l_mux2_1_28 \$2288 \$1466 \$1929 VPWR VGND \$2291 sg13cmos5l_mux2_1
* cell instance sg13cmos5l_mux2_1_29 r0 *1 0,0
Xsg13cmos5l_mux2_1_29 \$1718 \$1717 \$1929 VPWR VGND \$579 sg13cmos5l_mux2_1
* cell instance sg13cmos5l_mux2_1_30 r0 *1 0,0
Xsg13cmos5l_mux2_1_30 \$2583 \$1223 \$2754 VPWR VGND \$2755 sg13cmos5l_mux2_1
* cell instance sg13cmos5l_mux2_1_31 r0 *1 0,0
Xsg13cmos5l_mux2_1_31 \$3481 \$326 \$2754 VPWR VGND \$3133 sg13cmos5l_mux2_1
* cell instance sg13cmos5l_mux2_1_32 r0 *1 0,0
Xsg13cmos5l_mux2_1_32 \$970 \$976 \$1929 VPWR VGND \$456 sg13cmos5l_mux2_1
* cell instance sg13cmos5l_mux2_1_33 r0 *1 0,0
Xsg13cmos5l_mux2_1_33 \$453 \$454 \$647 VPWR VGND \$393 sg13cmos5l_mux2_1
* cell instance sg13cmos5l_mux2_1_34 r0 *1 0,0
Xsg13cmos5l_mux2_1_34 \$591 \$993 \$988 VPWR VGND \$992 sg13cmos5l_mux2_1
* cell instance sg13cmos5l_mux2_1_35 r0 *1 0,0
Xsg13cmos5l_mux2_1_35 \$480 \$591 \$140 VPWR VGND \$593 sg13cmos5l_mux2_1
* cell instance sg13cmos5l_mux2_1_36 r0 *1 0,0
Xsg13cmos5l_mux2_1_36 \$355 \$591 \$340 VPWR VGND \$216 sg13cmos5l_mux2_1
* cell instance sg13cmos5l_mux2_1_37 r0 *1 0,0
Xsg13cmos5l_mux2_1_37 \$873 \$591 \$201 VPWR VGND \$728 sg13cmos5l_mux2_1
* cell instance sg13cmos5l_mux2_1_38 r0 *1 0,0
Xsg13cmos5l_mux2_1_38 \$15080 \$15718 \$15717 VPWR VGND \$15529
+ sg13cmos5l_mux2_1
* cell instance sg13cmos5l_mux2_1_39 r0 *1 0,0
Xsg13cmos5l_mux2_1_39 \$16847 \$17337 \$14831 VPWR VGND \$217 sg13cmos5l_mux2_1
* cell instance sg13cmos5l_mux2_1_40 r0 *1 0,0
Xsg13cmos5l_mux2_1_40 \$15718 \$17833 \$15717 VPWR VGND \$17658
+ sg13cmos5l_mux2_1
* cell instance sg13cmos5l_mux2_1_41 r0 *1 0,0
Xsg13cmos5l_mux2_1_41 \$358 \$398 \$340 VPWR VGND \$359 sg13cmos5l_mux2_1
* cell instance sg13cmos5l_mux2_1_42 r0 *1 0,0
Xsg13cmos5l_mux2_1_42 \$17833 \$19563 \$15717 VPWR VGND \$19404
+ sg13cmos5l_mux2_1
* cell instance sg13cmos5l_mux2_1_43 r0 *1 0,0
Xsg13cmos5l_mux2_1_43 \$17835 \$17838 \$14831 VPWR VGND \$6500 sg13cmos5l_mux2_1
* cell instance sg13cmos5l_mux2_1_44 r0 *1 0,0
Xsg13cmos5l_mux2_1_44 \$1739 \$1740 \$199 VPWR VGND \$1607 sg13cmos5l_mux2_1
* cell instance sg13cmos5l_mux2_1_45 r0 *1 0,0
Xsg13cmos5l_mux2_1_45 \$495 \$398 \$140 VPWR VGND \$230 sg13cmos5l_mux2_1
* cell instance sg13cmos5l_mux2_1_46 r0 *1 0,0
Xsg13cmos5l_mux2_1_46 \$1740 \$2183 \$984 VPWR VGND \$2184 sg13cmos5l_mux2_1
* cell instance sg13cmos5l_mux2_1_47 r0 *1 0,0
Xsg13cmos5l_mux2_1_47 \$1841 \$1740 \$201 VPWR VGND \$1842 sg13cmos5l_mux2_1
* cell instance sg13cmos5l_mux2_1_48 r0 *1 0,0
Xsg13cmos5l_mux2_1_48 \$1614 \$1740 \$1113 VPWR VGND \$1615 sg13cmos5l_mux2_1
* cell instance sg13cmos5l_mux2_1_49 r0 *1 0,0
Xsg13cmos5l_mux2_1_49 \$17844 \$18963 \$14831 VPWR VGND \$13875
+ sg13cmos5l_mux2_1
* cell instance sg13cmos5l_mux2_1_50 r0 *1 0,0
Xsg13cmos5l_mux2_1_50 \$247 \$402 \$340 VPWR VGND \$371 sg13cmos5l_mux2_1
* cell instance sg13cmos5l_mux2_1_51 r0 *1 0,0
Xsg13cmos5l_mux2_1_51 \$402 \$612 \$988 VPWR VGND \$613 sg13cmos5l_mux2_1
* cell instance sg13cmos5l_mux2_1_52 r0 *1 0,0
Xsg13cmos5l_mux2_1_52 \$14613 \$15214 \$14831 VPWR VGND \$6407 sg13cmos5l_mux2_1
* cell instance sg13cmos5l_mux2_1_53 r0 *1 0,0
Xsg13cmos5l_mux2_1_53 \$17838 \$19564 \$15717 VPWR VGND \$19410
+ sg13cmos5l_mux2_1
* cell instance sg13cmos5l_mux2_1_54 r0 *1 0,0
Xsg13cmos5l_mux2_1_54 \$501 \$402 \$140 VPWR VGND \$502 sg13cmos5l_mux2_1
* cell instance sg13cmos5l_mux2_1_55 r0 *1 0,0
Xsg13cmos5l_mux2_1_55 \$885 \$402 \$348 VPWR VGND \$886 sg13cmos5l_mux2_1
* cell instance sg13cmos5l_mux2_1_56 r0 *1 0,0
Xsg13cmos5l_mux2_1_56 \$17339 \$16323 \$16322 VPWR VGND \$6488 sg13cmos5l_mux2_1
* cell instance sg13cmos5l_mux2_1_57 r0 *1 0,0
Xsg13cmos5l_mux2_1_57 \$1387 \$1381 \$340 VPWR VGND \$1384 sg13cmos5l_mux2_1
* cell instance sg13cmos5l_mux2_1_58 r0 *1 0,0
Xsg13cmos5l_mux2_1_58 \$17845 \$17848 \$14831 VPWR VGND \$6352 sg13cmos5l_mux2_1
* cell instance sg13cmos5l_mux2_1_59 r0 *1 0,0
Xsg13cmos5l_mux2_1_59 \$19564 \$18921 \$15717 VPWR VGND \$18786
+ sg13cmos5l_mux2_1
* cell instance sg13cmos5l_mux2_1_60 r0 *1 0,0
Xsg13cmos5l_mux2_1_60 \$15215 \$15216 \$14831 VPWR VGND \$6546 sg13cmos5l_mux2_1
* cell instance sg13cmos5l_mux2_1_61 r0 *1 0,0
Xsg13cmos5l_mux2_1_61 \$16325 \$16366 \$16322 VPWR VGND \$953 sg13cmos5l_mux2_1
* cell instance sg13cmos5l_mux2_1_62 r0 *1 0,0
Xsg13cmos5l_mux2_1_62 \$1855 \$1821 \$340 VPWR VGND \$1856 sg13cmos5l_mux2_1
* cell instance sg13cmos5l_mux2_1_63 r0 *1 0,0
Xsg13cmos5l_mux2_1_63 \$17852 \$16326 \$15717 VPWR VGND \$17310
+ sg13cmos5l_mux2_1
* cell instance sg13cmos5l_mux2_1_64 r0 *1 0,0
Xsg13cmos5l_mux2_1_64 \$762 \$592 \$340 VPWR VGND \$628 sg13cmos5l_mux2_1
* cell instance sg13cmos5l_mux2_1_65 r0 *1 0,0
Xsg13cmos5l_mux2_1_65 \$16366 \$15675 \$6502 VPWR VGND \$15547 sg13cmos5l_mux2_1
* cell instance sg13cmos5l_mux2_1_66 r0 *1 0,0
Xsg13cmos5l_mux2_1_66 \$18921 \$17852 \$15717 VPWR VGND \$17670
+ sg13cmos5l_mux2_1
* cell instance sg13cmos5l_mux2_1_67 r0 *1 0,0
Xsg13cmos5l_mux2_1_67 \$16326 \$16366 \$15717 VPWR VGND \$16208
+ sg13cmos5l_mux2_1
* cell instance sg13cmos5l_mux2_1_68 r0 *1 0,0
Xsg13cmos5l_mux2_1_68 \$644 \$592 \$140 VPWR VGND \$767 sg13cmos5l_mux2_1
* cell instance sg13cmos5l_mux2_1_69 r0 *1 0,0
Xsg13cmos5l_mux2_1_69 \$1821 \$2206 \$984 VPWR VGND \$2093 sg13cmos5l_mux2_1
* cell instance sg13cmos5l_mux2_1_70 r0 *1 0,0
Xsg13cmos5l_mux2_1_70 \$592 \$1147 \$988 VPWR VGND \$1148 sg13cmos5l_mux2_1
* cell instance sg13cmos5l_mux2_1_71 r0 *1 0,0
Xsg13cmos5l_mux2_1_71 \$1381 \$1635 \$988 VPWR VGND \$1636 sg13cmos5l_mux2_1
* cell instance sg13cmos5l_mux2_1_72 r0 *1 0,0
Xsg13cmos5l_mux2_1_72 \$1987 \$1821 \$348 VPWR VGND \$1988 sg13cmos5l_mux2_1
* cell instance sg13cmos5l_mux2_1_73 r0 *1 0,0
Xsg13cmos5l_mux2_1_73 \$1290 \$1381 \$140 VPWR VGND \$1399 sg13cmos5l_mux2_1
* cell instance sg13cmos5l_mux2_1_74 r0 *1 0,0
Xsg13cmos5l_mux2_1_74 \$1524 \$1381 \$201 VPWR VGND \$1525 sg13cmos5l_mux2_1
* cell instance sg13cmos5l_mux2_1_75 r0 *1 0,0
Xsg13cmos5l_mux2_1_75 \$1768 \$1821 \$140 VPWR VGND \$1769 sg13cmos5l_mux2_1
* cell instance sg13cmos5l_mux2_1_76 r0 *1 0,0
Xsg13cmos5l_mux2_1_76 \$924 \$592 \$201 VPWR VGND \$1030 sg13cmos5l_mux2_1
* cell instance sg13cmos5l_mux4_1_0 r0 *1 0,0
Xsg13cmos5l_mux4_1_0 \$573 \$138 \$516 \$466 \$579 \$454 VPWR VGND \$584
+ sg13cmos5l_mux4_1
* cell instance sg13cmos5l_mux4_1_1 r0 *1 0,0
Xsg13cmos5l_mux4_1_1 \$461 \$198 \$518 \$213 \$864 \$869 VPWR VGND \$921
+ sg13cmos5l_mux4_1
* cell instance sg13cmos5l_mux4_1_2 r0 *1 0,0
Xsg13cmos5l_mux4_1_2 \$461 \$198 \$518 \$213 \$579 \$454 VPWR VGND \$723
+ sg13cmos5l_mux4_1
* cell instance sg13cmos5l_mux4_1_3 r0 *1 0,0
Xsg13cmos5l_mux4_1_3 \$483 \$1124 \$486 \$785 \$996 \$869 VPWR VGND \$1001
+ sg13cmos5l_mux4_1
* cell instance sg13cmos5l_mux4_1_4 r0 *1 0,0
Xsg13cmos5l_mux4_1_4 \$3654 \$3499 \$4000 \$4149 \$4147 \$4060 VPWR VGND \$4153
+ sg13cmos5l_mux4_1
* cell instance sg13cmos5l_mux4_1_5 r0 *1 0,0
Xsg13cmos5l_mux4_1_5 \$1620 \$1958 \$1617 \$1960 \$996 \$869 VPWR VGND \$1964
+ sg13cmos5l_mux4_1
* cell instance sg13cmos5l_mux4_1_6 r0 *1 0,0
Xsg13cmos5l_mux4_1_6 \$399 \$1004 \$242 \$748 \$996 \$869 VPWR VGND \$1008
+ sg13cmos5l_mux4_1
* cell instance sg13cmos5l_mux4_1_7 r0 *1 0,0
Xsg13cmos5l_mux4_1_7 \$3148 \$2609 \$2922 \$2474 \$4060 \$4147 VPWR VGND \$4166
+ sg13cmos5l_mux4_1
* cell instance sg13cmos5l_mux4_1_8 r0 *1 0,0
Xsg13cmos5l_mux4_1_8 \$243 \$625 \$504 \$923 \$996 \$869 VPWR VGND \$1108
+ sg13cmos5l_mux4_1
* cell instance sg13cmos5l_mux4_1_9 r0 *1 0,0
Xsg13cmos5l_mux4_1_9 \$6550 \$6512 \$6513 \$6515 \$4147 \$4060 VPWR VGND \$4635
+ sg13cmos5l_mux4_1
* cell instance sg13cmos5l_mux4_1_10 r0 *1 0,0
Xsg13cmos5l_mux4_1_10 \$6303 \$4455 \$5427 \$5864 \$3990 \$4127 VPWR VGND
+ \$4633 sg13cmos5l_mux4_1
* cell instance sg13cmos5l_mux4_1_11 r0 *1 0,0
Xsg13cmos5l_mux4_1_11 \$3859 \$3347 \$2316 \$2946 \$4147 \$4060 VPWR VGND
+ \$4022 sg13cmos5l_mux4_1
* cell instance sg13cmos5l_mux4_1_12 r0 *1 0,0
Xsg13cmos5l_mux4_1_12 \$243 \$625 \$504 \$923 \$901 \$1020 VPWR VGND \$1367
+ sg13cmos5l_mux4_1
* cell instance sg13cmos5l_mux4_1_13 r0 *1 0,0
Xsg13cmos5l_mux4_1_13 \$1982 \$2200 \$1765 \$1976 \$996 \$869 VPWR VGND \$2173
+ sg13cmos5l_mux4_1
* cell instance sg13cmos5l_mux4_1_14 r0 *1 0,0
Xsg13cmos5l_mux4_1_14 \$1388 \$1279 \$1280 \$1282 \$996 \$869 VPWR VGND \$1245
+ sg13cmos5l_mux4_1
* cell instance sg13cmos5l_mux4_1_15 r0 *1 0,0
Xsg13cmos5l_mux4_1_15 \$1388 \$1279 \$1280 \$1282 \$901 \$1020 VPWR VGND \$1285
+ sg13cmos5l_mux4_1
* cell instance sg13cmos5l_mux4_1_16 r0 *1 0,0
Xsg13cmos5l_mux4_1_16 \$1518 \$1519 \$1520 \$1521 \$901 \$1020 VPWR VGND \$1375
+ sg13cmos5l_mux4_1
* cell instance sg13cmos5l_mux4_1_17 r0 *1 0,0
Xsg13cmos5l_mux4_1_17 \$626 \$898 \$763 \$1025 \$996 \$869 VPWR VGND \$1242
+ sg13cmos5l_mux4_1
* cell instance sg13cmos5l_mux4_1_18 r0 *1 0,0
Xsg13cmos5l_mux4_1_18 \$627 \$899 \$764 \$904 \$901 \$1020 VPWR VGND \$1376
+ sg13cmos5l_mux4_1
* cell instance sg13cmos5l_mux4_1_19 r0 *1 0,0
Xsg13cmos5l_mux4_1_19 \$626 \$898 \$763 \$1025 \$901 \$1020 VPWR VGND \$1240
+ sg13cmos5l_mux4_1
* cell instance sg13cmos5l_mux4_1_20 r0 *1 0,0
Xsg13cmos5l_mux4_1_20 \$6589 \$6599 \$6520 \$6522 \$4147 \$4127 VPWR VGND
+ \$4492 sg13cmos5l_mux4_1
* cell instance sg13cmos5l_mux4_1_21 r0 *1 0,0
Xsg13cmos5l_mux4_1_21 \$2340 \$3188 \$4030 \$3659 \$4147 \$4060 VPWR VGND
+ \$4345 sg13cmos5l_mux4_1
* cell instance sg13cmos5l_mux4_1_22 r0 *1 0,0
Xsg13cmos5l_mux4_1_22 \$2807 \$4833 \$4839 \$4638 \$4147 \$4060 VPWR VGND
+ \$4469 sg13cmos5l_mux4_1
* cell instance sg13cmos5l_nand2_1_0 r0 *1 0,0
Xsg13cmos5l_nand2_1_0 \$67 \$42 VPWR VGND \$1665 sg13cmos5l_nand2_1
* cell instance sg13cmos5l_nand2_1_1 r0 *1 0,0
Xsg13cmos5l_nand2_1_1 \$35 \$42 VPWR VGND \$11 sg13cmos5l_nand2_1
* cell instance sg13cmos5l_nand2_1_2 r0 *1 0,0
Xsg13cmos5l_nand2_1_2 \$5283 \$5892 VPWR VGND \$5893 sg13cmos5l_nand2_1
* cell instance sg13cmos5l_nand2_1_3 r0 *1 0,0
Xsg13cmos5l_nand2_1_3 \$16000 \$15071 VPWR VGND \$15072 sg13cmos5l_nand2_1
* cell instance sg13cmos5l_nand2_1_4 r0 *1 0,0
Xsg13cmos5l_nand2_1_4 \$157 \$792 VPWR VGND \$795 sg13cmos5l_nand2_1
* cell instance sg13cmos5l_nand2_1_5 r0 *1 0,0
Xsg13cmos5l_nand2_1_5 \$6077 \$5901 VPWR VGND \$6073 sg13cmos5l_nand2_1
* cell instance sg13cmos5l_nand2_1_6 r0 *1 0,0
Xsg13cmos5l_nand2_1_6 \$14531 \$13223 VPWR VGND \$14530 sg13cmos5l_nand2_1
* cell instance sg13cmos5l_nand2_1_7 r0 *1 0,0
Xsg13cmos5l_nand2_1_7 \$9629 \$8492 VPWR VGND \$9412 sg13cmos5l_nand2_1
* cell instance sg13cmos5l_nand2_1_8 r0 *1 0,0
Xsg13cmos5l_nand2_1_8 \$5892 \$4871 VPWR VGND \$6077 sg13cmos5l_nand2_1
* cell instance sg13cmos5l_nand2_1_9 r0 *1 0,0
Xsg13cmos5l_nand2_1_9 \$16678 \$15071 VPWR VGND \$17329 sg13cmos5l_nand2_1
* cell instance sg13cmos5l_nand2_1_10 r0 *1 0,0
Xsg13cmos5l_nand2_1_10 \$154 \$259 VPWR VGND \$151 sg13cmos5l_nand2_1
* cell instance sg13cmos5l_nand2_1_11 r0 *1 0,0
Xsg13cmos5l_nand2_1_11 \$10587 \$7913 VPWR VGND \$10588 sg13cmos5l_nand2_1
* cell instance sg13cmos5l_nand2_1_12 r0 *1 0,0
Xsg13cmos5l_nand2_1_12 \$8416 \$8492 VPWR VGND \$8412 sg13cmos5l_nand2_1
* cell instance sg13cmos5l_nand2_1_13 r0 *1 0,0
Xsg13cmos5l_nand2_1_13 \$11897 \$12049 VPWR VGND \$12268 sg13cmos5l_nand2_1
* cell instance sg13cmos5l_nand2_1_14 r0 *1 0,0
Xsg13cmos5l_nand2_1_14 \$12925 \$12049 VPWR VGND \$12705 sg13cmos5l_nand2_1
* cell instance sg13cmos5l_nand2_1_15 r0 *1 0,0
Xsg13cmos5l_nand2_1_15 \$2670 \$2383 VPWR VGND \$2811 sg13cmos5l_nand2_1
* cell instance sg13cmos5l_nand2_1_16 r0 *1 0,0
Xsg13cmos5l_nand2_1_16 \$11898 \$13864 VPWR VGND \$13836 sg13cmos5l_nand2_1
* cell instance sg13cmos5l_nand2_1_17 r0 *1 0,0
Xsg13cmos5l_nand2_1_17 \$11898 \$12704 VPWR VGND \$12706 sg13cmos5l_nand2_1
* cell instance sg13cmos5l_nand2_1_18 r0 *1 0,0
Xsg13cmos5l_nand2_1_18 \$261 \$1196 VPWR VGND \$652 sg13cmos5l_nand2_1
* cell instance sg13cmos5l_nand2_1_19 r0 *1 0,0
Xsg13cmos5l_nand2_1_19 \$928 \$926 VPWR VGND \$927 sg13cmos5l_nand2_1
* cell instance sg13cmos5l_nand2_1_20 r0 *1 0,0
Xsg13cmos5l_nand2_1_20 \$11898 \$11896 VPWR VGND \$11268 sg13cmos5l_nand2_1
* cell instance sg13cmos5l_nand2_1_21 r0 *1 0,0
Xsg13cmos5l_nand2_1_21 \$15682 \$15071 VPWR VGND \$15831 sg13cmos5l_nand2_1
* cell instance sg13cmos5l_nand2_1_22 r0 *1 0,0
Xsg13cmos5l_nand2_1_22 \$931 \$261 VPWR VGND \$1543 sg13cmos5l_nand2_1
* cell instance sg13cmos5l_nand2_1_23 r0 *1 0,0
Xsg13cmos5l_nand2_1_23 \$66 \$406 VPWR VGND \$523 sg13cmos5l_nand2_1
* cell instance sg13cmos5l_nand2_1_24 r0 *1 0,0
Xsg13cmos5l_nand2_1_24 \$5481 \$5480 VPWR VGND \$5471 sg13cmos5l_nand2_1
* cell instance sg13cmos5l_nand2_1_25 r0 *1 0,0
Xsg13cmos5l_nand2_1_25 \$5896 \$4871 VPWR VGND \$5481 sg13cmos5l_nand2_1
* cell instance sg13cmos5l_nand2_1_26 r0 *1 0,0
Xsg13cmos5l_nand2_1_26 \$1 \$523 VPWR VGND \$407 sg13cmos5l_nand2_1
* cell instance sg13cmos5l_nand2_1_27 r0 *1 0,0
Xsg13cmos5l_nand2_1_27 \$9933 \$8492 VPWR VGND \$10137 sg13cmos5l_nand2_1
* cell instance sg13cmos5l_nand2_1_28 r0 *1 0,0
Xsg13cmos5l_nand2_1_28 \$14533 \$12049 VPWR VGND \$14532 sg13cmos5l_nand2_1
* cell instance sg13cmos5l_nand2_1_29 r0 *1 0,0
Xsg13cmos5l_nand2_1_29 \$1055 \$1667 VPWR VGND \$158 sg13cmos5l_nand2_1
* cell instance sg13cmos5l_nand2_1_30 r0 *1 0,0
Xsg13cmos5l_nand2_1_30 \$1789 \$1667 VPWR VGND \$1175 sg13cmos5l_nand2_1
* cell instance sg13cmos5l_nand2_1_31 r0 *1 0,0
Xsg13cmos5l_nand2_1_31 \$9145 \$8492 VPWR VGND \$8853 sg13cmos5l_nand2_1
* cell instance sg13cmos5l_nand2_1_32 r0 *1 0,0
Xsg13cmos5l_nand2_1_32 \$12926 \$12049 VPWR VGND \$11899 sg13cmos5l_nand2_1
* cell instance sg13cmos5l_nand2_1_33 r0 *1 0,0
Xsg13cmos5l_nand2_1_33 \$18443 \$15071 VPWR VGND \$17675 sg13cmos5l_nand2_1
* cell instance sg13cmos5l_nand2_1_34 r0 *1 0,0
Xsg13cmos5l_nand2_1_34 \$153 \$943 VPWR VGND \$1306 sg13cmos5l_nand2_1
* cell instance sg13cmos5l_nand2_1_35 r0 *1 0,0
Xsg13cmos5l_nand2_1_35 \$8493 \$8492 VPWR VGND \$8418 sg13cmos5l_nand2_1
* cell instance sg13cmos5l_nand2_1_36 r0 *1 0,0
Xsg13cmos5l_nand2_1_36 \$13404 \$13223 VPWR VGND \$13403 sg13cmos5l_nand2_1
* cell instance sg13cmos5l_nand2_1_37 r0 *1 0,0
Xsg13cmos5l_nand2_1_37 \$1433 \$406 VPWR VGND \$1667 sg13cmos5l_nand2_1
* cell instance sg13cmos5l_nand2_1_38 r0 *1 0,0
Xsg13cmos5l_nand2_1_38 \$3744 \$3742 VPWR VGND \$2395 sg13cmos5l_nand2_1
* cell instance sg13cmos5l_nand2_1_39 r0 *1 0,0
Xsg13cmos5l_nand2_1_39 \$154 \$152 VPWR VGND \$9 sg13cmos5l_nand2_1
* cell instance sg13cmos5l_nand2_1_40 r0 *1 0,0
Xsg13cmos5l_nand2_1_40 \$931 \$426 VPWR VGND \$1779 sg13cmos5l_nand2_1
* cell instance sg13cmos5l_nand2_1_41 r0 *1 0,0
Xsg13cmos5l_nand2_1_41 \$4701 \$4871 VPWR VGND \$4880 sg13cmos5l_nand2_1
* cell instance sg13cmos5l_nand2_1_42 r0 *1 0,0
Xsg13cmos5l_nand2_1_42 \$3914 \$3913 VPWR VGND \$4483 sg13cmos5l_nand2_1
* cell instance sg13cmos5l_nand2_1_43 r0 *1 0,0
Xsg13cmos5l_nand2_1_43 \$19878 \$19423 VPWR VGND \$19877 sg13cmos5l_nand2_1
* cell instance sg13cmos5l_nand2_1_44 r0 *1 0,0
Xsg13cmos5l_nand2_1_44 \$3909 \$3912 VPWR VGND \$3917 sg13cmos5l_nand2_1
* cell instance sg13cmos5l_nand2_1_45 r0 *1 0,0
Xsg13cmos5l_nand2_1_45 \$67 \$406 VPWR VGND \$943 sg13cmos5l_nand2_1
* cell instance sg13cmos5l_nand2_1_46 r0 *1 0,0
Xsg13cmos5l_nand2_1_46 \$65 \$35 VPWR VGND \$521 sg13cmos5l_nand2_1
* cell instance sg13cmos5l_nand2_1_47 r0 *1 0,0
Xsg13cmos5l_nand2_1_47 \$1496 \$4878 VPWR VGND \$5290 sg13cmos5l_nand2_1
* cell instance sg13cmos5l_nand2_1_48 r0 *1 0,0
Xsg13cmos5l_nand2_1_48 \$10770 \$8492 VPWR VGND \$10138 sg13cmos5l_nand2_1
* cell instance sg13cmos5l_nand2_1_49 r0 *1 0,0
Xsg13cmos5l_nand2_1_49 \$2509 \$2506 VPWR VGND \$2400 sg13cmos5l_nand2_1
* cell instance sg13cmos5l_nand2_1_50 r0 *1 0,0
Xsg13cmos5l_nand2_1_50 \$4045 \$14535 VPWR VGND \$14034 sg13cmos5l_nand2_1
* cell instance sg13cmos5l_nand2_1_51 r0 *1 0,0
Xsg13cmos5l_nand2_1_51 \$4087 \$4207 VPWR VGND \$3913 sg13cmos5l_nand2_1
* cell instance sg13cmos5l_nand2_1_52 r0 *1 0,0
Xsg13cmos5l_nand2_1_52 \$4045 \$12424 VPWR VGND \$12272 sg13cmos5l_nand2_1
* cell instance sg13cmos5l_nand2_1_53 r0 *1 0,0
Xsg13cmos5l_nand2_1_53 \$153 \$1058 VPWR VGND \$1055 sg13cmos5l_nand2_1
* cell instance sg13cmos5l_nand2_1_54 r0 *1 0,0
Xsg13cmos5l_nand2_1_54 \$42 \$1664 VPWR VGND \$798 sg13cmos5l_nand2_1
* cell instance sg13cmos5l_nand2_1_55 r0 *1 0,0
Xsg13cmos5l_nand2_1_55 \$2399 \$2389 VPWR VGND \$2240 sg13cmos5l_nand2_1
* cell instance sg13cmos5l_nand2_1_56 r0 *1 0,0
Xsg13cmos5l_nand2_1_56 \$9262 \$8492 VPWR VGND \$9217 sg13cmos5l_nand2_1
* cell instance sg13cmos5l_nand2_1_57 r0 *1 0,0
Xsg13cmos5l_nand2_1_57 \$2396 \$2390 VPWR VGND \$2401 sg13cmos5l_nand2_1
* cell instance sg13cmos5l_nand2_1_58 r0 *1 0,0
Xsg13cmos5l_nand2_1_58 \$258 \$152 VPWR VGND \$70 sg13cmos5l_nand2_1
* cell instance sg13cmos5l_nand2_1_59 r0 *1 0,0
Xsg13cmos5l_nand2_1_59 \$2682 \$2676 VPWR VGND \$2402 sg13cmos5l_nand2_1
* cell instance sg13cmos5l_nand2_1_60 r0 *1 0,0
Xsg13cmos5l_nand2_1_60 \$1817 \$4092 VPWR VGND \$4369 sg13cmos5l_nand2_1
* cell instance sg13cmos5l_nand2_1_61 r0 *1 0,0
Xsg13cmos5l_nand2_1_61 \$11898 \$13405 VPWR VGND \$13229 sg13cmos5l_nand2_1
* cell instance sg13cmos5l_nand2_1_62 r0 *1 0,0
Xsg13cmos5l_nand2_1_62 \$14537 \$12425 VPWR VGND \$14536 sg13cmos5l_nand2_1
* cell instance sg13cmos5l_nand2_1_63 r0 *1 0,0
Xsg13cmos5l_nand2_1_63 \$649 \$664 VPWR VGND \$173 sg13cmos5l_nand2_1
* cell instance sg13cmos5l_nand2_1_64 r0 *1 0,0
Xsg13cmos5l_nand2_1_64 \$4045 \$14867 VPWR VGND \$15560 sg13cmos5l_nand2_1
* cell instance sg13cmos5l_nand2_1_65 r0 *1 0,0
Xsg13cmos5l_nand2_1_65 \$12929 \$12425 VPWR VGND \$12273 sg13cmos5l_nand2_1
* cell instance sg13cmos5l_nand2_1_66 r0 *1 0,0
Xsg13cmos5l_nand2_1_66 \$4045 \$12719 VPWR VGND \$12130 sg13cmos5l_nand2_1
* cell instance sg13cmos5l_nand2_1_67 r0 *1 0,0
Xsg13cmos5l_nand2_1_67 \$524 \$258 VPWR VGND \$411 sg13cmos5l_nand2_1
* cell instance sg13cmos5l_nand2_1_68 r0 *1 0,0
Xsg13cmos5l_nand2_1_68 \$4087 \$4203 VPWR VGND \$4206 sg13cmos5l_nand2_1
* cell instance sg13cmos5l_nand2_1_69 r0 *1 0,0
Xsg13cmos5l_nand2_1_69 \$10775 \$7913 VPWR VGND \$10774 sg13cmos5l_nand2_1
* cell instance sg13cmos5l_nand2_1_70 r0 *1 0,0
Xsg13cmos5l_nand2_1_70 \$649 \$153 VPWR VGND \$262 sg13cmos5l_nand2_1
* cell instance sg13cmos5l_nand2_1_71 r0 *1 0,0
Xsg13cmos5l_nand2_1_71 \$67 \$796 VPWR VGND \$294 sg13cmos5l_nand2_1
* cell instance sg13cmos5l_nand2_1_72 r0 *1 0,0
Xsg13cmos5l_nand2_1_72 \$3216 \$3392 VPWR VGND \$3398 sg13cmos5l_nand2_1
* cell instance sg13cmos5l_nand2_1_73 r0 *1 0,0
Xsg13cmos5l_nand2_1_73 \$2513 \$2514 VPWR VGND \$2245 sg13cmos5l_nand2_1
* cell instance sg13cmos5l_nand2_1_74 r0 *1 0,0
Xsg13cmos5l_nand2_1_74 \$4209 \$4208 VPWR VGND \$4207 sg13cmos5l_nand2_1
* cell instance sg13cmos5l_nand2_1_75 r0 *1 0,0
Xsg13cmos5l_nand2_1_75 \$6081 \$5099 VPWR VGND \$5921 sg13cmos5l_nand2_1
* cell instance sg13cmos5l_nand2_1_76 r0 *1 0,0
Xsg13cmos5l_nand2_1_76 \$19424 \$19423 VPWR VGND \$19421 sg13cmos5l_nand2_1
* cell instance sg13cmos5l_nand2_1_77 r0 *1 0,0
Xsg13cmos5l_nand2_1_77 \$4222 \$3025 VPWR VGND \$3015 sg13cmos5l_nand2_1
* cell instance sg13cmos5l_nand2_1_78 r0 *1 0,0
Xsg13cmos5l_nand2_1_78 \$3420 \$4092 VPWR VGND \$4093 sg13cmos5l_nand2_1
* cell instance sg13cmos5l_nand2_1_79 r0 *1 0,0
Xsg13cmos5l_nand2_1_79 \$262 \$1887 VPWR VGND \$2037 sg13cmos5l_nand2_1
* cell instance sg13cmos5l_nand2_1_80 r0 *1 0,0
Xsg13cmos5l_nand2_1_80 \$14035 \$15364 VPWR VGND \$14343 sg13cmos5l_nand2_1
* cell instance sg13cmos5l_nand2_1_81 r0 *1 0,0
Xsg13cmos5l_nand2_1_81 \$15076 \$16218 VPWR VGND \$16011 sg13cmos5l_nand2_1
* cell instance sg13cmos5l_nand2_1_82 r0 *1 0,0
Xsg13cmos5l_nand2_1_82 \$521 \$525 VPWR VGND \$526 sg13cmos5l_nand2_1
* cell instance sg13cmos5l_nand2_1_83 r0 *1 0,0
Xsg13cmos5l_nand2_1_83 \$14035 \$14879 VPWR VGND \$14621 sg13cmos5l_nand2_1
* cell instance sg13cmos5l_nand2_1_84 r0 *1 0,0
Xsg13cmos5l_nand2_1_84 \$8792 \$7813 VPWR VGND \$8776 sg13cmos5l_nand2_1
* cell instance sg13cmos5l_nand2_1_85 r0 *1 0,0
Xsg13cmos5l_nand2_1_85 \$649 \$42 VPWR VGND \$305 sg13cmos5l_nand2_1
* cell instance sg13cmos5l_nand2_1_86 r0 *1 0,0
Xsg13cmos5l_nand2_1_86 \$657 \$3 VPWR VGND \$683 sg13cmos5l_nand2_1
* cell instance sg13cmos5l_nand2_1_87 r0 *1 0,0
Xsg13cmos5l_nand2_1_87 \$3230 \$3756 VPWR VGND \$2503 sg13cmos5l_nand2_1
* cell instance sg13cmos5l_nand2_1_88 r0 *1 0,0
Xsg13cmos5l_nand2_1_88 \$43 \$1186 VPWR VGND \$1648 sg13cmos5l_nand2_1
* cell instance sg13cmos5l_nand2_1_89 r0 *1 0,0
Xsg13cmos5l_nand2_1_89 \$16693 \$15076 VPWR VGND \$16013 sg13cmos5l_nand2_1
* cell instance sg13cmos5l_nand2_1_90 r0 *1 0,0
Xsg13cmos5l_nand2_1_90 \$2111 \$802 VPWR VGND \$925 sg13cmos5l_nand2_1
* cell instance sg13cmos5l_nand2_1_91 r0 *1 0,0
Xsg13cmos5l_nand2_1_91 \$4045 \$3928 VPWR VGND \$2388 sg13cmos5l_nand2_1
* cell instance sg13cmos5l_nand2_1_92 r0 *1 0,0
Xsg13cmos5l_nand2_1_92 \$18929 \$19423 VPWR VGND \$18446 sg13cmos5l_nand2_1
* cell instance sg13cmos5l_nand2_1_93 r0 *1 0,0
Xsg13cmos5l_nand2_1_93 \$1664 \$796 VPWR VGND \$2117 sg13cmos5l_nand2_1
* cell instance sg13cmos5l_nand2_1_94 r0 *1 0,0
Xsg13cmos5l_nand2_1_94 \$8794 \$7913 VPWR VGND \$8793 sg13cmos5l_nand2_1
* cell instance sg13cmos5l_nand2_1_95 r0 *1 0,0
Xsg13cmos5l_nand2_1_95 \$9221 \$7913 VPWR VGND \$8883 sg13cmos5l_nand2_1
* cell instance sg13cmos5l_nand2_1_96 r0 *1 0,0
Xsg13cmos5l_nand2_1_96 \$415 \$2117 VPWR VGND \$650 sg13cmos5l_nand2_1
* cell instance sg13cmos5l_nand2_1_97 r0 *1 0,0
Xsg13cmos5l_nand2_1_97 \$2073 \$4873 VPWR VGND \$4905 sg13cmos5l_nand2_1
* cell instance sg13cmos5l_nand2_1_98 r0 *1 0,0
Xsg13cmos5l_nand2_1_98 \$14035 \$15079 VPWR VGND \$13840 sg13cmos5l_nand2_1
* cell instance sg13cmos5l_nand2_1_99 r0 *1 0,0
Xsg13cmos5l_nand2_1_99 \$11274 \$7913 VPWR VGND \$10780 sg13cmos5l_nand2_1
* cell instance sg13cmos5l_nand2_1_100 r0 *1 0,0
Xsg13cmos5l_nand2_1_100 \$79 \$36 VPWR VGND \$306 sg13cmos5l_nand2_1
* cell instance sg13cmos5l_nand2_1_101 r0 *1 0,0
Xsg13cmos5l_nand2_1_101 \$15076 \$19996 VPWR VGND \$20001 sg13cmos5l_nand2_1
* cell instance sg13cmos5l_nand2_1_102 r0 *1 0,0
Xsg13cmos5l_nand2_1_102 \$43 \$154 VPWR VGND \$660 sg13cmos5l_nand2_1
* cell instance sg13cmos5l_nand2_1_103 r0 *1 0,0
Xsg13cmos5l_nand2_1_103 \$525 \$937 VPWR VGND \$413 sg13cmos5l_nand2_1
* cell instance sg13cmos5l_nand2_1_104 r0 *1 0,0
Xsg13cmos5l_nand2_1_104 \$44 \$164 VPWR VGND \$415 sg13cmos5l_nand2_1
* cell instance sg13cmos5l_nand2_1_105 r0 *1 0,0
Xsg13cmos5l_nand2_1_105 \$65 \$306 VPWR VGND \$659 sg13cmos5l_nand2_1
* cell instance sg13cmos5l_nand2_1_106 r0 *1 0,0
Xsg13cmos5l_nand2_1_106 \$806 \$1189 VPWR VGND \$1894 sg13cmos5l_nand2_1
* cell instance sg13cmos5l_nand2_1_107 r0 *1 0,0
Xsg13cmos5l_nand2_1_107 \$15076 \$16691 VPWR VGND \$16014 sg13cmos5l_nand2_1
* cell instance sg13cmos5l_nand2_1_108 r0 *1 0,0
Xsg13cmos5l_nand2_1_108 \$7816 \$5745 VPWR VGND \$4909 sg13cmos5l_nand2_1
* cell instance sg13cmos5l_nand2_1_109 r0 *1 0,0
Xsg13cmos5l_nand2_1_109 \$19889 \$19423 VPWR VGND \$20000 sg13cmos5l_nand2_1
* cell instance sg13cmos5l_nand2_1_110 r0 *1 0,0
Xsg13cmos5l_nand2_1_110 \$1681 \$1894 VPWR VGND \$1795 sg13cmos5l_nand2_1
* cell instance sg13cmos5l_nand2_1_111 r0 *1 0,0
Xsg13cmos5l_nand2_1_111 \$14035 \$15080 VPWR VGND \$14043 sg13cmos5l_nand2_1
* cell instance sg13cmos5l_nand2_1_112 r0 *1 0,0
Xsg13cmos5l_nand2_1_112 \$20043 \$19890 VPWR VGND \$5702 sg13cmos5l_nand2_1
* cell instance sg13cmos5l_nand2_1_113 r0 *1 0,0
Xsg13cmos5l_nand2_1_113 \$3930 \$3230 VPWR VGND \$4097 sg13cmos5l_nand2_1
* cell instance sg13cmos5l_nand2_1_114 r0 *1 0,0
Xsg13cmos5l_nand2_1_114 \$3066 \$3014 VPWR VGND \$3762 sg13cmos5l_nand2_1
* cell instance sg13cmos5l_nand2_1_115 r0 *1 0,0
Xsg13cmos5l_nand2_1_115 \$43 \$646 VPWR VGND \$1079 sg13cmos5l_nand2_1
* cell instance sg13cmos5l_nand2_1_116 r0 *1 0,0
Xsg13cmos5l_nand2_1_116 \$44 \$36 VPWR VGND \$23 sg13cmos5l_nand2_1
* cell instance sg13cmos5l_nand2_1_117 r0 *1 0,0
Xsg13cmos5l_nand2_1_117 \$938 \$1173 VPWR VGND \$1650 sg13cmos5l_nand2_1
* cell instance sg13cmos5l_nand2_1_118 r0 *1 0,0
Xsg13cmos5l_nand2_1_118 \$274 \$1880 VPWR VGND \$2026 sg13cmos5l_nand2_1
* cell instance sg13cmos5l_nand2_1_119 r0 *1 0,0
Xsg13cmos5l_nand2_1_119 \$533 \$940 VPWR VGND \$1188 sg13cmos5l_nand2_1
* cell instance sg13cmos5l_nand2_1_120 r0 *1 0,0
Xsg13cmos5l_nand2_1_120 \$3939 \$4724 VPWR VGND \$4728 sg13cmos5l_nand2_1
* cell instance sg13cmos5l_nand2_1_121 r0 *1 0,0
Xsg13cmos5l_nand2_1_121 \$44 \$802 VPWR VGND \$539 sg13cmos5l_nand2_1
* cell instance sg13cmos5l_nand2_1_122 r0 *1 0,0
Xsg13cmos5l_nand2_1_122 \$290 \$91 VPWR VGND \$1441 sg13cmos5l_nand2_1
* cell instance sg13cmos5l_nand2_1_123 r0 *1 0,0
Xsg13cmos5l_nand2_1_123 \$20 \$1173 VPWR VGND \$1687 sg13cmos5l_nand2_1
* cell instance sg13cmos5l_nand2_1_124 r0 *1 0,0
Xsg13cmos5l_nand2_1_124 \$4919 \$5692 VPWR VGND \$4918 sg13cmos5l_nand2_1
* cell instance sg13cmos5l_nand2_1_125 r0 *1 0,0
Xsg13cmos5l_nand2_1_125 \$3708 \$3048 VPWR VGND \$4400 sg13cmos5l_nand2_1
* cell instance sg13cmos5l_nand2_1_126 r0 *1 0,0
Xsg13cmos5l_nand2_1_126 \$164 \$533 VPWR VGND \$807 sg13cmos5l_nand2_1
* cell instance sg13cmos5l_nand2_1_127 r0 *1 0,0
Xsg13cmos5l_nand2_1_127 \$4222 \$2056 VPWR VGND \$4547 sg13cmos5l_nand2_1
* cell instance sg13cmos5l_nand2_1_128 r0 *1 0,0
Xsg13cmos5l_nand2_1_128 \$1817 \$3009 VPWR VGND \$4549 sg13cmos5l_nand2_1
* cell instance sg13cmos5l_nand2_1_129 r0 *1 0,0
Xsg13cmos5l_nand2_1_129 \$646 \$290 VPWR VGND \$168 sg13cmos5l_nand2_1
* cell instance sg13cmos5l_nand2_1_130 r0 *1 0,0
Xsg13cmos5l_nand2_1_130 \$3052 \$3373 VPWR VGND \$3413 sg13cmos5l_nand2_1
* cell instance sg13cmos5l_nand2_1_131 r0 *1 0,0
Xsg13cmos5l_nand2_1_131 \$1817 \$3048 VPWR VGND \$4552 sg13cmos5l_nand2_1
* cell instance sg13cmos5l_nand2_1_132 r0 *1 0,0
Xsg13cmos5l_nand2_1_132 \$1165 \$3066 VPWR VGND \$3433 sg13cmos5l_nand2_1
* cell instance sg13cmos5l_nand2_1_133 r0 *1 0,0
Xsg13cmos5l_nand2_1_133 \$4065 \$3396 VPWR VGND \$4664 sg13cmos5l_nand2_1
* cell instance sg13cmos5l_nand2_1_134 r0 *1 0,0
Xsg13cmos5l_nand2_1_134 \$3614 \$1165 VPWR VGND \$3434 sg13cmos5l_nand2_1
* cell instance sg13cmos5l_nand2_1_135 r0 *1 0,0
Xsg13cmos5l_nand2_1_135 \$3129 \$4100 VPWR VGND \$4229 sg13cmos5l_nand2_1
* cell instance sg13cmos5l_nand2_1_136 r0 *1 0,0
Xsg13cmos5l_nand2_1_136 \$1801 \$68 VPWR VGND \$1537 sg13cmos5l_nand2_1
* cell instance sg13cmos5l_nand2_1_137 r0 *1 0,0
Xsg13cmos5l_nand2_1_137 \$3945 \$3939 VPWR VGND \$3950 sg13cmos5l_nand2_1
* cell instance sg13cmos5l_nand2_1_138 r0 *1 0,0
Xsg13cmos5l_nand2_1_138 \$1453 \$105 VPWR VGND \$1804 sg13cmos5l_nand2_1
* cell instance sg13cmos5l_nand2_1_139 r0 *1 0,0
Xsg13cmos5l_nand2_1_139 \$4234 \$3951 VPWR VGND \$4233 sg13cmos5l_nand2_1
* cell instance sg13cmos5l_nand2_1_140 r0 *1 0,0
Xsg13cmos5l_nand2_1_140 \$4734 \$4403 VPWR VGND \$4735 sg13cmos5l_nand2_1
* cell instance sg13cmos5l_nand2_1_141 r0 *1 0,0
Xsg13cmos5l_nand2_1_141 \$3615 \$4234 VPWR VGND \$4235 sg13cmos5l_nand2_1
* cell instance sg13cmos5l_nand2_1_142 r0 *1 0,0
Xsg13cmos5l_nand2_1_142 \$4561 \$3448 VPWR VGND \$4404 sg13cmos5l_nand2_1
* cell instance sg13cmos5l_nand2_1_143 r0 *1 0,0
Xsg13cmos5l_nand2_1_143 \$1306 \$1560 VPWR VGND \$1561 sg13cmos5l_nand2_1
* cell instance sg13cmos5l_nand2_1_144 r0 *1 0,0
Xsg13cmos5l_nand2_1_144 \$1805 \$1561 VPWR VGND \$1574 sg13cmos5l_nand2_1
* cell instance sg13cmos5l_nand2_1_145 r0 *1 0,0
Xsg13cmos5l_nand2_1_145 \$4237 \$4236 VPWR VGND \$3448 sg13cmos5l_nand2_1
* cell instance sg13cmos5l_nand2_1_146 r0 *1 0,0
Xsg13cmos5l_nand2_1_146 \$1067 \$1342 VPWR VGND \$1444 sg13cmos5l_nand2_1
* cell instance sg13cmos5l_nand2_1_147 r0 *1 0,0
Xsg13cmos5l_nand2_1_147 \$37 \$426 VPWR VGND \$1316 sg13cmos5l_nand2_1
* cell instance sg13cmos5l_nand2_1_148 r0 *1 0,0
Xsg13cmos5l_nand2_1_148 \$68 \$1073 VPWR VGND \$1810 sg13cmos5l_nand2_1
* cell instance sg13cmos5l_nand2_1_149 r0 *1 0,0
Xsg13cmos5l_nand2_1_149 \$4574 \$4242 VPWR VGND \$4573 sg13cmos5l_nand2_1
* cell instance sg13cmos5l_nand2_1_150 r0 *1 0,0
Xsg13cmos5l_nand2_1_150 \$2073 \$4562 VPWR VGND \$4747 sg13cmos5l_nand2_1
* cell instance sg13cmos5l_nand2_1_151 r0 *1 0,0
Xsg13cmos5l_nand2_1_151 \$4250 \$4241 VPWR VGND \$4242 sg13cmos5l_nand2_1
* cell instance sg13cmos5l_nand2_1_152 r0 *1 0,0
Xsg13cmos5l_nand2_1_152 \$1052 \$1695 VPWR VGND \$1809 sg13cmos5l_nand2_1
* cell instance sg13cmos5l_nand2_1_153 r0 *1 0,0
Xsg13cmos5l_nand2_1_153 \$7 \$175 VPWR VGND \$176 sg13cmos5l_nand2_1
* cell instance sg13cmos5l_nand2_1_154 r0 *1 0,0
Xsg13cmos5l_nand2_1_154 \$128 \$175 VPWR VGND \$545 sg13cmos5l_nand2_1
* cell instance sg13cmos5l_nand2_1_155 r0 *1 0,0
Xsg13cmos5l_nand2_1_155 \$1082 \$7 VPWR VGND \$108 sg13cmos5l_nand2_1
* cell instance sg13cmos5l_nand2_1_156 r0 *1 0,0
Xsg13cmos5l_nand2_1_156 \$1913 \$1905 VPWR VGND \$289 sg13cmos5l_nand2_1
* cell instance sg13cmos5l_nand2_1_157 r0 *1 0,0
Xsg13cmos5l_nand2_1_157 \$2890 \$819 VPWR VGND \$3096 sg13cmos5l_nand2_1
* cell instance sg13cmos5l_nand2_1_158 r0 *1 0,0
Xsg13cmos5l_nand2_1_158 \$1067 \$1343 VPWR VGND \$1448 sg13cmos5l_nand2_1
* cell instance sg13cmos5l_nand2_1_159 r0 *1 0,0
Xsg13cmos5l_nand2_1_159 \$2890 \$1879 VPWR VGND \$2974 sg13cmos5l_nand2_1
* cell instance sg13cmos5l_nand2_1_160 r0 *1 0,0
Xsg13cmos5l_nand2_1_160 \$119 \$50 VPWR VGND \$2556 sg13cmos5l_nand2_1
* cell instance sg13cmos5l_nand2_1_161 r0 *1 0,0
Xsg13cmos5l_nand2_1_161 \$521 \$283 VPWR VGND \$1701 sg13cmos5l_nand2_1
* cell instance sg13cmos5l_nand2_1_162 r0 *1 0,0
Xsg13cmos5l_nand2_1_162 \$119 \$1073 VPWR VGND \$1915 sg13cmos5l_nand2_1
* cell instance sg13cmos5l_nand2_1_163 r0 *1 0,0
Xsg13cmos5l_nand2_1_163 \$120 \$1344 VPWR VGND \$546 sg13cmos5l_nand2_1
* cell instance sg13cmos5l_nand2_1_164 r0 *1 0,0
Xsg13cmos5l_nand2_1_164 \$50 \$2707 VPWR VGND \$2035 sg13cmos5l_nand2_1
* cell instance sg13cmos5l_nand2_1_165 r0 *1 0,0
Xsg13cmos5l_nand2_1_165 \$38 \$1090 VPWR VGND \$956 sg13cmos5l_nand2_1
* cell instance sg13cmos5l_nand2_1_166 r0 *1 0,0
Xsg13cmos5l_nand2_1_166 \$2890 \$649 VPWR VGND \$2896 sg13cmos5l_nand2_1
* cell instance sg13cmos5l_nand2_1_167 r0 *1 0,0
Xsg13cmos5l_nand2_1_167 \$283 \$937 VPWR VGND \$1094 sg13cmos5l_nand2_1
* cell instance sg13cmos5l_nand2_1_168 r0 *1 0,0
Xsg13cmos5l_nand2_1_168 \$4967 \$5346 VPWR VGND \$4966 sg13cmos5l_nand2_1
* cell instance sg13cmos5l_nand2_1_169 r0 *1 0,0
Xsg13cmos5l_nand2_1_169 \$118 \$2890 VPWR VGND \$2976 sg13cmos5l_nand2_1
* cell instance sg13cmos5l_nand2_1_170 r0 *1 0,0
Xsg13cmos5l_nand2_1_170 \$2890 \$252 VPWR VGND \$3294 sg13cmos5l_nand2_1
* cell instance sg13cmos5l_nand2_1_171 r0 *1 0,0
Xsg13cmos5l_nand2_1_171 \$674 \$37 VPWR VGND \$669 sg13cmos5l_nand2_1
* cell instance sg13cmos5l_nand2_1_172 r0 *1 0,0
Xsg13cmos5l_nand2_1_172 \$2890 \$674 VPWR VGND \$2899 sg13cmos5l_nand2_1
* cell instance sg13cmos5l_nand2_1_173 r0 *1 0,0
Xsg13cmos5l_nand2_1_173 \$4972 \$4968 VPWR VGND \$4971 sg13cmos5l_nand2_1
* cell instance sg13cmos5l_nand2_1_174 r0 *1 0,0
Xsg13cmos5l_nand2_1_174 \$1096 \$1094 VPWR VGND \$675 sg13cmos5l_nand2_1
* cell instance sg13cmos5l_nand2_1_175 r0 *1 0,0
Xsg13cmos5l_nand2_1_175 \$674 \$1879 VPWR VGND \$1086 sg13cmos5l_nand2_1
* cell instance sg13cmos5l_nand2_1_176 r0 *1 0,0
Xsg13cmos5l_nand2_1_176 \$2890 \$120 VPWR VGND \$3476 sg13cmos5l_nand2_1
* cell instance sg13cmos5l_nand2_1_177 r0 *1 0,0
Xsg13cmos5l_nand2_1_177 \$4769 \$4968 VPWR VGND \$4768 sg13cmos5l_nand2_1
* cell instance sg13cmos5l_nand2_1_178 r0 *1 0,0
Xsg13cmos5l_nand2_1_178 \$2890 \$52 VPWR VGND \$2804 sg13cmos5l_nand2_1
* cell instance sg13cmos5l_nand2_1_179 r0 *1 0,0
Xsg13cmos5l_nand2_1_179 \$5396 \$4968 VPWR VGND \$5601 sg13cmos5l_nand2_1
* cell instance sg13cmos5l_nand2_1_180 r0 *1 0,0
Xsg13cmos5l_nand2_1_180 \$4980 \$5035 VPWR VGND \$4979 sg13cmos5l_nand2_1
* cell instance sg13cmos5l_nand2_1_181 r0 *1 0,0
Xsg13cmos5l_nand2_1_181 \$5375 \$4968 VPWR VGND \$5374 sg13cmos5l_nand2_1
* cell instance sg13cmos5l_nand2_1_182 r0 *1 0,0
Xsg13cmos5l_nand2_1_182 \$1471 \$3641 VPWR VGND \$3642 sg13cmos5l_nand2_1
* cell instance sg13cmos5l_nand2_1_183 r0 *1 0,0
Xsg13cmos5l_nand2_1_183 \$1067 \$1207 VPWR VGND \$1208 sg13cmos5l_nand2_1
* cell instance sg13cmos5l_nand2_1_184 r0 *1 0,0
Xsg13cmos5l_nand2_1_184 \$128 \$963 VPWR VGND \$964 sg13cmos5l_nand2_1
* cell instance sg13cmos5l_nand2_1_185 r0 *1 0,0
Xsg13cmos5l_nand2_1_185 \$547 \$117 VPWR VGND \$556 sg13cmos5l_nand2_1
* cell instance sg13cmos5l_nand2_1_186 r0 *1 0,0
Xsg13cmos5l_nand2_1_186 \$4769 \$4774 VPWR VGND \$4775 sg13cmos5l_nand2_1
* cell instance sg13cmos5l_nand2_1_187 r0 *1 0,0
Xsg13cmos5l_nand2_1_187 \$2432 \$2805 VPWR VGND \$3759 sg13cmos5l_nand2_1
* cell instance sg13cmos5l_nand2_1_188 r0 *1 0,0
Xsg13cmos5l_nand2_1_188 \$3133 \$2907 VPWR VGND \$3298 sg13cmos5l_nand2_1
* cell instance sg13cmos5l_nand2_1_189 r0 *1 0,0
Xsg13cmos5l_nand2_1_189 \$119 \$688 VPWR VGND \$132 sg13cmos5l_nand2_1
* cell instance sg13cmos5l_nand2_1_190 r0 *1 0,0
Xsg13cmos5l_nand2_1_190 \$118 \$52 VPWR VGND \$48 sg13cmos5l_nand2_1
* cell instance sg13cmos5l_nand2_1_191 r0 *1 0,0
Xsg13cmos5l_nand2_1_191 \$38 \$1194 VPWR VGND \$1096 sg13cmos5l_nand2_1
* cell instance sg13cmos5l_nand2_1_192 r0 *1 0,0
Xsg13cmos5l_nand2_1_192 \$118 \$688 VPWR VGND \$672 sg13cmos5l_nand2_1
* cell instance sg13cmos5l_nand2_1_193 r0 *1 0,0
Xsg13cmos5l_nand2_1_193 \$1913 \$116 VPWR VGND \$561 sg13cmos5l_nand2_1
* cell instance sg13cmos5l_nand2_1_194 r0 *1 0,0
Xsg13cmos5l_nand2_1_194 \$5392 \$5035 VPWR VGND \$5391 sg13cmos5l_nand2_1
* cell instance sg13cmos5l_nand2_1_195 r0 *1 0,0
Xsg13cmos5l_nand2_1_195 \$2432 \$2436 VPWR VGND \$2437 sg13cmos5l_nand2_1
* cell instance sg13cmos5l_nand2_1_196 r0 *1 0,0
Xsg13cmos5l_nand2_1_196 \$48 \$446 VPWR VGND \$442 sg13cmos5l_nand2_1
* cell instance sg13cmos5l_nand2_1_197 r0 *1 0,0
Xsg13cmos5l_nand2_1_197 \$2291 \$2755 VPWR VGND \$2902 sg13cmos5l_nand2_1
* cell instance sg13cmos5l_nand2_1_198 r0 *1 0,0
Xsg13cmos5l_nand2_1_198 \$2435 \$2755 VPWR VGND \$2580 sg13cmos5l_nand2_1
* cell instance sg13cmos5l_nand2_1_199 r0 *1 0,0
Xsg13cmos5l_nand2_1_199 \$561 \$1073 VPWR VGND \$560 sg13cmos5l_nand2_1
* cell instance sg13cmos5l_nand2_1_200 r0 *1 0,0
Xsg13cmos5l_nand2_1_200 \$3982 \$3977 VPWR VGND \$3981 sg13cmos5l_nand2_1
* cell instance sg13cmos5l_nand2_1_201 r0 *1 0,0
Xsg13cmos5l_nand2_1_201 \$4988 \$4774 VPWR VGND \$4992 sg13cmos5l_nand2_1
* cell instance sg13cmos5l_nand2_1_202 r0 *1 0,0
Xsg13cmos5l_nand2_1_202 \$38 \$134 VPWR VGND \$32 sg13cmos5l_nand2_1
* cell instance sg13cmos5l_nand2_1_203 r0 *1 0,0
Xsg13cmos5l_nand2_1_203 \$3441 \$3644 VPWR VGND \$2053 sg13cmos5l_nand2_1
* cell instance sg13cmos5l_nand2_1_204 r0 *1 0,0
Xsg13cmos5l_nand2_1_204 \$1356 \$1108 VPWR VGND \$1358 sg13cmos5l_nand2_1
* cell instance sg13cmos5l_nand2_1_205 r0 *1 0,0
Xsg13cmos5l_nand2_1_205 \$2437 \$2439 VPWR VGND \$2431 sg13cmos5l_nand2_1
* cell instance sg13cmos5l_nand2_1_206 r0 *1 0,0
Xsg13cmos5l_nand2_1_206 \$2805 \$2108 VPWR VGND \$1368 sg13cmos5l_nand2_1
* cell instance sg13cmos5l_nand2_1_207 r0 *1 0,0
Xsg13cmos5l_nand2_1_207 \$2805 \$3134 VPWR VGND \$3135 sg13cmos5l_nand2_1
* cell instance sg13cmos5l_nand2_1_208 r0 *1 0,0
Xsg13cmos5l_nand2_1_208 \$5646 \$4407 VPWR VGND \$4334 sg13cmos5l_nand2_1
* cell instance sg13cmos5l_nand2_1_209 r0 *1 0,0
Xsg13cmos5l_nand2_1_209 \$1361 \$1108 VPWR VGND \$1303 sg13cmos5l_nand2_1
* cell instance sg13cmos5l_nand2_1_210 r0 *1 0,0
Xsg13cmos5l_nand2_1_210 \$2156 \$2288 VPWR VGND \$2162 sg13cmos5l_nand2_1
* cell instance sg13cmos5l_nand2_1_211 r0 *1 0,0
Xsg13cmos5l_nand2_1_211 \$4236 \$4334 VPWR VGND \$4272 sg13cmos5l_nand2_1
* cell instance sg13cmos5l_nand2_1_212 r0 *1 0,0
Xsg13cmos5l_nand2_1_212 \$3135 \$3136 VPWR VGND \$2588 sg13cmos5l_nand2_1
* cell instance sg13cmos5l_nand2_1_213 r0 *1 0,0
Xsg13cmos5l_nand2_1_213 \$2440 \$2108 VPWR VGND \$1231 sg13cmos5l_nand2_1
* cell instance sg13cmos5l_nand2_1_214 r0 *1 0,0
Xsg13cmos5l_nand2_1_214 \$2908 \$3300 VPWR VGND \$2586 sg13cmos5l_nand2_1
* cell instance sg13cmos5l_nand2_1_215 r0 *1 0,0
Xsg13cmos5l_nand2_1_215 \$3129 \$2588 VPWR VGND \$3377 sg13cmos5l_nand2_1
* cell instance sg13cmos5l_nand2_1_216 r0 *1 0,0
Xsg13cmos5l_nand2_1_216 \$3133 \$3300 VPWR VGND \$3136 sg13cmos5l_nand2_1
* cell instance sg13cmos5l_nand2_1_217 r0 *1 0,0
Xsg13cmos5l_nand2_1_217 \$4288 \$4618 VPWR VGND \$4617 sg13cmos5l_nand2_1
* cell instance sg13cmos5l_nand2_1_218 r0 *1 0,0
Xsg13cmos5l_nand2_1_218 \$4127 \$4129 VPWR VGND \$4126 sg13cmos5l_nand2_1
* cell instance sg13cmos5l_nand2_1_219 r0 *1 0,0
Xsg13cmos5l_nand2_1_219 \$4129 \$3313 VPWR VGND \$4128 sg13cmos5l_nand2_1
* cell instance sg13cmos5l_nand2_1_220 r0 *1 0,0
Xsg13cmos5l_nand2_1_220 \$4130 \$4128 VPWR VGND \$4131 sg13cmos5l_nand2_1
* cell instance sg13cmos5l_nand2_1_221 r0 *1 0,0
Xsg13cmos5l_nand2_1_221 \$981 \$787 VPWR VGND \$984 sg13cmos5l_nand2_1
* cell instance sg13cmos5l_nand2_1_222 r0 *1 0,0
Xsg13cmos5l_nand2_1_222 \$4288 \$4274 VPWR VGND \$4285 sg13cmos5l_nand2_1
* cell instance sg13cmos5l_nand2_1_223 r0 *1 0,0
Xsg13cmos5l_nand2_1_223 \$564 \$454 VPWR VGND \$577 sg13cmos5l_nand2_1
* cell instance sg13cmos5l_nand2_1_224 r0 *1 0,0
Xsg13cmos5l_nand2_1_224 \$2650 \$2067 VPWR VGND \$2913 sg13cmos5l_nand2_1
* cell instance sg13cmos5l_nand2_1_225 r0 *1 0,0
Xsg13cmos5l_nand2_1_225 \$458 \$340 VPWR VGND \$396 sg13cmos5l_nand2_1
* cell instance sg13cmos5l_nand2_1_226 r0 *1 0,0
Xsg13cmos5l_nand2_1_226 \$4130 \$4126 VPWR VGND \$3649 sg13cmos5l_nand2_1
* cell instance sg13cmos5l_nand2_1_227 r0 *1 0,0
Xsg13cmos5l_nand2_1_227 \$1367 \$1355 VPWR VGND \$1366 sg13cmos5l_nand2_1
* cell instance sg13cmos5l_nand2_1_228 r0 *1 0,0
Xsg13cmos5l_nand2_1_228 \$2156 \$2906 VPWR VGND \$3142 sg13cmos5l_nand2_1
* cell instance sg13cmos5l_nand2_1_229 r0 *1 0,0
Xsg13cmos5l_nand2_1_229 \$4685 \$4466 VPWR VGND \$5216 sg13cmos5l_nand2_1
* cell instance sg13cmos5l_nand2_1_230 r0 *1 0,0
Xsg13cmos5l_nand2_1_230 \$458 \$140 VPWR VGND \$141 sg13cmos5l_nand2_1
* cell instance sg13cmos5l_nand2_1_231 r0 *1 0,0
Xsg13cmos5l_nand2_1_231 \$458 \$201 VPWR VGND \$202 sg13cmos5l_nand2_1
* cell instance sg13cmos5l_nand2_1_232 r0 *1 0,0
Xsg13cmos5l_nand2_1_232 \$1825 \$1948 VPWR VGND \$1728 sg13cmos5l_nand2_1
* cell instance sg13cmos5l_nand2_1_233 r0 *1 0,0
Xsg13cmos5l_nand2_1_233 \$2361 \$2173 VPWR VGND \$2297 sg13cmos5l_nand2_1
* cell instance sg13cmos5l_nand2_1_234 r0 *1 0,0
Xsg13cmos5l_nand2_1_234 \$1832 \$1944 VPWR VGND \$1949 sg13cmos5l_nand2_1
* cell instance sg13cmos5l_nand2_1_235 r0 *1 0,0
Xsg13cmos5l_nand2_1_235 \$4139 \$4444 VPWR VGND \$4683 sg13cmos5l_nand2_1
* cell instance sg13cmos5l_nand2_1_236 r0 *1 0,0
Xsg13cmos5l_nand2_1_236 \$1247 \$921 VPWR VGND \$1246 sg13cmos5l_nand2_1
* cell instance sg13cmos5l_nand2_1_237 r0 *1 0,0
Xsg13cmos5l_nand2_1_237 \$1494 \$921 VPWR VGND \$1492 sg13cmos5l_nand2_1
* cell instance sg13cmos5l_nand2_1_238 r0 *1 0,0
Xsg13cmos5l_nand2_1_238 \$2180 \$1964 VPWR VGND \$2364 sg13cmos5l_nand2_1
* cell instance sg13cmos5l_nand2_1_239 r0 *1 0,0
Xsg13cmos5l_nand2_1_239 \$1477 \$1245 VPWR VGND \$1498 sg13cmos5l_nand2_1
* cell instance sg13cmos5l_nand2_1_240 r0 *1 0,0
Xsg13cmos5l_nand2_1_240 \$4007 \$2929 VPWR VGND \$4623 sg13cmos5l_nand2_1
* cell instance sg13cmos5l_nand2_1_241 r0 *1 0,0
Xsg13cmos5l_nand2_1_241 \$7989 \$7988 VPWR VGND \$3837 sg13cmos5l_nand2_1
* cell instance sg13cmos5l_nand2_1_242 r0 *1 0,0
Xsg13cmos5l_nand2_1_242 \$8236 \$7988 VPWR VGND \$4142 sg13cmos5l_nand2_1
* cell instance sg13cmos5l_nand2_1_243 r0 *1 0,0
Xsg13cmos5l_nand2_1_243 \$4618 \$5421 VPWR VGND \$5423 sg13cmos5l_nand2_1
* cell instance sg13cmos5l_nand2_1_244 r0 *1 0,0
Xsg13cmos5l_nand2_1_244 \$19561 \$16322 VPWR VGND \$5791 sg13cmos5l_nand2_1
* cell instance sg13cmos5l_nand2_1_245 r0 *1 0,0
Xsg13cmos5l_nand2_1_245 \$4304 \$3166 VPWR VGND \$4820 sg13cmos5l_nand2_1
* cell instance sg13cmos5l_nand2_1_246 r0 *1 0,0
Xsg13cmos5l_nand2_1_246 \$4815 \$5223 VPWR VGND \$4130 sg13cmos5l_nand2_1
* cell instance sg13cmos5l_nand2_1_247 r0 *1 0,0
Xsg13cmos5l_nand2_1_247 \$4629 \$4008 VPWR VGND \$4805 sg13cmos5l_nand2_1
* cell instance sg13cmos5l_nand2_1_248 r0 *1 0,0
Xsg13cmos5l_nand2_1_248 \$14831 \$15718 VPWR VGND \$15212 sg13cmos5l_nand2_1
* cell instance sg13cmos5l_nand2_1_249 r0 *1 0,0
Xsg13cmos5l_nand2_1_249 \$1471 \$1008 VPWR VGND \$1597 sg13cmos5l_nand2_1
* cell instance sg13cmos5l_nand2_1_250 r0 *1 0,0
Xsg13cmos5l_nand2_1_250 \$8502 \$7988 VPWR VGND \$3832 sg13cmos5l_nand2_1
* cell instance sg13cmos5l_nand2_1_251 r0 *1 0,0
Xsg13cmos5l_nand2_1_251 \$1367 \$1459 VPWR VGND \$1836 sg13cmos5l_nand2_1
* cell instance sg13cmos5l_nand2_1_252 r0 *1 0,0
Xsg13cmos5l_nand2_1_252 \$8503 \$7988 VPWR VGND \$7063 sg13cmos5l_nand2_1
* cell instance sg13cmos5l_nand2_1_253 r0 *1 0,0
Xsg13cmos5l_nand2_1_253 \$1256 \$1001 VPWR VGND \$2448 sg13cmos5l_nand2_1
* cell instance sg13cmos5l_nand2_1_254 r0 *1 0,0
Xsg13cmos5l_nand2_1_254 \$5224 \$4157 VPWR VGND \$4442 sg13cmos5l_nand2_1
* cell instance sg13cmos5l_nand2_1_255 r0 *1 0,0
Xsg13cmos5l_nand2_1_255 \$7991 \$7988 VPWR VGND \$3339 sg13cmos5l_nand2_1
* cell instance sg13cmos5l_nand2_1_256 r0 *1 0,0
Xsg13cmos5l_nand2_1_256 \$8504 \$7988 VPWR VGND \$6419 sg13cmos5l_nand2_1
* cell instance sg13cmos5l_nand2_1_257 r0 *1 0,0
Xsg13cmos5l_nand2_1_257 \$398 \$201 VPWR VGND \$608 sg13cmos5l_nand2_1
* cell instance sg13cmos5l_nand2_1_258 r0 *1 0,0
Xsg13cmos5l_nand2_1_258 \$4424 \$3313 VPWR VGND \$4490 sg13cmos5l_nand2_1
* cell instance sg13cmos5l_nand2_1_259 r0 *1 0,0
Xsg13cmos5l_nand2_1_259 \$9788 \$7988 VPWR VGND \$4299 sg13cmos5l_nand2_1
* cell instance sg13cmos5l_nand2_1_260 r0 *1 0,0
Xsg13cmos5l_nand2_1_260 \$14190 \$7958 VPWR VGND \$6584 sg13cmos5l_nand2_1
* cell instance sg13cmos5l_nand2_1_261 r0 *1 0,0
Xsg13cmos5l_nand2_1_261 \$4821 \$4490 VPWR VGND \$1881 sg13cmos5l_nand2_1
* cell instance sg13cmos5l_nand2_1_262 r0 *1 0,0
Xsg13cmos5l_nand2_1_262 \$7992 \$7988 VPWR VGND \$7656 sg13cmos5l_nand2_1
* cell instance sg13cmos5l_nand2_1_263 r0 *1 0,0
Xsg13cmos5l_nand2_1_263 \$8801 \$8225 VPWR VGND \$5663 sg13cmos5l_nand2_1
* cell instance sg13cmos5l_nand2_1_264 r0 *1 0,0
Xsg13cmos5l_nand2_1_264 \$7993 \$7958 VPWR VGND \$3162 sg13cmos5l_nand2_1
* cell instance sg13cmos5l_nand2_1_265 r0 *1 0,0
Xsg13cmos5l_nand2_1_265 \$7994 \$7958 VPWR VGND \$4491 sg13cmos5l_nand2_1
* cell instance sg13cmos5l_nand2_1_266 r0 *1 0,0
Xsg13cmos5l_nand2_1_266 \$3835 \$4825 VPWR VGND \$4302 sg13cmos5l_nand2_1
* cell instance sg13cmos5l_nand2_1_267 r0 *1 0,0
Xsg13cmos5l_nand2_1_267 \$9627 \$7958 VPWR VGND \$7353 sg13cmos5l_nand2_1
* cell instance sg13cmos5l_nand2_1_268 r0 *1 0,0
Xsg13cmos5l_nand2_1_268 \$9369 \$7958 VPWR VGND \$2940 sg13cmos5l_nand2_1
* cell instance sg13cmos5l_nand2_1_269 r0 *1 0,0
Xsg13cmos5l_nand2_1_269 \$7871 \$8225 VPWR VGND \$5860 sg13cmos5l_nand2_1
* cell instance sg13cmos5l_nand2_1_270 r0 *1 0,0
Xsg13cmos5l_nand2_1_270 \$2081 \$1622 VPWR VGND \$2082 sg13cmos5l_nand2_1
* cell instance sg13cmos5l_nand2_1_271 r0 *1 0,0
Xsg13cmos5l_nand2_1_271 \$2941 \$2929 VPWR VGND \$2936 sg13cmos5l_nand2_1
* cell instance sg13cmos5l_nand2_1_272 r0 *1 0,0
Xsg13cmos5l_nand2_1_272 \$7872 \$7958 VPWR VGND \$7664 sg13cmos5l_nand2_1
* cell instance sg13cmos5l_nand2_1_273 r0 *1 0,0
Xsg13cmos5l_nand2_1_273 \$8510 \$7958 VPWR VGND \$4167 sg13cmos5l_nand2_1
* cell instance sg13cmos5l_nand2_1_274 r0 *1 0,0
Xsg13cmos5l_nand2_1_274 \$5448 \$5672 VPWR VGND \$5416 sg13cmos5l_nand2_1
* cell instance sg13cmos5l_nand2_1_275 r0 *1 0,0
Xsg13cmos5l_nand2_1_275 \$8511 \$8202 VPWR VGND \$2781 sg13cmos5l_nand2_1
* cell instance sg13cmos5l_nand2_1_276 r0 *1 0,0
Xsg13cmos5l_nand2_1_276 \$8238 \$8202 VPWR VGND \$7874 sg13cmos5l_nand2_1
* cell instance sg13cmos5l_nand2_1_277 r0 *1 0,0
Xsg13cmos5l_nand2_1_277 \$8512 \$8202 VPWR VGND \$6314 sg13cmos5l_nand2_1
* cell instance sg13cmos5l_nand2_1_278 r0 *1 0,0
Xsg13cmos5l_nand2_1_278 \$9373 \$8202 VPWR VGND \$3723 sg13cmos5l_nand2_1
* cell instance sg13cmos5l_nand2_1_279 r0 *1 0,0
Xsg13cmos5l_nand2_1_279 \$5677 \$5676 VPWR VGND \$5639 sg13cmos5l_nand2_1
* cell instance sg13cmos5l_nand2_1_280 r0 *1 0,0
Xsg13cmos5l_nand2_1_280 \$8513 \$8202 VPWR VGND \$7079 sg13cmos5l_nand2_1
* cell instance sg13cmos5l_nand2_1_281 r0 *1 0,0
Xsg13cmos5l_nand2_1_281 \$4637 \$6054 VPWR VGND \$5648 sg13cmos5l_nand2_1
* cell instance sg13cmos5l_nand2_1_282 r0 *1 0,0
Xsg13cmos5l_nand2_1_282 \$4306 \$4834 VPWR VGND \$5008 sg13cmos5l_nand2_1
* cell instance sg13cmos5l_nand2_1_283 r0 *1 0,0
Xsg13cmos5l_nand2_1_283 \$8809 \$7997 VPWR VGND \$4640 sg13cmos5l_nand2_1
* cell instance sg13cmos5l_nand2_1_284 r0 *1 0,0
Xsg13cmos5l_nand2_1_284 \$7998 \$7997 VPWR VGND \$3874 sg13cmos5l_nand2_1
* cell instance sg13cmos5l_nand2_1_285 r0 *1 0,0
Xsg13cmos5l_nand2_1_285 \$8514 \$7997 VPWR VGND \$3362 sg13cmos5l_nand2_1
* cell instance sg13cmos5l_nand2_1_286 r0 *1 0,0
Xsg13cmos5l_nand2_1_286 \$8515 \$7997 VPWR VGND \$6323 sg13cmos5l_nand2_1
* cell instance sg13cmos5l_nand2_1_287 r0 *1 0,0
Xsg13cmos5l_nand2_1_287 \$3865 \$4317 VPWR VGND \$4301 sg13cmos5l_nand2_1
* cell instance sg13cmos5l_nand2_1_288 r0 *1 0,0
Xsg13cmos5l_nand2_1_288 \$8241 \$7997 VPWR VGND \$5246 sg13cmos5l_nand2_1
* cell instance sg13cmos5l_nand2_1_289 r0 *1 0,0
Xsg13cmos5l_nand2_1_289 \$8242 \$7997 VPWR VGND \$4647 sg13cmos5l_nand2_1
* cell instance sg13cmos5l_nand2_1_290 r0 *1 0,0
Xsg13cmos5l_nand2_1_290 \$8516 \$8202 VPWR VGND \$7094 sg13cmos5l_nand2_1
* cell instance sg13cmos5l_nand2_1_291 r0 *1 0,0
Xsg13cmos5l_nand2_1_291 \$11411 \$7997 VPWR VGND \$5886 sg13cmos5l_nand2_1
* cell instance sg13cmos5l_nand2_1_292 r0 *1 0,0
Xsg13cmos5l_nand2_1_292 \$9205 \$7997 VPWR VGND \$4040 sg13cmos5l_nand2_1
* cell instance sg13cmos5l_nand2_1_293 r0 *1 0,0
Xsg13cmos5l_nand2_1_293 \$8400 \$8202 VPWR VGND \$8001 sg13cmos5l_nand2_1
* cell instance sg13cmos5l_nand2b_1_0 r0 *1 0,0
Xsg13cmos5l_nand2b_1_0 \$4874 \$5291 VPWR VGND \$5482 sg13cmos5l_nand2b_1
* cell instance sg13cmos5l_nand2b_1_1 r0 *1 0,0
Xsg13cmos5l_nand2b_1_1 \$5300 \$5295 VPWR VGND \$5291 sg13cmos5l_nand2b_1
* cell instance sg13cmos5l_nand2b_1_2 r0 *1 0,0
Xsg13cmos5l_nand2b_1_2 \$4091 \$4089 VPWR VGND \$4085 sg13cmos5l_nand2b_1
* cell instance sg13cmos5l_nand2b_1_3 r0 *1 0,0
Xsg13cmos5l_nand2b_1_3 \$19 \$261 VPWR VGND \$73 sg13cmos5l_nand2b_1
* cell instance sg13cmos5l_nand2b_1_4 r0 *1 0,0
Xsg13cmos5l_nand2b_1_4 \$3230 \$3756 VPWR VGND \$3704 sg13cmos5l_nand2b_1
* cell instance sg13cmos5l_nand2b_1_5 r0 *1 0,0
Xsg13cmos5l_nand2b_1_5 \$3399 \$2691 VPWR VGND \$2692 sg13cmos5l_nand2b_1
* cell instance sg13cmos5l_nand2b_1_6 r0 *1 0,0
Xsg13cmos5l_nand2b_1_6 \$19997 \$5702 VPWR VGND \$17695 sg13cmos5l_nand2b_1
* cell instance sg13cmos5l_nand2b_1_7 r0 *1 0,0
Xsg13cmos5l_nand2b_1_7 \$2694 \$2691 VPWR VGND \$2696 sg13cmos5l_nand2b_1
* cell instance sg13cmos5l_nand2b_1_8 r0 *1 0,0
Xsg13cmos5l_nand2b_1_8 \$2 \$963 VPWR VGND \$2125 sg13cmos5l_nand2b_1
* cell instance sg13cmos5l_nand2b_1_9 r0 *1 0,0
Xsg13cmos5l_nand2b_1_9 \$3248 \$5702 VPWR VGND \$5322 sg13cmos5l_nand2b_1
* cell instance sg13cmos5l_nand2b_1_10 r0 *1 0,0
Xsg13cmos5l_nand2b_1_10 \$117 \$806 VPWR VGND \$1439 sg13cmos5l_nand2b_1
* cell instance sg13cmos5l_nand2b_1_11 r0 *1 0,0
Xsg13cmos5l_nand2b_1_11 \$25 \$1 VPWR VGND \$96 sg13cmos5l_nand2b_1
* cell instance sg13cmos5l_nand2b_1_12 r0 *1 0,0
Xsg13cmos5l_nand2b_1_12 \$20160 \$5469 VPWR VGND \$20065 sg13cmos5l_nand2b_1
* cell instance sg13cmos5l_nand2b_1_13 r0 *1 0,0
Xsg13cmos5l_nand2b_1_13 \$3437 \$3436 VPWR VGND \$3255 sg13cmos5l_nand2b_1
* cell instance sg13cmos5l_nand2b_1_14 r0 *1 0,0
Xsg13cmos5l_nand2b_1_14 \$5579 \$5568 VPWR VGND \$5581 sg13cmos5l_nand2b_1
* cell instance sg13cmos5l_nand2b_1_15 r0 *1 0,0
Xsg13cmos5l_nand2b_1_15 \$1344 \$963 VPWR VGND \$1422 sg13cmos5l_nand2b_1
* cell instance sg13cmos5l_nand2b_1_16 r0 *1 0,0
Xsg13cmos5l_nand2b_1_16 \$3298 \$2805 VPWR VGND \$2835 sg13cmos5l_nand2b_1
* cell instance sg13cmos5l_nand2b_1_17 r0 *1 0,0
Xsg13cmos5l_nand2b_1_17 \$3705 \$2073 VPWR VGND \$3800 sg13cmos5l_nand2b_1
* cell instance sg13cmos5l_nand2b_1_18 r0 *1 0,0
Xsg13cmos5l_nand2b_1_18 \$1357 \$1358 VPWR VGND \$1473 sg13cmos5l_nand2b_1
* cell instance sg13cmos5l_nand2b_1_19 r0 *1 0,0
Xsg13cmos5l_nand2b_1_19 \$313 \$185 VPWR VGND \$390 sg13cmos5l_nand2b_1
* cell instance sg13cmos5l_nand2b_1_20 r0 *1 0,0
Xsg13cmos5l_nand2b_1_20 \$2580 \$2108 VPWR VGND \$1833 sg13cmos5l_nand2b_1
* cell instance sg13cmos5l_nand2b_1_21 r0 *1 0,0
Xsg13cmos5l_nand2b_1_21 \$1108 \$1356 VPWR VGND \$1166 sg13cmos5l_nand2b_1
* cell instance sg13cmos5l_nand2b_1_22 r0 *1 0,0
Xsg13cmos5l_nand2b_1_22 \$2977 \$3804 VPWR VGND \$4125 sg13cmos5l_nand2b_1
* cell instance sg13cmos5l_nand2b_1_23 r0 *1 0,0
Xsg13cmos5l_nand2b_1_23 \$1584 \$1236 VPWR VGND \$1479 sg13cmos5l_nand2b_1
* cell instance sg13cmos5l_nand2b_1_24 r0 *1 0,0
Xsg13cmos5l_nand2b_1_24 \$565 \$853 VPWR VGND \$919 sg13cmos5l_nand2b_1
* cell instance sg13cmos5l_nand2b_1_25 r0 *1 0,0
Xsg13cmos5l_nand2b_1_25 \$853 \$567 VPWR VGND \$983 sg13cmos5l_nand2b_1
* cell instance sg13cmos5l_nand2b_1_26 r0 *1 0,0
Xsg13cmos5l_nand2b_1_26 \$2294 \$2297 VPWR VGND \$2295 sg13cmos5l_nand2b_1
* cell instance sg13cmos5l_nand2b_1_27 r0 *1 0,0
Xsg13cmos5l_nand2b_1_27 \$4139 \$4004 VPWR VGND \$4293 sg13cmos5l_nand2b_1
* cell instance sg13cmos5l_nand2b_1_28 r0 *1 0,0
Xsg13cmos5l_nand2b_1_28 \$2069 \$2364 VPWR VGND \$2302 sg13cmos5l_nand2b_1
* cell instance sg13cmos5l_nand2b_1_29 r0 *1 0,0
Xsg13cmos5l_nand2b_1_29 \$1964 \$2180 VPWR VGND \$2597 sg13cmos5l_nand2b_1
* cell instance sg13cmos5l_nand2b_1_30 r0 *1 0,0
Xsg13cmos5l_nand2b_1_30 \$2174 \$2448 VPWR VGND \$2762 sg13cmos5l_nand2b_1
* cell instance sg13cmos5l_nand2b_1_31 r0 *1 0,0
Xsg13cmos5l_nand2b_1_31 \$20108 \$20062 VPWR VGND \$20109 sg13cmos5l_nand2b_1
* cell instance sg13cmos5l_nand2b_1_32 r0 *1 0,0
Xsg13cmos5l_nand2b_1_32 \$3313 \$2929 VPWR VGND \$3341 sg13cmos5l_nand2b_1
* cell instance sg13cmos5l_nand3_1_0 r0 *1 0,0
Xsg13cmos5l_nand3_1_0 \$1882 \$79 \$285 VPWR VGND \$1430 sg13cmos5l_nand3_1
* cell instance sg13cmos5l_nand3_1_1 r0 *1 0,0
Xsg13cmos5l_nand3_1_1 \$1052 \$1173 \$1430 VPWR VGND \$1174 sg13cmos5l_nand3_1
* cell instance sg13cmos5l_nand3_1_2 r0 *1 0,0
Xsg13cmos5l_nand3_1_2 \$5047 \$5286 \$5897 VPWR VGND \$5480 sg13cmos5l_nand3_1
* cell instance sg13cmos5l_nand3_1_3 r0 *1 0,0
Xsg13cmos5l_nand3_1_3 \$2670 \$2383 \$2233 VPWR VGND \$2996 sg13cmos5l_nand3_1
* cell instance sg13cmos5l_nand3_1_4 r0 *1 0,0
Xsg13cmos5l_nand3_1_4 \$1176 \$1175 \$1174 VPWR VGND \$926 sg13cmos5l_nand3_1
* cell instance sg13cmos5l_nand3_1_5 r0 *1 0,0
Xsg13cmos5l_nand3_1_5 \$153 \$258 \$152 VPWR VGND \$150 sg13cmos5l_nand3_1
* cell instance sg13cmos5l_nand3_1_6 r0 *1 0,0
Xsg13cmos5l_nand3_1_6 \$3914 \$3913 \$3911 VPWR VGND \$3912 sg13cmos5l_nand3_1
* cell instance sg13cmos5l_nand3_1_7 r0 *1 0,0
Xsg13cmos5l_nand3_1_7 \$1882 \$1433 \$796 VPWR VGND \$1546 sg13cmos5l_nand3_1
* cell instance sg13cmos5l_nand3_1_8 r0 *1 0,0
Xsg13cmos5l_nand3_1_8 \$3002 \$3000 \$3001 VPWR VGND \$2509 sg13cmos5l_nand3_1
* cell instance sg13cmos5l_nand3_1_9 r0 *1 0,0
Xsg13cmos5l_nand3_1_9 \$3224 \$3223 \$3221 VPWR VGND \$3222 sg13cmos5l_nand3_1
* cell instance sg13cmos5l_nand3_1_10 r0 *1 0,0
Xsg13cmos5l_nand3_1_10 \$65 \$66 \$796 VPWR VGND \$797 sg13cmos5l_nand3_1
* cell instance sg13cmos5l_nand3_1_11 r0 *1 0,0
Xsg13cmos5l_nand3_1_11 \$4087 \$4084 \$4088 VPWR VGND \$4089 sg13cmos5l_nand3_1
* cell instance sg13cmos5l_nand3_1_12 r0 *1 0,0
Xsg13cmos5l_nand3_1_12 \$1671 \$1667 \$1669 VPWR VGND \$1670 sg13cmos5l_nand3_1
* cell instance sg13cmos5l_nand3_1_13 r0 *1 0,0
Xsg13cmos5l_nand3_1_13 \$3597 \$3596 \$3594 VPWR VGND \$3595 sg13cmos5l_nand3_1
* cell instance sg13cmos5l_nand3_1_14 r0 *1 0,0
Xsg13cmos5l_nand3_1_14 \$2824 \$3005 \$2823 VPWR VGND \$2682 sg13cmos5l_nand3_1
* cell instance sg13cmos5l_nand3_1_15 r0 *1 0,0
Xsg13cmos5l_nand3_1_15 \$1882 \$664 \$1433 VPWR VGND \$1887 sg13cmos5l_nand3_1
* cell instance sg13cmos5l_nand3_1_16 r0 *1 0,0
Xsg13cmos5l_nand3_1_16 \$3216 \$3399 \$3392 VPWR VGND \$3022 sg13cmos5l_nand3_1
* cell instance sg13cmos5l_nand3_1_17 r0 *1 0,0
Xsg13cmos5l_nand3_1_17 \$20036 \$20084 \$20078 VPWR VGND \$20083
+ sg13cmos5l_nand3_1
* cell instance sg13cmos5l_nand3_1_18 r0 *1 0,0
Xsg13cmos5l_nand3_1_18 \$4521 \$4203 \$4208 VPWR VGND \$3230 sg13cmos5l_nand3_1
* cell instance sg13cmos5l_nand3_1_19 r0 *1 0,0
Xsg13cmos5l_nand3_1_19 \$20043 \$20042 \$19996 VPWR VGND \$19970
+ sg13cmos5l_nand3_1
* cell instance sg13cmos5l_nand3_1_20 r0 *1 0,0
Xsg13cmos5l_nand3_1_20 \$73 \$76 \$74 VPWR VGND \$75 sg13cmos5l_nand3_1
* cell instance sg13cmos5l_nand3_1_21 r0 *1 0,0
Xsg13cmos5l_nand3_1_21 \$646 \$1546 \$683 VPWR VGND \$2022 sg13cmos5l_nand3_1
* cell instance sg13cmos5l_nand3_1_22 r0 *1 0,0
Xsg13cmos5l_nand3_1_22 \$2510 \$2693 \$2692 VPWR VGND \$2520 sg13cmos5l_nand3_1
* cell instance sg13cmos5l_nand3_1_23 r0 *1 0,0
Xsg13cmos5l_nand3_1_23 \$2510 \$2697 \$2696 VPWR VGND \$2420 sg13cmos5l_nand3_1
* cell instance sg13cmos5l_nand3_1_24 r0 *1 0,0
Xsg13cmos5l_nand3_1_24 \$4902 \$4064 \$4399 VPWR VGND \$4907 sg13cmos5l_nand3_1
* cell instance sg13cmos5l_nand3_1_25 r0 *1 0,0
Xsg13cmos5l_nand3_1_25 \$4909 \$4486 \$4907 VPWR VGND \$4908 sg13cmos5l_nand3_1
* cell instance sg13cmos5l_nand3_1_26 r0 *1 0,0
Xsg13cmos5l_nand3_1_26 \$5091 \$4064 \$4399 VPWR VGND \$4910 sg13cmos5l_nand3_1
* cell instance sg13cmos5l_nand3_1_27 r0 *1 0,0
Xsg13cmos5l_nand3_1_27 \$4890 \$4064 \$4724 VPWR VGND \$4723 sg13cmos5l_nand3_1
* cell instance sg13cmos5l_nand3_1_28 r0 *1 0,0
Xsg13cmos5l_nand3_1_28 \$3939 \$4397 \$2640 VPWR VGND \$3033 sg13cmos5l_nand3_1
* cell instance sg13cmos5l_nand3_1_29 r0 *1 0,0
Xsg13cmos5l_nand3_1_29 \$2541 \$2260 \$2539 VPWR VGND \$2540 sg13cmos5l_nand3_1
* cell instance sg13cmos5l_nand3_1_30 r0 *1 0,0
Xsg13cmos5l_nand3_1_30 \$3248 \$3939 \$4399 VPWR VGND \$4730 sg13cmos5l_nand3_1
* cell instance sg13cmos5l_nand3_1_31 r0 *1 0,0
Xsg13cmos5l_nand3_1_31 \$3941 \$3939 \$4399 VPWR VGND \$4401 sg13cmos5l_nand3_1
* cell instance sg13cmos5l_nand3_1_32 r0 *1 0,0
Xsg13cmos5l_nand3_1_32 \$44 \$79 \$164 VPWR VGND \$264 sg13cmos5l_nand3_1
* cell instance sg13cmos5l_nand3_1_33 r0 *1 0,0
Xsg13cmos5l_nand3_1_33 \$50 \$2 \$1686 VPWR VGND \$1690 sg13cmos5l_nand3_1
* cell instance sg13cmos5l_nand3_1_34 r0 *1 0,0
Xsg13cmos5l_nand3_1_34 \$664 \$24 \$18 VPWR VGND \$1196 sg13cmos5l_nand3_1
* cell instance sg13cmos5l_nand3_1_35 r0 *1 0,0
Xsg13cmos5l_nand3_1_35 \$525 \$1173 \$2 VPWR VGND \$944 sg13cmos5l_nand3_1
* cell instance sg13cmos5l_nand3_1_36 r0 *1 0,0
Xsg13cmos5l_nand3_1_36 \$1801 \$289 \$117 VPWR VGND \$1800 sg13cmos5l_nand3_1
* cell instance sg13cmos5l_nand3_1_37 r0 *1 0,0
Xsg13cmos5l_nand3_1_37 \$426 \$1666 \$1800 VPWR VGND \$1802 sg13cmos5l_nand3_1
* cell instance sg13cmos5l_nand3_1_38 r0 *1 0,0
Xsg13cmos5l_nand3_1_38 \$261 \$1537 \$1196 VPWR VGND \$2027 sg13cmos5l_nand3_1
* cell instance sg13cmos5l_nand3_1_39 r0 *1 0,0
Xsg13cmos5l_nand3_1_39 \$100 \$1082 \$802 VPWR VGND \$430 sg13cmos5l_nand3_1
* cell instance sg13cmos5l_nand3_1_40 r0 *1 0,0
Xsg13cmos5l_nand3_1_40 \$101 \$29 \$172 VPWR VGND \$60 sg13cmos5l_nand3_1
* cell instance sg13cmos5l_nand3_1_41 r0 *1 0,0
Xsg13cmos5l_nand3_1_41 \$1 \$48 \$57 VPWR VGND \$101 sg13cmos5l_nand3_1
* cell instance sg13cmos5l_nand3_1_42 r0 *1 0,0
Xsg13cmos5l_nand3_1_42 \$864 \$2434 \$4234 VPWR VGND \$5134 sg13cmos5l_nand3_1
* cell instance sg13cmos5l_nand3_1_43 r0 *1 0,0
Xsg13cmos5l_nand3_1_43 \$435 \$430 \$1546 VPWR VGND \$1342 sg13cmos5l_nand3_1
* cell instance sg13cmos5l_nand3_1_44 r0 *1 0,0
Xsg13cmos5l_nand3_1_44 \$3052 \$3264 \$3066 VPWR VGND \$3442 sg13cmos5l_nand3_1
* cell instance sg13cmos5l_nand3_1_45 r0 *1 0,0
Xsg13cmos5l_nand3_1_45 \$102 \$539 \$943 VPWR VGND \$954 sg13cmos5l_nand3_1
* cell instance sg13cmos5l_nand3_1_46 r0 *1 0,0
Xsg13cmos5l_nand3_1_46 \$547 \$6 \$307 VPWR VGND \$813 sg13cmos5l_nand3_1
* cell instance sg13cmos5l_nand3_1_47 r0 *1 0,0
Xsg13cmos5l_nand3_1_47 \$11 \$173 \$1695 VPWR VGND \$671 sg13cmos5l_nand3_1
* cell instance sg13cmos5l_nand3_1_48 r0 *1 0,0
Xsg13cmos5l_nand3_1_48 \$4247 \$3789 \$4248 VPWR VGND \$3956 sg13cmos5l_nand3_1
* cell instance sg13cmos5l_nand3_1_49 r0 *1 0,0
Xsg13cmos5l_nand3_1_49 \$102 \$1 \$421 VPWR VGND \$2135 sg13cmos5l_nand3_1
* cell instance sg13cmos5l_nand3_1_50 r0 *1 0,0
Xsg13cmos5l_nand3_1_50 \$551 \$546 \$683 VPWR VGND \$1343 sg13cmos5l_nand3_1
* cell instance sg13cmos5l_nand3_1_51 r0 *1 0,0
Xsg13cmos5l_nand3_1_51 \$826 \$108 \$801 VPWR VGND \$825 sg13cmos5l_nand3_1
* cell instance sg13cmos5l_nand3_1_52 r0 *1 0,0
Xsg13cmos5l_nand3_1_52 \$118 \$50 \$116 VPWR VGND \$117 sg13cmos5l_nand3_1
* cell instance sg13cmos5l_nand3_1_53 r0 *1 0,0
Xsg13cmos5l_nand3_1_53 \$3033 \$3303 \$3203 VPWR VGND \$2822 sg13cmos5l_nand3_1
* cell instance sg13cmos5l_nand3_1_54 r0 *1 0,0
Xsg13cmos5l_nand3_1_54 \$956 \$827 \$954 VPWR VGND \$955 sg13cmos5l_nand3_1
* cell instance sg13cmos5l_nand3_1_55 r0 *1 0,0
Xsg13cmos5l_nand3_1_55 \$674 \$548 \$678 VPWR VGND \$679 sg13cmos5l_nand3_1
* cell instance sg13cmos5l_nand3_1_56 r0 *1 0,0
Xsg13cmos5l_nand3_1_56 \$32 \$1548 \$1546 VPWR VGND \$1704 sg13cmos5l_nand3_1
* cell instance sg13cmos5l_nand3_1_57 r0 *1 0,0
Xsg13cmos5l_nand3_1_57 \$52 \$38 \$128 VPWR VGND \$61 sg13cmos5l_nand3_1
* cell instance sg13cmos5l_nand3_1_58 r0 *1 0,0
Xsg13cmos5l_nand3_1_58 \$4967 \$4769 \$4774 VPWR VGND \$5183 sg13cmos5l_nand3_1
* cell instance sg13cmos5l_nand3_1_59 r0 *1 0,0
Xsg13cmos5l_nand3_1_59 \$32 \$61 \$53 VPWR VGND \$51 sg13cmos5l_nand3_1
* cell instance sg13cmos5l_nand3_1_60 r0 *1 0,0
Xsg13cmos5l_nand3_1_60 \$119 \$306 \$305 VPWR VGND \$307 sg13cmos5l_nand3_1
* cell instance sg13cmos5l_nand3_1_61 r0 *1 0,0
Xsg13cmos5l_nand3_1_61 \$120 \$132 \$117 VPWR VGND \$53 sg13cmos5l_nand3_1
* cell instance sg13cmos5l_nand3_1_62 r0 *1 0,0
Xsg13cmos5l_nand3_1_62 \$5396 \$4988 \$4774 VPWR VGND \$5394 sg13cmos5l_nand3_1
* cell instance sg13cmos5l_nand3_1_63 r0 *1 0,0
Xsg13cmos5l_nand3_1_63 \$2432 \$2291 \$2436 VPWR VGND \$4560 sg13cmos5l_nand3_1
* cell instance sg13cmos5l_nand3_1_64 r0 *1 0,0
Xsg13cmos5l_nand3_1_64 \$833 \$105 \$561 VPWR VGND \$1710 sg13cmos5l_nand3_1
* cell instance sg13cmos5l_nand3_1_65 r0 *1 0,0
Xsg13cmos5l_nand3_1_65 \$2291 \$2436 \$2108 VPWR VGND \$1583 sg13cmos5l_nand3_1
* cell instance sg13cmos5l_nand3_1_66 r0 *1 0,0
Xsg13cmos5l_nand3_1_66 \$5396 \$5392 \$4988 VPWR VGND \$5409 sg13cmos5l_nand3_1
* cell instance sg13cmos5l_nand3_1_67 r0 *1 0,0
Xsg13cmos5l_nand3_1_67 \$4004 \$4236 \$4334 VPWR VGND \$3804 sg13cmos5l_nand3_1
* cell instance sg13cmos5l_nand3_1_68 r0 *1 0,0
Xsg13cmos5l_nand3_1_68 \$1655 \$1479 \$1474 VPWR VGND \$1589 sg13cmos5l_nand3_1
* cell instance sg13cmos5l_nand3_1_69 r0 *1 0,0
Xsg13cmos5l_nand3_1_69 \$4287 \$4130 \$4126 VPWR VGND \$4996 sg13cmos5l_nand3_1
* cell instance sg13cmos5l_nand3_1_70 r0 *1 0,0
Xsg13cmos5l_nand3_1_70 \$4623 \$5215 \$5214 VPWR VGND \$5213 sg13cmos5l_nand3_1
* cell instance sg13cmos5l_nand3_1_71 r0 *1 0,0
Xsg13cmos5l_nand3_1_71 \$4618 \$4304 \$5216 VPWR VGND \$5215 sg13cmos5l_nand3_1
* cell instance sg13cmos5l_nand3_1_72 r0 *1 0,0
Xsg13cmos5l_nand3_1_72 \$5651 \$5218 \$5650 VPWR VGND \$5642 sg13cmos5l_nand3_1
* cell instance sg13cmos5l_nand3_1_73 r0 *1 0,0
Xsg13cmos5l_nand3_1_73 \$2217 \$3651 \$3649 VPWR VGND \$3650 sg13cmos5l_nand3_1
* cell instance sg13cmos5l_nand3_1_74 r0 *1 0,0
Xsg13cmos5l_nand3_1_74 \$2294 \$2069 \$2174 VPWR VGND \$2068 sg13cmos5l_nand3_1
* cell instance sg13cmos5l_nand3_1_75 r0 *1 0,0
Xsg13cmos5l_nand3_1_75 \$3835 \$3324 \$4131 VPWR VGND \$3658 sg13cmos5l_nand3_1
* cell instance sg13cmos5l_nand3_1_76 r0 *1 0,0
Xsg13cmos5l_nand3_1_76 \$2767 \$2601 \$2305 VPWR VGND \$2766 sg13cmos5l_nand3_1
* cell instance sg13cmos5l_nand3_1_77 r0 *1 0,0
Xsg13cmos5l_nand3_1_77 \$3835 \$5836 \$4817 VPWR VGND \$4818 sg13cmos5l_nand3_1
* cell instance sg13cmos5l_nand3_1_78 r0 *1 0,0
Xsg13cmos5l_nand3_1_78 \$20239 \$20214 \$19891 VPWR VGND \$20062
+ sg13cmos5l_nand3_1
* cell instance sg13cmos5l_nand3_1_79 r0 *1 0,0
Xsg13cmos5l_nand3_1_79 \$6579 \$5223 \$4186 VPWR VGND \$6417 sg13cmos5l_nand3_1
* cell instance sg13cmos5l_nand3_1_80 r0 *1 0,0
Xsg13cmos5l_nand3_1_80 \$2988 \$3835 \$3341 VPWR VGND \$3337 sg13cmos5l_nand3_1
* cell instance sg13cmos5l_nand3_1_81 r0 *1 0,0
Xsg13cmos5l_nand3_1_81 \$5228 \$4819 \$4186 VPWR VGND \$5227 sg13cmos5l_nand3_1
* cell instance sg13cmos5l_nand3_1_82 r0 *1 0,0
Xsg13cmos5l_nand3_1_82 \$5857 \$4457 \$4186 VPWR VGND \$6045 sg13cmos5l_nand3_1
* cell instance sg13cmos5l_nand3_1_83 r0 *1 0,0
Xsg13cmos5l_nand3_1_83 \$6508 \$4186 \$1881 VPWR VGND \$6507 sg13cmos5l_nand3_1
* cell instance sg13cmos5l_nand3_1_84 r0 *1 0,0
Xsg13cmos5l_nand3_1_84 \$2938 \$2778 \$2936 VPWR VGND \$2937 sg13cmos5l_nand3_1
* cell instance sg13cmos5l_nand3_1_85 r0 *1 0,0
Xsg13cmos5l_nand3_1_85 \$4425 \$6306 \$4186 VPWR VGND \$6309 sg13cmos5l_nand3_1
* cell instance sg13cmos5l_nand3_1_86 r0 *1 0,0
Xsg13cmos5l_nand3_1_86 \$5234 \$1952 \$4186 VPWR VGND \$5233 sg13cmos5l_nand3_1
* cell instance sg13cmos5l_nand3_1_87 r0 *1 0,0
Xsg13cmos5l_nand3_1_87 \$1976 \$901 \$1020 VPWR VGND \$1975 sg13cmos5l_nand3_1
* cell instance sg13cmos5l_nand3_1_88 r0 *1 0,0
Xsg13cmos5l_nand3_1_88 \$3172 \$3183 \$4015 VPWR VGND \$3359 sg13cmos5l_nand3_1
* cell instance sg13cmos5l_nand3_1_89 r0 *1 0,0
Xsg13cmos5l_nand3_1_89 \$6524 \$3869 \$4186 VPWR VGND \$6312 sg13cmos5l_nand3_1
* cell instance sg13cmos5l_nand3_1_90 r0 *1 0,0
Xsg13cmos5l_nand3_1_90 \$3990 \$6860 \$5043 VPWR VGND \$6794 sg13cmos5l_nand3_1
* cell instance sg13cmos5l_nand3_1_91 r0 *1 0,0
Xsg13cmos5l_nand3_1_91 \$6308 \$5237 \$5006 VPWR VGND \$5236 sg13cmos5l_nand3_1
* cell instance sg13cmos5l_nand3_1_92 r0 *1 0,0
Xsg13cmos5l_nand3_1_92 \$4306 \$3695 \$4318 VPWR VGND \$4179 sg13cmos5l_nand3_1
* cell instance sg13cmos5l_nand3_1_93 r0 *1 0,0
Xsg13cmos5l_nand3_1_93 \$6308 \$4650 \$5423 VPWR VGND \$5680 sg13cmos5l_nand3_1
* cell instance sg13cmos5l_nand3b_1_0 r0 *1 0,0
Xsg13cmos5l_nand3b_1_0 \$281 \$166 \$251 VPWR VGND \$278 sg13cmos5l_nand3b_1
* cell instance sg13cmos5l_nand3b_1_1 r0 *1 0,0
Xsg13cmos5l_nand3b_1_1 \$946 \$646 \$525 VPWR VGND \$947 sg13cmos5l_nand3b_1
* cell instance sg13cmos5l_nand3b_1_2 r0 *1 0,0
Xsg13cmos5l_nand3b_1_2 \$1452 \$1443 \$551 VPWR VGND \$1568 sg13cmos5l_nand3b_1
* cell instance sg13cmos5l_nand3b_1_3 r0 *1 0,0
Xsg13cmos5l_nand3b_1_3 \$549 \$825 \$955 VPWR VGND \$958 sg13cmos5l_nand3b_1
* cell instance sg13cmos5l_nand3b_1_4 r0 *1 0,0
Xsg13cmos5l_nand3b_1_4 \$963 \$6 \$289 VPWR VGND \$1921 sg13cmos5l_nand3b_1
* cell instance sg13cmos5l_nand3b_1_5 r0 *1 0,0
Xsg13cmos5l_nand3b_1_5 \$2977 \$3804 \$4288 VPWR VGND \$3988 sg13cmos5l_nand3b_1
* cell instance sg13cmos5l_nand3b_1_6 r0 *1 0,0
Xsg13cmos5l_nand3b_1_6 \$1934 \$2164 \$1726 VPWR VGND \$2171 sg13cmos5l_nand3b_1
* cell instance sg13cmos5l_nand3b_1_7 r0 *1 0,0
Xsg13cmos5l_nand3b_1_7 \$20240 \$20239 \$20214 VPWR VGND \$20058
+ sg13cmos5l_nand3b_1
* cell instance sg13cmos5l_nand3b_1_8 r0 *1 0,0
Xsg13cmos5l_nand3b_1_8 \$3166 \$3170 \$2938 VPWR VGND \$3169 sg13cmos5l_nand3b_1
* cell instance sg13cmos5l_nand3b_1_9 r0 *1 0,0
Xsg13cmos5l_nand3b_1_9 \$4826 \$3858 \$4306 VPWR VGND \$4832 sg13cmos5l_nand3b_1
* cell instance sg13cmos5l_nand3b_1_10 r0 *1 0,0
Xsg13cmos5l_nand3b_1_10 \$2929 \$2782 \$2938 VPWR VGND \$2944
+ sg13cmos5l_nand3b_1
* cell instance sg13cmos5l_nand3b_1_11 r0 *1 0,0
Xsg13cmos5l_nand3b_1_11 \$4024 \$4028 \$4306 VPWR VGND \$4043
+ sg13cmos5l_nand3b_1
* cell instance sg13cmos5l_nand4_1_0 r0 *1 0,0
Xsg13cmos5l_nand4_1_0 \$67 \$66 \$11 \$1052 VPWR VGND \$1053 sg13cmos5l_nand4_1
* cell instance sg13cmos5l_nand4_1_1 r0 *1 0,0
Xsg13cmos5l_nand4_1_1 \$1664 \$1665 \$521 \$1052 VPWR VGND \$1666
+ sg13cmos5l_nand4_1
* cell instance sg13cmos5l_nand4_1_2 r0 *1 0,0
Xsg13cmos5l_nand4_1_2 \$5047 \$5286 \$6079 \$5893 VPWR VGND \$5901
+ sg13cmos5l_nand4_1
* cell instance sg13cmos5l_nand4_1_3 r0 *1 0,0
Xsg13cmos5l_nand4_1_3 \$5720 \$5718 \$5719 \$5482 VPWR VGND \$4878
+ sg13cmos5l_nand4_1
* cell instance sg13cmos5l_nand4_1_4 r0 *1 0,0
Xsg13cmos5l_nand4_1_4 \$798 \$1055 \$69 \$1546 VPWR VGND \$1309
+ sg13cmos5l_nand4_1
* cell instance sg13cmos5l_nand4_1_5 r0 *1 0,0
Xsg13cmos5l_nand4_1_5 \$20043 \$20042 \$19996 \$20032 VPWR VGND \$20041
+ sg13cmos5l_nand4_1
* cell instance sg13cmos5l_nand4_1_6 r0 *1 0,0
Xsg13cmos5l_nand4_1_6 \$7096 \$6394 \$6089 \$5925 VPWR VGND \$6088
+ sg13cmos5l_nand4_1
* cell instance sg13cmos5l_nand4_1_7 r0 *1 0,0
Xsg13cmos5l_nand4_1_7 \$5741 \$5928 \$5929 \$5922 VPWR VGND \$4906
+ sg13cmos5l_nand4_1
* cell instance sg13cmos5l_nand4_1_8 r0 *1 0,0
Xsg13cmos5l_nand4_1_8 \$6402 \$6399 \$6401 \$6400 VPWR VGND \$5758
+ sg13cmos5l_nand4_1
* cell instance sg13cmos5l_nand4_1_9 r0 *1 0,0
Xsg13cmos5l_nand4_1_9 \$5303 \$5515 \$5520 \$5518 VPWR VGND \$5519
+ sg13cmos5l_nand4_1
* cell instance sg13cmos5l_nand4_1_10 r0 *1 0,0
Xsg13cmos5l_nand4_1_10 \$5921 \$5944 \$5740 \$6480 VPWR VGND \$5098
+ sg13cmos5l_nand4_1
* cell instance sg13cmos5l_nand4_1_11 r0 *1 0,0
Xsg13cmos5l_nand4_1_11 \$5093 \$5096 \$4910 \$4723 VPWR VGND \$5097
+ sg13cmos5l_nand4_1
* cell instance sg13cmos5l_nand4_1_12 r0 *1 0,0
Xsg13cmos5l_nand4_1_12 \$3928 \$2827 \$3014 \$4100 VPWR VGND \$920
+ sg13cmos5l_nand4_1
* cell instance sg13cmos5l_nand4_1_13 r0 *1 0,0
Xsg13cmos5l_nand4_1_13 \$276 \$2248 \$261 \$796 VPWR VGND \$2539
+ sg13cmos5l_nand4_1
* cell instance sg13cmos5l_nand4_1_14 r0 *1 0,0
Xsg13cmos5l_nand4_1_14 \$681 \$278 \$277 \$273 VPWR VGND \$279
+ sg13cmos5l_nand4_1
* cell instance sg13cmos5l_nand4_1_15 r0 *1 0,0
Xsg13cmos5l_nand4_1_15 \$4730 \$4725 \$4728 \$4727 VPWR VGND \$4729
+ sg13cmos5l_nand4_1
* cell instance sg13cmos5l_nand4_1_16 r0 *1 0,0
Xsg13cmos5l_nand4_1_16 \$4401 \$4918 \$4915 \$5265 VPWR VGND \$4857
+ sg13cmos5l_nand4_1
* cell instance sg13cmos5l_nand4_1_17 r0 *1 0,0
Xsg13cmos5l_nand4_1_17 \$152 \$947 \$1075 \$944 VPWR VGND \$1076
+ sg13cmos5l_nand4_1
* cell instance sg13cmos5l_nand4_1_18 r0 *1 0,0
Xsg13cmos5l_nand4_1_18 \$4222 \$1817 \$3048 \$3396 VPWR VGND \$4228
+ sg13cmos5l_nand4_1
* cell instance sg13cmos5l_nand4_1_19 r0 *1 0,0
Xsg13cmos5l_nand4_1_19 \$5547 \$5542 \$5546 \$5545 VPWR VGND \$4963
+ sg13cmos5l_nand4_1
* cell instance sg13cmos5l_nand4_1_20 r0 *1 0,0
Xsg13cmos5l_nand4_1_20 \$3945 \$3615 \$3783 \$4064 VPWR VGND \$3781
+ sg13cmos5l_nand4_1
* cell instance sg13cmos5l_nand4_1_21 r0 *1 0,0
Xsg13cmos5l_nand4_1_21 \$3709 \$3782 \$3437 \$3781 VPWR VGND \$2999
+ sg13cmos5l_nand4_1
* cell instance sg13cmos5l_nand4_1_22 r0 *1 0,0
Xsg13cmos5l_nand4_1_22 \$3945 \$3939 \$3615 \$3783 VPWR VGND \$3709
+ sg13cmos5l_nand4_1
* cell instance sg13cmos5l_nand4_1_23 r0 *1 0,0
Xsg13cmos5l_nand4_1_23 \$3618 \$3615 \$3783 \$4324 VPWR VGND \$3437
+ sg13cmos5l_nand4_1
* cell instance sg13cmos5l_nand4_1_24 r0 *1 0,0
Xsg13cmos5l_nand4_1_24 \$171 \$132 \$525 \$12 VPWR VGND \$172 sg13cmos5l_nand4_1
* cell instance sg13cmos5l_nand4_1_25 r0 *1 0,0
Xsg13cmos5l_nand4_1_25 \$826 \$1804 \$1196 \$69 VPWR VGND \$1805
+ sg13cmos5l_nand4_1
* cell instance sg13cmos5l_nand4_1_26 r0 *1 0,0
Xsg13cmos5l_nand4_1_26 \$3618 \$4049 \$3441 \$3951 VPWR VGND \$3782
+ sg13cmos5l_nand4_1
* cell instance sg13cmos5l_nand4_1_27 r0 *1 0,0
Xsg13cmos5l_nand4_1_27 \$48 \$173 \$1537 \$264 VPWR VGND \$291
+ sg13cmos5l_nand4_1
* cell instance sg13cmos5l_nand4_1_28 r0 *1 0,0
Xsg13cmos5l_nand4_1_28 \$435 \$798 \$1196 \$264 VPWR VGND \$1195
+ sg13cmos5l_nand4_1
* cell instance sg13cmos5l_nand4_1_29 r0 *1 0,0
Xsg13cmos5l_nand4_1_29 \$1913 \$1890 \$1453 \$2722 VPWR VGND \$1912
+ sg13cmos5l_nand4_1
* cell instance sg13cmos5l_nand4_1_30 r0 *1 0,0
Xsg13cmos5l_nand4_1_30 \$435 \$546 \$415 \$437 VPWR VGND \$434
+ sg13cmos5l_nand4_1
* cell instance sg13cmos5l_nand4_1_31 r0 *1 0,0
Xsg13cmos5l_nand4_1_31 \$4247 \$3789 \$3283 \$4248 VPWR VGND \$3955
+ sg13cmos5l_nand4_1
* cell instance sg13cmos5l_nand4_1_32 r0 *1 0,0
Xsg13cmos5l_nand4_1_32 \$2038 \$2135 \$1802 \$1571 VPWR VGND \$2042
+ sg13cmos5l_nand4_1
* cell instance sg13cmos5l_nand4_1_33 r0 *1 0,0
Xsg13cmos5l_nand4_1_33 \$546 \$32 \$61 \$437 VPWR VGND \$1206 sg13cmos5l_nand4_1
* cell instance sg13cmos5l_nand4_1_34 r0 *1 0,0
Xsg13cmos5l_nand4_1_34 \$252 \$546 \$108 \$1196 VPWR VGND \$548
+ sg13cmos5l_nand4_1
* cell instance sg13cmos5l_nand4_1_35 r0 *1 0,0
Xsg13cmos5l_nand4_1_35 \$4967 \$4769 \$5375 \$4774 VPWR VGND \$4770
+ sg13cmos5l_nand4_1
* cell instance sg13cmos5l_nand4_1_36 r0 *1 0,0
Xsg13cmos5l_nand4_1_36 \$3133 \$2907 \$3299 \$2902 VPWR VGND \$3203
+ sg13cmos5l_nand4_1
* cell instance sg13cmos5l_nand4_1_37 r0 *1 0,0
Xsg13cmos5l_nand4_1_37 \$183 \$34 \$137 \$184 VPWR VGND \$185 sg13cmos5l_nand4_1
* cell instance sg13cmos5l_nand4_1_38 r0 *1 0,0
Xsg13cmos5l_nand4_1_38 \$2062 \$1935 \$2061 \$2059 VPWR VGND \$2060
+ sg13cmos5l_nand4_1
* cell instance sg13cmos5l_nand4_1_39 r0 *1 0,0
Xsg13cmos5l_nand4_1_39 \$2297 \$2364 \$2448 \$1598 VPWR VGND \$2447
+ sg13cmos5l_nand4_1
* cell instance sg13cmos5l_nand4_1_40 r0 *1 0,0
Xsg13cmos5l_nand4_1_40 \$2772 \$2450 \$2771 \$2769 VPWR VGND \$2770
+ sg13cmos5l_nand4_1
* cell instance sg13cmos5l_nand4_1_41 r0 *1 0,0
Xsg13cmos5l_nand4_1_41 \$1379 \$1503 \$1500 \$1501 VPWR VGND \$1502
+ sg13cmos5l_nand4_1
* cell instance sg13cmos5l_nand4_1_42 r0 *1 0,0
Xsg13cmos5l_nand4_1_42 \$4815 \$6308 \$6445 \$4682 VPWR VGND \$6444
+ sg13cmos5l_nand4_1
* cell instance sg13cmos5l_nor2_1_0 r0 *1 0,0
Xsg13cmos5l_nor2_1_0 \$1664 \$1665 VPWR VGND \$1679 sg13cmos5l_nor2_1
* cell instance sg13cmos5l_nor2_1_1 r0 *1 0,0
Xsg13cmos5l_nor2_1_1 \$521 \$150 VPWR VGND \$522 sg13cmos5l_nor2_1
* cell instance sg13cmos5l_nor2_1_2 r0 *1 0,0
Xsg13cmos5l_nor2_1_2 \$931 \$2011 VPWR VGND \$2012 sg13cmos5l_nor2_1
* cell instance sg13cmos5l_nor2_1_3 r0 *1 0,0
Xsg13cmos5l_nor2_1_3 \$931 \$1409 VPWR VGND \$1431 sg13cmos5l_nor2_1
* cell instance sg13cmos5l_nor2_1_4 r0 *1 0,0
Xsg13cmos5l_nor2_1_4 \$6918 \$6561 VPWR VGND \$6555 sg13cmos5l_nor2_1
* cell instance sg13cmos5l_nor2_1_5 r0 *1 0,0
Xsg13cmos5l_nor2_1_5 \$258 \$259 VPWR VGND \$826 sg13cmos5l_nor2_1
* cell instance sg13cmos5l_nor2_1_6 r0 *1 0,0
Xsg13cmos5l_nor2_1_6 \$5045 \$5047 VPWR VGND \$4871 sg13cmos5l_nor2_1
* cell instance sg13cmos5l_nor2_1_7 r0 *1 0,0
Xsg13cmos5l_nor2_1_7 \$7208 \$6561 VPWR VGND \$7171 sg13cmos5l_nor2_1
* cell instance sg13cmos5l_nor2_1_8 r0 *1 0,0
Xsg13cmos5l_nor2_1_8 \$154 \$259 VPWR VGND \$6 sg13cmos5l_nor2_1
* cell instance sg13cmos5l_nor2_1_9 r0 *1 0,0
Xsg13cmos5l_nor2_1_9 \$4229 \$4873 VPWR VGND \$5047 sg13cmos5l_nor2_1
* cell instance sg13cmos5l_nor2_1_10 r0 *1 0,0
Xsg13cmos5l_nor2_1_10 \$3216 \$2503 VPWR VGND \$3217 sg13cmos5l_nor2_1
* cell instance sg13cmos5l_nor2_1_11 r0 *1 0,0
Xsg13cmos5l_nor2_1_11 \$2386 \$2233 VPWR VGND \$2387 sg13cmos5l_nor2_1
* cell instance sg13cmos5l_nor2_1_12 r0 *1 0,0
Xsg13cmos5l_nor2_1_12 \$2233 \$2503 VPWR VGND \$2815 sg13cmos5l_nor2_1
* cell instance sg13cmos5l_nor2_1_13 r0 *1 0,0
Xsg13cmos5l_nor2_1_13 \$7893 \$7165 VPWR VGND \$8215 sg13cmos5l_nor2_1
* cell instance sg13cmos5l_nor2_1_14 r0 *1 0,0
Xsg13cmos5l_nor2_1_14 \$3591 \$2996 VPWR VGND \$3392 sg13cmos5l_nor2_1
* cell instance sg13cmos5l_nor2_1_15 r0 *1 0,0
Xsg13cmos5l_nor2_1_15 \$5051 \$4874 VPWR VGND \$4875 sg13cmos5l_nor2_1
* cell instance sg13cmos5l_nor2_1_16 r0 *1 0,0
Xsg13cmos5l_nor2_1_16 \$2383 \$2503 VPWR VGND \$2504 sg13cmos5l_nor2_1
* cell instance sg13cmos5l_nor2_1_17 r0 *1 0,0
Xsg13cmos5l_nor2_1_17 \$2386 \$3216 VPWR VGND \$3218 sg13cmos5l_nor2_1
* cell instance sg13cmos5l_nor2_1_18 r0 *1 0,0
Xsg13cmos5l_nor2_1_18 \$2388 \$2387 VPWR VGND \$2389 sg13cmos5l_nor2_1
* cell instance sg13cmos5l_nor2_1_19 r0 *1 0,0
Xsg13cmos5l_nor2_1_19 \$6466 \$5045 VPWR VGND \$6372 sg13cmos5l_nor2_1
* cell instance sg13cmos5l_nor2_1_20 r0 *1 0,0
Xsg13cmos5l_nor2_1_20 \$154 \$152 VPWR VGND \$39 sg13cmos5l_nor2_1
* cell instance sg13cmos5l_nor2_1_21 r0 *1 0,0
Xsg13cmos5l_nor2_1_21 \$8216 \$6561 VPWR VGND \$7808 sg13cmos5l_nor2_1
* cell instance sg13cmos5l_nor2_1_22 r0 *1 0,0
Xsg13cmos5l_nor2_1_22 \$7709 \$7210 VPWR VGND \$7209 sg13cmos5l_nor2_1
* cell instance sg13cmos5l_nor2_1_23 r0 *1 0,0
Xsg13cmos5l_nor2_1_23 \$153 \$258 VPWR VGND \$12 sg13cmos5l_nor2_1
* cell instance sg13cmos5l_nor2_1_24 r0 *1 0,0
Xsg13cmos5l_nor2_1_24 \$19420 \$18792 VPWR VGND \$18927 sg13cmos5l_nor2_1
* cell instance sg13cmos5l_nor2_1_25 r0 *1 0,0
Xsg13cmos5l_nor2_1_25 \$1789 \$152 VPWR VGND \$426 sg13cmos5l_nor2_1
* cell instance sg13cmos5l_nor2_1_26 r0 *1 0,0
Xsg13cmos5l_nor2_1_26 \$66 \$258 VPWR VGND \$260 sg13cmos5l_nor2_1
* cell instance sg13cmos5l_nor2_1_27 r0 *1 0,0
Xsg13cmos5l_nor2_1_27 \$103 \$1073 VPWR VGND \$2015 sg13cmos5l_nor2_1
* cell instance sg13cmos5l_nor2_1_28 r0 *1 0,0
Xsg13cmos5l_nor2_1_28 \$7211 \$7210 VPWR VGND \$7377 sg13cmos5l_nor2_1
* cell instance sg13cmos5l_nor2_1_29 r0 *1 0,0
Xsg13cmos5l_nor2_1_29 \$6377 \$5045 VPWR VGND \$6375 sg13cmos5l_nor2_1
* cell instance sg13cmos5l_nor2_1_30 r0 *1 0,0
Xsg13cmos5l_nor2_1_30 \$8142 \$8494 VPWR VGND \$8420 sg13cmos5l_nor2_1
* cell instance sg13cmos5l_nor2_1_31 r0 *1 0,0
Xsg13cmos5l_nor2_1_31 \$3915 \$3910 VPWR VGND \$3916 sg13cmos5l_nor2_1
* cell instance sg13cmos5l_nor2_1_32 r0 *1 0,0
Xsg13cmos5l_nor2_1_32 \$6562 \$6561 VPWR VGND \$6560 sg13cmos5l_nor2_1
* cell instance sg13cmos5l_nor2_1_33 r0 *1 0,0
Xsg13cmos5l_nor2_1_33 \$5926 \$8219 VPWR VGND \$19237 sg13cmos5l_nor2_1
* cell instance sg13cmos5l_nor2_1_34 r0 *1 0,0
Xsg13cmos5l_nor2_1_34 \$7705 \$6094 VPWR VGND \$7712 sg13cmos5l_nor2_1
* cell instance sg13cmos5l_nor2_1_35 r0 *1 0,0
Xsg13cmos5l_nor2_1_35 \$65 \$36 VPWR VGND \$68 sg13cmos5l_nor2_1
* cell instance sg13cmos5l_nor2_1_36 r0 *1 0,0
Xsg13cmos5l_nor2_1_36 \$6087 \$5045 VPWR VGND \$6378 sg13cmos5l_nor2_1
* cell instance sg13cmos5l_nor2_1_37 r0 *1 0,0
Xsg13cmos5l_nor2_1_37 \$16329 \$18792 VPWR VGND \$16102 sg13cmos5l_nor2_1
* cell instance sg13cmos5l_nor2_1_38 r0 *1 0,0
Xsg13cmos5l_nor2_1_38 \$6920 \$7491 VPWR VGND \$7378 sg13cmos5l_nor2_1
* cell instance sg13cmos5l_nor2_1_39 r0 *1 0,0
Xsg13cmos5l_nor2_1_39 \$1647 \$645 VPWR VGND \$1669 sg13cmos5l_nor2_1
* cell instance sg13cmos5l_nor2_1_40 r0 *1 0,0
Xsg13cmos5l_nor2_1_40 \$4320 \$4207 VPWR VGND \$4088 sg13cmos5l_nor2_1
* cell instance sg13cmos5l_nor2_1_41 r0 *1 0,0
Xsg13cmos5l_nor2_1_41 \$4511 \$3914 VPWR VGND \$4512 sg13cmos5l_nor2_1
* cell instance sg13cmos5l_nor2_1_42 r0 *1 0,0
Xsg13cmos5l_nor2_1_42 \$153 \$943 VPWR VGND \$1647 sg13cmos5l_nor2_1
* cell instance sg13cmos5l_nor2_1_43 r0 *1 0,0
Xsg13cmos5l_nor2_1_43 \$57 \$70 VPWR VGND \$145 sg13cmos5l_nor2_1
* cell instance sg13cmos5l_nor2_1_44 r0 *1 0,0
Xsg13cmos5l_nor2_1_44 \$157 \$2 VPWR VGND \$410 sg13cmos5l_nor2_1
* cell instance sg13cmos5l_nor2_1_45 r0 *1 0,0
Xsg13cmos5l_nor2_1_45 \$1882 \$1667 VPWR VGND \$1880 sg13cmos5l_nor2_1
* cell instance sg13cmos5l_nor2_1_46 r0 *1 0,0
Xsg13cmos5l_nor2_1_46 \$18444 \$18792 VPWR VGND \$17331 sg13cmos5l_nor2_1
* cell instance sg13cmos5l_nor2_1_47 r0 *1 0,0
Xsg13cmos5l_nor2_1_47 \$6568 \$7165 VPWR VGND \$6566 sg13cmos5l_nor2_1
* cell instance sg13cmos5l_nor2_1_48 r0 *1 0,0
Xsg13cmos5l_nor2_1_48 \$5485 \$5293 VPWR VGND \$5721 sg13cmos5l_nor2_1
* cell instance sg13cmos5l_nor2_1_49 r0 *1 0,0
Xsg13cmos5l_nor2_1_49 \$5295 \$5293 VPWR VGND \$5454 sg13cmos5l_nor2_1
* cell instance sg13cmos5l_nor2_1_50 r0 *1 0,0
Xsg13cmos5l_nor2_1_50 \$7811 \$7165 VPWR VGND \$7810 sg13cmos5l_nor2_1
* cell instance sg13cmos5l_nor2_1_51 r0 *1 0,0
Xsg13cmos5l_nor2_1_51 \$7812 \$6930 VPWR VGND \$18690 sg13cmos5l_nor2_1
* cell instance sg13cmos5l_nor2_1_52 r0 *1 0,0
Xsg13cmos5l_nor2_1_52 \$18484 \$17692 VPWR VGND \$18691 sg13cmos5l_nor2_1
* cell instance sg13cmos5l_nor2_1_53 r0 *1 0,0
Xsg13cmos5l_nor2_1_53 \$259 \$411 VPWR VGND \$412 sg13cmos5l_nor2_1
* cell instance sg13cmos5l_nor2_1_54 r0 *1 0,0
Xsg13cmos5l_nor2_1_54 \$1779 \$1883 VPWR VGND \$1884 sg13cmos5l_nor2_1
* cell instance sg13cmos5l_nor2_1_55 r0 *1 0,0
Xsg13cmos5l_nor2_1_55 \$4894 \$5293 VPWR VGND \$5292 sg13cmos5l_nor2_1
* cell instance sg13cmos5l_nor2_1_56 r0 *1 0,0
Xsg13cmos5l_nor2_1_56 \$42 \$69 VPWR VGND \$159 sg13cmos5l_nor2_1
* cell instance sg13cmos5l_nor2_1_57 r0 *1 0,0
Xsg13cmos5l_nor2_1_57 \$6926 \$7165 VPWR VGND \$6924 sg13cmos5l_nor2_1
* cell instance sg13cmos5l_nor2_1_58 r0 *1 0,0
Xsg13cmos5l_nor2_1_58 \$8018 \$8008 VPWR VGND \$16863 sg13cmos5l_nor2_1
* cell instance sg13cmos5l_nor2_1_59 r0 *1 0,0
Xsg13cmos5l_nor2_1_59 \$524 \$802 VPWR VGND \$803 sg13cmos5l_nor2_1
* cell instance sg13cmos5l_nor2_1_60 r0 *1 0,0
Xsg13cmos5l_nor2_1_60 \$67 \$35 VPWR VGND \$657 sg13cmos5l_nor2_1
* cell instance sg13cmos5l_nor2_1_61 r0 *1 0,0
Xsg13cmos5l_nor2_1_61 \$262 \$2 VPWR VGND \$1062 sg13cmos5l_nor2_1
* cell instance sg13cmos5l_nor2_1_62 r0 *1 0,0
Xsg13cmos5l_nor2_1_62 \$657 \$798 VPWR VGND \$935 sg13cmos5l_nor2_1
* cell instance sg13cmos5l_nor2_1_63 r0 *1 0,0
Xsg13cmos5l_nor2_1_63 \$20039 \$20041 VPWR VGND \$20040 sg13cmos5l_nor2_1
* cell instance sg13cmos5l_nor2_1_64 r0 *1 0,0
Xsg13cmos5l_nor2_1_64 \$2516 \$2677 VPWR VGND \$2683 sg13cmos5l_nor2_1
* cell instance sg13cmos5l_nor2_1_65 r0 *1 0,0
Xsg13cmos5l_nor2_1_65 \$4873 \$4899 VPWR VGND \$4900 sg13cmos5l_nor2_1
* cell instance sg13cmos5l_nor2_1_66 r0 *1 0,0
Xsg13cmos5l_nor2_1_66 \$5728 \$5293 VPWR VGND \$5501 sg13cmos5l_nor2_1
* cell instance sg13cmos5l_nor2_1_67 r0 *1 0,0
Xsg13cmos5l_nor2_1_67 \$4871 \$4900 VPWR VGND \$4901 sg13cmos5l_nor2_1
* cell instance sg13cmos5l_nor2_1_68 r0 *1 0,0
Xsg13cmos5l_nor2_1_68 \$17690 \$17692 VPWR VGND \$17691 sg13cmos5l_nor2_1
* cell instance sg13cmos5l_nor2_1_69 r0 *1 0,0
Xsg13cmos5l_nor2_1_69 \$103 \$805 VPWR VGND \$528 sg13cmos5l_nor2_1
* cell instance sg13cmos5l_nor2_1_70 r0 *1 0,0
Xsg13cmos5l_nor2_1_70 \$4210 \$4214 VPWR VGND \$4525 sg13cmos5l_nor2_1
* cell instance sg13cmos5l_nor2_1_71 r0 *1 0,0
Xsg13cmos5l_nor2_1_71 \$19425 \$18792 VPWR VGND \$19245 sg13cmos5l_nor2_1
* cell instance sg13cmos5l_nor2_1_72 r0 *1 0,0
Xsg13cmos5l_nor2_1_72 \$802 \$1189 VPWR VGND \$805 sg13cmos5l_nor2_1
* cell instance sg13cmos5l_nor2_1_73 r0 *1 0,0
Xsg13cmos5l_nor2_1_73 \$4902 \$4896 VPWR VGND \$4903 sg13cmos5l_nor2_1
* cell instance sg13cmos5l_nor2_1_74 r0 *1 0,0
Xsg13cmos5l_nor2_1_74 \$6569 \$5513 VPWR VGND \$6905 sg13cmos5l_nor2_1
* cell instance sg13cmos5l_nor2_1_75 r0 *1 0,0
Xsg13cmos5l_nor2_1_75 \$15076 \$19996 VPWR VGND \$20016 sg13cmos5l_nor2_1
* cell instance sg13cmos5l_nor2_1_76 r0 *1 0,0
Xsg13cmos5l_nor2_1_76 \$3915 \$3052 VPWR VGND \$3756 sg13cmos5l_nor2_1
* cell instance sg13cmos5l_nor2_1_77 r0 *1 0,0
Xsg13cmos5l_nor2_1_77 \$3705 \$4214 VPWR VGND \$4213 sg13cmos5l_nor2_1
* cell instance sg13cmos5l_nor2_1_78 r0 *1 0,0
Xsg13cmos5l_nor2_1_78 \$1664 \$154 VPWR VGND \$2251 sg13cmos5l_nor2_1
* cell instance sg13cmos5l_nor2_1_79 r0 *1 0,0
Xsg13cmos5l_nor2_1_79 \$5079 \$5728 VPWR VGND \$5074 sg13cmos5l_nor2_1
* cell instance sg13cmos5l_nor2_1_80 r0 *1 0,0
Xsg13cmos5l_nor2_1_80 \$4719 \$5307 VPWR VGND \$19886 sg13cmos5l_nor2_1
* cell instance sg13cmos5l_nor2_1_81 r0 *1 0,0
Xsg13cmos5l_nor2_1_81 \$36 \$18 VPWR VGND \$20 sg13cmos5l_nor2_1
* cell instance sg13cmos5l_nor2_1_82 r0 *1 0,0
Xsg13cmos5l_nor2_1_82 \$65 \$79 VPWR VGND \$1186 sg13cmos5l_nor2_1
* cell instance sg13cmos5l_nor2_1_83 r0 *1 0,0
Xsg13cmos5l_nor2_1_83 \$259 \$931 VPWR VGND \$1067 sg13cmos5l_nor2_1
* cell instance sg13cmos5l_nor2_1_84 r0 *1 0,0
Xsg13cmos5l_nor2_1_84 \$36 \$43 VPWR VGND \$125 sg13cmos5l_nor2_1
* cell instance sg13cmos5l_nor2_1_85 r0 *1 0,0
Xsg13cmos5l_nor2_1_85 \$3930 \$3052 VPWR VGND \$3014 sg13cmos5l_nor2_1
* cell instance sg13cmos5l_nor2_1_86 r0 *1 0,0
Xsg13cmos5l_nor2_1_86 \$3930 \$3759 VPWR VGND \$4092 sg13cmos5l_nor2_1
* cell instance sg13cmos5l_nor2_1_87 r0 *1 0,0
Xsg13cmos5l_nor2_1_87 \$1892 \$1678 VPWR VGND \$1677 sg13cmos5l_nor2_1
* cell instance sg13cmos5l_nor2_1_88 r0 *1 0,0
Xsg13cmos5l_nor2_1_88 \$306 \$415 VPWR VGND \$416 sg13cmos5l_nor2_1
* cell instance sg13cmos5l_nor2_1_89 r0 *1 0,0
Xsg13cmos5l_nor2_1_89 \$65 \$306 VPWR VGND \$938 sg13cmos5l_nor2_1
* cell instance sg13cmos5l_nor2_1_90 r0 *1 0,0
Xsg13cmos5l_nor2_1_90 \$3758 \$3759 VPWR VGND \$3933 sg13cmos5l_nor2_1
* cell instance sg13cmos5l_nor2_1_91 r0 *1 0,0
Xsg13cmos5l_nor2_1_91 \$152 \$251 VPWR VGND \$267 sg13cmos5l_nor2_1
* cell instance sg13cmos5l_nor2_1_92 r0 *1 0,0
Xsg13cmos5l_nor2_1_92 \$1790 \$1796 VPWR VGND \$1896 sg13cmos5l_nor2_1
* cell instance sg13cmos5l_nor2_1_93 r0 *1 0,0
Xsg13cmos5l_nor2_1_93 \$807 \$1430 VPWR VGND \$530 sg13cmos5l_nor2_1
* cell instance sg13cmos5l_nor2_1_94 r0 *1 0,0
Xsg13cmos5l_nor2_1_94 \$2827 \$2529 VPWR VGND \$2834 sg13cmos5l_nor2_1
* cell instance sg13cmos5l_nor2_1_95 r0 *1 0,0
Xsg13cmos5l_nor2_1_95 \$3413 \$3412 VPWR VGND \$3231 sg13cmos5l_nor2_1
* cell instance sg13cmos5l_nor2_1_96 r0 *1 0,0
Xsg13cmos5l_nor2_1_96 \$525 \$411 VPWR VGND \$532 sg13cmos5l_nor2_1
* cell instance sg13cmos5l_nor2_1_97 r0 *1 0,0
Xsg13cmos5l_nor2_1_97 \$2691 \$2388 VPWR VGND \$3236 sg13cmos5l_nor2_1
* cell instance sg13cmos5l_nor2_1_98 r0 *1 0,0
Xsg13cmos5l_nor2_1_98 \$290 \$251 VPWR VGND \$274 sg13cmos5l_nor2_1
* cell instance sg13cmos5l_nor2_1_99 r0 *1 0,0
Xsg13cmos5l_nor2_1_99 \$1899 \$1415 VPWR VGND \$1901 sg13cmos5l_nor2_1
* cell instance sg13cmos5l_nor2_1_100 r0 *1 0,0
Xsg13cmos5l_nor2_1_100 \$24 \$533 VPWR VGND \$1686 sg13cmos5l_nor2_1
* cell instance sg13cmos5l_nor2_1_101 r0 *1 0,0
Xsg13cmos5l_nor2_1_101 \$4547 \$4400 VPWR VGND \$4724 sg13cmos5l_nor2_1
* cell instance sg13cmos5l_nor2_1_102 r0 *1 0,0
Xsg13cmos5l_nor2_1_102 \$164 \$796 VPWR VGND \$963 sg13cmos5l_nor2_1
* cell instance sg13cmos5l_nor2_1_103 r0 *1 0,0
Xsg13cmos5l_nor2_1_103 \$646 \$1191 VPWR VGND \$1888 sg13cmos5l_nor2_1
* cell instance sg13cmos5l_nor2_1_104 r0 *1 0,0
Xsg13cmos5l_nor2_1_104 \$4550 \$4228 VPWR VGND \$4323 sg13cmos5l_nor2_1
* cell instance sg13cmos5l_nor2_1_105 r0 *1 0,0
Xsg13cmos5l_nor2_1_105 \$103 \$25 VPWR VGND \$26 sg13cmos5l_nor2_1
* cell instance sg13cmos5l_nor2_1_106 r0 *1 0,0
Xsg13cmos5l_nor2_1_106 \$3614 \$3433 VPWR VGND \$3129 sg13cmos5l_nor2_1
* cell instance sg13cmos5l_nor2_1_107 r0 *1 0,0
Xsg13cmos5l_nor2_1_107 \$1165 \$3373 VPWR VGND \$3423 sg13cmos5l_nor2_1
* cell instance sg13cmos5l_nor2_1_108 r0 *1 0,0
Xsg13cmos5l_nor2_1_108 \$5335 \$3087 VPWR VGND \$5336 sg13cmos5l_nor2_1
* cell instance sg13cmos5l_nor2_1_109 r0 *1 0,0
Xsg13cmos5l_nor2_1_109 \$2554 \$2555 VPWR VGND \$1559 sg13cmos5l_nor2_1
* cell instance sg13cmos5l_nor2_1_110 r0 *1 0,0
Xsg13cmos5l_nor2_1_110 \$525 \$1079 VPWR VGND \$1080 sg13cmos5l_nor2_1
* cell instance sg13cmos5l_nor2_1_111 r0 *1 0,0
Xsg13cmos5l_nor2_1_111 \$4942 \$3087 VPWR VGND \$4943 sg13cmos5l_nor2_1
* cell instance sg13cmos5l_nor2_1_112 r0 *1 0,0
Xsg13cmos5l_nor2_1_112 \$4561 \$4562 VPWR VGND \$4666 sg13cmos5l_nor2_1
* cell instance sg13cmos5l_nor2_1_113 r0 *1 0,0
Xsg13cmos5l_nor2_1_113 \$4562 \$4229 VPWR VGND \$3628 sg13cmos5l_nor2_1
* cell instance sg13cmos5l_nor2_1_114 r0 *1 0,0
Xsg13cmos5l_nor2_1_114 \$37 \$94 VPWR VGND \$29 sg13cmos5l_nor2_1
* cell instance sg13cmos5l_nor2_1_115 r0 *1 0,0
Xsg13cmos5l_nor2_1_115 \$864 \$2434 VPWR VGND \$4405 sg13cmos5l_nor2_1
* cell instance sg13cmos5l_nor2_1_116 r0 *1 0,0
Xsg13cmos5l_nor2_1_116 \$5027 \$3087 VPWR VGND \$5135 sg13cmos5l_nor2_1
* cell instance sg13cmos5l_nor2_1_117 r0 *1 0,0
Xsg13cmos5l_nor2_1_117 \$2722 \$539 VPWR VGND \$2132 sg13cmos5l_nor2_1
* cell instance sg13cmos5l_nor2_1_118 r0 *1 0,0
Xsg13cmos5l_nor2_1_118 \$5500 \$2434 VPWR VGND \$3951 sg13cmos5l_nor2_1
* cell instance sg13cmos5l_nor2_1_119 r0 *1 0,0
Xsg13cmos5l_nor2_1_119 \$3783 \$3441 VPWR VGND \$3620 sg13cmos5l_nor2_1
* cell instance sg13cmos5l_nor2_1_120 r0 *1 0,0
Xsg13cmos5l_nor2_1_120 \$3762 \$3782 VPWR VGND \$647 sg13cmos5l_nor2_1
* cell instance sg13cmos5l_nor2_1_121 r0 *1 0,0
Xsg13cmos5l_nor2_1_121 \$4556 \$4403 VPWR VGND \$4572 sg13cmos5l_nor2_1
* cell instance sg13cmos5l_nor2_1_122 r0 *1 0,0
Xsg13cmos5l_nor2_1_122 \$4562 \$3955 VPWR VGND \$3954 sg13cmos5l_nor2_1
* cell instance sg13cmos5l_nor2_1_123 r0 *1 0,0
Xsg13cmos5l_nor2_1_123 \$20183 \$222 VPWR VGND \$20199 sg13cmos5l_nor2_1
* cell instance sg13cmos5l_nor2_1_124 r0 *1 0,0
Xsg13cmos5l_nor2_1_124 \$3288 \$3447 VPWR VGND \$3446 sg13cmos5l_nor2_1
* cell instance sg13cmos5l_nor2_1_125 r0 *1 0,0
Xsg13cmos5l_nor2_1_125 \$102 \$561 VPWR VGND \$2725 sg13cmos5l_nor2_1
* cell instance sg13cmos5l_nor2_1_126 r0 *1 0,0
Xsg13cmos5l_nor2_1_126 \$5350 \$3628 VPWR VGND \$5568 sg13cmos5l_nor2_1
* cell instance sg13cmos5l_nor2_1_127 r0 *1 0,0
Xsg13cmos5l_nor2_1_127 \$1086 \$1087 VPWR VGND \$1088 sg13cmos5l_nor2_1
* cell instance sg13cmos5l_nor2_1_128 r0 *1 0,0
Xsg13cmos5l_nor2_1_128 \$3448 \$3445 VPWR VGND \$3447 sg13cmos5l_nor2_1
* cell instance sg13cmos5l_nor2_1_129 r0 *1 0,0
Xsg13cmos5l_nor2_1_129 \$100 \$102 VPWR VGND \$1695 sg13cmos5l_nor2_1
* cell instance sg13cmos5l_nor2_1_130 r0 *1 0,0
Xsg13cmos5l_nor2_1_130 \$3628 \$647 VPWR VGND \$2890 sg13cmos5l_nor2_1
* cell instance sg13cmos5l_nor2_1_131 r0 *1 0,0
Xsg13cmos5l_nor2_1_131 \$3283 \$3630 VPWR VGND \$3284 sg13cmos5l_nor2_1
* cell instance sg13cmos5l_nor2_1_132 r0 *1 0,0
Xsg13cmos5l_nor2_1_132 \$2975 \$3087 VPWR VGND \$3098 sg13cmos5l_nor2_1
* cell instance sg13cmos5l_nor2_1_133 r0 *1 0,0
Xsg13cmos5l_nor2_1_133 \$119 \$688 VPWR VGND \$104 sg13cmos5l_nor2_1
* cell instance sg13cmos5l_nor2_1_134 r0 *1 0,0
Xsg13cmos5l_nor2_1_134 \$20192 \$222 VPWR VGND \$20204 sg13cmos5l_nor2_1
* cell instance sg13cmos5l_nor2_1_135 r0 *1 0,0
Xsg13cmos5l_nor2_1_135 \$119 \$116 VPWR VGND \$1090 sg13cmos5l_nor2_1
* cell instance sg13cmos5l_nor2_1_136 r0 *1 0,0
Xsg13cmos5l_nor2_1_136 \$20114 \$222 VPWR VGND \$20205 sg13cmos5l_nor2_1
* cell instance sg13cmos5l_nor2_1_137 r0 *1 0,0
Xsg13cmos5l_nor2_1_137 \$2217 \$2977 VPWR VGND \$3111 sg13cmos5l_nor2_1
* cell instance sg13cmos5l_nor2_1_138 r0 *1 0,0
Xsg13cmos5l_nor2_1_138 \$20189 \$222 VPWR VGND \$20206 sg13cmos5l_nor2_1
* cell instance sg13cmos5l_nor2_1_139 r0 *1 0,0
Xsg13cmos5l_nor2_1_139 \$2240 \$105 VPWR VGND \$1341 sg13cmos5l_nor2_1
* cell instance sg13cmos5l_nor2_1_140 r0 *1 0,0
Xsg13cmos5l_nor2_1_140 \$4252 \$4250 VPWR VGND \$4329 sg13cmos5l_nor2_1
* cell instance sg13cmos5l_nor2_1_141 r0 *1 0,0
Xsg13cmos5l_nor2_1_141 \$252 \$177 VPWR VGND \$300 sg13cmos5l_nor2_1
* cell instance sg13cmos5l_nor2_1_142 r0 *1 0,0
Xsg13cmos5l_nor2_1_142 \$959 \$1097 VPWR VGND \$917 sg13cmos5l_nor2_1
* cell instance sg13cmos5l_nor2_1_143 r0 *1 0,0
Xsg13cmos5l_nor2_1_143 \$3640 \$647 VPWR VGND \$3473 sg13cmos5l_nor2_1
* cell instance sg13cmos5l_nor2_1_144 r0 *1 0,0
Xsg13cmos5l_nor2_1_144 \$3641 \$4235 VPWR VGND \$3640 sg13cmos5l_nor2_1
* cell instance sg13cmos5l_nor2_1_145 r0 *1 0,0
Xsg13cmos5l_nor2_1_145 \$3298 \$3299 VPWR VGND \$3025 sg13cmos5l_nor2_1
* cell instance sg13cmos5l_nor2_1_146 r0 *1 0,0
Xsg13cmos5l_nor2_1_146 \$551 \$965 VPWR VGND \$1092 sg13cmos5l_nor2_1
* cell instance sg13cmos5l_nor2_1_147 r0 *1 0,0
Xsg13cmos5l_nor2_1_147 \$2554 \$2021 VPWR VGND \$1582 sg13cmos5l_nor2_1
* cell instance sg13cmos5l_nor2_1_148 r0 *1 0,0
Xsg13cmos5l_nor2_1_148 \$649 \$52 VPWR VGND \$134 sg13cmos5l_nor2_1
* cell instance sg13cmos5l_nor2_1_149 r0 *1 0,0
Xsg13cmos5l_nor2_1_149 \$118 \$116 VPWR VGND \$1194 sg13cmos5l_nor2_1
* cell instance sg13cmos5l_nor2_1_150 r0 *1 0,0
Xsg13cmos5l_nor2_1_150 \$3133 \$3300 VPWR VGND \$2432 sg13cmos5l_nor2_1
* cell instance sg13cmos5l_nor2_1_151 r0 *1 0,0
Xsg13cmos5l_nor2_1_151 \$688 \$833 VPWR VGND \$446 sg13cmos5l_nor2_1
* cell instance sg13cmos5l_nor2_1_152 r0 *1 0,0
Xsg13cmos5l_nor2_1_152 \$151 \$559 VPWR VGND \$558 sg13cmos5l_nor2_1
* cell instance sg13cmos5l_nor2_1_153 r0 *1 0,0
Xsg13cmos5l_nor2_1_153 \$4424 \$2977 VPWR VGND \$4607 sg13cmos5l_nor2_1
* cell instance sg13cmos5l_nor2_1_154 r0 *1 0,0
Xsg13cmos5l_nor2_1_154 \$118 \$157 VPWR VGND \$559 sg13cmos5l_nor2_1
* cell instance sg13cmos5l_nor2_1_155 r0 *1 0,0
Xsg13cmos5l_nor2_1_155 \$2435 \$2436 VPWR VGND \$2805 sg13cmos5l_nor2_1
* cell instance sg13cmos5l_nor2_1_156 r0 *1 0,0
Xsg13cmos5l_nor2_1_156 \$3248 \$2049 VPWR VGND \$2050 sg13cmos5l_nor2_1
* cell instance sg13cmos5l_nor2_1_157 r0 *1 0,0
Xsg13cmos5l_nor2_1_157 \$103 \$133 VPWR VGND \$136 sg13cmos5l_nor2_1
* cell instance sg13cmos5l_nor2_1_158 r0 *1 0,0
Xsg13cmos5l_nor2_1_158 \$4425 \$2977 VPWR VGND \$4426 sg13cmos5l_nor2_1
* cell instance sg13cmos5l_nor2_1_159 r0 *1 0,0
Xsg13cmos5l_nor2_1_159 \$3133 \$2907 VPWR VGND \$3134 sg13cmos5l_nor2_1
* cell instance sg13cmos5l_nor2_1_160 r0 *1 0,0
Xsg13cmos5l_nor2_1_160 \$1494 \$4119 VPWR VGND \$4121 sg13cmos5l_nor2_1
* cell instance sg13cmos5l_nor2_1_161 r0 *1 0,0
Xsg13cmos5l_nor2_1_161 \$4121 \$4122 VPWR VGND \$2759 sg13cmos5l_nor2_1
* cell instance sg13cmos5l_nor2_1_162 r0 *1 0,0
Xsg13cmos5l_nor2_1_162 \$2291 \$2755 VPWR VGND \$2440 sg13cmos5l_nor2_1
* cell instance sg13cmos5l_nor2_1_163 r0 *1 0,0
Xsg13cmos5l_nor2_1_163 \$4057 \$3983 VPWR VGND \$4122 sg13cmos5l_nor2_1
* cell instance sg13cmos5l_nor2_1_164 r0 *1 0,0
Xsg13cmos5l_nor2_1_164 \$2908 \$2907 VPWR VGND \$2108 sg13cmos5l_nor2_1
* cell instance sg13cmos5l_nor2_1_165 r0 *1 0,0
Xsg13cmos5l_nor2_1_165 \$1356 \$1108 VPWR VGND \$1357 sg13cmos5l_nor2_1
* cell instance sg13cmos5l_nor2_1_166 r0 *1 0,0
Xsg13cmos5l_nor2_1_166 \$648 \$47 VPWR VGND \$137 sg13cmos5l_nor2_1
* cell instance sg13cmos5l_nor2_1_167 r0 *1 0,0
Xsg13cmos5l_nor2_1_167 \$1368 \$1473 VPWR VGND \$1658 sg13cmos5l_nor2_1
* cell instance sg13cmos5l_nor2_1_168 r0 *1 0,0
Xsg13cmos5l_nor2_1_168 \$3705 \$55 VPWR VGND \$3711 sg13cmos5l_nor2_1
* cell instance sg13cmos5l_nor2_1_169 r0 *1 0,0
Xsg13cmos5l_nor2_1_169 \$2580 \$2586 VPWR VGND \$2585 sg13cmos5l_nor2_1
* cell instance sg13cmos5l_nor2_1_170 r0 *1 0,0
Xsg13cmos5l_nor2_1_170 \$2902 \$2586 VPWR VGND \$1724 sg13cmos5l_nor2_1
* cell instance sg13cmos5l_nor2_1_171 r0 *1 0,0
Xsg13cmos5l_nor2_1_171 \$2588 \$1361 VPWR VGND \$2439 sg13cmos5l_nor2_1
* cell instance sg13cmos5l_nor2_1_172 r0 *1 0,0
Xsg13cmos5l_nor2_1_172 \$2902 \$3136 VPWR VGND \$1365 sg13cmos5l_nor2_1
* cell instance sg13cmos5l_nor2_1_173 r0 *1 0,0
Xsg13cmos5l_nor2_1_173 \$55 \$1008 VPWR VGND \$1819 sg13cmos5l_nor2_1
* cell instance sg13cmos5l_nor2_1_174 r0 *1 0,0
Xsg13cmos5l_nor2_1_174 \$64 \$1242 VPWR VGND \$1167 sg13cmos5l_nor2_1
* cell instance sg13cmos5l_nor2_1_175 r0 *1 0,0
Xsg13cmos5l_nor2_1_175 \$1952 \$4615 VPWR VGND \$4995 sg13cmos5l_nor2_1
* cell instance sg13cmos5l_nor2_1_176 r0 *1 0,0
Xsg13cmos5l_nor2_1_176 \$20083 \$19970 VPWR VGND \$20214 sg13cmos5l_nor2_1
* cell instance sg13cmos5l_nor2_1_177 r0 *1 0,0
Xsg13cmos5l_nor2_1_177 \$565 \$647 VPWR VGND \$563 sg13cmos5l_nor2_1
* cell instance sg13cmos5l_nor2_1_178 r0 *1 0,0
Xsg13cmos5l_nor2_1_178 \$1231 \$2164 VPWR VGND \$2163 sg13cmos5l_nor2_1
* cell instance sg13cmos5l_nor2_1_179 r0 *1 0,0
Xsg13cmos5l_nor2_1_179 \$3026 \$2431 VPWR VGND \$2909 sg13cmos5l_nor2_1
* cell instance sg13cmos5l_nor2_1_180 r0 *1 0,0
Xsg13cmos5l_nor2_1_180 \$2107 \$1936 VPWR VGND \$2065 sg13cmos5l_nor2_1
* cell instance sg13cmos5l_nor2_1_181 r0 *1 0,0
Xsg13cmos5l_nor2_1_181 \$2156 \$2909 VPWR VGND \$2980 sg13cmos5l_nor2_1
* cell instance sg13cmos5l_nor2_1_182 r0 *1 0,0
Xsg13cmos5l_nor2_1_182 \$1368 \$2295 VPWR VGND \$2444 sg13cmos5l_nor2_1
* cell instance sg13cmos5l_nor2_1_183 r0 *1 0,0
Xsg13cmos5l_nor2_1_183 \$988 \$458 VPWR VGND \$457 sg13cmos5l_nor2_1
* cell instance sg13cmos5l_nor2_1_184 r0 *1 0,0
Xsg13cmos5l_nor2_1_184 \$3313 \$4623 VPWR VGND \$4621 sg13cmos5l_nor2_1
* cell instance sg13cmos5l_nor2_1_185 r0 *1 0,0
Xsg13cmos5l_nor2_1_185 \$1940 \$1944 VPWR VGND \$1933 sg13cmos5l_nor2_1
* cell instance sg13cmos5l_nor2_1_186 r0 *1 0,0
Xsg13cmos5l_nor2_1_186 \$4285 \$4131 VPWR VGND \$4338 sg13cmos5l_nor2_1
* cell instance sg13cmos5l_nor2_1_187 r0 *1 0,0
Xsg13cmos5l_nor2_1_187 \$1236 \$1238 VPWR VGND \$1237 sg13cmos5l_nor2_1
* cell instance sg13cmos5l_nor2_1_188 r0 *1 0,0
Xsg13cmos5l_nor2_1_188 \$4288 \$4274 VPWR VGND \$4289 sg13cmos5l_nor2_1
* cell instance sg13cmos5l_nor2_1_189 r0 *1 0,0
Xsg13cmos5l_nor2_1_189 \$4685 \$4127 VPWR VGND \$6019 sg13cmos5l_nor2_1
* cell instance sg13cmos5l_nor2_1_190 r0 *1 0,0
Xsg13cmos5l_nor2_1_190 \$1240 \$1242 VPWR VGND \$1238 sg13cmos5l_nor2_1
* cell instance sg13cmos5l_nor2_1_191 r0 *1 0,0
Xsg13cmos5l_nor2_1_191 \$2065 \$2172 VPWR VGND \$2300 sg13cmos5l_nor2_1
* cell instance sg13cmos5l_nor2_1_192 r0 *1 0,0
Xsg13cmos5l_nor2_1_192 \$973 \$1106 VPWR VGND \$985 sg13cmos5l_nor2_1
* cell instance sg13cmos5l_nor2_1_193 r0 *1 0,0
Xsg13cmos5l_nor2_1_193 \$2150 \$2173 VPWR VGND \$2172 sg13cmos5l_nor2_1
* cell instance sg13cmos5l_nor2_1_194 r0 *1 0,0
Xsg13cmos5l_nor2_1_194 \$2361 \$2173 VPWR VGND \$2294 sg13cmos5l_nor2_1
* cell instance sg13cmos5l_nor2_1_195 r0 *1 0,0
Xsg13cmos5l_nor2_1_195 \$4293 \$4015 VPWR VGND \$4681 sg13cmos5l_nor2_1
* cell instance sg13cmos5l_nor2_1_196 r0 *1 0,0
Xsg13cmos5l_nor2_1_196 \$4285 \$5700 VPWR VGND \$5653 sg13cmos5l_nor2_1
* cell instance sg13cmos5l_nor2_1_197 r0 *1 0,0
Xsg13cmos5l_nor2_1_197 \$1244 \$1245 VPWR VGND \$1243 sg13cmos5l_nor2_1
* cell instance sg13cmos5l_nor2_1_198 r0 *1 0,0
Xsg13cmos5l_nor2_1_198 \$4285 \$4817 VPWR VGND \$5000 sg13cmos5l_nor2_1
* cell instance sg13cmos5l_nor2_1_199 r0 *1 0,0
Xsg13cmos5l_nor2_1_199 \$4139 \$4004 VPWR VGND \$4003 sg13cmos5l_nor2_1
* cell instance sg13cmos5l_nor2_1_200 r0 *1 0,0
Xsg13cmos5l_nor2_1_200 \$4293 \$4318 VPWR VGND \$5465 sg13cmos5l_nor2_1
* cell instance sg13cmos5l_nor2_1_201 r0 *1 0,0
Xsg13cmos5l_nor2_1_201 \$2180 \$1964 VPWR VGND \$2069 sg13cmos5l_nor2_1
* cell instance sg13cmos5l_nor2_1_202 r0 *1 0,0
Xsg13cmos5l_nor2_1_202 \$1368 \$2302 VPWR VGND \$2304 sg13cmos5l_nor2_1
* cell instance sg13cmos5l_nor2_1_203 r0 *1 0,0
Xsg13cmos5l_nor2_1_203 \$1368 \$1371 VPWR VGND \$1602 sg13cmos5l_nor2_1
* cell instance sg13cmos5l_nor2_1_204 r0 *1 0,0
Xsg13cmos5l_nor2_1_204 \$1584 \$2364 VPWR VGND \$2306 sg13cmos5l_nor2_1
* cell instance sg13cmos5l_nor2_1_205 r0 *1 0,0
Xsg13cmos5l_nor2_1_205 \$4812 \$5421 VPWR VGND \$5700 sg13cmos5l_nor2_1
* cell instance sg13cmos5l_nor2_1_206 r0 *1 0,0
Xsg13cmos5l_nor2_1_206 \$4285 \$5890 VPWR VGND \$5840 sg13cmos5l_nor2_1
* cell instance sg13cmos5l_nor2_1_207 r0 *1 0,0
Xsg13cmos5l_nor2_1_207 \$8236 \$9009 VPWR VGND \$9008 sg13cmos5l_nor2_1
* cell instance sg13cmos5l_nor2_1_208 r0 *1 0,0
Xsg13cmos5l_nor2_1_208 \$19891 \$19892 VPWR VGND \$4774 sg13cmos5l_nor2_1
* cell instance sg13cmos5l_nor2_1_209 r0 *1 0,0
Xsg13cmos5l_nor2_1_209 \$19401 \$5409 VPWR VGND \$19891 sg13cmos5l_nor2_1
* cell instance sg13cmos5l_nor2_1_210 r0 *1 0,0
Xsg13cmos5l_nor2_1_210 \$993 \$862 VPWR VGND \$1251 sg13cmos5l_nor2_1
* cell instance sg13cmos5l_nor2_1_211 r0 *1 0,0
Xsg13cmos5l_nor2_1_211 \$1838 \$1008 VPWR VGND \$1944 sg13cmos5l_nor2_1
* cell instance sg13cmos5l_nor2_1_212 r0 *1 0,0
Xsg13cmos5l_nor2_1_212 \$5890 \$4293 VPWR VGND \$6041 sg13cmos5l_nor2_1
* cell instance sg13cmos5l_nor2_1_213 r0 *1 0,0
Xsg13cmos5l_nor2_1_213 \$16847 \$16365 VPWR VGND \$16662 sg13cmos5l_nor2_1
* cell instance sg13cmos5l_nor2_1_214 r0 *1 0,0
Xsg13cmos5l_nor2_1_214 \$1584 \$2448 VPWR VGND \$2449 sg13cmos5l_nor2_1
* cell instance sg13cmos5l_nor2_1_215 r0 *1 0,0
Xsg13cmos5l_nor2_1_215 \$1833 \$2174 VPWR VGND \$2603 sg13cmos5l_nor2_1
* cell instance sg13cmos5l_nor2_1_216 r0 *1 0,0
Xsg13cmos5l_nor2_1_216 \$4815 \$5223 VPWR VGND \$2929 sg13cmos5l_nor2_1
* cell instance sg13cmos5l_nor2_1_217 r0 *1 0,0
Xsg13cmos5l_nor2_1_217 \$2603 \$2449 VPWR VGND \$2771 sg13cmos5l_nor2_1
* cell instance sg13cmos5l_nor2_1_218 r0 *1 0,0
Xsg13cmos5l_nor2_1_218 \$5890 \$4453 VPWR VGND \$6348 sg13cmos5l_nor2_1
* cell instance sg13cmos5l_nor2_1_219 r0 *1 0,0
Xsg13cmos5l_nor2_1_219 \$9788 \$9183 VPWR VGND \$9241 sg13cmos5l_nor2_1
* cell instance sg13cmos5l_nor2_1_220 r0 *1 0,0
Xsg13cmos5l_nor2_1_220 \$7989 \$9009 VPWR VGND \$11262 sg13cmos5l_nor2_1
* cell instance sg13cmos5l_nor2_1_221 r0 *1 0,0
Xsg13cmos5l_nor2_1_221 \$1835 \$1954 VPWR VGND \$2061 sg13cmos5l_nor2_1
* cell instance sg13cmos5l_nor2_1_222 r0 *1 0,0
Xsg13cmos5l_nor2_1_222 \$7991 \$12050 VPWR VGND \$12255 sg13cmos5l_nor2_1
* cell instance sg13cmos5l_nor2_1_223 r0 *1 0,0
Xsg13cmos5l_nor2_1_223 \$14190 \$13476 VPWR VGND \$13843 sg13cmos5l_nor2_1
* cell instance sg13cmos5l_nor2_1_224 r0 *1 0,0
Xsg13cmos5l_nor2_1_224 \$17835 \$16365 VPWR VGND \$17659 sg13cmos5l_nor2_1
* cell instance sg13cmos5l_nor2_1_225 r0 *1 0,0
Xsg13cmos5l_nor2_1_225 \$5890 \$4683 VPWR VGND \$6349 sg13cmos5l_nor2_1
* cell instance sg13cmos5l_nor2_1_226 r0 *1 0,0
Xsg13cmos5l_nor2_1_226 \$1256 \$1001 VPWR VGND \$2174 sg13cmos5l_nor2_1
* cell instance sg13cmos5l_nor2_1_227 r0 *1 0,0
Xsg13cmos5l_nor2_1_227 \$3868 \$4819 VPWR VGND \$3166 sg13cmos5l_nor2_1
* cell instance sg13cmos5l_nor2_1_228 r0 *1 0,0
Xsg13cmos5l_nor2_1_228 \$8502 \$9009 VPWR VGND \$9424 sg13cmos5l_nor2_1
* cell instance sg13cmos5l_nor2_1_229 r0 *1 0,0
Xsg13cmos5l_nor2_1_229 \$988 \$398 VPWR VGND \$1258 sg13cmos5l_nor2_1
* cell instance sg13cmos5l_nor2_1_230 r0 *1 0,0
Xsg13cmos5l_nor2_1_230 \$4466 \$5003 VPWR VGND \$4822 sg13cmos5l_nor2_1
* cell instance sg13cmos5l_nor2_1_231 r0 *1 0,0
Xsg13cmos5l_nor2_1_231 \$8801 \$13476 VPWR VGND \$12557 sg13cmos5l_nor2_1
* cell instance sg13cmos5l_nor2_1_232 r0 *1 0,0
Xsg13cmos5l_nor2_1_232 \$4821 \$4822 VPWR VGND \$4819 sg13cmos5l_nor2_1
* cell instance sg13cmos5l_nor2_1_233 r0 *1 0,0
Xsg13cmos5l_nor2_1_233 \$3865 \$6515 VPWR VGND \$6581 sg13cmos5l_nor2_1
* cell instance sg13cmos5l_nor2_1_234 r0 *1 0,0
Xsg13cmos5l_nor2_1_234 \$8504 \$9009 VPWR VGND \$10601 sg13cmos5l_nor2_1
* cell instance sg13cmos5l_nor2_1_235 r0 *1 0,0
Xsg13cmos5l_nor2_1_235 \$7993 \$12050 VPWR VGND \$11880 sg13cmos5l_nor2_1
* cell instance sg13cmos5l_nor2_1_236 r0 *1 0,0
Xsg13cmos5l_nor2_1_236 \$14613 \$14614 VPWR VGND \$14690 sg13cmos5l_nor2_1
* cell instance sg13cmos5l_nor2_1_237 r0 *1 0,0
Xsg13cmos5l_nor2_1_237 \$8510 \$9183 VPWR VGND \$9427 sg13cmos5l_nor2_1
* cell instance sg13cmos5l_nor2_1_238 r0 *1 0,0
Xsg13cmos5l_nor2_1_238 \$9369 \$9183 VPWR VGND \$9242 sg13cmos5l_nor2_1
* cell instance sg13cmos5l_nor2_1_239 r0 *1 0,0
Xsg13cmos5l_nor2_1_239 \$901 \$740 VPWR VGND \$870 sg13cmos5l_nor2_1
* cell instance sg13cmos5l_nor2_1_240 r0 *1 0,0
Xsg13cmos5l_nor2_1_240 \$17339 \$14614 VPWR VGND \$16321 sg13cmos5l_nor2_1
* cell instance sg13cmos5l_nor2_1_241 r0 *1 0,0
Xsg13cmos5l_nor2_1_241 \$579 \$740 VPWR VGND \$1126 sg13cmos5l_nor2_1
* cell instance sg13cmos5l_nor2_1_242 r0 *1 0,0
Xsg13cmos5l_nor2_1_242 \$17844 \$14614 VPWR VGND \$17842 sg13cmos5l_nor2_1
* cell instance sg13cmos5l_nor2_1_243 r0 *1 0,0
Xsg13cmos5l_nor2_1_243 \$9627 \$9789 VPWR VGND \$9430 sg13cmos5l_nor2_1
* cell instance sg13cmos5l_nor2_1_244 r0 *1 0,0
Xsg13cmos5l_nor2_1_244 \$7994 \$12050 VPWR VGND \$13000 sg13cmos5l_nor2_1
* cell instance sg13cmos5l_nor2_1_245 r0 *1 0,0
Xsg13cmos5l_nor2_1_245 \$7871 \$13476 VPWR VGND \$14191 sg13cmos5l_nor2_1
* cell instance sg13cmos5l_nor2_1_246 r0 *1 0,0
Xsg13cmos5l_nor2_1_246 \$625 \$862 VPWR VGND \$1134 sg13cmos5l_nor2_1
* cell instance sg13cmos5l_nor2_1_247 r0 *1 0,0
Xsg13cmos5l_nor2_1_247 \$8511 \$11903 VPWR VGND \$11714 sg13cmos5l_nor2_1
* cell instance sg13cmos5l_nor2_1_248 r0 *1 0,0
Xsg13cmos5l_nor2_1_248 \$17845 \$4421 VPWR VGND \$17665 sg13cmos5l_nor2_1
* cell instance sg13cmos5l_nor2_1_249 r0 *1 0,0
Xsg13cmos5l_nor2_1_249 \$4685 \$4466 VPWR VGND \$4465 sg13cmos5l_nor2_1
* cell instance sg13cmos5l_nor2_1_250 r0 *1 0,0
Xsg13cmos5l_nor2_1_250 \$7872 \$9789 VPWR VGND \$10931 sg13cmos5l_nor2_1
* cell instance sg13cmos5l_nor2_1_251 r0 *1 0,0
Xsg13cmos5l_nor2_1_251 \$4821 \$4466 VPWR VGND \$4631 sg13cmos5l_nor2_1
* cell instance sg13cmos5l_nor2_1_252 r0 *1 0,0
Xsg13cmos5l_nor2_1_252 \$4821 \$4490 VPWR VGND \$4682 sg13cmos5l_nor2_1
* cell instance sg13cmos5l_nor2_1_253 r0 *1 0,0
Xsg13cmos5l_nor2_1_253 \$9373 \$9026 VPWR VGND \$9024 sg13cmos5l_nor2_1
* cell instance sg13cmos5l_nor2_1_254 r0 *1 0,0
Xsg13cmos5l_nor2_1_254 \$15215 \$14614 VPWR VGND \$14764 sg13cmos5l_nor2_1
* cell instance sg13cmos5l_nor2_1_255 r0 *1 0,0
Xsg13cmos5l_nor2_1_255 \$4685 \$3868 VPWR VGND \$4826 sg13cmos5l_nor2_1
* cell instance sg13cmos5l_nor2_1_256 r0 *1 0,0
Xsg13cmos5l_nor2_1_256 \$8512 \$13003 VPWR VGND \$13703 sg13cmos5l_nor2_1
* cell instance sg13cmos5l_nor2_1_257 r0 *1 0,0
Xsg13cmos5l_nor2_1_257 \$3865 \$2316 VPWR VGND \$3866 sg13cmos5l_nor2_1
* cell instance sg13cmos5l_nor2_1_258 r0 *1 0,0
Xsg13cmos5l_nor2_1_258 \$16325 \$14614 VPWR VGND \$16324 sg13cmos5l_nor2_1
* cell instance sg13cmos5l_nor2_1_259 r0 *1 0,0
Xsg13cmos5l_nor2_1_259 \$5428 \$6520 VPWR VGND \$7537 sg13cmos5l_nor2_1
* cell instance sg13cmos5l_nor2_1_260 r0 *1 0,0
Xsg13cmos5l_nor2_1_260 \$4618 \$4026 VPWR VGND \$4186 sg13cmos5l_nor2_1
* cell instance sg13cmos5l_nor2_1_261 r0 *1 0,0
Xsg13cmos5l_nor2_1_261 \$2200 \$862 VPWR VGND \$2084 sg13cmos5l_nor2_1
* cell instance sg13cmos5l_nor2_1_262 r0 *1 0,0
Xsg13cmos5l_nor2_1_262 \$8503 \$9789 VPWR VGND \$10932 sg13cmos5l_nor2_1
* cell instance sg13cmos5l_nor2_1_263 r0 *1 0,0
Xsg13cmos5l_nor2_1_263 \$3865 \$2340 VPWR VGND \$3870 sg13cmos5l_nor2_1
* cell instance sg13cmos5l_nor2_1_264 r0 *1 0,0
Xsg13cmos5l_nor2_1_264 \$7992 \$9789 VPWR VGND \$9411 sg13cmos5l_nor2_1
* cell instance sg13cmos5l_nor2_1_265 r0 *1 0,0
Xsg13cmos5l_nor2_1_265 \$8238 \$13003 VPWR VGND \$14329 sg13cmos5l_nor2_1
* cell instance sg13cmos5l_nor2_1_266 r0 *1 0,0
Xsg13cmos5l_nor2_1_266 \$8809 \$11903 VPWR VGND \$11904 sg13cmos5l_nor2_1
* cell instance sg13cmos5l_nor2_1_267 r0 *1 0,0
Xsg13cmos5l_nor2_1_267 \$8513 \$13003 VPWR VGND \$13002 sg13cmos5l_nor2_1
* cell instance sg13cmos5l_nor2_1_268 r0 *1 0,0
Xsg13cmos5l_nor2_1_268 \$8514 \$9026 VPWR VGND \$9028 sg13cmos5l_nor2_1
* cell instance sg13cmos5l_nor2_1_269 r0 *1 0,0
Xsg13cmos5l_nor2_1_269 \$8241 \$6348 VPWR VGND \$10608 sg13cmos5l_nor2_1
* cell instance sg13cmos5l_nor2_1_270 r0 *1 0,0
Xsg13cmos5l_nor2_1_270 \$7998 \$6041 VPWR VGND \$9628 sg13cmos5l_nor2_1
* cell instance sg13cmos5l_nor2_1_271 r0 *1 0,0
Xsg13cmos5l_nor2_1_271 \$11411 \$11903 VPWR VGND \$11412 sg13cmos5l_nor2_1
* cell instance sg13cmos5l_nor2_1_272 r0 *1 0,0
Xsg13cmos5l_nor2_1_272 \$8400 \$6349 VPWR VGND \$14521 sg13cmos5l_nor2_1
* cell instance sg13cmos5l_nor2_1_273 r0 *1 0,0
Xsg13cmos5l_nor2_1_273 \$8515 \$11903 VPWR VGND \$12223 sg13cmos5l_nor2_1
* cell instance sg13cmos5l_nor2_1_274 r0 *1 0,0
Xsg13cmos5l_nor2_1_274 \$8242 \$9026 VPWR VGND \$9383 sg13cmos5l_nor2_1
* cell instance sg13cmos5l_nor2_1_275 r0 *1 0,0
Xsg13cmos5l_nor2_1_275 \$9205 \$9026 VPWR VGND \$9030 sg13cmos5l_nor2_1
* cell instance sg13cmos5l_nor2_1_276 r0 *1 0,0
Xsg13cmos5l_nor2_1_276 \$8516 \$13003 VPWR VGND \$13480 sg13cmos5l_nor2_1
* cell instance sg13cmos5l_nor2b_1_0 r0 *1 0,0
Xsg13cmos5l_nor2b_1_0 \$4199 \$3910 VPWR VGND \$4203 sg13cmos5l_nor2b_1
* cell instance sg13cmos5l_nor2b_1_1 r0 *1 0,0
Xsg13cmos5l_nor2b_1_1 \$5295 \$5485 VPWR VGND \$4874 sg13cmos5l_nor2b_1
* cell instance sg13cmos5l_nor2b_1_2 r0 *1 0,0
Xsg13cmos5l_nor2b_1_2 \$11700 \$11740 VPWR VGND \$13839 sg13cmos5l_nor2b_1
* cell instance sg13cmos5l_nor2b_1_3 r0 *1 0,0
Xsg13cmos5l_nor2b_1_3 \$9283 \$11740 VPWR VGND \$11702 sg13cmos5l_nor2b_1
* cell instance sg13cmos5l_nor2b_1_4 r0 *1 0,0
Xsg13cmos5l_nor2b_1_4 \$8007 \$12720 VPWR VGND \$14539 sg13cmos5l_nor2b_1
* cell instance sg13cmos5l_nor2b_1_5 r0 *1 0,0
Xsg13cmos5l_nor2b_1_5 \$6397 \$11740 VPWR VGND \$13236 sg13cmos5l_nor2b_1
* cell instance sg13cmos5l_nor2b_1_6 r0 *1 0,0
Xsg13cmos5l_nor2b_1_6 \$8531 \$11740 VPWR VGND \$12133 sg13cmos5l_nor2b_1
* cell instance sg13cmos5l_nor2b_1_7 r0 *1 0,0
Xsg13cmos5l_nor2b_1_7 \$5738 \$11741 VPWR VGND \$11271 sg13cmos5l_nor2b_1
* cell instance sg13cmos5l_nor2b_1_8 r0 *1 0,0
Xsg13cmos5l_nor2b_1_8 \$8218 \$11741 VPWR VGND \$12136 sg13cmos5l_nor2b_1
* cell instance sg13cmos5l_nor2b_1_9 r0 *1 0,0
Xsg13cmos5l_nor2b_1_9 \$9331 \$11741 VPWR VGND \$12137 sg13cmos5l_nor2b_1
* cell instance sg13cmos5l_nor2b_1_10 r0 *1 0,0
Xsg13cmos5l_nor2b_1_10 \$3230 \$3412 VPWR VGND \$3416 sg13cmos5l_nor2b_1
* cell instance sg13cmos5l_nor2b_1_11 r0 *1 0,0
Xsg13cmos5l_nor2b_1_11 \$2717 \$3760 VPWR VGND \$3777 sg13cmos5l_nor2b_1
* cell instance sg13cmos5l_nor2b_1_12 r0 *1 0,0
Xsg13cmos5l_nor2b_1_12 \$20157 \$5469 VPWR VGND \$20064 sg13cmos5l_nor2b_1
* cell instance sg13cmos5l_nor2b_1_13 r0 *1 0,0
Xsg13cmos5l_nor2b_1_13 \$20164 \$5469 VPWR VGND \$20007 sg13cmos5l_nor2b_1
* cell instance sg13cmos5l_nor2b_1_14 r0 *1 0,0
Xsg13cmos5l_nor2b_1_14 \$20169 \$5469 VPWR VGND \$20008 sg13cmos5l_nor2b_1
* cell instance sg13cmos5l_nor2b_1_15 r0 *1 0,0
Xsg13cmos5l_nor2b_1_15 \$4235 \$4911 VPWR VGND \$2802 sg13cmos5l_nor2b_1
* cell instance sg13cmos5l_nor2b_1_16 r0 *1 0,0
Xsg13cmos5l_nor2b_1_16 \$20172 \$5469 VPWR VGND \$20057 sg13cmos5l_nor2b_1
* cell instance sg13cmos5l_nor2b_1_17 r0 *1 0,0
Xsg13cmos5l_nor2b_1_17 \$3762 \$3783 VPWR VGND \$4234 sg13cmos5l_nor2b_1
* cell instance sg13cmos5l_nor2b_1_18 r0 *1 0,0
Xsg13cmos5l_nor2b_1_18 \$2132 \$2548 VPWR VGND \$2559 sg13cmos5l_nor2b_1
* cell instance sg13cmos5l_nor2b_1_19 r0 *1 0,0
Xsg13cmos5l_nor2b_1_19 \$1356 \$1108 VPWR VGND \$1109 sg13cmos5l_nor2b_1
* cell instance sg13cmos5l_nor2b_1_20 r0 *1 0,0
Xsg13cmos5l_nor2b_1_20 \$1929 \$3481 VPWR VGND \$3307 sg13cmos5l_nor2b_1
* cell instance sg13cmos5l_nor2b_1_21 r0 *1 0,0
Xsg13cmos5l_nor2b_1_21 \$1583 \$1492 VPWR VGND \$1493 sg13cmos5l_nor2b_1
* cell instance sg13cmos5l_nor2b_1_22 r0 *1 0,0
Xsg13cmos5l_nor2b_1_22 \$4004 \$4139 VPWR VGND \$4145 sg13cmos5l_nor2b_1
* cell instance sg13cmos5l_nor2b_1_23 r0 *1 0,0
Xsg13cmos5l_nor2b_1_23 \$4425 \$4466 VPWR VGND \$4468 sg13cmos5l_nor2b_1
* cell instance sg13cmos5l_nor3_1_0 r0 *1 0,0
Xsg13cmos5l_nor3_1_0 \$3909 \$4077 \$4076 VPWR VGND \$3910 sg13cmos5l_nor3_1
* cell instance sg13cmos5l_nor3_1_1 r0 *1 0,0
Xsg13cmos5l_nor3_1_1 \$42 \$153 \$78 VPWR VGND \$645 sg13cmos5l_nor3_1
* cell instance sg13cmos5l_nor3_1_2 r0 *1 0,0
Xsg13cmos5l_nor3_1_2 \$103 \$1073 \$1057 VPWR VGND \$1056 sg13cmos5l_nor3_1
* cell instance sg13cmos5l_nor3_1_3 r0 *1 0,0
Xsg13cmos5l_nor3_1_3 \$1789 \$1647 \$1880 VPWR VGND \$1330 sg13cmos5l_nor3_1
* cell instance sg13cmos5l_nor3_1_4 r0 *1 0,0
Xsg13cmos5l_nor3_1_4 \$1647 \$645 \$1880 VPWR VGND \$1883 sg13cmos5l_nor3_1
* cell instance sg13cmos5l_nor3_1_5 r0 *1 0,0
Xsg13cmos5l_nor3_1_5 \$154 \$158 \$159 VPWR VGND \$160 sg13cmos5l_nor3_1
* cell instance sg13cmos5l_nor3_1_6 r0 *1 0,0
Xsg13cmos5l_nor3_1_6 \$651 \$1182 \$1315 VPWR VGND \$1314 sg13cmos5l_nor3_1
* cell instance sg13cmos5l_nor3_1_7 r0 *1 0,0
Xsg13cmos5l_nor3_1_7 \$3705 \$4517 \$4705 VPWR VGND \$4208 sg13cmos5l_nor3_1
* cell instance sg13cmos5l_nor3_1_8 r0 *1 0,0
Xsg13cmos5l_nor3_1_8 \$1579 \$1434 \$1435 VPWR VGND \$1313 sg13cmos5l_nor3_1
* cell instance sg13cmos5l_nor3_1_9 r0 *1 0,0
Xsg13cmos5l_nor3_1_9 \$646 \$416 \$1679 VPWR VGND \$1678 sg13cmos5l_nor3_1
* cell instance sg13cmos5l_nor3_1_10 r0 *1 0,0
Xsg13cmos5l_nor3_1_10 \$657 \$938 \$1079 VPWR VGND \$1068 sg13cmos5l_nor3_1
* cell instance sg13cmos5l_nor3_1_11 r0 *1 0,0
Xsg13cmos5l_nor3_1_11 \$1328 \$1414 \$811 VPWR VGND \$1415 sg13cmos5l_nor3_1
* cell instance sg13cmos5l_nor3_1_12 r0 *1 0,0
Xsg13cmos5l_nor3_1_12 \$4222 \$3427 \$4400 VPWR VGND \$4399 sg13cmos5l_nor3_1
* cell instance sg13cmos5l_nor3_1_13 r0 *1 0,0
Xsg13cmos5l_nor3_1_13 \$1441 \$1071 \$1330 VPWR VGND \$1329 sg13cmos5l_nor3_1
* cell instance sg13cmos5l_nor3_1_14 r0 *1 0,0
Xsg13cmos5l_nor3_1_14 \$1328 \$1329 \$148 VPWR VGND \$1417 sg13cmos5l_nor3_1
* cell instance sg13cmos5l_nor3_1_15 r0 *1 0,0
Xsg13cmos5l_nor3_1_15 \$285 \$18 \$150 VPWR VGND \$92 sg13cmos5l_nor3_1
* cell instance sg13cmos5l_nor3_1_16 r0 *1 0,0
Xsg13cmos5l_nor3_1_16 \$91 \$93 \$28 VPWR VGND \$148 sg13cmos5l_nor3_1
* cell instance sg13cmos5l_nor3_1_17 r0 *1 0,0
Xsg13cmos5l_nor3_1_17 \$50 \$1065 \$1079 VPWR VGND \$1651 sg13cmos5l_nor3_1
* cell instance sg13cmos5l_nor3_1_18 r0 *1 0,0
Xsg13cmos5l_nor3_1_18 \$94 \$420 \$92 VPWR VGND \$90 sg13cmos5l_nor3_1
* cell instance sg13cmos5l_nor3_1_19 r0 *1 0,0
Xsg13cmos5l_nor3_1_19 \$4549 \$4550 \$4664 VPWR VGND \$4731 sg13cmos5l_nor3_1
* cell instance sg13cmos5l_nor3_1_20 r0 *1 0,0
Xsg13cmos5l_nor3_1_20 \$4549 \$4226 \$4664 VPWR VGND \$5099 sg13cmos5l_nor3_1
* cell instance sg13cmos5l_nor3_1_21 r0 *1 0,0
Xsg13cmos5l_nor3_1_21 \$4550 \$4552 \$4547 VPWR VGND \$4663 sg13cmos5l_nor3_1
* cell instance sg13cmos5l_nor3_1_22 r0 *1 0,0
Xsg13cmos5l_nor3_1_22 \$4550 \$4552 \$4664 VPWR VGND \$4665 sg13cmos5l_nor3_1
* cell instance sg13cmos5l_nor3_1_23 r0 *1 0,0
Xsg13cmos5l_nor3_1_23 \$4229 \$4228 \$4226 VPWR VGND \$4230 sg13cmos5l_nor3_1
* cell instance sg13cmos5l_nor3_1_24 r0 *1 0,0
Xsg13cmos5l_nor3_1_24 \$651 \$668 \$423 VPWR VGND \$667 sg13cmos5l_nor3_1
* cell instance sg13cmos5l_nor3_1_25 r0 *1 0,0
Xsg13cmos5l_nor3_1_25 \$4552 \$4226 \$4664 VPWR VGND \$4556 sg13cmos5l_nor3_1
* cell instance sg13cmos5l_nor3_1_26 r0 *1 0,0
Xsg13cmos5l_nor3_1_26 \$817 \$665 \$818 VPWR VGND \$916 sg13cmos5l_nor3_1
* cell instance sg13cmos5l_nor3_1_27 r0 *1 0,0
Xsg13cmos5l_nor3_1_27 \$276 \$662 \$807 VPWR VGND \$818 sg13cmos5l_nor3_1
* cell instance sg13cmos5l_nor3_1_28 r0 *1 0,0
Xsg13cmos5l_nor3_1_28 \$1801 \$1341 \$421 VPWR VGND \$2129 sg13cmos5l_nor3_1
* cell instance sg13cmos5l_nor3_1_29 r0 *1 0,0
Xsg13cmos5l_nor3_1_29 \$1173 \$1907 \$937 VPWR VGND \$1908 sg13cmos5l_nor3_1
* cell instance sg13cmos5l_nor3_1_30 r0 *1 0,0
Xsg13cmos5l_nor3_1_30 \$3708 \$3048 \$3396 VPWR VGND \$3616 sg13cmos5l_nor3_1
* cell instance sg13cmos5l_nor3_1_31 r0 *1 0,0
Xsg13cmos5l_nor3_1_31 \$290 \$1079 \$925 VPWR VGND \$948 sg13cmos5l_nor3_1
* cell instance sg13cmos5l_nor3_1_32 r0 *1 0,0
Xsg13cmos5l_nor3_1_32 \$819 \$668 \$948 VPWR VGND \$8 sg13cmos5l_nor3_1
* cell instance sg13cmos5l_nor3_1_33 r0 *1 0,0
Xsg13cmos5l_nor3_1_33 \$2554 \$1065 \$2035 VPWR VGND \$2032 sg13cmos5l_nor3_1
* cell instance sg13cmos5l_nor3_1_34 r0 *1 0,0
Xsg13cmos5l_nor3_1_34 \$2556 \$798 \$1316 VPWR VGND \$2424 sg13cmos5l_nor3_1
* cell instance sg13cmos5l_nor3_1_35 r0 *1 0,0
Xsg13cmos5l_nor3_1_35 \$294 \$669 \$660 VPWR VGND \$668 sg13cmos5l_nor3_1
* cell instance sg13cmos5l_nor3_1_36 r0 *1 0,0
Xsg13cmos5l_nor3_1_36 \$5346 \$3628 \$3784 VPWR VGND \$5347 sg13cmos5l_nor3_1
* cell instance sg13cmos5l_nor3_1_37 r0 *1 0,0
Xsg13cmos5l_nor3_1_37 \$669 \$2562 \$2559 VPWR VGND \$2563 sg13cmos5l_nor3_1
* cell instance sg13cmos5l_nor3_1_38 r0 *1 0,0
Xsg13cmos5l_nor3_1_38 \$2554 \$2561 \$2725 VPWR VGND \$2562 sg13cmos5l_nor3_1
* cell instance sg13cmos5l_nor3_1_39 r0 *1 0,0
Xsg13cmos5l_nor3_1_39 \$660 \$1441 \$307 VPWR VGND \$1447 sg13cmos5l_nor3_1
* cell instance sg13cmos5l_nor3_1_40 r0 *1 0,0
Xsg13cmos5l_nor3_1_40 \$4560 \$20064 \$20199 VPWR VGND \$6014 sg13cmos5l_nor3_1
* cell instance sg13cmos5l_nor3_1_41 r0 *1 0,0
Xsg13cmos5l_nor3_1_41 \$4560 \$20204 \$20057 VPWR VGND \$2310 sg13cmos5l_nor3_1
* cell instance sg13cmos5l_nor3_1_42 r0 *1 0,0
Xsg13cmos5l_nor3_1_42 \$120 \$1344 \$1090 VPWR VGND \$1452 sg13cmos5l_nor3_1
* cell instance sg13cmos5l_nor3_1_43 r0 *1 0,0
Xsg13cmos5l_nor3_1_43 \$1913 \$93 \$2117 VPWR VGND \$2143 sg13cmos5l_nor3_1
* cell instance sg13cmos5l_nor3_1_44 r0 *1 0,0
Xsg13cmos5l_nor3_1_44 \$4560 \$20007 \$20205 VPWR VGND \$5832 sg13cmos5l_nor3_1
* cell instance sg13cmos5l_nor3_1_45 r0 *1 0,0
Xsg13cmos5l_nor3_1_45 \$3641 \$4117 \$4248 VPWR VGND \$4256 sg13cmos5l_nor3_1
* cell instance sg13cmos5l_nor3_1_46 r0 *1 0,0
Xsg13cmos5l_nor3_1_46 \$93 \$1065 \$2035 VPWR VGND \$684 sg13cmos5l_nor3_1
* cell instance sg13cmos5l_nor3_1_47 r0 *1 0,0
Xsg13cmos5l_nor3_1_47 \$2901 \$2900 \$1947 VPWR VGND \$2746 sg13cmos5l_nor3_1
* cell instance sg13cmos5l_nor3_1_48 r0 *1 0,0
Xsg13cmos5l_nor3_1_48 \$648 \$834 \$1101 VPWR VGND \$682 sg13cmos5l_nor3_1
* cell instance sg13cmos5l_nor3_1_49 r0 *1 0,0
Xsg13cmos5l_nor3_1_49 \$2434 \$2291 \$2437 VPWR VGND \$1355 sg13cmos5l_nor3_1
* cell instance sg13cmos5l_nor3_1_50 r0 *1 0,0
Xsg13cmos5l_nor3_1_50 \$4560 \$5830 \$5415 VPWR VGND \$2594 sg13cmos5l_nor3_1
* cell instance sg13cmos5l_nor3_1_51 r0 *1 0,0
Xsg13cmos5l_nor3_1_51 \$4572 \$4616 \$4803 VPWR VGND \$4570 sg13cmos5l_nor3_1
* cell instance sg13cmos5l_nor3_1_52 r0 *1 0,0
Xsg13cmos5l_nor3_1_52 \$4572 \$5213 \$5637 VPWR VGND \$5633 sg13cmos5l_nor3_1
* cell instance sg13cmos5l_nor3_1_53 r0 *1 0,0
Xsg13cmos5l_nor3_1_53 \$4572 \$5642 \$5643 VPWR VGND \$5641 sg13cmos5l_nor3_1
* cell instance sg13cmos5l_nor3_1_54 r0 *1 0,0
Xsg13cmos5l_nor3_1_54 \$4572 \$5417 \$5418 VPWR VGND \$5414 sg13cmos5l_nor3_1
* cell instance sg13cmos5l_nor3_1_55 r0 *1 0,0
Xsg13cmos5l_nor3_1_55 \$3377 \$2760 \$3141 VPWR VGND \$3140 sg13cmos5l_nor3_1
* cell instance sg13cmos5l_nor3_1_56 r0 *1 0,0
Xsg13cmos5l_nor3_1_56 \$2648 \$2761 \$2171 VPWR VGND \$2760 sg13cmos5l_nor3_1
* cell instance sg13cmos5l_nor3_1_57 r0 *1 0,0
Xsg13cmos5l_nor3_1_57 \$2064 \$2169 \$1731 VPWR VGND \$2067 sg13cmos5l_nor3_1
* cell instance sg13cmos5l_nor3_1_58 r0 *1 0,0
Xsg13cmos5l_nor3_1_58 \$1724 \$1824 \$1365 VPWR VGND \$1945 sg13cmos5l_nor3_1
* cell instance sg13cmos5l_nor3_1_59 r0 *1 0,0
Xsg13cmos5l_nor3_1_59 \$858 \$851 \$987 VPWR VGND \$1113 sg13cmos5l_nor3_1
* cell instance sg13cmos5l_nor3_1_60 r0 *1 0,0
Xsg13cmos5l_nor3_1_60 \$4285 \$4189 \$920 VPWR VGND \$4291 sg13cmos5l_nor3_1
* cell instance sg13cmos5l_nor3_1_61 r0 *1 0,0
Xsg13cmos5l_nor3_1_61 \$850 \$989 \$1106 VPWR VGND \$987 sg13cmos5l_nor3_1
* cell instance sg13cmos5l_nor3_1_62 r0 *1 0,0
Xsg13cmos5l_nor3_1_62 \$5653 \$5465 \$5420 VPWR VGND \$5654 sg13cmos5l_nor3_1
* cell instance sg13cmos5l_nor3_1_63 r0 *1 0,0
Xsg13cmos5l_nor3_1_63 \$4453 \$4189 \$920 VPWR VGND \$4454 sg13cmos5l_nor3_1
* cell instance sg13cmos5l_nor3_1_64 r0 *1 0,0
Xsg13cmos5l_nor3_1_64 \$4683 \$4189 \$920 VPWR VGND \$4628 sg13cmos5l_nor3_1
* cell instance sg13cmos5l_nor3_1_65 r0 *1 0,0
Xsg13cmos5l_nor3_1_65 \$2306 \$2304 \$2070 VPWR VGND \$2305 sg13cmos5l_nor3_1
* cell instance sg13cmos5l_nor3_1_66 r0 *1 0,0
Xsg13cmos5l_nor3_1_66 \$4293 \$4189 \$920 VPWR VGND \$3548 sg13cmos5l_nor3_1
* cell instance sg13cmos5l_nor4_1_0 r0 *1 0,0
Xsg13cmos5l_nor4_1_0 \$1544 \$1410 \$1547 \$1431 VPWR VGND \$1536
+ sg13cmos5l_nor4_1
* cell instance sg13cmos5l_nor4_1_1 r0 *1 0,0
Xsg13cmos5l_nor4_1_1 \$1884 \$2012 \$1885 \$1886 VPWR VGND \$2001
+ sg13cmos5l_nor4_1
* cell instance sg13cmos5l_nor4_1_2 r0 *1 0,0
Xsg13cmos5l_nor4_1_2 \$645 \$530 \$531 \$532 VPWR VGND \$418 sg13cmos5l_nor4_1
* cell instance sg13cmos5l_nor4_1_3 r0 *1 0,0
Xsg13cmos5l_nor4_1_3 \$1318 \$1897 \$1900 \$1555 VPWR VGND \$1899
+ sg13cmos5l_nor4_1
* cell instance sg13cmos5l_nor4_1_4 r0 *1 0,0
Xsg13cmos5l_nor4_1_4 \$4222 \$3708 \$3009 \$3396 VPWR VGND \$4397
+ sg13cmos5l_nor4_1
* cell instance sg13cmos5l_nor4_1_5 r0 *1 0,0
Xsg13cmos5l_nor4_1_5 \$2643 \$2719 \$3420 \$3026 VPWR VGND \$4102
+ sg13cmos5l_nor4_1
* cell instance sg13cmos5l_nor4_1_6 r0 *1 0,0
Xsg13cmos5l_nor4_1_6 \$4104 \$2719 \$3420 \$3026 VPWR VGND \$4064
+ sg13cmos5l_nor4_1
* cell instance sg13cmos5l_nor4_1_7 r0 *1 0,0
Xsg13cmos5l_nor4_1_7 \$93 \$419 \$286 \$421 VPWR VGND \$420 sg13cmos5l_nor4_1
* cell instance sg13cmos5l_nor4_1_8 r0 *1 0,0
Xsg13cmos5l_nor4_1_8 \$4065 \$4549 \$2056 \$4550 VPWR VGND \$4551
+ sg13cmos5l_nor4_1
* cell instance sg13cmos5l_nor4_1_9 r0 *1 0,0
Xsg13cmos5l_nor4_1_9 \$4222 \$3708 \$3048 \$3396 VPWR VGND \$3945
+ sg13cmos5l_nor4_1
* cell instance sg13cmos5l_nor4_1_10 r0 *1 0,0
Xsg13cmos5l_nor4_1_10 \$819 \$1418 \$820 \$1693 VPWR VGND \$1692
+ sg13cmos5l_nor4_1
* cell instance sg13cmos5l_nor4_1_11 r0 *1 0,0
Xsg13cmos5l_nor4_1_11 \$100 \$24 \$134 \$93 VPWR VGND \$94 sg13cmos5l_nor4_1
* cell instance sg13cmos5l_nor4_1_12 r0 *1 0,0
Xsg13cmos5l_nor4_1_12 \$4065 \$3708 \$3048 \$3396 VPWR VGND \$4324
+ sg13cmos5l_nor4_1
* cell instance sg13cmos5l_nor4_1_13 r0 *1 0,0
Xsg13cmos5l_nor4_1_13 \$4065 \$3708 \$3009 \$2056 VPWR VGND \$4049
+ sg13cmos5l_nor4_1
* cell instance sg13cmos5l_nor4_1_14 r0 *1 0,0
Xsg13cmos5l_nor4_1_14 \$3266 \$3934 \$3619 \$3620 VPWR VGND \$2821
+ sg13cmos5l_nor4_1
* cell instance sg13cmos5l_nor4_1_15 r0 *1 0,0
Xsg13cmos5l_nor4_1_15 \$102 \$68 \$104 \$1905 VPWR VGND \$2560 sg13cmos5l_nor4_1
* cell instance sg13cmos5l_nor4_1_16 r0 *1 0,0
Xsg13cmos5l_nor4_1_16 \$102 \$103 \$68 \$104 VPWR VGND \$47 sg13cmos5l_nor4_1
* cell instance sg13cmos5l_nor4_1_17 r0 *1 0,0
Xsg13cmos5l_nor4_1_17 \$3248 \$2049 \$3423 \$647 VPWR VGND \$3784
+ sg13cmos5l_nor4_1
* cell instance sg13cmos5l_nor4_1_18 r0 *1 0,0
Xsg13cmos5l_nor4_1_18 \$681 \$1699 \$1696 \$1445 VPWR VGND \$1700
+ sg13cmos5l_nor4_1
* cell instance sg13cmos5l_nor4_1_19 r0 *1 0,0
Xsg13cmos5l_nor4_1_19 \$681 \$2563 \$2271 \$1447 VPWR VGND \$2273
+ sg13cmos5l_nor4_1
* cell instance sg13cmos5l_nor4_1_20 r0 *1 0,0
Xsg13cmos5l_nor4_1_20 \$119 \$50 \$116 \$120 VPWR VGND \$121 sg13cmos5l_nor4_1
* cell instance sg13cmos5l_nor4_1_21 r0 *1 0,0
Xsg13cmos5l_nor4_1_21 \$684 \$440 \$60 \$686 VPWR VGND \$685 sg13cmos5l_nor4_1
* cell instance sg13cmos5l_nor4_1_22 r0 *1 0,0
Xsg13cmos5l_nor4_1_22 \$20108 \$20207 \$20001 \$20083 VPWR VGND \$5350
+ sg13cmos5l_nor4_1
* cell instance sg13cmos5l_nor4_1_23 r0 *1 0,0
Xsg13cmos5l_nor4_1_23 \$3133 \$3300 \$2291 \$2436 VPWR VGND \$3783
+ sg13cmos5l_nor4_1
* cell instance sg13cmos5l_nor4_1_24 r0 *1 0,0
Xsg13cmos5l_nor4_1_24 \$3133 \$3300 \$2435 \$2436 VPWR VGND \$2640
+ sg13cmos5l_nor4_1
* cell instance sg13cmos5l_nor4_1_25 r0 *1 0,0
Xsg13cmos5l_nor4_1_25 \$3133 \$3300 \$2435 \$2755 VPWR VGND \$3441
+ sg13cmos5l_nor4_1
* cell instance sg13cmos5l_nor4_1_26 r0 *1 0,0
Xsg13cmos5l_nor4_1_26 \$312 \$136 \$46 \$311 VPWR VGND \$313 sg13cmos5l_nor4_1
* cell instance sg13cmos5l_nor4_1_27 r0 *1 0,0
Xsg13cmos5l_nor4_1_27 \$4560 \$5205 \$20008 \$20206 VPWR VGND \$54
+ sg13cmos5l_nor4_1
* cell instance sg13cmos5l_nor4_1_28 r0 *1 0,0
Xsg13cmos5l_nor4_1_28 \$54 \$1658 \$1359 \$1585 VPWR VGND \$1720
+ sg13cmos5l_nor4_1
* cell instance sg13cmos5l_nor4_1_29 r0 *1 0,0
Xsg13cmos5l_nor4_1_29 \$4572 \$5209 \$4995 \$5211 VPWR VGND \$4962
+ sg13cmos5l_nor4_1
* cell instance sg13cmos5l_nor4_1_30 r0 *1 0,0
Xsg13cmos5l_nor4_1_30 \$2594 \$2444 \$2443 \$2362 VPWR VGND \$2591
+ sg13cmos5l_nor4_1
* cell instance sg13cmos5l_nor4_1_31 r0 *1 0,0
Xsg13cmos5l_nor4_1_31 \$4572 \$4621 \$4619 \$4338 VPWR VGND \$4622
+ sg13cmos5l_nor4_1
* cell instance sg13cmos5l_nor4_1_32 r0 *1 0,0
Xsg13cmos5l_nor4_1_32 \$1725 \$1237 \$1592 \$1727 VPWR VGND \$1726
+ sg13cmos5l_nor4_1
* cell instance sg13cmos5l_nor4_1_33 r0 *1 0,0
Xsg13cmos5l_nor4_1_33 \$4572 \$4624 \$4814 \$4681 VPWR VGND \$4813
+ sg13cmos5l_nor4_1
* cell instance sg13cmos5l_nor4_1_34 r0 *1 0,0
Xsg13cmos5l_nor4_1_34 \$4572 \$4999 \$5000 \$5001 VPWR VGND \$4273
+ sg13cmos5l_nor4_1
* cell instance sg13cmos5l_nor4_1_35 r0 *1 0,0
Xsg13cmos5l_nor4_1_35 \$3865 \$6513 \$4130 \$6019 VPWR VGND \$6505
+ sg13cmos5l_nor4_1
* cell instance sg13cmos5l_nor4_1_36 r0 *1 0,0
Xsg13cmos5l_nor4_1_36 \$2941 \$4812 \$4026 \$5216 VPWR VGND \$5043
+ sg13cmos5l_nor4_1
* cell instance sg13cmos5l_o21ai_1_0 r0 *1 0,0
Xsg13cmos5l_o21ai_1_0 \$3235 \$15071 \$17329 VPWR VGND \$17131
+ sg13cmos5l_o21ai_1
* cell instance sg13cmos5l_o21ai_1_1 r0 *1 0,0
Xsg13cmos5l_o21ai_1_1 \$3019 \$15071 \$15072 VPWR VGND \$15070
+ sg13cmos5l_o21ai_1
* cell instance sg13cmos5l_o21ai_1_2 r0 *1 0,0
Xsg13cmos5l_o21ai_1_2 \$3235 \$13223 \$14530 VPWR VGND \$14036
+ sg13cmos5l_o21ai_1
* cell instance sg13cmos5l_o21ai_1_3 r0 *1 0,0
Xsg13cmos5l_o21ai_1_3 \$3019 \$12049 \$12268 VPWR VGND \$12007
+ sg13cmos5l_o21ai_1
* cell instance sg13cmos5l_o21ai_1_4 r0 *1 0,0
Xsg13cmos5l_o21ai_1_4 \$2700 \$12049 \$12705 VPWR VGND \$13005
+ sg13cmos5l_o21ai_1
* cell instance sg13cmos5l_o21ai_1_5 r0 *1 0,0
Xsg13cmos5l_o21ai_1_5 \$2700 \$15071 \$15831 VPWR VGND \$16001
+ sg13cmos5l_o21ai_1
* cell instance sg13cmos5l_o21ai_1_6 r0 *1 0,0
Xsg13cmos5l_o21ai_1_6 \$8851 \$9631 \$9412 VPWR VGND \$9296 sg13cmos5l_o21ai_1
* cell instance sg13cmos5l_o21ai_1_7 r0 *1 0,0
Xsg13cmos5l_o21ai_1_7 \$8851 \$9932 \$10137 VPWR VGND \$10030 sg13cmos5l_o21ai_1
* cell instance sg13cmos5l_o21ai_1_8 r0 *1 0,0
Xsg13cmos5l_o21ai_1_8 \$8851 \$10766 \$10588 VPWR VGND \$10764
+ sg13cmos5l_o21ai_1
* cell instance sg13cmos5l_o21ai_1_9 r0 *1 0,0
Xsg13cmos5l_o21ai_1_9 \$8851 \$9302 \$8853 VPWR VGND \$9258 sg13cmos5l_o21ai_1
* cell instance sg13cmos5l_o21ai_1_10 r0 *1 0,0
Xsg13cmos5l_o21ai_1_10 \$8851 \$9215 \$8412 VPWR VGND \$8489 sg13cmos5l_o21ai_1
* cell instance sg13cmos5l_o21ai_1_11 r0 *1 0,0
Xsg13cmos5l_o21ai_1_11 \$3738 \$3739 \$3741 VPWR VGND \$3740 sg13cmos5l_o21ai_1
* cell instance sg13cmos5l_o21ai_1_12 r0 *1 0,0
Xsg13cmos5l_o21ai_1_12 \$2818 \$12049 \$14532 VPWR VGND \$14335
+ sg13cmos5l_o21ai_1
* cell instance sg13cmos5l_o21ai_1_13 r0 *1 0,0
Xsg13cmos5l_o21ai_1_13 \$2818 \$15071 \$17675 VPWR VGND \$17632
+ sg13cmos5l_o21ai_1
* cell instance sg13cmos5l_o21ai_1_14 r0 *1 0,0
Xsg13cmos5l_o21ai_1_14 \$653 \$927 \$931 VPWR VGND \$930 sg13cmos5l_o21ai_1
* cell instance sg13cmos5l_o21ai_1_15 r0 *1 0,0
Xsg13cmos5l_o21ai_1_15 \$8851 \$9141 \$8418 VPWR VGND \$8419 sg13cmos5l_o21ai_1
* cell instance sg13cmos5l_o21ai_1_16 r0 *1 0,0
Xsg13cmos5l_o21ai_1_16 \$2678 \$12049 \$11899 VPWR VGND \$12227
+ sg13cmos5l_o21ai_1
* cell instance sg13cmos5l_o21ai_1_17 r0 *1 0,0
Xsg13cmos5l_o21ai_1_17 \$5337 \$13223 \$13403 VPWR VGND \$13402
+ sg13cmos5l_o21ai_1
* cell instance sg13cmos5l_o21ai_1_18 r0 *1 0,0
Xsg13cmos5l_o21ai_1_18 \$4877 \$4878 \$4880 VPWR VGND \$4879 sg13cmos5l_o21ai_1
* cell instance sg13cmos5l_o21ai_1_19 r0 *1 0,0
Xsg13cmos5l_o21ai_1_19 \$158 \$645 \$426 VPWR VGND \$928 sg13cmos5l_o21ai_1
* cell instance sg13cmos5l_o21ai_1_20 r0 *1 0,0
Xsg13cmos5l_o21ai_1_20 \$5337 \$19423 \$19877 VPWR VGND \$19835
+ sg13cmos5l_o21ai_1
* cell instance sg13cmos5l_o21ai_1_21 r0 *1 0,0
Xsg13cmos5l_o21ai_1_21 \$8851 \$9216 \$9217 VPWR VGND \$8854 sg13cmos5l_o21ai_1
* cell instance sg13cmos5l_o21ai_1_22 r0 *1 0,0
Xsg13cmos5l_o21ai_1_22 \$8851 \$10446 \$10138 VPWR VGND \$9935
+ sg13cmos5l_o21ai_1
* cell instance sg13cmos5l_o21ai_1_23 r0 *1 0,0
Xsg13cmos5l_o21ai_1_23 \$2998 \$2999 \$2383 VPWR VGND \$3000 sg13cmos5l_o21ai_1
* cell instance sg13cmos5l_o21ai_1_24 r0 *1 0,0
Xsg13cmos5l_o21ai_1_24 \$5291 \$5059 \$5290 VPWR VGND \$5050 sg13cmos5l_o21ai_1
* cell instance sg13cmos5l_o21ai_1_25 r0 *1 0,0
Xsg13cmos5l_o21ai_1_25 \$2998 \$2999 \$3590 VPWR VGND \$3596 sg13cmos5l_o21ai_1
* cell instance sg13cmos5l_o21ai_1_26 r0 *1 0,0
Xsg13cmos5l_o21ai_1_26 \$4077 \$4084 \$4087 VPWR VGND \$3911 sg13cmos5l_o21ai_1
* cell instance sg13cmos5l_o21ai_1_27 r0 *1 0,0
Xsg13cmos5l_o21ai_1_27 \$35 \$1058 \$153 VPWR VGND \$1179 sg13cmos5l_o21ai_1
* cell instance sg13cmos5l_o21ai_1_28 r0 *1 0,0
Xsg13cmos5l_o21ai_1_28 \$2821 \$2822 \$2961 VPWR VGND \$3002 sg13cmos5l_o21ai_1
* cell instance sg13cmos5l_o21ai_1_29 r0 *1 0,0
Xsg13cmos5l_o21ai_1_29 \$2821 \$2822 \$2812 VPWR VGND \$2824 sg13cmos5l_o21ai_1
* cell instance sg13cmos5l_o21ai_1_30 r0 *1 0,0
Xsg13cmos5l_o21ai_1_30 \$2998 \$2999 \$3216 VPWR VGND \$3223 sg13cmos5l_o21ai_1
* cell instance sg13cmos5l_o21ai_1_31 r0 *1 0,0
Xsg13cmos5l_o21ai_1_31 \$4367 \$3913 \$4369 VPWR VGND \$4368 sg13cmos5l_o21ai_1
* cell instance sg13cmos5l_o21ai_1_32 r0 *1 0,0
Xsg13cmos5l_o21ai_1_32 \$67 \$35 \$66 VPWR VGND \$69 sg13cmos5l_o21ai_1
* cell instance sg13cmos5l_o21ai_1_33 r0 *1 0,0
Xsg13cmos5l_o21ai_1_33 \$802 \$69 \$1179 VPWR VGND \$1181 sg13cmos5l_o21ai_1
* cell instance sg13cmos5l_o21ai_1_34 r0 *1 0,0
Xsg13cmos5l_o21ai_1_34 \$68 \$69 \$145 VPWR VGND \$156 sg13cmos5l_o21ai_1
* cell instance sg13cmos5l_o21ai_1_35 r0 *1 0,0
Xsg13cmos5l_o21ai_1_35 \$410 \$407 \$156 VPWR VGND \$670 sg13cmos5l_o21ai_1
* cell instance sg13cmos5l_o21ai_1_36 r0 *1 0,0
Xsg13cmos5l_o21ai_1_36 \$2998 \$2999 \$2233 VPWR VGND \$3005 sg13cmos5l_o21ai_1
* cell instance sg13cmos5l_o21ai_1_37 r0 *1 0,0
Xsg13cmos5l_o21ai_1_37 \$2821 \$2822 \$3393 VPWR VGND \$3224 sg13cmos5l_o21ai_1
* cell instance sg13cmos5l_o21ai_1_38 r0 *1 0,0
Xsg13cmos5l_o21ai_1_38 \$3751 \$12425 \$14536 VPWR VGND \$15074
+ sg13cmos5l_o21ai_1
* cell instance sg13cmos5l_o21ai_1_39 r0 *1 0,0
Xsg13cmos5l_o21ai_1_39 \$799 \$1056 \$931 VPWR VGND \$1060 sg13cmos5l_o21ai_1
* cell instance sg13cmos5l_o21ai_1_40 r0 *1 0,0
Xsg13cmos5l_o21ai_1_40 \$2821 \$2822 \$3593 VPWR VGND \$3597 sg13cmos5l_o21ai_1
* cell instance sg13cmos5l_o21ai_1_41 r0 *1 0,0
Xsg13cmos5l_o21ai_1_41 \$2386 \$2233 \$2510 VPWR VGND \$2403 sg13cmos5l_o21ai_1
* cell instance sg13cmos5l_o21ai_1_42 r0 *1 0,0
Xsg13cmos5l_o21ai_1_42 \$2688 \$12425 \$12273 VPWR VGND \$12271
+ sg13cmos5l_o21ai_1
* cell instance sg13cmos5l_o21ai_1_43 r0 *1 0,0
Xsg13cmos5l_o21ai_1_43 \$78 \$798 \$797 VPWR VGND \$414 sg13cmos5l_o21ai_1
* cell instance sg13cmos5l_o21ai_1_44 r0 *1 0,0
Xsg13cmos5l_o21ai_1_44 \$3751 \$5134 \$19421 VPWR VGND \$19241
+ sg13cmos5l_o21ai_1
* cell instance sg13cmos5l_o21ai_1_45 r0 *1 0,0
Xsg13cmos5l_o21ai_1_45 \$3590 \$2503 \$3753 VPWR VGND \$3749 sg13cmos5l_o21ai_1
* cell instance sg13cmos5l_o21ai_1_46 r0 *1 0,0
Xsg13cmos5l_o21ai_1_46 \$11740 \$8431 \$11900 VPWR VGND \$13231
+ sg13cmos5l_o21ai_1
* cell instance sg13cmos5l_o21ai_1_47 r0 *1 0,0
Xsg13cmos5l_o21ai_1_47 \$6476 \$10772 \$10774 VPWR VGND \$10594
+ sg13cmos5l_o21ai_1
* cell instance sg13cmos5l_o21ai_1_48 r0 *1 0,0
Xsg13cmos5l_o21ai_1_48 \$13839 \$13231 \$14034 VPWR VGND uo_out[2]
+ sg13cmos5l_o21ai_1
* cell instance sg13cmos5l_o21ai_1_49 r0 *1 0,0
Xsg13cmos5l_o21ai_1_49 \$8411 \$11740 \$11900 VPWR VGND \$11703
+ sg13cmos5l_o21ai_1
* cell instance sg13cmos5l_o21ai_1_50 r0 *1 0,0
Xsg13cmos5l_o21ai_1_50 \$12720 \$9928 \$11900 VPWR VGND \$14341
+ sg13cmos5l_o21ai_1
* cell instance sg13cmos5l_o21ai_1_51 r0 *1 0,0
Xsg13cmos5l_o21ai_1_51 \$36 \$18 \$803 VPWR VGND \$801 sg13cmos5l_o21ai_1
* cell instance sg13cmos5l_o21ai_1_52 r0 *1 0,0
Xsg13cmos5l_o21ai_1_52 \$2998 \$2999 \$2670 VPWR VGND \$3012 sg13cmos5l_o21ai_1
* cell instance sg13cmos5l_o21ai_1_53 r0 *1 0,0
Xsg13cmos5l_o21ai_1_53 \$11702 \$11703 \$12130 VPWR VGND uo_out[0]
+ sg13cmos5l_o21ai_1
* cell instance sg13cmos5l_o21ai_1_54 r0 *1 0,0
Xsg13cmos5l_o21ai_1_54 \$1062 \$935 \$1 VPWR VGND \$1063 sg13cmos5l_o21ai_1
* cell instance sg13cmos5l_o21ai_1_55 r0 *1 0,0
Xsg13cmos5l_o21ai_1_55 \$4207 \$4206 \$4093 VPWR VGND \$4201 sg13cmos5l_o21ai_1
* cell instance sg13cmos5l_o21ai_1_56 r0 *1 0,0
Xsg13cmos5l_o21ai_1_56 \$4521 \$3705 \$4517 VPWR VGND \$4522 sg13cmos5l_o21ai_1
* cell instance sg13cmos5l_o21ai_1_57 r0 *1 0,0
Xsg13cmos5l_o21ai_1_57 \$11740 \$9042 \$11900 VPWR VGND \$12563
+ sg13cmos5l_o21ai_1
* cell instance sg13cmos5l_o21ai_1_58 r0 *1 0,0
Xsg13cmos5l_o21ai_1_58 \$14539 \$14341 \$15560 VPWR VGND uo_out[3]
+ sg13cmos5l_o21ai_1
* cell instance sg13cmos5l_o21ai_1_59 r0 *1 0,0
Xsg13cmos5l_o21ai_1_59 \$2821 \$2822 \$2516 VPWR VGND \$2825 sg13cmos5l_o21ai_1
* cell instance sg13cmos5l_o21ai_1_60 r0 *1 0,0
Xsg13cmos5l_o21ai_1_60 \$15076 \$2818 \$15077 VPWR VGND \$7722
+ sg13cmos5l_o21ai_1
* cell instance sg13cmos5l_o21ai_1_61 r0 *1 0,0
Xsg13cmos5l_o21ai_1_61 \$2517 \$2518 \$2386 VPWR VGND \$2513 sg13cmos5l_o21ai_1
* cell instance sg13cmos5l_o21ai_1_62 r0 *1 0,0
Xsg13cmos5l_o21ai_1_62 \$11740 \$6396 \$11900 VPWR VGND \$11704
+ sg13cmos5l_o21ai_1
* cell instance sg13cmos5l_o21ai_1_63 r0 *1 0,0
Xsg13cmos5l_o21ai_1_63 \$13236 \$12563 \$13836 VPWR VGND uo_out[7]
+ sg13cmos5l_o21ai_1
* cell instance sg13cmos5l_o21ai_1_64 r0 *1 0,0
Xsg13cmos5l_o21ai_1_64 \$14035 \$3751 \$14541 VPWR VGND \$9637
+ sg13cmos5l_o21ai_1
* cell instance sg13cmos5l_o21ai_1_65 r0 *1 0,0
Xsg13cmos5l_o21ai_1_65 \$6476 \$8877 \$8776 VPWR VGND \$8497 sg13cmos5l_o21ai_1
* cell instance sg13cmos5l_o21ai_1_66 r0 *1 0,0
Xsg13cmos5l_o21ai_1_66 \$3399 \$2503 \$3567 VPWR VGND \$3198 sg13cmos5l_o21ai_1
* cell instance sg13cmos5l_o21ai_1_67 r0 *1 0,0
Xsg13cmos5l_o21ai_1_67 \$12133 \$11704 \$12706 VPWR VGND uo_out[4]
+ sg13cmos5l_o21ai_1
* cell instance sg13cmos5l_o21ai_1_68 r0 *1 0,0
Xsg13cmos5l_o21ai_1_68 \$4731 \$4551 \$4325 VPWR VGND \$7505 sg13cmos5l_o21ai_1
* cell instance sg13cmos5l_o21ai_1_69 r0 *1 0,0
Xsg13cmos5l_o21ai_1_69 \$14035 \$2700 \$14042 VPWR VGND \$9638
+ sg13cmos5l_o21ai_1
* cell instance sg13cmos5l_o21ai_1_70 r0 *1 0,0
Xsg13cmos5l_o21ai_1_70 \$11741 \$6482 \$11900 VPWR VGND \$11270
+ sg13cmos5l_o21ai_1
* cell instance sg13cmos5l_o21ai_1_71 r0 *1 0,0
Xsg13cmos5l_o21ai_1_71 \$1648 \$1316 \$1318 VPWR VGND \$1886 sg13cmos5l_o21ai_1
* cell instance sg13cmos5l_o21ai_1_72 r0 *1 0,0
Xsg13cmos5l_o21ai_1_72 \$936 \$1185 \$1318 VPWR VGND \$1410 sg13cmos5l_o21ai_1
* cell instance sg13cmos5l_o21ai_1_73 r0 *1 0,0
Xsg13cmos5l_o21ai_1_73 \$3404 \$3016 \$2386 VPWR VGND \$2693 sg13cmos5l_o21ai_1
* cell instance sg13cmos5l_o21ai_1_74 r0 *1 0,0
Xsg13cmos5l_o21ai_1_74 \$36 \$78 \$260 VPWR VGND \$265 sg13cmos5l_o21ai_1
* cell instance sg13cmos5l_o21ai_1_75 r0 *1 0,0
Xsg13cmos5l_o21ai_1_75 \$11271 \$11270 \$11268 VPWR VGND uo_out[5]
+ sg13cmos5l_o21ai_1
* cell instance sg13cmos5l_o21ai_1_76 r0 *1 0,0
Xsg13cmos5l_o21ai_1_76 \$12136 \$13079 \$13229 VPWR VGND uo_out[6]
+ sg13cmos5l_o21ai_1
* cell instance sg13cmos5l_o21ai_1_77 r0 *1 0,0
Xsg13cmos5l_o21ai_1_77 \$15076 \$2688 \$16013 VPWR VGND \$7222
+ sg13cmos5l_o21ai_1
* cell instance sg13cmos5l_o21ai_1_78 r0 *1 0,0
Xsg13cmos5l_o21ai_1_78 \$20042 \$19996 \$62 VPWR VGND \$19997 sg13cmos5l_o21ai_1
* cell instance sg13cmos5l_o21ai_1_79 r0 *1 0,0
Xsg13cmos5l_o21ai_1_79 \$6479 \$8881 \$8793 VPWR VGND \$8549 sg13cmos5l_o21ai_1
* cell instance sg13cmos5l_o21ai_1_80 r0 *1 0,0
Xsg13cmos5l_o21ai_1_80 \$2826 \$2503 \$2827 VPWR VGND \$2828 sg13cmos5l_o21ai_1
* cell instance sg13cmos5l_o21ai_1_81 r0 *1 0,0
Xsg13cmos5l_o21ai_1_81 \$6479 \$9044 \$8883 VPWR VGND \$8884 sg13cmos5l_o21ai_1
* cell instance sg13cmos5l_o21ai_1_82 r0 *1 0,0
Xsg13cmos5l_o21ai_1_82 \$6479 \$10046 \$10780 VPWR VGND \$10596
+ sg13cmos5l_o21ai_1
* cell instance sg13cmos5l_o21ai_1_83 r0 *1 0,0
Xsg13cmos5l_o21ai_1_83 \$11741 \$9046 \$11900 VPWR VGND \$13079
+ sg13cmos5l_o21ai_1
* cell instance sg13cmos5l_o21ai_1_84 r0 *1 0,0
Xsg13cmos5l_o21ai_1_84 \$65 \$79 \$36 VPWR VGND \$7 sg13cmos5l_o21ai_1
* cell instance sg13cmos5l_o21ai_1_85 r0 *1 0,0
Xsg13cmos5l_o21ai_1_85 \$1175 \$2021 \$1336 VPWR VGND \$1892 sg13cmos5l_o21ai_1
* cell instance sg13cmos5l_o21ai_1_86 r0 *1 0,0
Xsg13cmos5l_o21ai_1_86 \$2678 \$19423 \$18446 VPWR VGND \$18164
+ sg13cmos5l_o21ai_1
* cell instance sg13cmos5l_o21ai_1_87 r0 *1 0,0
Xsg13cmos5l_o21ai_1_87 \$2688 \$19423 \$20000 VPWR VGND \$19999
+ sg13cmos5l_o21ai_1
* cell instance sg13cmos5l_o21ai_1_88 r0 *1 0,0
Xsg13cmos5l_o21ai_1_88 \$14035 \$3019 \$13406 VPWR VGND \$10050
+ sg13cmos5l_o21ai_1
* cell instance sg13cmos5l_o21ai_1_89 r0 *1 0,0
Xsg13cmos5l_o21ai_1_89 \$3008 \$2829 \$2830 VPWR VGND \$2697 sg13cmos5l_o21ai_1
* cell instance sg13cmos5l_o21ai_1_90 r0 *1 0,0
Xsg13cmos5l_o21ai_1_90 \$660 \$943 \$1321 VPWR VGND \$1412 sg13cmos5l_o21ai_1
* cell instance sg13cmos5l_o21ai_1_91 r0 *1 0,0
Xsg13cmos5l_o21ai_1_91 \$12137 \$12139 \$12272 VPWR VGND uo_out[1]
+ sg13cmos5l_o21ai_1
* cell instance sg13cmos5l_o21ai_1_92 r0 *1 0,0
Xsg13cmos5l_o21ai_1_92 \$15076 \$2678 \$16219 VPWR VGND \$7563
+ sg13cmos5l_o21ai_1
* cell instance sg13cmos5l_o21ai_1_93 r0 *1 0,0
Xsg13cmos5l_o21ai_1_93 \$11741 \$7816 \$11900 VPWR VGND \$12139
+ sg13cmos5l_o21ai_1
* cell instance sg13cmos5l_o21ai_1_94 r0 *1 0,0
Xsg13cmos5l_o21ai_1_94 \$14035 \$5337 \$13407 VPWR VGND \$11273
+ sg13cmos5l_o21ai_1
* cell instance sg13cmos5l_o21ai_1_95 r0 *1 0,0
Xsg13cmos5l_o21ai_1_95 \$660 \$1430 \$1439 VPWR VGND \$1438 sg13cmos5l_o21ai_1
* cell instance sg13cmos5l_o21ai_1_96 r0 *1 0,0
Xsg13cmos5l_o21ai_1_96 \$3758 \$3759 \$2835 VPWR VGND \$2998 sg13cmos5l_o21ai_1
* cell instance sg13cmos5l_o21ai_1_97 r0 *1 0,0
Xsg13cmos5l_o21ai_1_97 \$938 \$1679 \$1671 VPWR VGND \$1681 sg13cmos5l_o21ai_1
* cell instance sg13cmos5l_o21ai_1_98 r0 *1 0,0
Xsg13cmos5l_o21ai_1_98 \$1316 \$2118 \$1318 VPWR VGND \$2120 sg13cmos5l_o21ai_1
* cell instance sg13cmos5l_o21ai_1_99 r0 *1 0,0
Xsg13cmos5l_o21ai_1_99 \$3230 \$3434 \$3413 VPWR VGND \$2677 sg13cmos5l_o21ai_1
* cell instance sg13cmos5l_o21ai_1_100 r0 *1 0,0
Xsg13cmos5l_o21ai_1_100 \$43 \$306 \$171 VPWR VGND \$80 sg13cmos5l_o21ai_1
* cell instance sg13cmos5l_o21ai_1_101 r0 *1 0,0
Xsg13cmos5l_o21ai_1_101 \$416 \$22 \$261 VPWR VGND \$271 sg13cmos5l_o21ai_1
* cell instance sg13cmos5l_o21ai_1_102 r0 *1 0,0
Xsg13cmos5l_o21ai_1_102 \$646 \$683 \$1894 VPWR VGND \$2025 sg13cmos5l_o21ai_1
* cell instance sg13cmos5l_o21ai_1_103 r0 *1 0,0
Xsg13cmos5l_o21ai_1_103 \$22 \$80 \$70 VPWR VGND \$166 sg13cmos5l_o21ai_1
* cell instance sg13cmos5l_o21ai_1_104 r0 *1 0,0
Xsg13cmos5l_o21ai_1_104 \$3934 \$3933 \$3915 VPWR VGND \$3935 sg13cmos5l_o21ai_1
* cell instance sg13cmos5l_o21ai_1_105 r0 *1 0,0
Xsg13cmos5l_o21ai_1_105 \$3762 \$2835 \$2827 VPWR VGND \$3763 sg13cmos5l_o21ai_1
* cell instance sg13cmos5l_o21ai_1_106 r0 *1 0,0
Xsg13cmos5l_o21ai_1_106 \$1441 \$1439 \$651 VPWR VGND \$1435 sg13cmos5l_o21ai_1
* cell instance sg13cmos5l_o21ai_1_107 r0 *1 0,0
Xsg13cmos5l_o21ai_1_107 \$521 \$1079 \$1650 VPWR VGND \$1683 sg13cmos5l_o21ai_1
* cell instance sg13cmos5l_o21ai_1_108 r0 *1 0,0
Xsg13cmos5l_o21ai_1_108 \$290 \$418 \$271 VPWR VGND \$63 sg13cmos5l_o21ai_1
* cell instance sg13cmos5l_o21ai_1_109 r0 *1 0,0
Xsg13cmos5l_o21ai_1_109 \$272 \$160 \$274 VPWR VGND \$273 sg13cmos5l_o21ai_1
* cell instance sg13cmos5l_o21ai_1_110 r0 *1 0,0
Xsg13cmos5l_o21ai_1_110 \$2111 \$2117 \$533 VPWR VGND \$82 sg13cmos5l_o21ai_1
* cell instance sg13cmos5l_o21ai_1_111 r0 *1 0,0
Xsg13cmos5l_o21ai_1_111 \$3052 \$3232 \$3233 VPWR VGND \$3031 sg13cmos5l_o21ai_1
* cell instance sg13cmos5l_o21ai_1_112 r0 *1 0,0
Xsg13cmos5l_o21ai_1_112 \$1880 \$82 \$2261 VPWR VGND \$2260 sg13cmos5l_o21ai_1
* cell instance sg13cmos5l_o21ai_1_113 r0 *1 0,0
Xsg13cmos5l_o21ai_1_113 \$18 \$798 \$941 VPWR VGND \$940 sg13cmos5l_o21ai_1
* cell instance sg13cmos5l_o21ai_1_114 r0 *1 0,0
Xsg13cmos5l_o21ai_1_114 \$1058 \$406 \$24 VPWR VGND \$941 sg13cmos5l_o21ai_1
* cell instance sg13cmos5l_o21ai_1_115 r0 *1 0,0
Xsg13cmos5l_o21ai_1_115 \$534 \$538 \$267 VPWR VGND \$277 sg13cmos5l_o21ai_1
* cell instance sg13cmos5l_o21ai_1_116 r0 *1 0,0
Xsg13cmos5l_o21ai_1_116 \$681 \$84 \$279 VPWR VGND \$282 sg13cmos5l_o21ai_1
* cell instance sg13cmos5l_o21ai_1_117 r0 *1 0,0
Xsg13cmos5l_o21ai_1_117 \$936 \$1331 \$1318 VPWR VGND \$1328 sg13cmos5l_o21ai_1
* cell instance sg13cmos5l_o21ai_1_118 r0 *1 0,0
Xsg13cmos5l_o21ai_1_118 \$406 \$938 \$260 VPWR VGND \$1075 sg13cmos5l_o21ai_1
* cell instance sg13cmos5l_o21ai_1_119 r0 *1 0,0
Xsg13cmos5l_o21ai_1_119 \$3943 \$3941 \$3775 VPWR VGND \$4104 sg13cmos5l_o21ai_1
* cell instance sg13cmos5l_o21ai_1_120 r0 *1 0,0
Xsg13cmos5l_o21ai_1_120 \$286 \$413 \$287 VPWR VGND \$89 sg13cmos5l_o21ai_1
* cell instance sg13cmos5l_o21ai_1_121 r0 *1 0,0
Xsg13cmos5l_o21ai_1_121 \$50 \$1065 \$538 VPWR VGND \$814 sg13cmos5l_o21ai_1
* cell instance sg13cmos5l_o21ai_1_122 r0 *1 0,0
Xsg13cmos5l_o21ai_1_122 \$3426 \$2717 \$3249 VPWR VGND \$2056 sg13cmos5l_o21ai_1
* cell instance sg13cmos5l_o21ai_1_123 r0 *1 0,0
Xsg13cmos5l_o21ai_1_123 \$1688 \$1651 \$290 VPWR VGND \$1652 sg13cmos5l_o21ai_1
* cell instance sg13cmos5l_o21ai_1_124 r0 *1 0,0
Xsg13cmos5l_o21ai_1_124 \$533 \$158 \$274 VPWR VGND \$2267 sg13cmos5l_o21ai_1
* cell instance sg13cmos5l_o21ai_1_125 r0 *1 0,0
Xsg13cmos5l_o21ai_1_125 \$2548 \$2267 \$1318 VPWR VGND \$2549 sg13cmos5l_o21ai_1
* cell instance sg13cmos5l_o21ai_1_126 r0 *1 0,0
Xsg13cmos5l_o21ai_1_126 \$3250 \$2717 \$3251 VPWR VGND \$4065 sg13cmos5l_o21ai_1
* cell instance sg13cmos5l_o21ai_1_127 r0 *1 0,0
Xsg13cmos5l_o21ai_1_127 \$539 \$150 \$91 VPWR VGND \$46 sg13cmos5l_o21ai_1
* cell instance sg13cmos5l_o21ai_1_128 r0 *1 0,0
Xsg13cmos5l_o21ai_1_128 \$26 \$2130 \$37 VPWR VGND \$2268 sg13cmos5l_o21ai_1
* cell instance sg13cmos5l_o21ai_1_129 r0 *1 0,0
Xsg13cmos5l_o21ai_1_129 \$276 \$664 \$24 VPWR VGND \$286 sg13cmos5l_o21ai_1
* cell instance sg13cmos5l_o21ai_1_130 r0 *1 0,0
Xsg13cmos5l_o21ai_1_130 \$2129 \$2027 \$2131 VPWR VGND \$2130 sg13cmos5l_o21ai_1
* cell instance sg13cmos5l_o21ai_1_131 r0 *1 0,0
Xsg13cmos5l_o21ai_1_131 \$3046 \$3043 \$3049 VPWR VGND \$3048 sg13cmos5l_o21ai_1
* cell instance sg13cmos5l_o21ai_1_132 r0 *1 0,0
Xsg13cmos5l_o21ai_1_132 \$5414 \$5758 \$5769 VPWR VGND \$2772 sg13cmos5l_o21ai_1
* cell instance sg13cmos5l_o21ai_1_133 r0 *1 0,0
Xsg13cmos5l_o21ai_1_133 \$1341 \$421 \$806 VPWR VGND \$1340 sg13cmos5l_o21ai_1
* cell instance sg13cmos5l_o21ai_1_134 r0 *1 0,0
Xsg13cmos5l_o21ai_1_134 \$134 \$415 \$941 VPWR VGND \$541 sg13cmos5l_o21ai_1
* cell instance sg13cmos5l_o21ai_1_135 r0 *1 0,0
Xsg13cmos5l_o21ai_1_135 \$134 \$1191 \$1082 VPWR VGND \$1081 sg13cmos5l_o21ai_1
* cell instance sg13cmos5l_o21ai_1_136 r0 *1 0,0
Xsg13cmos5l_o21ai_1_136 \$1080 \$1908 \$1336 VPWR VGND \$1910 sg13cmos5l_o21ai_1
* cell instance sg13cmos5l_o21ai_1_137 r0 *1 0,0
Xsg13cmos5l_o21ai_1_137 \$18 \$286 \$430 VPWR VGND \$427 sg13cmos5l_o21ai_1
* cell instance sg13cmos5l_o21ai_1_138 r0 *1 0,0
Xsg13cmos5l_o21ai_1_138 \$435 \$1804 \$2270 VPWR VGND \$2269 sg13cmos5l_o21ai_1
* cell instance sg13cmos5l_o21ai_1_139 r0 *1 0,0
Xsg13cmos5l_o21ai_1_139 \$104 \$662 \$1907 VPWR VGND \$2270 sg13cmos5l_o21ai_1
* cell instance sg13cmos5l_o21ai_1_140 r0 *1 0,0
Xsg13cmos5l_o21ai_1_140 \$3448 \$4564 \$4404 VPWR VGND \$4566 sg13cmos5l_o21ai_1
* cell instance sg13cmos5l_o21ai_1_141 r0 *1 0,0
Xsg13cmos5l_o21ai_1_141 \$286 \$421 \$69 VPWR VGND \$544 sg13cmos5l_o21ai_1
* cell instance sg13cmos5l_o21ai_1_142 r0 *1 0,0
Xsg13cmos5l_o21ai_1_142 \$3266 \$3619 \$3129 VPWR VGND \$3440 sg13cmos5l_o21ai_1
* cell instance sg13cmos5l_o21ai_1_143 r0 *1 0,0
Xsg13cmos5l_o21ai_1_143 \$1065 \$2035 \$1912 VPWR VGND \$2133 sg13cmos5l_o21ai_1
* cell instance sg13cmos5l_o21ai_1_144 r0 *1 0,0
Xsg13cmos5l_o21ai_1_144 \$4570 \$4729 \$864 VPWR VGND \$4571 sg13cmos5l_o21ai_1
* cell instance sg13cmos5l_o21ai_1_145 r0 *1 0,0
Xsg13cmos5l_o21ai_1_145 \$1905 \$283 \$426 VPWR VGND \$1198 sg13cmos5l_o21ai_1
* cell instance sg13cmos5l_o21ai_1_146 r0 *1 0,0
Xsg13cmos5l_o21ai_1_146 \$1165 \$3066 \$3440 VPWR VGND \$3374 sg13cmos5l_o21ai_1
* cell instance sg13cmos5l_o21ai_1_147 r0 *1 0,0
Xsg13cmos5l_o21ai_1_147 \$2560 \$2561 \$426 VPWR VGND \$2541 sg13cmos5l_o21ai_1
* cell instance sg13cmos5l_o21ai_1_148 r0 *1 0,0
Xsg13cmos5l_o21ai_1_148 \$1453 \$105 \$57 VPWR VGND \$106 sg13cmos5l_o21ai_1
* cell instance sg13cmos5l_o21ai_1_149 r0 *1 0,0
Xsg13cmos5l_o21ai_1_149 \$93 \$1085 \$1198 VPWR VGND \$1200 sg13cmos5l_o21ai_1
* cell instance sg13cmos5l_o21ai_1_150 r0 *1 0,0
Xsg13cmos5l_o21ai_1_150 \$4953 \$4562 \$4747 VPWR VGND \$4954 sg13cmos5l_o21ai_1
* cell instance sg13cmos5l_o21ai_1_151 r0 *1 0,0
Xsg13cmos5l_o21ai_1_151 \$3448 \$4113 \$4573 VPWR VGND \$4575 sg13cmos5l_o21ai_1
* cell instance sg13cmos5l_o21ai_1_152 r0 *1 0,0
Xsg13cmos5l_o21ai_1_152 \$4114 \$4243 \$3957 VPWR VGND \$4241 sg13cmos5l_o21ai_1
* cell instance sg13cmos5l_o21ai_1_153 r0 *1 0,0
Xsg13cmos5l_o21ai_1_153 \$2037 \$1807 \$428 VPWR VGND \$2038 sg13cmos5l_o21ai_1
* cell instance sg13cmos5l_o21ai_1_154 r0 *1 0,0
Xsg13cmos5l_o21ai_1_154 \$20255 \$222 \$20065 VPWR VGND \$5415
+ sg13cmos5l_o21ai_1
* cell instance sg13cmos5l_o21ai_1_155 r0 *1 0,0
Xsg13cmos5l_o21ai_1_155 \$4586 \$3473 \$2974 VPWR VGND \$4959 sg13cmos5l_o21ai_1
* cell instance sg13cmos5l_o21ai_1_156 r0 *1 0,0
Xsg13cmos5l_o21ai_1_156 \$4953 \$3473 \$3096 VPWR VGND \$4960 sg13cmos5l_o21ai_1
* cell instance sg13cmos5l_o21ai_1_157 r0 *1 0,0
Xsg13cmos5l_o21ai_1_157 \$1090 \$1905 \$102 VPWR VGND \$437 sg13cmos5l_o21ai_1
* cell instance sg13cmos5l_o21ai_1_158 r0 *1 0,0
Xsg13cmos5l_o21ai_1_158 \$1605 \$3957 \$4250 VPWR VGND \$4249 sg13cmos5l_o21ai_1
* cell instance sg13cmos5l_o21ai_1_159 r0 *1 0,0
Xsg13cmos5l_o21ai_1_159 \$5346 \$5591 \$5791 VPWR VGND \$5788 sg13cmos5l_o21ai_1
* cell instance sg13cmos5l_o21ai_1_160 r0 *1 0,0
Xsg13cmos5l_o21ai_1_160 \$5346 \$4959 \$5360 VPWR VGND \$5357 sg13cmos5l_o21ai_1
* cell instance sg13cmos5l_o21ai_1_161 r0 *1 0,0
Xsg13cmos5l_o21ai_1_161 \$1916 \$1918 \$1879 VPWR VGND \$1919 sg13cmos5l_o21ai_1
* cell instance sg13cmos5l_o21ai_1_162 r0 *1 0,0
Xsg13cmos5l_o21ai_1_162 \$2037 \$1452 \$428 VPWR VGND \$2139 sg13cmos5l_o21ai_1
* cell instance sg13cmos5l_o21ai_1_163 r0 *1 0,0
Xsg13cmos5l_o21ai_1_163 \$4962 \$4963 \$2310 VPWR VGND \$1655 sg13cmos5l_o21ai_1
* cell instance sg13cmos5l_o21ai_1_164 r0 *1 0,0
Xsg13cmos5l_o21ai_1_164 \$4116 \$3473 \$2896 VPWR VGND \$4765 sg13cmos5l_o21ai_1
* cell instance sg13cmos5l_o21ai_1_165 r0 *1 0,0
Xsg13cmos5l_o21ai_1_165 \$5346 \$4765 \$4965 VPWR VGND \$4964 sg13cmos5l_o21ai_1
* cell instance sg13cmos5l_o21ai_1_166 r0 *1 0,0
Xsg13cmos5l_o21ai_1_166 \$103 \$937 \$1921 VPWR VGND \$1918 sg13cmos5l_o21ai_1
* cell instance sg13cmos5l_o21ai_1_167 r0 *1 0,0
Xsg13cmos5l_o21ai_1_167 \$3448 \$3959 \$3961 VPWR VGND \$3795 sg13cmos5l_o21ai_1
* cell instance sg13cmos5l_o21ai_1_168 r0 *1 0,0
Xsg13cmos5l_o21ai_1_168 \$3471 \$3473 \$3294 VPWR VGND \$3474 sg13cmos5l_o21ai_1
* cell instance sg13cmos5l_o21ai_1_169 r0 *1 0,0
Xsg13cmos5l_o21ai_1_169 \$4558 \$3473 \$2976 VPWR VGND \$4767 sg13cmos5l_o21ai_1
* cell instance sg13cmos5l_o21ai_1_170 r0 *1 0,0
Xsg13cmos5l_o21ai_1_170 \$673 \$670 \$648 VPWR VGND \$677 sg13cmos5l_o21ai_1
* cell instance sg13cmos5l_o21ai_1_171 r0 *1 0,0
Xsg13cmos5l_o21ai_1_171 \$1186 \$1094 \$1346 VPWR VGND \$1207 sg13cmos5l_o21ai_1
* cell instance sg13cmos5l_o21ai_1_172 r0 *1 0,0
Xsg13cmos5l_o21ai_1_172 \$388 \$129 \$382 VPWR VGND \$301 sg13cmos5l_o21ai_1
* cell instance sg13cmos5l_o21ai_1_173 r0 *1 0,0
Xsg13cmos5l_o21ai_1_173 \$4968 \$3474 \$4970 VPWR VGND \$4969 sg13cmos5l_o21ai_1
* cell instance sg13cmos5l_o21ai_1_174 r0 *1 0,0
Xsg13cmos5l_o21ai_1_174 \$3448 \$3797 \$3795 VPWR VGND \$3798 sg13cmos5l_o21ai_1
* cell instance sg13cmos5l_o21ai_1_175 r0 *1 0,0
Xsg13cmos5l_o21ai_1_175 \$1186 \$1094 \$1081 VPWR VGND \$1095 sg13cmos5l_o21ai_1
* cell instance sg13cmos5l_o21ai_1_176 r0 *1 0,0
Xsg13cmos5l_o21ai_1_176 \$3289 \$3473 \$2899 VPWR VGND \$4188 sg13cmos5l_o21ai_1
* cell instance sg13cmos5l_o21ai_1_177 r0 *1 0,0
Xsg13cmos5l_o21ai_1_177 \$4968 \$4188 \$5600 VPWR VGND \$5599 sg13cmos5l_o21ai_1
* cell instance sg13cmos5l_o21ai_1_178 r0 *1 0,0
Xsg13cmos5l_o21ai_1_178 \$38 \$1341 \$1346 VPWR VGND \$678 sg13cmos5l_o21ai_1
* cell instance sg13cmos5l_o21ai_1_179 r0 *1 0,0
Xsg13cmos5l_o21ai_1_179 \$5346 \$4767 \$5257 VPWR VGND \$5364 sg13cmos5l_o21ai_1
* cell instance sg13cmos5l_o21ai_1_180 r0 *1 0,0
Xsg13cmos5l_o21ai_1_180 \$9 \$122 \$37 VPWR VGND \$31 sg13cmos5l_o21ai_1
* cell instance sg13cmos5l_o21ai_1_181 r0 *1 0,0
Xsg13cmos5l_o21ai_1_181 \$4247 \$3473 \$3476 VPWR VGND \$4595 sg13cmos5l_o21ai_1
* cell instance sg13cmos5l_o21ai_1_182 r0 *1 0,0
Xsg13cmos5l_o21ai_1_182 \$4968 \$4595 \$4978 VPWR VGND \$4973 sg13cmos5l_o21ai_1
* cell instance sg13cmos5l_o21ai_1_183 r0 *1 0,0
Xsg13cmos5l_o21ai_1_183 \$253 \$1574 \$174 VPWR VGND \$1575 sg13cmos5l_o21ai_1
* cell instance sg13cmos5l_o21ai_1_184 r0 *1 0,0
Xsg13cmos5l_o21ai_1_184 \$4594 \$3473 \$2804 VPWR VGND \$4596 sg13cmos5l_o21ai_1
* cell instance sg13cmos5l_o21ai_1_185 r0 *1 0,0
Xsg13cmos5l_o21ai_1_185 \$4968 \$4596 \$5373 VPWR VGND \$5372 sg13cmos5l_o21ai_1
* cell instance sg13cmos5l_o21ai_1_186 r0 *1 0,0
Xsg13cmos5l_o21ai_1_186 \$684 \$2274 \$1879 VPWR VGND \$2275 sg13cmos5l_o21ai_1
* cell instance sg13cmos5l_o21ai_1_187 r0 *1 0,0
Xsg13cmos5l_o21ai_1_187 \$4065 \$2431 \$1165 VPWR VGND \$2900 sg13cmos5l_o21ai_1
* cell instance sg13cmos5l_o21ai_1_188 r0 *1 0,0
Xsg13cmos5l_o21ai_1_188 \$3420 \$2431 \$1165 VPWR VGND \$3128 sg13cmos5l_o21ai_1
* cell instance sg13cmos5l_o21ai_1_189 r0 *1 0,0
Xsg13cmos5l_o21ai_1_189 \$116 \$128 \$181 VPWR VGND \$180 sg13cmos5l_o21ai_1
* cell instance sg13cmos5l_o21ai_1_190 r0 *1 0,0
Xsg13cmos5l_o21ai_1_190 \$685 \$1210 \$301 VPWR VGND \$1211 sg13cmos5l_o21ai_1
* cell instance sg13cmos5l_o21ai_1_191 r0 *1 0,0
Xsg13cmos5l_o21ai_1_191 \$1349 \$1208 \$681 VPWR VGND \$1210 sg13cmos5l_o21ai_1
* cell instance sg13cmos5l_o21ai_1_192 r0 *1 0,0
Xsg13cmos5l_o21ai_1_192 \$181 \$177 \$428 VPWR VGND \$183 sg13cmos5l_o21ai_1
* cell instance sg13cmos5l_o21ai_1_193 r0 *1 0,0
Xsg13cmos5l_o21ai_1_193 \$3973 \$3976 \$3974 VPWR VGND \$3977 sg13cmos5l_o21ai_1
* cell instance sg13cmos5l_o21ai_1_194 r0 *1 0,0
Xsg13cmos5l_o21ai_1_194 \$1099 \$1710 \$2033 VPWR VGND \$2046 sg13cmos5l_o21ai_1
* cell instance sg13cmos5l_o21ai_1_195 r0 *1 0,0
Xsg13cmos5l_o21ai_1_195 \$2719 \$2431 \$1165 VPWR VGND \$2578 sg13cmos5l_o21ai_1
* cell instance sg13cmos5l_o21ai_1_196 r0 *1 0,0
Xsg13cmos5l_o21ai_1_196 \$116 \$105 \$175 VPWR VGND \$445 sg13cmos5l_o21ai_1
* cell instance sg13cmos5l_o21ai_1_197 r0 *1 0,0
Xsg13cmos5l_o21ai_1_197 \$3973 \$1247 \$4052 VPWR VGND \$3978 sg13cmos5l_o21ai_1
* cell instance sg13cmos5l_o21ai_1_198 r0 *1 0,0
Xsg13cmos5l_o21ai_1_198 \$2906 \$2754 \$2753 VPWR VGND \$3300 sg13cmos5l_o21ai_1
* cell instance sg13cmos5l_o21ai_1_199 r0 *1 0,0
Xsg13cmos5l_o21ai_1_199 \$2106 \$1929 \$2048 VPWR VGND \$2047 sg13cmos5l_o21ai_1
* cell instance sg13cmos5l_o21ai_1_200 r0 *1 0,0
Xsg13cmos5l_o21ai_1_200 \$1453 \$105 \$120 VPWR VGND \$969 sg13cmos5l_o21ai_1
* cell instance sg13cmos5l_o21ai_1_201 r0 *1 0,0
Xsg13cmos5l_o21ai_1_201 \$2288 \$1929 \$2154 VPWR VGND \$2435 sg13cmos5l_o21ai_1
* cell instance sg13cmos5l_o21ai_1_202 r0 *1 0,0
Xsg13cmos5l_o21ai_1_202 \$3979 \$3981 \$4119 VPWR VGND \$3983 sg13cmos5l_o21ai_1
* cell instance sg13cmos5l_o21ai_1_203 r0 *1 0,0
Xsg13cmos5l_o21ai_1_203 \$996 \$4613 \$4614 VPWR VGND \$3644 sg13cmos5l_o21ai_1
* cell instance sg13cmos5l_o21ai_1_204 r0 *1 0,0
Xsg13cmos5l_o21ai_1_204 \$2583 \$2754 \$2582 VPWR VGND \$2436 sg13cmos5l_o21ai_1
* cell instance sg13cmos5l_o21ai_1_205 r0 *1 0,0
Xsg13cmos5l_o21ai_1_205 \$1718 \$1929 \$2008 VPWR VGND \$691 sg13cmos5l_o21ai_1
* cell instance sg13cmos5l_o21ai_1_206 r0 *1 0,0
Xsg13cmos5l_o21ai_1_206 \$2434 \$4323 \$864 VPWR VGND \$3478 sg13cmos5l_o21ai_1
* cell instance sg13cmos5l_o21ai_1_207 r0 *1 0,0
Xsg13cmos5l_o21ai_1_207 \$1584 \$1358 \$1467 VPWR VGND \$1585 sg13cmos5l_o21ai_1
* cell instance sg13cmos5l_o21ai_1_208 r0 *1 0,0
Xsg13cmos5l_o21ai_1_208 \$447 \$63 \$1879 VPWR VGND \$450 sg13cmos5l_o21ai_1
* cell instance sg13cmos5l_o21ai_1_209 r0 *1 0,0
Xsg13cmos5l_o21ai_1_209 \$5633 \$6088 \$5832 VPWR VGND \$2062 sg13cmos5l_o21ai_1
* cell instance sg13cmos5l_o21ai_1_210 r0 *1 0,0
Xsg13cmos5l_o21ai_1_210 \$2643 \$2431 \$2060 VPWR VGND \$2161 sg13cmos5l_o21ai_1
* cell instance sg13cmos5l_o21ai_1_211 r0 *1 0,0
Xsg13cmos5l_o21ai_1_211 \$2156 \$2161 \$2162 VPWR VGND \$398 sg13cmos5l_o21ai_1
* cell instance sg13cmos5l_o21ai_1_212 r0 *1 0,0
Xsg13cmos5l_o21ai_1_212 \$4425 \$4615 \$4617 VPWR VGND \$4616 sg13cmos5l_o21ai_1
* cell instance sg13cmos5l_o21ai_1_213 r0 *1 0,0
Xsg13cmos5l_o21ai_1_213 \$4288 \$3804 \$3988 VPWR VGND \$3805 sg13cmos5l_o21ai_1
* cell instance sg13cmos5l_o21ai_1_214 r0 *1 0,0
Xsg13cmos5l_o21ai_1_214 \$4288 \$4618 \$4004 VPWR VGND \$4615 sg13cmos5l_o21ai_1
* cell instance sg13cmos5l_o21ai_1_215 r0 *1 0,0
Xsg13cmos5l_o21ai_1_215 \$4906 \$5641 \$6014 VPWR VGND \$2767 sg13cmos5l_o21ai_1
* cell instance sg13cmos5l_o21ai_1_216 r0 *1 0,0
Xsg13cmos5l_o21ai_1_216 \$1833 \$2294 \$2431 VPWR VGND \$2443 sg13cmos5l_o21ai_1
* cell instance sg13cmos5l_o21ai_1_217 r0 *1 0,0
Xsg13cmos5l_o21ai_1_217 \$4127 \$4623 \$4996 VPWR VGND \$5211 sg13cmos5l_o21ai_1
* cell instance sg13cmos5l_o21ai_1_218 r0 *1 0,0
Xsg13cmos5l_o21ai_1_218 \$1473 \$1483 \$1358 VPWR VGND \$1593 sg13cmos5l_o21ai_1
* cell instance sg13cmos5l_o21ai_1_219 r0 *1 0,0
Xsg13cmos5l_o21ai_1_219 \$3135 \$2650 \$2911 VPWR VGND \$2910 sg13cmos5l_o21ai_1
* cell instance sg13cmos5l_o21ai_1_220 r0 *1 0,0
Xsg13cmos5l_o21ai_1_220 \$453 \$565 \$973 VPWR VGND \$981 sg13cmos5l_o21ai_1
* cell instance sg13cmos5l_o21ai_1_221 r0 *1 0,0
Xsg13cmos5l_o21ai_1_221 \$2295 \$1939 \$2297 VPWR VGND \$2296 sg13cmos5l_o21ai_1
* cell instance sg13cmos5l_o21ai_1_222 r0 *1 0,0
Xsg13cmos5l_o21ai_1_222 \$4288 \$4618 \$4274 VPWR VGND \$4449 sg13cmos5l_o21ai_1
* cell instance sg13cmos5l_o21ai_1_223 r0 *1 0,0
Xsg13cmos5l_o21ai_1_223 \$1833 \$1238 \$1366 VPWR VGND \$1362 sg13cmos5l_o21ai_1
* cell instance sg13cmos5l_o21ai_1_224 r0 *1 0,0
Xsg13cmos5l_o21ai_1_224 \$1824 \$1365 \$1825 VPWR VGND \$1727 sg13cmos5l_o21ai_1
* cell instance sg13cmos5l_o21ai_1_225 r0 *1 0,0
Xsg13cmos5l_o21ai_1_225 \$1584 \$2297 \$2177 VPWR VGND \$2362 sg13cmos5l_o21ai_1
* cell instance sg13cmos5l_o21ai_1_226 r0 *1 0,0
Xsg13cmos5l_o21ai_1_226 \$5216 \$4126 \$5039 VPWR VGND \$5218 sg13cmos5l_o21ai_1
* cell instance sg13cmos5l_o21ai_1_227 r0 *1 0,0
Xsg13cmos5l_o21ai_1_227 \$4130 \$6019 \$4287 VPWR VGND \$5651 sg13cmos5l_o21ai_1
* cell instance sg13cmos5l_o21ai_1_228 r0 *1 0,0
Xsg13cmos5l_o21ai_1_228 \$138 \$340 \$396 VPWR VGND \$337 sg13cmos5l_o21ai_1
* cell instance sg13cmos5l_o21ai_1_229 r0 *1 0,0
Xsg13cmos5l_o21ai_1_229 \$1945 \$1825 \$1828 VPWR VGND \$1947 sg13cmos5l_o21ai_1
* cell instance sg13cmos5l_o21ai_1_230 r0 *1 0,0
Xsg13cmos5l_o21ai_1_230 \$2982 \$3128 \$3142 VPWR VGND \$591 sg13cmos5l_o21ai_1
* cell instance sg13cmos5l_o21ai_1_231 r0 *1 0,0
Xsg13cmos5l_o21ai_1_231 \$2445 \$2300 \$2597 VPWR VGND \$2764 sg13cmos5l_o21ai_1
* cell instance sg13cmos5l_o21ai_1_232 r0 *1 0,0
Xsg13cmos5l_o21ai_1_232 \$3990 \$4683 \$5218 VPWR VGND \$5420 sg13cmos5l_o21ai_1
* cell instance sg13cmos5l_o21ai_1_233 r0 *1 0,0
Xsg13cmos5l_o21ai_1_233 \$2985 \$3317 \$3319 VPWR VGND \$3318 sg13cmos5l_o21ai_1
* cell instance sg13cmos5l_o21ai_1_234 r0 *1 0,0
Xsg13cmos5l_o21ai_1_234 \$2217 \$3654 \$3650 VPWR VGND \$3655 sg13cmos5l_o21ai_1
* cell instance sg13cmos5l_o21ai_1_235 r0 *1 0,0
Xsg13cmos5l_o21ai_1_235 \$466 \$140 \$141 VPWR VGND \$467 sg13cmos5l_o21ai_1
* cell instance sg13cmos5l_o21ai_1_236 r0 *1 0,0
Xsg13cmos5l_o21ai_1_236 \$1949 \$2068 \$2108 VPWR VGND \$1948 sg13cmos5l_o21ai_1
* cell instance sg13cmos5l_o21ai_1_237 r0 *1 0,0
Xsg13cmos5l_o21ai_1_237 \$2916 \$2913 \$2447 VPWR VGND \$3141 sg13cmos5l_o21ai_1
* cell instance sg13cmos5l_o21ai_1_238 r0 *1 0,0
Xsg13cmos5l_o21ai_1_238 \$2302 \$2446 \$2364 VPWR VGND \$2598 sg13cmos5l_o21ai_1
* cell instance sg13cmos5l_o21ai_1_239 r0 *1 0,0
Xsg13cmos5l_o21ai_1_239 \$516 \$201 \$202 VPWR VGND \$469 sg13cmos5l_o21ai_1
* cell instance sg13cmos5l_o21ai_1_240 r0 *1 0,0
Xsg13cmos5l_o21ai_1_240 \$3661 \$4059 \$4001 VPWR VGND \$3999 sg13cmos5l_o21ai_1
* cell instance sg13cmos5l_o21ai_1_241 r0 *1 0,0
Xsg13cmos5l_o21ai_1_241 \$1492 \$1584 \$1783 VPWR VGND \$1827 sg13cmos5l_o21ai_1
* cell instance sg13cmos5l_o21ai_1_242 r0 *1 0,0
Xsg13cmos5l_o21ai_1_242 \$3834 \$3499 \$4818 VPWR VGND \$4141 sg13cmos5l_o21ai_1
* cell instance sg13cmos5l_o21ai_1_243 r0 *1 0,0
Xsg13cmos5l_o21ai_1_243 \$4453 \$5423 \$5654 VPWR VGND \$5417 sg13cmos5l_o21ai_1
* cell instance sg13cmos5l_o21ai_1_244 r0 *1 0,0
Xsg13cmos5l_o21ai_1_244 \$3835 \$3659 \$3658 VPWR VGND \$3660 sg13cmos5l_o21ai_1
* cell instance sg13cmos5l_o21ai_1_245 r0 *1 0,0
Xsg13cmos5l_o21ai_1_245 \$1492 \$1371 \$1498 VPWR VGND \$1485 sg13cmos5l_o21ai_1
* cell instance sg13cmos5l_o21ai_1_246 r0 *1 0,0
Xsg13cmos5l_o21ai_1_246 \$1494 \$921 \$1832 VPWR VGND \$1783 sg13cmos5l_o21ai_1
* cell instance sg13cmos5l_o21ai_1_247 r0 *1 0,0
Xsg13cmos5l_o21ai_1_247 \$3661 \$3662 \$3664 VPWR VGND \$3663 sg13cmos5l_o21ai_1
* cell instance sg13cmos5l_o21ai_1_248 r0 *1 0,0
Xsg13cmos5l_o21ai_1_248 \$1833 \$2069 \$2071 VPWR VGND \$2070 sg13cmos5l_o21ai_1
* cell instance sg13cmos5l_o21ai_1_249 r0 *1 0,0
Xsg13cmos5l_o21ai_1_249 \$5470 \$6413 \$6347 VPWR VGND \$6036 sg13cmos5l_o21ai_1
* cell instance sg13cmos5l_o21ai_1_250 r0 *1 0,0
Xsg13cmos5l_o21ai_1_250 \$2985 \$3153 \$3154 VPWR VGND \$3146 sg13cmos5l_o21ai_1
* cell instance sg13cmos5l_o21ai_1_251 r0 *1 0,0
Xsg13cmos5l_o21ai_1_251 \$5003 \$4623 \$4820 VPWR VGND \$5001 sg13cmos5l_o21ai_1
* cell instance sg13cmos5l_o21ai_1_252 r0 *1 0,0
Xsg13cmos5l_o21ai_1_252 \$5409 \$19893 \$19401 VPWR VGND \$19856
+ sg13cmos5l_o21ai_1
* cell instance sg13cmos5l_o21ai_1_253 r0 *1 0,0
Xsg13cmos5l_o21ai_1_253 \$14831 \$3235 \$14611 VPWR VGND \$6409
+ sg13cmos5l_o21ai_1
* cell instance sg13cmos5l_o21ai_1_254 r0 *1 0,0
Xsg13cmos5l_o21ai_1_254 \$1477 \$1245 \$1832 VPWR VGND \$1501 sg13cmos5l_o21ai_1
* cell instance sg13cmos5l_o21ai_1_255 r0 *1 0,0
Xsg13cmos5l_o21ai_1_255 \$3381 \$4293 \$4295 VPWR VGND \$4294 sg13cmos5l_o21ai_1
* cell instance sg13cmos5l_o21ai_1_256 r0 *1 0,0
Xsg13cmos5l_o21ai_1_256 \$6043 \$7350 \$7351 VPWR VGND \$7191 sg13cmos5l_o21ai_1
* cell instance sg13cmos5l_o21ai_1_257 r0 *1 0,0
Xsg13cmos5l_o21ai_1_257 \$5470 \$5842 \$5656 VPWR VGND \$5843 sg13cmos5l_o21ai_1
* cell instance sg13cmos5l_o21ai_1_258 r0 *1 0,0
Xsg13cmos5l_o21ai_1_258 \$1833 \$1944 \$1955 VPWR VGND \$1954 sg13cmos5l_o21ai_1
* cell instance sg13cmos5l_o21ai_1_259 r0 *1 0,0
Xsg13cmos5l_o21ai_1_259 \$1584 \$1597 \$1836 VPWR VGND \$1835 sg13cmos5l_o21ai_1
* cell instance sg13cmos5l_o21ai_1_260 r0 *1 0,0
Xsg13cmos5l_o21ai_1_260 \$5428 \$4000 \$6417 VPWR VGND \$6416 sg13cmos5l_o21ai_1
* cell instance sg13cmos5l_o21ai_1_261 r0 *1 0,0
Xsg13cmos5l_o21ai_1_261 \$6043 \$7065 \$7352 VPWR VGND \$6851 sg13cmos5l_o21ai_1
* cell instance sg13cmos5l_o21ai_1_262 r0 *1 0,0
Xsg13cmos5l_o21ai_1_262 \$605 \$201 \$608 VPWR VGND \$607 sg13cmos5l_o21ai_1
* cell instance sg13cmos5l_o21ai_1_263 r0 *1 0,0
Xsg13cmos5l_o21ai_1_263 \$5470 \$6422 \$6304 VPWR VGND \$6423 sg13cmos5l_o21ai_1
* cell instance sg13cmos5l_o21ai_1_264 r0 *1 0,0
Xsg13cmos5l_o21ai_1_264 \$4821 \$4490 \$4618 VPWR VGND \$4015 sg13cmos5l_o21ai_1
* cell instance sg13cmos5l_o21ai_1_265 r0 *1 0,0
Xsg13cmos5l_o21ai_1_265 \$5428 \$6515 \$6045 VPWR VGND \$6506 sg13cmos5l_o21ai_1
* cell instance sg13cmos5l_o21ai_1_266 r0 *1 0,0
Xsg13cmos5l_o21ai_1_266 \$2985 \$2933 \$2934 VPWR VGND \$2920 sg13cmos5l_o21ai_1
* cell instance sg13cmos5l_o21ai_1_267 r0 *1 0,0
Xsg13cmos5l_o21ai_1_267 \$5428 \$4455 \$5227 VPWR VGND \$5429 sg13cmos5l_o21ai_1
* cell instance sg13cmos5l_o21ai_1_268 r0 *1 0,0
Xsg13cmos5l_o21ai_1_268 \$3868 \$4457 \$3381 VPWR VGND \$4300 sg13cmos5l_o21ai_1
* cell instance sg13cmos5l_o21ai_1_269 r0 *1 0,0
Xsg13cmos5l_o21ai_1_269 \$3661 \$3856 \$4013 VPWR VGND \$3850 sg13cmos5l_o21ai_1
* cell instance sg13cmos5l_o21ai_1_270 r0 *1 0,0
Xsg13cmos5l_o21ai_1_270 \$3865 \$4300 \$4301 VPWR VGND \$4298 sg13cmos5l_o21ai_1
* cell instance sg13cmos5l_o21ai_1_271 r0 *1 0,0
Xsg13cmos5l_o21ai_1_271 \$5428 \$4149 \$6507 VPWR VGND \$6509 sg13cmos5l_o21ai_1
* cell instance sg13cmos5l_o21ai_1_272 r0 *1 0,0
Xsg13cmos5l_o21ai_1_272 \$2985 \$2775 \$2776 VPWR VGND \$2608 sg13cmos5l_o21ai_1
* cell instance sg13cmos5l_o21ai_1_273 r0 *1 0,0
Xsg13cmos5l_o21ai_1_273 \$5228 \$4683 \$4824 VPWR VGND \$5004 sg13cmos5l_o21ai_1
* cell instance sg13cmos5l_o21ai_1_274 r0 *1 0,0
Xsg13cmos5l_o21ai_1_274 \$5470 \$5665 \$5432 VPWR VGND \$5431 sg13cmos5l_o21ai_1
* cell instance sg13cmos5l_o21ai_1_275 r0 *1 0,0
Xsg13cmos5l_o21ai_1_275 \$3835 \$3148 \$2937 VPWR VGND \$3163 sg13cmos5l_o21ai_1
* cell instance sg13cmos5l_o21ai_1_276 r0 *1 0,0
Xsg13cmos5l_o21ai_1_276 \$2922 \$3835 \$4302 VPWR VGND \$4462 sg13cmos5l_o21ai_1
* cell instance sg13cmos5l_o21ai_1_277 r0 *1 0,0
Xsg13cmos5l_o21ai_1_277 \$2938 \$3347 \$3169 VPWR VGND \$3167 sg13cmos5l_o21ai_1
* cell instance sg13cmos5l_o21ai_1_278 r0 *1 0,0
Xsg13cmos5l_o21ai_1_278 \$7354 \$7196 \$7168 VPWR VGND \$6853 sg13cmos5l_o21ai_1
* cell instance sg13cmos5l_o21ai_1_279 r0 *1 0,0
Xsg13cmos5l_o21ai_1_279 \$2655 \$2613 \$2614 VPWR VGND \$2313 sg13cmos5l_o21ai_1
* cell instance sg13cmos5l_o21ai_1_280 r0 *1 0,0
Xsg13cmos5l_o21ai_1_280 \$3868 \$1952 \$3866 VPWR VGND \$3860 sg13cmos5l_o21ai_1
* cell instance sg13cmos5l_o21ai_1_281 r0 *1 0,0
Xsg13cmos5l_o21ai_1_281 \$6308 \$6303 \$5233 VPWR VGND \$5861 sg13cmos5l_o21ai_1
* cell instance sg13cmos5l_o21ai_1_282 r0 *1 0,0
Xsg13cmos5l_o21ai_1_282 \$7354 \$7663 \$7533 VPWR VGND \$7661 sg13cmos5l_o21ai_1
* cell instance sg13cmos5l_o21ai_1_283 r0 *1 0,0
Xsg13cmos5l_o21ai_1_283 \$2655 \$3538 \$3539 VPWR VGND \$3350 sg13cmos5l_o21ai_1
* cell instance sg13cmos5l_o21ai_1_284 r0 *1 0,0
Xsg13cmos5l_o21ai_1_284 \$6308 \$6513 \$6309 VPWR VGND \$7198 sg13cmos5l_o21ai_1
* cell instance sg13cmos5l_o21ai_1_285 r0 *1 0,0
Xsg13cmos5l_o21ai_1_285 \$4821 \$2941 \$5216 VPWR VGND \$1952 sg13cmos5l_o21ai_1
* cell instance sg13cmos5l_o21ai_1_286 r0 *1 0,0
Xsg13cmos5l_o21ai_1_286 \$1958 \$862 \$2082 VPWR VGND \$2199 sg13cmos5l_o21ai_1
* cell instance sg13cmos5l_o21ai_1_287 r0 *1 0,0
Xsg13cmos5l_o21ai_1_287 \$2938 \$3859 \$3860 VPWR VGND \$3685 sg13cmos5l_o21ai_1
* cell instance sg13cmos5l_o21ai_1_288 r0 *1 0,0
Xsg13cmos5l_o21ai_1_288 \$2938 \$2609 \$2944 VPWR VGND \$2942 sg13cmos5l_o21ai_1
* cell instance sg13cmos5l_o21ai_1_289 r0 *1 0,0
Xsg13cmos5l_o21ai_1_289 \$6308 \$5427 \$6312 VPWR VGND \$6311 sg13cmos5l_o21ai_1
* cell instance sg13cmos5l_o21ai_1_290 r0 *1 0,0
Xsg13cmos5l_o21ai_1_290 \$2938 \$2316 \$3688 VPWR VGND \$3687 sg13cmos5l_o21ai_1
* cell instance sg13cmos5l_o21ai_1_291 r0 *1 0,0
Xsg13cmos5l_o21ai_1_291 \$7354 \$7665 \$7666 VPWR VGND \$7539 sg13cmos5l_o21ai_1
* cell instance sg13cmos5l_o21ai_1_292 r0 *1 0,0
Xsg13cmos5l_o21ai_1_292 \$2655 \$2621 \$2622 VPWR VGND \$2472 sg13cmos5l_o21ai_1
* cell instance sg13cmos5l_o21ai_1_293 r0 *1 0,0
Xsg13cmos5l_o21ai_1_293 \$2655 \$3544 \$3545 VPWR VGND \$3356 sg13cmos5l_o21ai_1
* cell instance sg13cmos5l_o21ai_1_294 r0 *1 0,0
Xsg13cmos5l_o21ai_1_294 \$7354 \$7080 \$7355 VPWR VGND \$6859 sg13cmos5l_o21ai_1
* cell instance sg13cmos5l_o21ai_1_295 r0 *1 0,0
Xsg13cmos5l_o21ai_1_295 \$3868 \$3869 \$3870 VPWR VGND \$3688 sg13cmos5l_o21ai_1
* cell instance sg13cmos5l_o21ai_1_296 r0 *1 0,0
Xsg13cmos5l_o21ai_1_296 \$5428 \$5864 \$6444 VPWR VGND \$6447 sg13cmos5l_o21ai_1
* cell instance sg13cmos5l_o21ai_1_297 r0 *1 0,0
Xsg13cmos5l_o21ai_1_297 \$5666 \$6315 \$6317 VPWR VGND \$5870 sg13cmos5l_o21ai_1
* cell instance sg13cmos5l_o21ai_1_298 r0 *1 0,0
Xsg13cmos5l_o21ai_1_298 \$4306 \$2474 \$5008 VPWR VGND \$4837 sg13cmos5l_o21ai_1
* cell instance sg13cmos5l_o21ai_1_299 r0 *1 0,0
Xsg13cmos5l_o21ai_1_299 \$3172 \$2946 \$3359 VPWR VGND \$3360 sg13cmos5l_o21ai_1
* cell instance sg13cmos5l_o21ai_1_300 r0 *1 0,0
Xsg13cmos5l_o21ai_1_300 \$6336 \$4453 \$6320 VPWR VGND \$5678 sg13cmos5l_o21ai_1
* cell instance sg13cmos5l_o21ai_1_301 r0 *1 0,0
Xsg13cmos5l_o21ai_1_301 \$2628 \$2784 \$2626 VPWR VGND \$2785 sg13cmos5l_o21ai_1
* cell instance sg13cmos5l_o21ai_1_302 r0 *1 0,0
Xsg13cmos5l_o21ai_1_302 \$3534 \$3692 \$3549 VPWR VGND \$3693 sg13cmos5l_o21ai_1
* cell instance sg13cmos5l_o21ai_1_303 r0 *1 0,0
Xsg13cmos5l_o21ai_1_303 \$6308 \$2807 \$5236 VPWR VGND \$5239 sg13cmos5l_o21ai_1
* cell instance sg13cmos5l_o21ai_1_304 r0 *1 0,0
Xsg13cmos5l_o21ai_1_304 \$2628 \$2629 \$2341 VPWR VGND \$2338 sg13cmos5l_o21ai_1
* cell instance sg13cmos5l_o21ai_1_305 r0 *1 0,0
Xsg13cmos5l_o21ai_1_305 \$3534 \$4175 \$4172 VPWR VGND \$4032 sg13cmos5l_o21ai_1
* cell instance sg13cmos5l_o21ai_1_306 r0 *1 0,0
Xsg13cmos5l_o21ai_1_306 \$5666 \$6324 \$6059 VPWR VGND \$6449 sg13cmos5l_o21ai_1
* cell instance sg13cmos5l_o21ai_1_307 r0 *1 0,0
Xsg13cmos5l_o21ai_1_307 \$6308 \$4833 \$5680 VPWR VGND \$5884 sg13cmos5l_o21ai_1
* cell instance sg13cmos5l_o21ai_1_308 r0 *1 0,0
Xsg13cmos5l_o21ai_1_308 \$6617 \$6863 \$6800 VPWR VGND \$6597 sg13cmos5l_o21ai_1
* cell instance sg13cmos5l_o21ai_1_309 r0 *1 0,0
Xsg13cmos5l_o21ai_1_309 \$4306 \$4839 \$4832 VPWR VGND \$4845 sg13cmos5l_o21ai_1
* cell instance sg13cmos5l_o21ai_1_310 r0 *1 0,0
Xsg13cmos5l_o21ai_1_310 \$6617 \$7803 \$7202 VPWR VGND \$7674 sg13cmos5l_o21ai_1
* cell instance sg13cmos5l_o21ai_1_311 r0 *1 0,0
Xsg13cmos5l_o21ai_1_311 \$5666 \$5682 \$5683 VPWR VGND \$5011 sg13cmos5l_o21ai_1
* cell instance sg13cmos5l_o21ai_1_312 r0 *1 0,0
Xsg13cmos5l_o21ai_1_312 \$3534 \$4847 \$4848 VPWR VGND \$4644 sg13cmos5l_o21ai_1
* cell instance sg13cmos5l_o21ai_1_313 r0 *1 0,0
Xsg13cmos5l_o21ai_1_313 \$3172 \$3188 \$4179 VPWR VGND \$4178 sg13cmos5l_o21ai_1
* cell instance sg13cmos5l_o21ai_1_314 r0 *1 0,0
Xsg13cmos5l_o21ai_1_314 \$2628 \$3365 \$3363 VPWR VGND \$3189 sg13cmos5l_o21ai_1
* cell instance sg13cmos5l_o21ai_1_315 r0 *1 0,0
Xsg13cmos5l_o21ai_1_315 \$5428 \$6599 \$6794 VPWR VGND \$6802 sg13cmos5l_o21ai_1
* cell instance sg13cmos5l_o21ai_1_316 r0 *1 0,0
Xsg13cmos5l_o21ai_1_316 \$4306 \$2340 \$4043 VPWR VGND \$4042 sg13cmos5l_o21ai_1
* cell instance sg13cmos5l_or2_1_0 r0 *1 0,0
Xsg13cmos5l_or2_1_0 \$66 \$406 VPWR VGND \$157 sg13cmos5l_or2_1
* cell instance sg13cmos5l_or2_1_1 r0 *1 0,0
Xsg13cmos5l_or2_1_1 \$5283 \$5892 VPWR VGND \$6079 sg13cmos5l_or2_1
* cell instance sg13cmos5l_or2_1_2 r0 *1 0,0
Xsg13cmos5l_or2_1_2 \$4229 \$4873 VPWR VGND \$4877 sg13cmos5l_or2_1
* cell instance sg13cmos5l_or2_1_3 r0 *1 0,0
Xsg13cmos5l_or2_1_3 \$4483 \$3916 VPWR VGND \$3739 sg13cmos5l_or2_1
* cell instance sg13cmos5l_or2_1_4 r0 *1 0,0
Xsg13cmos5l_or2_1_4 \$5051 \$4878 VPWR VGND \$5059 sg13cmos5l_or2_1
* cell instance sg13cmos5l_or2_1_5 r0 *1 0,0
Xsg13cmos5l_or2_1_5 \$651 \$1672 VPWR VGND \$1676 sg13cmos5l_or2_1
* cell instance sg13cmos5l_or2_1_6 r0 *1 0,0
Xsg13cmos5l_or2_1_6 \$2826 \$3022 VPWR VGND \$3227 sg13cmos5l_or2_1
* cell instance sg13cmos5l_or2_1_7 r0 *1 0,0
Xsg13cmos5l_or2_1_7 \$2821 \$2822 VPWR VGND \$3406 sg13cmos5l_or2_1
* cell instance sg13cmos5l_or2_1_8 r0 *1 0,0
Xsg13cmos5l_or2_1_8 \$2998 \$2999 VPWR VGND \$3229 sg13cmos5l_or2_1
* cell instance sg13cmos5l_or2_1_9 r0 *1 0,0
Xsg13cmos5l_or2_1_9 \$807 \$1430 VPWR VGND \$1323 sg13cmos5l_or2_1
* cell instance sg13cmos5l_or2_1_10 r0 *1 0,0
Xsg13cmos5l_or2_1_10 \$864 \$2434 VPWR VGND \$222 sg13cmos5l_or2_1
* cell instance sg13cmos5l_or2_1_11 r0 *1 0,0
Xsg13cmos5l_or2_1_11 \$4235 \$5646 VPWR VGND \$5890 sg13cmos5l_or2_1
* cell instance sg13cmos5l_or2_1_12 r0 *1 0,0
Xsg13cmos5l_or2_1_12 \$9 \$53 VPWR VGND \$34 sg13cmos5l_or2_1
* cell instance sg13cmos5l_or2_1_13 r0 *1 0,0
Xsg13cmos5l_or2_1_13 \$1234 \$1229 VPWR VGND \$1235 sg13cmos5l_or2_1
* cell instance sg13cmos5l_or2_1_14 r0 *1 0,0
Xsg13cmos5l_or2_1_14 \$1940 \$1944 VPWR VGND \$1937 sg13cmos5l_or2_1
* cell instance sg13cmos5l_or2_1_15 r0 *1 0,0
Xsg13cmos5l_or2_1_15 \$4127 \$3990 VPWR VGND \$3313 sg13cmos5l_or2_1
* cell instance sg13cmos5l_or2_1_16 r0 *1 0,0
Xsg13cmos5l_or2_1_16 \$1236 \$1238 VPWR VGND \$1234 sg13cmos5l_or2_1
* cell instance sg13cmos5l_or2_1_17 r0 *1 0,0
Xsg13cmos5l_or2_1_17 \$4139 \$4004 VPWR VGND \$4453 sg13cmos5l_or2_1
* cell instance sg13cmos5l_or2_1_18 r0 *1 0,0
Xsg13cmos5l_or2_1_18 \$1368 \$2762 VPWR VGND \$2769 sg13cmos5l_or2_1
* cell instance sg13cmos5l_or2_1_19 r0 *1 0,0
Xsg13cmos5l_or2_1_19 \$1602 \$1502 VPWR VGND \$1732 sg13cmos5l_or2_1
* cell instance sg13cmos5l_or2_1_20 r0 *1 0,0
Xsg13cmos5l_or2_1_20 \$1584 \$1498 VPWR VGND \$1500 sg13cmos5l_or2_1
* cell instance sg13cmos5l_or2_1_21 r0 *1 0,0
Xsg13cmos5l_or2_1_21 \$4685 \$4466 VPWR VGND \$5223 sg13cmos5l_or2_1
* cell instance sg13cmos5l_or2_1_22 r0 *1 0,0
Xsg13cmos5l_or2_1_22 \$579 \$1020 VPWR VGND \$862 sg13cmos5l_or2_1
* cell instance sg13cmos5l_or3_1_0 r0 *1 0,0
Xsg13cmos5l_or3_1_0 \$2388 \$3220 \$3218 VPWR VGND \$2385 sg13cmos5l_or3_1
* cell instance sg13cmos5l_or3_1_1 r0 *1 0,0
Xsg13cmos5l_or3_1_1 \$4521 \$3705 \$4517 VPWR VGND \$4367 sg13cmos5l_or3_1
* cell instance sg13cmos5l_or3_1_2 r0 *1 0,0
Xsg13cmos5l_or3_1_2 \$1051 \$808 \$1068 VPWR VGND \$1070 sg13cmos5l_or3_1
* cell instance sg13cmos5l_or3_1_3 r0 *1 0,0
Xsg13cmos5l_or3_1_3 \$2388 \$2837 \$2834 VPWR VGND \$1202 sg13cmos5l_or3_1
* cell instance sg13cmos5l_or3_1_4 r0 *1 0,0
Xsg13cmos5l_or3_1_4 \$3612 \$3248 \$2049 VPWR VGND \$3775 sg13cmos5l_or3_1
* cell instance sg13cmos5l_or3_1_5 r0 *1 0,0
Xsg13cmos5l_or3_1_5 \$3246 \$3248 \$2049 VPWR VGND \$3249 sg13cmos5l_or3_1
* cell instance sg13cmos5l_or3_1_6 r0 *1 0,0
Xsg13cmos5l_or3_1_6 \$3431 \$3248 \$2049 VPWR VGND \$3251 sg13cmos5l_or3_1
* cell instance sg13cmos5l_or3_1_7 r0 *1 0,0
Xsg13cmos5l_or3_1_7 \$4552 \$4226 \$4547 VPWR VGND \$4554 sg13cmos5l_or3_1
* cell instance sg13cmos5l_or3_1_8 r0 *1 0,0
Xsg13cmos5l_or3_1_8 \$4552 \$4226 \$4664 VPWR VGND \$4189 sg13cmos5l_or3_1
* cell instance sg13cmos5l_or3_1_9 r0 *1 0,0
Xsg13cmos5l_or3_1_9 \$2870 \$3248 \$2049 VPWR VGND \$3049 sg13cmos5l_or3_1
* cell instance sg13cmos5l_or3_1_10 r0 *1 0,0
Xsg13cmos5l_or3_1_10 \$2577 \$2153 \$2146 VPWR VGND \$2753 sg13cmos5l_or3_1
* cell instance sg13cmos5l_or3_1_11 r0 *1 0,0
Xsg13cmos5l_or3_1_11 \$2148 \$2153 \$2146 VPWR VGND \$2048 sg13cmos5l_or3_1
* cell instance sg13cmos5l_or3_1_12 r0 *1 0,0
Xsg13cmos5l_or3_1_12 \$1466 \$2153 \$2146 VPWR VGND \$2154 sg13cmos5l_or3_1
* cell instance sg13cmos5l_or3_1_13 r0 *1 0,0
Xsg13cmos5l_or3_1_13 \$1717 \$2153 \$2049 VPWR VGND \$2008 sg13cmos5l_or3_1
* cell instance sg13cmos5l_or3_1_14 r0 *1 0,0
Xsg13cmos5l_or3_1_14 \$1223 \$2153 \$2146 VPWR VGND \$2582 sg13cmos5l_or3_1
* cell instance sg13cmos5l_or4_1_0 r0 *1 0,0
Xsg13cmos5l_or4_1_0 \$4104 \$2719 \$3420 \$3026 VPWR VGND \$4226
+ sg13cmos5l_or4_1
* cell instance sg13cmos5l_or4_1_1 r0 *1 0,0
Xsg13cmos5l_or4_1_1 \$4065 \$4549 \$2056 \$4226 VPWR VGND \$4873
+ sg13cmos5l_or4_1
* cell instance sg13cmos5l_or4_1_2 r0 *1 0,0
Xsg13cmos5l_or4_1_2 \$2643 \$2719 \$3420 \$3026 VPWR VGND \$4550
+ sg13cmos5l_or4_1
* cell instance sg13cmos5l_or4_1_3 r0 *1 0,0
Xsg13cmos5l_or4_1_3 \$1735 \$1488 \$1595 \$1728 VPWR VGND \$1731
+ sg13cmos5l_or4_1
* cell instance sg13cmos5l_tiehi_0 r0 *1 0,0
Xsg13cmos5l_tiehi_0 \$19984 VPWR VGND sg13cmos5l_tiehi
* cell instance sg13cmos5l_tiehi_1 r0 *1 0,0
Xsg13cmos5l_tiehi_1 \$6102 VPWR VGND sg13cmos5l_tiehi
* cell instance sg13cmos5l_tiehi_2 r0 *1 0,0
Xsg13cmos5l_tiehi_2 \$6110 VPWR VGND sg13cmos5l_tiehi
* cell instance sg13cmos5l_tiehi_3 r0 *1 0,0
Xsg13cmos5l_tiehi_3 \$6127 VPWR VGND sg13cmos5l_tiehi
* cell instance sg13cmos5l_tiehi_4 r0 *1 0,0
Xsg13cmos5l_tiehi_4 \$6138 VPWR VGND sg13cmos5l_tiehi
* cell instance sg13cmos5l_tiehi_5 r0 *1 0,0
Xsg13cmos5l_tiehi_5 \$6149 VPWR VGND sg13cmos5l_tiehi
* cell instance sg13cmos5l_tiehi_6 r0 *1 0,0
Xsg13cmos5l_tiehi_6 \$6160 VPWR VGND sg13cmos5l_tiehi
* cell instance sg13cmos5l_tiehi_7 r0 *1 0,0
Xsg13cmos5l_tiehi_7 \$6171 VPWR VGND sg13cmos5l_tiehi
* cell instance sg13cmos5l_tiehi_8 r0 *1 0,0
Xsg13cmos5l_tiehi_8 \$6182 VPWR VGND sg13cmos5l_tiehi
* cell instance sg13cmos5l_tiehi_9 r0 *1 0,0
Xsg13cmos5l_tiehi_9 \$6208 VPWR VGND sg13cmos5l_tiehi
* cell instance sg13cmos5l_tiehi_10 r0 *1 0,0
Xsg13cmos5l_tiehi_10 \$6212 VPWR VGND sg13cmos5l_tiehi
* cell instance sg13cmos5l_tiehi_11 r0 *1 0,0
Xsg13cmos5l_tiehi_11 \$6228 VPWR VGND sg13cmos5l_tiehi
* cell instance sg13cmos5l_tiehi_12 r0 *1 0,0
Xsg13cmos5l_tiehi_12 \$6576 VPWR VGND sg13cmos5l_tiehi
* cell instance sg13cmos5l_tiehi_13 r0 *1 0,0
Xsg13cmos5l_tiehi_13 \$6249 VPWR VGND sg13cmos5l_tiehi
* cell instance sg13cmos5l_tiehi_14 r0 *1 0,0
Xsg13cmos5l_tiehi_14 \$6261 VPWR VGND sg13cmos5l_tiehi
* cell instance sg13cmos5l_tiehi_15 r0 *1 0,0
Xsg13cmos5l_tiehi_15 \$6273 VPWR VGND sg13cmos5l_tiehi
* cell instance sg13cmos5l_tiehi_16 r0 *1 0,0
Xsg13cmos5l_tiehi_16 \$6284 VPWR VGND sg13cmos5l_tiehi
* cell instance sg13cmos5l_tiehi_17 r0 *1 0,0
Xsg13cmos5l_tiehi_17 \$6291 VPWR VGND sg13cmos5l_tiehi
* cell instance sg13cmos5l_tielo_0 r0 *1 0,0
Xsg13cmos5l_tielo_0 \$6609 VPWR VGND sg13cmos5l_tielo
* cell instance sg13cmos5l_tielo_1 r0 *1 0,0
Xsg13cmos5l_tielo_1 \$6339 VPWR VGND sg13cmos5l_tielo
* cell instance sg13cmos5l_tielo_2 r0 *1 0,0
Xsg13cmos5l_tielo_2 \$6106 VPWR VGND sg13cmos5l_tielo
* cell instance sg13cmos5l_tielo_3 r0 *1 0,0
Xsg13cmos5l_tielo_3 \$6111 VPWR VGND sg13cmos5l_tielo
* cell instance sg13cmos5l_tielo_4 r0 *1 0,0
Xsg13cmos5l_tielo_4 \$6120 VPWR VGND sg13cmos5l_tielo
* cell instance sg13cmos5l_tielo_5 r0 *1 0,0
Xsg13cmos5l_tielo_5 \$6340 VPWR VGND sg13cmos5l_tielo
* cell instance sg13cmos5l_tielo_6 r0 *1 0,0
Xsg13cmos5l_tielo_6 \$6131 VPWR VGND sg13cmos5l_tielo
* cell instance sg13cmos5l_tielo_7 r0 *1 0,0
Xsg13cmos5l_tielo_7 \$6341 VPWR VGND sg13cmos5l_tielo
* cell instance sg13cmos5l_tielo_8 r0 *1 0,0
Xsg13cmos5l_tielo_8 \$6142 VPWR VGND sg13cmos5l_tielo
* cell instance sg13cmos5l_tielo_9 r0 *1 0,0
Xsg13cmos5l_tielo_9 \$6342 VPWR VGND sg13cmos5l_tielo
* cell instance sg13cmos5l_tielo_10 r0 *1 0,0
Xsg13cmos5l_tielo_10 \$6154 VPWR VGND sg13cmos5l_tielo
* cell instance sg13cmos5l_tielo_11 r0 *1 0,0
Xsg13cmos5l_tielo_11 \$6343 VPWR VGND sg13cmos5l_tielo
* cell instance sg13cmos5l_tielo_12 r0 *1 0,0
Xsg13cmos5l_tielo_12 \$6165 VPWR VGND sg13cmos5l_tielo
* cell instance sg13cmos5l_tielo_13 r0 *1 0,0
Xsg13cmos5l_tielo_13 \$6344 VPWR VGND sg13cmos5l_tielo
* cell instance sg13cmos5l_tielo_14 r0 *1 0,0
Xsg13cmos5l_tielo_14 \$6175 VPWR VGND sg13cmos5l_tielo
* cell instance sg13cmos5l_tielo_15 r0 *1 0,0
Xsg13cmos5l_tielo_15 \$6345 VPWR VGND sg13cmos5l_tielo
* cell instance sg13cmos5l_tielo_16 r0 *1 0,0
Xsg13cmos5l_tielo_16 \$5778 VPWR VGND sg13cmos5l_tielo
* cell instance sg13cmos5l_tielo_17 r0 *1 0,0
Xsg13cmos5l_tielo_17 \$5888 VPWR VGND sg13cmos5l_tielo
* cell instance sg13cmos5l_tielo_18 r0 *1 0,0
Xsg13cmos5l_tielo_18 \$5586 VPWR VGND sg13cmos5l_tielo
* cell instance sg13cmos5l_tielo_19 r0 *1 0,0
Xsg13cmos5l_tielo_19 \$6188 VPWR VGND sg13cmos5l_tielo
* cell instance sg13cmos5l_tielo_20 r0 *1 0,0
Xsg13cmos5l_tielo_20 \$5794 VPWR VGND sg13cmos5l_tielo
* cell instance sg13cmos5l_tielo_21 r0 *1 0,0
Xsg13cmos5l_tielo_21 \$6906 VPWR VGND sg13cmos5l_tielo
* cell instance sg13cmos5l_tielo_22 r0 *1 0,0
Xsg13cmos5l_tielo_22 \$5798 VPWR VGND sg13cmos5l_tielo
* cell instance sg13cmos5l_tielo_23 r0 *1 0,0
Xsg13cmos5l_tielo_23 \$5804 VPWR VGND sg13cmos5l_tielo
* cell instance sg13cmos5l_tielo_24 r0 *1 0,0
Xsg13cmos5l_tielo_24 \$5976 VPWR VGND sg13cmos5l_tielo
* cell instance sg13cmos5l_tielo_25 r0 *1 0,0
Xsg13cmos5l_tielo_25 \$5980 VPWR VGND sg13cmos5l_tielo
* cell instance sg13cmos5l_tielo_26 r0 *1 0,0
Xsg13cmos5l_tielo_26 \$5984 VPWR VGND sg13cmos5l_tielo
* cell instance sg13cmos5l_tielo_27 r0 *1 0,0
Xsg13cmos5l_tielo_27 \$5992 VPWR VGND sg13cmos5l_tielo
* cell instance sg13cmos5l_tielo_28 r0 *1 0,0
Xsg13cmos5l_tielo_28 \$5996 VPWR VGND sg13cmos5l_tielo
* cell instance sg13cmos5l_tielo_29 r0 *1 0,0
Xsg13cmos5l_tielo_29 \$6217 VPWR VGND sg13cmos5l_tielo
* cell instance sg13cmos5l_tielo_30 r0 *1 0,0
Xsg13cmos5l_tielo_30 \$6221 VPWR VGND sg13cmos5l_tielo
* cell instance sg13cmos5l_tielo_31 r0 *1 0,0
Xsg13cmos5l_tielo_31 \$6007 VPWR VGND sg13cmos5l_tielo
* cell instance sg13cmos5l_tielo_32 r0 *1 0,0
Xsg13cmos5l_tielo_32 \$6011 VPWR VGND sg13cmos5l_tielo
* cell instance sg13cmos5l_tielo_33 r0 *1 0,0
Xsg13cmos5l_tielo_33 \$6242 VPWR VGND sg13cmos5l_tielo
* cell instance sg13cmos5l_tielo_34 r0 *1 0,0
Xsg13cmos5l_tielo_34 \$6246 VPWR VGND sg13cmos5l_tielo
* cell instance sg13cmos5l_tielo_35 r0 *1 0,0
Xsg13cmos5l_tielo_35 \$6254 VPWR VGND sg13cmos5l_tielo
* cell instance sg13cmos5l_tielo_36 r0 *1 0,0
Xsg13cmos5l_tielo_36 \$6258 VPWR VGND sg13cmos5l_tielo
* cell instance sg13cmos5l_tielo_37 r0 *1 0,0
Xsg13cmos5l_tielo_37 \$6266 VPWR VGND sg13cmos5l_tielo
* cell instance sg13cmos5l_tielo_38 r0 *1 0,0
Xsg13cmos5l_tielo_38 \$6270 VPWR VGND sg13cmos5l_tielo
* cell instance sg13cmos5l_tielo_39 r0 *1 0,0
Xsg13cmos5l_tielo_39 \$6278 VPWR VGND sg13cmos5l_tielo
* cell instance sg13cmos5l_tielo_40 r0 *1 0,0
Xsg13cmos5l_tielo_40 \$6346 VPWR VGND sg13cmos5l_tielo
* cell instance sg13cmos5l_tielo_41 r0 *1 0,0
Xsg13cmos5l_tielo_41 \$6017 VPWR VGND sg13cmos5l_tielo
* cell instance sg13cmos5l_tielo_42 r0 *1 0,0
Xsg13cmos5l_tielo_42 \$6022 VPWR VGND sg13cmos5l_tielo
* cell instance sg13cmos5l_tielo_43 r0 *1 0,0
Xsg13cmos5l_tielo_43 \$6295 VPWR VGND sg13cmos5l_tielo
* cell instance sg13cmos5l_tielo_44 r0 *1 0,0
Xsg13cmos5l_tielo_44 \$6577 VPWR VGND sg13cmos5l_tielo
* cell instance sg13cmos5l_xnor2_1_0 r0 *1 0,0
Xsg13cmos5l_xnor2_1_0 \$2233 \$2811 VPWR VGND \$2812 sg13cmos5l_xnor2_1
* cell instance sg13cmos5l_xnor2_1_1 r0 *1 0,0
Xsg13cmos5l_xnor2_1_1 \$5896 \$5893 VPWR VGND \$5897 sg13cmos5l_xnor2_1
* cell instance sg13cmos5l_xnor2_1_2 r0 *1 0,0
Xsg13cmos5l_xnor2_1_2 \$3216 \$3392 VPWR VGND \$3388 sg13cmos5l_xnor2_1
* cell instance sg13cmos5l_xnor2_1_3 r0 *1 0,0
Xsg13cmos5l_xnor2_1_3 \$2670 \$2383 VPWR VGND \$2673 sg13cmos5l_xnor2_1
* cell instance sg13cmos5l_xnor2_1_4 r0 *1 0,0
Xsg13cmos5l_xnor2_1_4 \$9215 \$9214 VPWR VGND \$9141 sg13cmos5l_xnor2_1
* cell instance sg13cmos5l_xnor2_1_5 r0 *1 0,0
Xsg13cmos5l_xnor2_1_5 \$9932 \$10591 VPWR VGND \$10766 sg13cmos5l_xnor2_1
* cell instance sg13cmos5l_xnor2_1_6 r0 *1 0,0
Xsg13cmos5l_xnor2_1_6 \$3590 \$2996 VPWR VGND \$3593 sg13cmos5l_xnor2_1
* cell instance sg13cmos5l_xnor2_1_7 r0 *1 0,0
Xsg13cmos5l_xnor2_1_7 \$9392 \$9932 VPWR VGND \$9631 sg13cmos5l_xnor2_1
* cell instance sg13cmos5l_xnor2_1_8 r0 *1 0,0
Xsg13cmos5l_xnor2_1_8 \$5283 \$5903 VPWR VGND \$5718 sg13cmos5l_xnor2_1
* cell instance sg13cmos5l_xnor2_1_9 r0 *1 0,0
Xsg13cmos5l_xnor2_1_9 \$6368 \$6081 VPWR VGND \$5719 sg13cmos5l_xnor2_1
* cell instance sg13cmos5l_xnor2_1_10 r0 *1 0,0
Xsg13cmos5l_xnor2_1_10 \$9635 \$10768 VPWR VGND \$10591 sg13cmos5l_xnor2_1
* cell instance sg13cmos5l_xnor2_1_11 r0 *1 0,0
Xsg13cmos5l_xnor2_1_11 \$5906 \$5715 VPWR VGND \$5720 sg13cmos5l_xnor2_1
* cell instance sg13cmos5l_xnor2_1_12 r0 *1 0,0
Xsg13cmos5l_xnor2_1_12 \$9623 \$9420 VPWR VGND \$9932 sg13cmos5l_xnor2_1
* cell instance sg13cmos5l_xnor2_1_13 r0 *1 0,0
Xsg13cmos5l_xnor2_1_13 \$9624 \$9623 VPWR VGND \$9214 sg13cmos5l_xnor2_1
* cell instance sg13cmos5l_xnor2_1_14 r0 *1 0,0
Xsg13cmos5l_xnor2_1_14 \$65 \$35 VPWR VGND \$40 sg13cmos5l_xnor2_1
* cell instance sg13cmos5l_xnor2_1_15 r0 *1 0,0
Xsg13cmos5l_xnor2_1_15 \$6409 \$9414 VPWR VGND \$9623 sg13cmos5l_xnor2_1
* cell instance sg13cmos5l_xnor2_1_16 r0 *1 0,0
Xsg13cmos5l_xnor2_1_16 \$9042 \$9539 VPWR VGND \$9414 sg13cmos5l_xnor2_1
* cell instance sg13cmos5l_xnor2_1_17 r0 *1 0,0
Xsg13cmos5l_xnor2_1_17 \$9635 \$10595 VPWR VGND \$9539 sg13cmos5l_xnor2_1
* cell instance sg13cmos5l_xnor2_1_18 r0 *1 0,0
Xsg13cmos5l_xnor2_1_18 \$2111 \$42 VPWR VGND \$2115 sg13cmos5l_xnor2_1
* cell instance sg13cmos5l_xnor2_1_19 r0 *1 0,0
Xsg13cmos5l_xnor2_1_19 \$9307 \$9308 VPWR VGND \$9215 sg13cmos5l_xnor2_1
* cell instance sg13cmos5l_xnor2_1_20 r0 *1 0,0
Xsg13cmos5l_xnor2_1_20 \$9283 \$217 VPWR VGND \$9311 sg13cmos5l_xnor2_1
* cell instance sg13cmos5l_xnor2_1_21 r0 *1 0,0
Xsg13cmos5l_xnor2_1_21 \$7222 \$9219 VPWR VGND \$9308 sg13cmos5l_xnor2_1
* cell instance sg13cmos5l_xnor2_1_22 r0 *1 0,0
Xsg13cmos5l_xnor2_1_22 \$67 \$35 VPWR VGND \$17 sg13cmos5l_xnor2_1
* cell instance sg13cmos5l_xnor2_1_23 r0 *1 0,0
Xsg13cmos5l_xnor2_1_23 \$9624 \$9311 VPWR VGND \$9392 sg13cmos5l_xnor2_1
* cell instance sg13cmos5l_xnor2_1_24 r0 *1 0,0
Xsg13cmos5l_xnor2_1_24 \$20036 \$6502 VPWR VGND \$20021 sg13cmos5l_xnor2_1
* cell instance sg13cmos5l_xnor2_1_25 r0 *1 0,0
Xsg13cmos5l_xnor2_1_25 \$9392 \$9419 VPWR VGND \$9936 sg13cmos5l_xnor2_1
* cell instance sg13cmos5l_xnor2_1_26 r0 *1 0,0
Xsg13cmos5l_xnor2_1_26 \$8007 \$6352 VPWR VGND \$10595 sg13cmos5l_xnor2_1
* cell instance sg13cmos5l_xnor2_1_27 r0 *1 0,0
Xsg13cmos5l_xnor2_1_27 \$7722 \$9220 VPWR VGND \$9265 sg13cmos5l_xnor2_1
* cell instance sg13cmos5l_xnor2_1_28 r0 *1 0,0
Xsg13cmos5l_xnor2_1_28 \$8431 \$9316 VPWR VGND \$9220 sg13cmos5l_xnor2_1
* cell instance sg13cmos5l_xnor2_1_29 r0 *1 0,0
Xsg13cmos5l_xnor2_1_29 \$9638 \$9936 VPWR VGND \$9307 sg13cmos5l_xnor2_1
* cell instance sg13cmos5l_xnor2_1_30 r0 *1 0,0
Xsg13cmos5l_xnor2_1_30 \$3399 \$3398 VPWR VGND \$3402 sg13cmos5l_xnor2_1
* cell instance sg13cmos5l_xnor2_1_31 r0 *1 0,0
Xsg13cmos5l_xnor2_1_31 \$9273 \$9265 VPWR VGND \$8774 sg13cmos5l_xnor2_1
* cell instance sg13cmos5l_xnor2_1_32 r0 *1 0,0
Xsg13cmos5l_xnor2_1_32 \$6397 \$6407 VPWR VGND \$9635 sg13cmos5l_xnor2_1
* cell instance sg13cmos5l_xnor2_1_33 r0 *1 0,0
Xsg13cmos5l_xnor2_1_33 \$9637 \$9625 VPWR VGND \$9420 sg13cmos5l_xnor2_1
* cell instance sg13cmos5l_xnor2_1_34 r0 *1 0,0
Xsg13cmos5l_xnor2_1_34 \$20084 \$20041 VPWR VGND \$20087 sg13cmos5l_xnor2_1
* cell instance sg13cmos5l_xnor2_1_35 r0 *1 0,0
Xsg13cmos5l_xnor2_1_35 \$8774 \$8875 VPWR VGND \$8877 sg13cmos5l_xnor2_1
* cell instance sg13cmos5l_xnor2_1_36 r0 *1 0,0
Xsg13cmos5l_xnor2_1_36 \$9928 \$10140 VPWR VGND \$9625 sg13cmos5l_xnor2_1
* cell instance sg13cmos5l_xnor2_1_37 r0 *1 0,0
Xsg13cmos5l_xnor2_1_37 \$8531 \$6488 VPWR VGND \$9624 sg13cmos5l_xnor2_1
* cell instance sg13cmos5l_xnor2_1_38 r0 *1 0,0
Xsg13cmos5l_xnor2_1_38 \$10140 \$12930 VPWR VGND \$10768 sg13cmos5l_xnor2_1
* cell instance sg13cmos5l_xnor2_1_39 r0 *1 0,0
Xsg13cmos5l_xnor2_1_39 \$11700 \$13875 VPWR VGND \$12930 sg13cmos5l_xnor2_1
* cell instance sg13cmos5l_xnor2_1_40 r0 *1 0,0
Xsg13cmos5l_xnor2_1_40 \$8880 \$9318 VPWR VGND \$8881 sg13cmos5l_xnor2_1
* cell instance sg13cmos5l_xnor2_1_41 r0 *1 0,0
Xsg13cmos5l_xnor2_1_41 \$9304 \$9322 VPWR VGND \$8880 sg13cmos5l_xnor2_1
* cell instance sg13cmos5l_xnor2_1_42 r0 *1 0,0
Xsg13cmos5l_xnor2_1_42 \$4210 \$3705 VPWR VGND \$4216 sg13cmos5l_xnor2_1
* cell instance sg13cmos5l_xnor2_1_43 r0 *1 0,0
Xsg13cmos5l_xnor2_1_43 \$8880 \$9273 VPWR VGND \$9044 sg13cmos5l_xnor2_1
* cell instance sg13cmos5l_xnor2_1_44 r0 *1 0,0
Xsg13cmos5l_xnor2_1_44 \$8218 \$953 VPWR VGND \$10140 sg13cmos5l_xnor2_1
* cell instance sg13cmos5l_xnor2_1_45 r0 *1 0,0
Xsg13cmos5l_xnor2_1_45 \$11273 \$11272 VPWR VGND \$9273 sg13cmos5l_xnor2_1
* cell instance sg13cmos5l_xnor2_1_46 r0 *1 0,0
Xsg13cmos5l_xnor2_1_46 \$2826 \$3022 VPWR VGND \$3024 sg13cmos5l_xnor2_1
* cell instance sg13cmos5l_xnor2_1_47 r0 *1 0,0
Xsg13cmos5l_xnor2_1_47 \$7563 \$9325 VPWR VGND \$9322 sg13cmos5l_xnor2_1
* cell instance sg13cmos5l_xnor2_1_48 r0 *1 0,0
Xsg13cmos5l_xnor2_1_48 \$7816 \$9624 VPWR VGND \$9325 sg13cmos5l_xnor2_1
* cell instance sg13cmos5l_xnor2_1_49 r0 *1 0,0
Xsg13cmos5l_xnor2_1_49 \$10050 \$9937 VPWR VGND \$9304 sg13cmos5l_xnor2_1
* cell instance sg13cmos5l_xnor2_1_50 r0 *1 0,0
Xsg13cmos5l_xnor2_1_50 \$9316 \$9287 VPWR VGND \$10139 sg13cmos5l_xnor2_1
* cell instance sg13cmos5l_xnor2_1_51 r0 *1 0,0
Xsg13cmos5l_xnor2_1_51 \$2529 \$3227 VPWR VGND \$3412 sg13cmos5l_xnor2_1
* cell instance sg13cmos5l_xnor2_1_52 r0 *1 0,0
Xsg13cmos5l_xnor2_1_52 \$9331 \$6500 VPWR VGND \$9287 sg13cmos5l_xnor2_1
* cell instance sg13cmos5l_xnor2_1_53 r0 *1 0,0
Xsg13cmos5l_xnor2_1_53 \$5738 \$6546 VPWR VGND \$9316 sg13cmos5l_xnor2_1
* cell instance sg13cmos5l_xnor2_1_54 r0 *1 0,0
Xsg13cmos5l_xnor2_1_54 \$4561 \$4590 VPWR VGND \$4411 sg13cmos5l_xnor2_1
* cell instance sg13cmos5l_xnor2_1_55 r0 *1 0,0
Xsg13cmos5l_xnor2_1_55 \$4980 \$4770 VPWR VGND \$4773 sg13cmos5l_xnor2_1
* cell instance sg13cmos5l_xnor2_1_56 r0 *1 0,0
Xsg13cmos5l_xnor2_1_56 \$5375 \$5183 VPWR VGND \$5185 sg13cmos5l_xnor2_1
* cell instance sg13cmos5l_xnor2_1_57 r0 *1 0,0
Xsg13cmos5l_xnor2_1_57 \$4967 \$4775 VPWR VGND \$4776 sg13cmos5l_xnor2_1
* cell instance sg13cmos5l_xnor2_1_58 r0 *1 0,0
Xsg13cmos5l_xnor2_1_58 \$5392 \$5394 VPWR VGND \$5395 sg13cmos5l_xnor2_1
* cell instance sg13cmos5l_xnor2_1_59 r0 *1 0,0
Xsg13cmos5l_xnor2_1_59 \$2612 \$4376 VPWR VGND \$3982 sg13cmos5l_xnor2_1
* cell instance sg13cmos5l_xnor2_1_60 r0 *1 0,0
Xsg13cmos5l_xnor2_1_60 \$5396 \$4992 VPWR VGND \$5398 sg13cmos5l_xnor2_1
* cell instance sg13cmos5l_xnor2_1_61 r0 *1 0,0
Xsg13cmos5l_xnor2_1_61 \$4735 \$3712 VPWR VGND \$4799 sg13cmos5l_xnor2_1
* cell instance sg13cmos5l_xnor2_1_62 r0 *1 0,0
Xsg13cmos5l_xnor2_1_62 \$4735 \$4012 VPWR VGND \$5038 sg13cmos5l_xnor2_1
* cell instance sg13cmos5l_xnor2_1_63 r0 *1 0,0
Xsg13cmos5l_xnor2_1_63 \$4735 \$727 VPWR VGND \$5636 sg13cmos5l_xnor2_1
* cell instance sg13cmos5l_xnor2_1_64 r0 *1 0,0
Xsg13cmos5l_xnor2_1_64 \$1933 \$1224 VPWR VGND \$1934 sg13cmos5l_xnor2_1
* cell instance sg13cmos5l_xnor2_1_65 r0 *1 0,0
Xsg13cmos5l_xnor2_1_65 \$4735 \$4442 VPWR VGND \$5209 sg13cmos5l_xnor2_1
* cell instance sg13cmos5l_xnor2_1_66 r0 *1 0,0
Xsg13cmos5l_xnor2_1_66 \$1473 \$1226 VPWR VGND \$1588 sg13cmos5l_xnor2_1
* cell instance sg13cmos5l_xnor2_1_67 r0 *1 0,0
Xsg13cmos5l_xnor2_1_67 \$4735 \$5639 VPWR VGND \$5637 sg13cmos5l_xnor2_1
* cell instance sg13cmos5l_xnor2_1_68 r0 *1 0,0
Xsg13cmos5l_xnor2_1_68 \$2107 \$1936 VPWR VGND \$2164 sg13cmos5l_xnor2_1
* cell instance sg13cmos5l_xnor2_1_69 r0 *1 0,0
Xsg13cmos5l_xnor2_1_69 \$2107 \$1939 VPWR VGND \$2169 sg13cmos5l_xnor2_1
* cell instance sg13cmos5l_xnor2_1_70 r0 *1 0,0
Xsg13cmos5l_xnor2_1_70 \$1937 \$1593 VPWR VGND \$2064 sg13cmos5l_xnor2_1
* cell instance sg13cmos5l_xnor2_1_71 r0 *1 0,0
Xsg13cmos5l_xnor2_1_71 \$4735 \$5416 VPWR VGND \$5643 sg13cmos5l_xnor2_1
* cell instance sg13cmos5l_xnor2_1_72 r0 *1 0,0
Xsg13cmos5l_xnor2_1_72 \$20207 \$20214 VPWR VGND \$20220 sg13cmos5l_xnor2_1
* cell instance sg13cmos5l_xnor2_1_73 r0 *1 0,0
Xsg13cmos5l_xnor2_1_73 \$1592 \$1483 VPWR VGND \$1595 sg13cmos5l_xnor2_1
* cell instance sg13cmos5l_xnor2_1_74 r0 *1 0,0
Xsg13cmos5l_xnor2_1_74 \$4735 \$5648 VPWR VGND \$5418 sg13cmos5l_xnor2_1
* cell instance sg13cmos5l_xnor2_1_75 r0 *1 0,0
Xsg13cmos5l_xnor2_1_75 \$2302 \$2300 VPWR VGND \$2648 sg13cmos5l_xnor2_1
* cell instance sg13cmos5l_xnor2_1_76 r0 *1 0,0
Xsg13cmos5l_xnor2_1_76 \$1234 \$1485 VPWR VGND \$1488 sg13cmos5l_xnor2_1
* cell instance sg13cmos5l_xnor2_1_77 r0 *1 0,0
Xsg13cmos5l_xnor2_1_77 \$2445 \$2296 VPWR VGND \$2650 sg13cmos5l_xnor2_1
* cell instance sg13cmos5l_xnor2_1_78 r0 *1 0,0
Xsg13cmos5l_xnor2_1_78 \$3832 \$3655 VPWR VGND \$3317 sg13cmos5l_xnor2_1
* cell instance sg13cmos5l_xnor2_1_79 r0 *1 0,0
Xsg13cmos5l_xnor2_1_79 \$2762 \$2598 VPWR VGND \$2916 sg13cmos5l_xnor2_1
* cell instance sg13cmos5l_xnor2_1_80 r0 *1 0,0
Xsg13cmos5l_xnor2_1_80 \$1494 \$921 VPWR VGND \$1825 sg13cmos5l_xnor2_1
* cell instance sg13cmos5l_xnor2_1_81 r0 *1 0,0
Xsg13cmos5l_xnor2_1_81 \$4142 \$4141 VPWR VGND \$4059 sg13cmos5l_xnor2_1
* cell instance sg13cmos5l_xnor2_1_82 r0 *1 0,0
Xsg13cmos5l_xnor2_1_82 \$3837 \$3660 VPWR VGND \$3662 sg13cmos5l_xnor2_1
* cell instance sg13cmos5l_xnor2_1_83 r0 *1 0,0
Xsg13cmos5l_xnor2_1_83 \$1477 \$1245 VPWR VGND \$1371 sg13cmos5l_xnor2_1
* cell instance sg13cmos5l_xnor2_1_84 r0 *1 0,0
Xsg13cmos5l_xnor2_1_84 \$6416 \$6419 VPWR VGND \$6413 sg13cmos5l_xnor2_1
* cell instance sg13cmos5l_xnor2_1_85 r0 *1 0,0
Xsg13cmos5l_xnor2_1_85 \$4299 \$4298 VPWR VGND \$3856 sg13cmos5l_xnor2_1
* cell instance sg13cmos5l_xnor2_1_86 r0 *1 0,0
Xsg13cmos5l_xnor2_1_86 \$6506 \$6584 VPWR VGND \$6422 sg13cmos5l_xnor2_1
* cell instance sg13cmos5l_xnor2_1_87 r0 *1 0,0
Xsg13cmos5l_xnor2_1_87 \$5429 \$5663 VPWR VGND \$5665 sg13cmos5l_xnor2_1
* cell instance sg13cmos5l_xnor2_1_88 r0 *1 0,0
Xsg13cmos5l_xnor2_1_88 \$3162 \$3163 VPWR VGND \$2933 sg13cmos5l_xnor2_1
* cell instance sg13cmos5l_xnor2_1_89 r0 *1 0,0
Xsg13cmos5l_xnor2_1_89 \$4491 \$4462 VPWR VGND \$2775 sg13cmos5l_xnor2_1
* cell instance sg13cmos5l_xnor2_1_90 r0 *1 0,0
Xsg13cmos5l_xnor2_1_90 \$6509 \$7353 VPWR VGND \$7196 sg13cmos5l_xnor2_1
* cell instance sg13cmos5l_xnor2_1_91 r0 *1 0,0
Xsg13cmos5l_xnor2_1_91 \$5861 \$5860 VPWR VGND \$5842 sg13cmos5l_xnor2_1
* cell instance sg13cmos5l_xnor2_1_92 r0 *1 0,0
Xsg13cmos5l_xnor2_1_92 \$2940 \$3167 VPWR VGND \$2613 sg13cmos5l_xnor2_1
* cell instance sg13cmos5l_xnor2_1_93 r0 *1 0,0
Xsg13cmos5l_xnor2_1_93 \$4167 \$3685 VPWR VGND \$3538 sg13cmos5l_xnor2_1
* cell instance sg13cmos5l_xnor2_1_94 r0 *1 0,0
Xsg13cmos5l_xnor2_1_94 \$7198 \$7664 VPWR VGND \$7663 sg13cmos5l_xnor2_1
* cell instance sg13cmos5l_xnor2_1_95 r0 *1 0,0
Xsg13cmos5l_xnor2_1_95 \$2781 \$2942 VPWR VGND \$2621 sg13cmos5l_xnor2_1
* cell instance sg13cmos5l_xnor2_1_96 r0 *1 0,0
Xsg13cmos5l_xnor2_1_96 \$7537 \$7874 VPWR VGND \$7665 sg13cmos5l_xnor2_1
* cell instance sg13cmos5l_xnor2_1_97 r0 *1 0,0
Xsg13cmos5l_xnor2_1_97 \$7079 \$6447 VPWR VGND \$7080 sg13cmos5l_xnor2_1
* cell instance sg13cmos5l_xnor2_1_98 r0 *1 0,0
Xsg13cmos5l_xnor2_1_98 \$6311 \$6314 VPWR VGND \$6315 sg13cmos5l_xnor2_1
* cell instance sg13cmos5l_xnor2_1_99 r0 *1 0,0
Xsg13cmos5l_xnor2_1_99 \$3723 \$3687 VPWR VGND \$3544 sg13cmos5l_xnor2_1
* cell instance sg13cmos5l_xnor2_1_100 r0 *1 0,0
Xsg13cmos5l_xnor2_1_100 \$4640 \$4837 VPWR VGND \$2784 sg13cmos5l_xnor2_1
* cell instance sg13cmos5l_xnor2_1_101 r0 *1 0,0
Xsg13cmos5l_xnor2_1_101 \$3362 \$3360 VPWR VGND \$2629 sg13cmos5l_xnor2_1
* cell instance sg13cmos5l_xnor2_1_102 r0 *1 0,0
Xsg13cmos5l_xnor2_1_102 \$6323 \$5239 VPWR VGND \$6324 sg13cmos5l_xnor2_1
* cell instance sg13cmos5l_xnor2_1_103 r0 *1 0,0
Xsg13cmos5l_xnor2_1_103 \$4647 \$4178 VPWR VGND \$4175 sg13cmos5l_xnor2_1
* cell instance sg13cmos5l_xnor2_1_104 r0 *1 0,0
Xsg13cmos5l_xnor2_1_104 \$5886 \$5884 VPWR VGND \$5682 sg13cmos5l_xnor2_1
* cell instance sg13cmos5l_xnor2_1_105 r0 *1 0,0
Xsg13cmos5l_xnor2_1_105 \$6802 \$8001 VPWR VGND \$7803 sg13cmos5l_xnor2_1
* cell instance sg13cmos5l_xnor2_1_106 r0 *1 0,0
Xsg13cmos5l_xnor2_1_106 \$5246 \$4845 VPWR VGND \$4847 sg13cmos5l_xnor2_1
* cell instance sg13cmos5l_xnor2_1_107 r0 *1 0,0
Xsg13cmos5l_xnor2_1_107 \$4040 \$4042 VPWR VGND \$3365 sg13cmos5l_xnor2_1
* cell instance sg13cmos5l_xor2_1_0 r0 *1 0,0
Xsg13cmos5l_xor2_1_0 \$2233 \$2811 VPWR VGND \$2960 sg13cmos5l_xor2_1
* cell instance sg13cmos5l_xor2_1_1 r0 *1 0,0
Xsg13cmos5l_xor2_1_1 \$5050 \$4875 VPWR VGND \$5286 sg13cmos5l_xor2_1
* cell instance sg13cmos5l_xor2_1_2 r0 *1 0,0
Xsg13cmos5l_xor2_1_2 \$9215 \$9304 VPWR VGND \$9302 sg13cmos5l_xor2_1
* cell instance sg13cmos5l_xor2_1_3 r0 *1 0,0
Xsg13cmos5l_xor2_1_3 \$9304 \$10768 VPWR VGND \$10446 sg13cmos5l_xor2_1
* cell instance sg13cmos5l_xor2_1_4 r0 *1 0,0
Xsg13cmos5l_xor2_1_4 \$2670 \$2383 VPWR VGND \$2961 sg13cmos5l_xor2_1
* cell instance sg13cmos5l_xor2_1_5 r0 *1 0,0
Xsg13cmos5l_xor2_1_5 \$3216 \$3392 VPWR VGND \$3393 sg13cmos5l_xor2_1
* cell instance sg13cmos5l_xor2_1_6 r0 *1 0,0
Xsg13cmos5l_xor2_1_6 \$8774 \$9623 VPWR VGND \$9216 sg13cmos5l_xor2_1
* cell instance sg13cmos5l_xor2_1_7 r0 *1 0,0
Xsg13cmos5l_xor2_1_7 \$8411 \$9539 VPWR VGND \$9219 sg13cmos5l_xor2_1
* cell instance sg13cmos5l_xor2_1_8 r0 *1 0,0
Xsg13cmos5l_xor2_1_8 \$9539 \$9273 VPWR VGND \$10772 sg13cmos5l_xor2_1
* cell instance sg13cmos5l_xor2_1_9 r0 *1 0,0
Xsg13cmos5l_xor2_1_9 \$20078 \$20040 VPWR VGND \$20080 sg13cmos5l_xor2_1
* cell instance sg13cmos5l_xor2_1_10 r0 *1 0,0
Xsg13cmos5l_xor2_1_10 \$6396 \$9635 VPWR VGND \$9419 sg13cmos5l_xor2_1
* cell instance sg13cmos5l_xor2_1_11 r0 *1 0,0
Xsg13cmos5l_xor2_1_11 \$5050 \$5073 VPWR VGND \$4899 sg13cmos5l_xor2_1
* cell instance sg13cmos5l_xor2_1_12 r0 *1 0,0
Xsg13cmos5l_xor2_1_12 \$9392 \$9316 VPWR VGND \$9318 sg13cmos5l_xor2_1
* cell instance sg13cmos5l_xor2_1_13 r0 *1 0,0
Xsg13cmos5l_xor2_1_13 \$10139 \$10140 VPWR VGND \$8875 sg13cmos5l_xor2_1
* cell instance sg13cmos5l_xor2_1_14 r0 *1 0,0
Xsg13cmos5l_xor2_1_14 \$9307 \$10139 VPWR VGND \$10046 sg13cmos5l_xor2_1
* cell instance sg13cmos5l_xor2_1_15 r0 *1 0,0
Xsg13cmos5l_xor2_1_15 \$6482 \$10139 VPWR VGND \$9937 sg13cmos5l_xor2_1
* cell instance sg13cmos5l_xor2_1_16 r0 *1 0,0
Xsg13cmos5l_xor2_1_16 \$9046 \$10768 VPWR VGND \$11272 sg13cmos5l_xor2_1
* cell instance sg13cmos5l_xor2_1_17 r0 *1 0,0
Xsg13cmos5l_xor2_1_17 \$4521 \$2217 VPWR VGND \$4052 sg13cmos5l_xor2_1
* cell instance sg13cmos5l_xor2_1_18 r0 *1 0,0
Xsg13cmos5l_xor2_1_18 \$4769 \$5377 VPWR VGND \$5379 sg13cmos5l_xor2_1
* cell instance sg13cmos5l_xor2_1_19 r0 *1 0,0
Xsg13cmos5l_xor2_1_19 \$4972 \$4990 VPWR VGND \$5194 sg13cmos5l_xor2_1
* cell instance sg13cmos5l_xor2_1_20 r0 *1 0,0
Xsg13cmos5l_xor2_1_20 \$4735 \$4805 VPWR VGND \$4803 sg13cmos5l_xor2_1
* cell instance sg13cmos5l_xor2_1_21 r0 *1 0,0
Xsg13cmos5l_xor2_1_21 \$2762 \$2764 VPWR VGND \$2761 sg13cmos5l_xor2_1
* cell instance sg13cmos5l_xor2_1_22 r0 *1 0,0
Xsg13cmos5l_xor2_1_22 \$1371 \$1246 VPWR VGND \$1725 sg13cmos5l_xor2_1
* cell instance sg13cmos5l_xor2_1_23 r0 *1 0,0
Xsg13cmos5l_xor2_1_23 \$1492 \$1371 VPWR VGND \$1735 sg13cmos5l_xor2_1
* cell instance sg13cmos5l_xor2_1_24 r0 *1 0,0
Xsg13cmos5l_xor2_1_24 \$7063 \$6578 VPWR VGND \$7065 sg13cmos5l_xor2_1
* cell instance sg13cmos5l_xor2_1_25 r0 *1 0,0
Xsg13cmos5l_xor2_1_25 \$3337 \$3339 VPWR VGND \$3153 sg13cmos5l_xor2_1
* cell instance sg13cmos5l_xor2_1_26 r0 *1 0,0
Xsg13cmos5l_xor2_1_26 \$2759 \$4156 VPWR VGND \$4158 sg13cmos5l_xor2_1
* cell instance sg13cmos5l_xor2_1_27 r0 *1 0,0
Xsg13cmos5l_xor2_1_27 \$7656 \$6613 VPWR VGND \$7350 sg13cmos5l_xor2_1
* cell instance sg13cmos5l_xor2_1_28 r0 *1 0,0
Xsg13cmos5l_xor2_1_28 \$3872 \$3874 VPWR VGND \$3692 sg13cmos5l_xor2_1
* cell instance sg13cmos5l_xor2_1_29 r0 *1 0,0
Xsg13cmos5l_xor2_1_29 \$6799 \$7094 VPWR VGND \$6863 sg13cmos5l_xor2_1
.ENDS tt_um_2amlogic_protocol_emulator

* cell sg13cmos5l_xor2_1
* pin A
* pin B
* pin VDD
* pin VSS
* pin X
.SUBCKT sg13cmos5l_xor2_1 A B VDD VSS X
.ENDS sg13cmos5l_xor2_1

* cell sg13cmos5l_xnor2_1
* pin A
* pin B
* pin VDD
* pin VSS
* pin Y
.SUBCKT sg13cmos5l_xnor2_1 A B VDD VSS Y
.ENDS sg13cmos5l_xnor2_1

* cell sg13cmos5l_tielo
* pin L_LO
* pin VDD
* pin VSS
.SUBCKT sg13cmos5l_tielo L_LO VDD VSS
.ENDS sg13cmos5l_tielo

* cell sg13cmos5l_tiehi
* pin L_HI
* pin VDD
* pin VSS
.SUBCKT sg13cmos5l_tiehi L_HI VDD VSS
.ENDS sg13cmos5l_tiehi

* cell sg13cmos5l_or4_1
* pin A
* pin B
* pin C
* pin D
* pin VDD
* pin VSS
* pin X
.SUBCKT sg13cmos5l_or4_1 A B C D VDD VSS X
.ENDS sg13cmos5l_or4_1

* cell sg13cmos5l_or3_1
* pin A
* pin B
* pin C
* pin VDD
* pin VSS
* pin X
.SUBCKT sg13cmos5l_or3_1 A B C VDD VSS X
.ENDS sg13cmos5l_or3_1

* cell sg13cmos5l_or2_1
* pin A
* pin B
* pin VDD
* pin VSS
* pin X
.SUBCKT sg13cmos5l_or2_1 A B VDD VSS X
.ENDS sg13cmos5l_or2_1

* cell sg13cmos5l_o21ai_1
* pin A1
* pin A2
* pin B1
* pin VDD
* pin VSS
* pin Y
.SUBCKT sg13cmos5l_o21ai_1 A1 A2 B1 VDD VSS Y
.ENDS sg13cmos5l_o21ai_1

* cell sg13cmos5l_nor4_1
* pin A
* pin B
* pin C
* pin D
* pin VDD
* pin VSS
* pin Y
.SUBCKT sg13cmos5l_nor4_1 A B C D VDD VSS Y
.ENDS sg13cmos5l_nor4_1

* cell sg13cmos5l_nor3_1
* pin A
* pin B
* pin C
* pin VDD
* pin VSS
* pin Y
.SUBCKT sg13cmos5l_nor3_1 A B C VDD VSS Y
.ENDS sg13cmos5l_nor3_1

* cell sg13cmos5l_nor2b_1
* pin A
* pin B_N
* pin VDD
* pin VSS
* pin Y
.SUBCKT sg13cmos5l_nor2b_1 A B_N VDD VSS Y
.ENDS sg13cmos5l_nor2b_1

* cell sg13cmos5l_nor2_1
* pin A
* pin B
* pin VDD
* pin VSS
* pin Y
.SUBCKT sg13cmos5l_nor2_1 A B VDD VSS Y
.ENDS sg13cmos5l_nor2_1

* cell sg13cmos5l_nand4_1
* pin A
* pin B
* pin C
* pin D
* pin VDD
* pin VSS
* pin Y
.SUBCKT sg13cmos5l_nand4_1 A B C D VDD VSS Y
.ENDS sg13cmos5l_nand4_1

* cell sg13cmos5l_nand3b_1
* pin A_N
* pin B
* pin C
* pin VDD
* pin VSS
* pin Y
.SUBCKT sg13cmos5l_nand3b_1 A_N B C VDD VSS Y
.ENDS sg13cmos5l_nand3b_1

* cell sg13cmos5l_nand3_1
* pin A
* pin B
* pin C
* pin VDD
* pin VSS
* pin Y
.SUBCKT sg13cmos5l_nand3_1 A B C VDD VSS Y
.ENDS sg13cmos5l_nand3_1

* cell sg13cmos5l_nand2b_1
* pin A_N
* pin B
* pin VDD
* pin VSS
* pin Y
.SUBCKT sg13cmos5l_nand2b_1 A_N B VDD VSS Y
.ENDS sg13cmos5l_nand2b_1

* cell sg13cmos5l_nand2_1
* pin A
* pin B
* pin VDD
* pin VSS
* pin Y
.SUBCKT sg13cmos5l_nand2_1 A B VDD VSS Y
.ENDS sg13cmos5l_nand2_1

* cell sg13cmos5l_mux4_1
* pin A0
* pin A1
* pin A2
* pin A3
* pin S0
* pin S1
* pin VDD
* pin VSS
* pin X
.SUBCKT sg13cmos5l_mux4_1 A0 A1 A2 A3 S0 S1 VDD VSS X
.ENDS sg13cmos5l_mux4_1

* cell sg13cmos5l_mux2_1
* pin A0
* pin A1
* pin S
* pin VDD
* pin VSS
* pin X
.SUBCKT sg13cmos5l_mux2_1 A0 A1 S VDD VSS X
.ENDS sg13cmos5l_mux2_1

* cell sg13cmos5l_inv_8
* pin A
* pin VDD
* pin VSS
* pin Y
.SUBCKT sg13cmos5l_inv_8 A VDD VSS Y
.ENDS sg13cmos5l_inv_8

* cell sg13cmos5l_inv_4
* pin A
* pin VDD
* pin VSS
* pin Y
.SUBCKT sg13cmos5l_inv_4 A VDD VSS Y
.ENDS sg13cmos5l_inv_4

* cell sg13cmos5l_inv_2
* pin A
* pin VDD
* pin VSS
* pin Y
.SUBCKT sg13cmos5l_inv_2 A VDD VSS Y
.ENDS sg13cmos5l_inv_2

* cell sg13cmos5l_inv_1
* pin A
* pin VDD
* pin VSS
* pin Y
.SUBCKT sg13cmos5l_inv_1 A VDD VSS Y
.ENDS sg13cmos5l_inv_1

* cell sg13cmos5l_fill_2
* pin VDD
* pin VSS
.SUBCKT sg13cmos5l_fill_2 VDD VSS
.ENDS sg13cmos5l_fill_2

* cell sg13cmos5l_fill_1
* pin VDD
* pin VSS
.SUBCKT sg13cmos5l_fill_1 VDD VSS
.ENDS sg13cmos5l_fill_1

* cell sg13cmos5l_dlygate4sd3_1
* pin A
* pin VDD
* pin VSS
* pin X
.SUBCKT sg13cmos5l_dlygate4sd3_1 A VDD VSS X
.ENDS sg13cmos5l_dlygate4sd3_1

* cell sg13cmos5l_dfrbpq_1
* pin CLK
* pin D
* pin Q
* pin RESET_B
* pin VDD
* pin VSS
.SUBCKT sg13cmos5l_dfrbpq_1 CLK D Q RESET_B VDD VSS
.ENDS sg13cmos5l_dfrbpq_1

* cell sg13cmos5l_decap_8
* pin VDD
* pin VSS
.SUBCKT sg13cmos5l_decap_8 VDD VSS
.ENDS sg13cmos5l_decap_8

* cell sg13cmos5l_decap_4
* pin VDD
* pin VSS
.SUBCKT sg13cmos5l_decap_4 VDD VSS
.ENDS sg13cmos5l_decap_4

* cell sg13cmos5l_buf_8
* pin A
* pin VDD
* pin VSS
* pin X
.SUBCKT sg13cmos5l_buf_8 A VDD VSS X
.ENDS sg13cmos5l_buf_8

* cell sg13cmos5l_buf_4
* pin A
* pin VDD
* pin VSS
* pin X
.SUBCKT sg13cmos5l_buf_4 A VDD VSS X
.ENDS sg13cmos5l_buf_4

* cell sg13cmos5l_buf_1
* pin A
* pin VDD
* pin VSS
* pin X
.SUBCKT sg13cmos5l_buf_1 A VDD VSS X
.ENDS sg13cmos5l_buf_1

* cell sg13cmos5l_antennanp
* pin A
* pin VDD
* pin VSS
.SUBCKT sg13cmos5l_antennanp A VDD VSS
.ENDS sg13cmos5l_antennanp

* cell sg13cmos5l_and4_1
* pin A
* pin B
* pin C
* pin D
* pin VDD
* pin VSS
* pin X
.SUBCKT sg13cmos5l_and4_1 A B C D VDD VSS X
.ENDS sg13cmos5l_and4_1

* cell sg13cmos5l_and3_1
* pin A
* pin B
* pin C
* pin VDD
* pin VSS
* pin X
.SUBCKT sg13cmos5l_and3_1 A B C VDD VSS X
.ENDS sg13cmos5l_and3_1

* cell sg13cmos5l_and2_1
* pin A
* pin B
* pin VDD
* pin VSS
* pin X
.SUBCKT sg13cmos5l_and2_1 A B VDD VSS X
.ENDS sg13cmos5l_and2_1

* cell sg13cmos5l_a22oi_1
* pin A1
* pin A2
* pin B1
* pin B2
* pin VDD
* pin VSS
* pin Y
.SUBCKT sg13cmos5l_a22oi_1 A1 A2 B1 B2 VDD VSS Y
.ENDS sg13cmos5l_a22oi_1

* cell sg13cmos5l_a221oi_1
* pin A1
* pin A2
* pin B1
* pin B2
* pin C1
* pin VDD
* pin VSS
* pin Y
.SUBCKT sg13cmos5l_a221oi_1 A1 A2 B1 B2 C1 VDD VSS Y
.ENDS sg13cmos5l_a221oi_1

* cell sg13cmos5l_a21oi_1
* pin A1
* pin A2
* pin B1
* pin VDD
* pin VSS
* pin Y
.SUBCKT sg13cmos5l_a21oi_1 A1 A2 B1 VDD VSS Y
.ENDS sg13cmos5l_a21oi_1

* cell sg13cmos5l_a21o_1
* pin A1
* pin A2
* pin B1
* pin VDD
* pin VSS
* pin X
.SUBCKT sg13cmos5l_a21o_1 A1 A2 B1 VDD VSS X
.ENDS sg13cmos5l_a21o_1

* cell RM_IHPSG13_1P_256x16_c2_bm_bist
* pin A_ADDR<0>
* pin A_ADDR<1>
* pin A_ADDR<2>
* pin A_ADDR<3>
* pin A_ADDR<4>
* pin A_ADDR<5>
* pin A_ADDR<6>
* pin A_ADDR<7>
* pin A_BIST_ADDR<0>
* pin A_BIST_ADDR<1>
* pin A_BIST_ADDR<2>
* pin A_BIST_ADDR<3>
* pin A_BIST_ADDR<4>
* pin A_BIST_ADDR<5>
* pin A_BIST_ADDR<6>
* pin A_BIST_ADDR<7>
* pin A_BIST_BM<0>
* pin A_BIST_BM<10>
* pin A_BIST_BM<11>
* pin A_BIST_BM<12>
* pin A_BIST_BM<13>
* pin A_BIST_BM<14>
* pin A_BIST_BM<15>
* pin A_BIST_BM<1>
* pin A_BIST_BM<2>
* pin A_BIST_BM<3>
* pin A_BIST_BM<4>
* pin A_BIST_BM<5>
* pin A_BIST_BM<6>
* pin A_BIST_BM<7>
* pin A_BIST_BM<8>
* pin A_BIST_BM<9>
* pin A_BIST_CLK
* pin A_BIST_DIN<0>
* pin A_BIST_DIN<10>
* pin A_BIST_DIN<11>
* pin A_BIST_DIN<12>
* pin A_BIST_DIN<13>
* pin A_BIST_DIN<14>
* pin A_BIST_DIN<15>
* pin A_BIST_DIN<1>
* pin A_BIST_DIN<2>
* pin A_BIST_DIN<3>
* pin A_BIST_DIN<4>
* pin A_BIST_DIN<5>
* pin A_BIST_DIN<6>
* pin A_BIST_DIN<7>
* pin A_BIST_DIN<8>
* pin A_BIST_DIN<9>
* pin A_BIST_EN
* pin A_BIST_MEN
* pin A_BIST_REN
* pin A_BIST_WEN
* pin A_BM<0>
* pin A_BM<10>
* pin A_BM<11>
* pin A_BM<12>
* pin A_BM<13>
* pin A_BM<14>
* pin A_BM<15>
* pin A_BM<1>
* pin A_BM<2>
* pin A_BM<3>
* pin A_BM<4>
* pin A_BM<5>
* pin A_BM<6>
* pin A_BM<7>
* pin A_BM<8>
* pin A_BM<9>
* pin A_CLK
* pin A_DIN<0>
* pin A_DIN<10>
* pin A_DIN<11>
* pin A_DIN<12>
* pin A_DIN<13>
* pin A_DIN<14>
* pin A_DIN<15>
* pin A_DIN<1>
* pin A_DIN<2>
* pin A_DIN<3>
* pin A_DIN<4>
* pin A_DIN<5>
* pin A_DIN<6>
* pin A_DIN<7>
* pin A_DIN<8>
* pin A_DIN<9>
* pin A_DLY
* pin A_DOUT<0>
* pin A_DOUT<10>
* pin A_DOUT<11>
* pin A_DOUT<12>
* pin A_DOUT<13>
* pin A_DOUT<14>
* pin A_DOUT<15>
* pin A_DOUT<1>
* pin A_DOUT<2>
* pin A_DOUT<3>
* pin A_DOUT<4>
* pin A_DOUT<5>
* pin A_DOUT<6>
* pin A_DOUT<7>
* pin A_DOUT<8>
* pin A_DOUT<9>
* pin A_MEN
* pin A_REN
* pin A_WEN
* pin VDD!
* pin VDDARRAY!
* pin VSS!
.SUBCKT RM_IHPSG13_1P_256x16_c2_bm_bist A_ADDR<0> A_ADDR<1> A_ADDR<2> A_ADDR<3>
+ A_ADDR<4> A_ADDR<5> A_ADDR<6> A_ADDR<7> A_BIST_ADDR<0> A_BIST_ADDR<1>
+ A_BIST_ADDR<2> A_BIST_ADDR<3> A_BIST_ADDR<4> A_BIST_ADDR<5> A_BIST_ADDR<6>
+ A_BIST_ADDR<7> A_BIST_BM<0> A_BIST_BM<10> A_BIST_BM<11> A_BIST_BM<12>
+ A_BIST_BM<13> A_BIST_BM<14> A_BIST_BM<15> A_BIST_BM<1> A_BIST_BM<2>
+ A_BIST_BM<3> A_BIST_BM<4> A_BIST_BM<5> A_BIST_BM<6> A_BIST_BM<7> A_BIST_BM<8>
+ A_BIST_BM<9> A_BIST_CLK A_BIST_DIN<0> A_BIST_DIN<10> A_BIST_DIN<11>
+ A_BIST_DIN<12> A_BIST_DIN<13> A_BIST_DIN<14> A_BIST_DIN<15> A_BIST_DIN<1>
+ A_BIST_DIN<2> A_BIST_DIN<3> A_BIST_DIN<4> A_BIST_DIN<5> A_BIST_DIN<6>
+ A_BIST_DIN<7> A_BIST_DIN<8> A_BIST_DIN<9> A_BIST_EN A_BIST_MEN A_BIST_REN
+ A_BIST_WEN A_BM<0> A_BM<10> A_BM<11> A_BM<12> A_BM<13> A_BM<14> A_BM<15>
+ A_BM<1> A_BM<2> A_BM<3> A_BM<4> A_BM<5> A_BM<6> A_BM<7> A_BM<8> A_BM<9> A_CLK
+ A_DIN<0> A_DIN<10> A_DIN<11> A_DIN<12> A_DIN<13> A_DIN<14> A_DIN<15> A_DIN<1>
+ A_DIN<2> A_DIN<3> A_DIN<4> A_DIN<5> A_DIN<6> A_DIN<7> A_DIN<8> A_DIN<9> A_DLY
+ A_DOUT<0> A_DOUT<10> A_DOUT<11> A_DOUT<12> A_DOUT<13> A_DOUT<14> A_DOUT<15>
+ A_DOUT<1> A_DOUT<2> A_DOUT<3> A_DOUT<4> A_DOUT<5> A_DOUT<6> A_DOUT<7>
+ A_DOUT<8> A_DOUT<9> A_MEN A_REN A_WEN VDD! VDDARRAY! VSS!
.ENDS RM_IHPSG13_1P_256x16_c2_bm_bist
