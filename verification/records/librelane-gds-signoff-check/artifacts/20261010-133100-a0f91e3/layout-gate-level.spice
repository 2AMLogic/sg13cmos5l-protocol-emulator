* extracted by klt extract --deck sg13cmos5l

* cell tt_um_2amlogic_protocol_emulator
* pin VGND
* pin VPWR
* pin clk
* pin rst_n
* pin ui_in[0]
* pin ui_in[1]
* pin ui_in[2]
* pin ui_in[3]
* pin ui_in[4]
* pin ui_in[5]
* pin ui_in[6]
* pin ui_in[7]
* pin uio_in[0]
* pin uio_in[1]
* pin uio_in[2]
* pin uio_in[3]
* pin uio_in[4]
* pin uio_in[5]
* pin uio_in[6]
* pin uio_in[7]
* pin uio_oe[0]
* pin uio_oe[1]
* pin uio_oe[2]
* pin uio_oe[3]
* pin uio_oe[4]
* pin uio_oe[5]
* pin uio_oe[6]
* pin uio_oe[7]
* pin uio_out[0]
* pin uio_out[1]
* pin uio_out[2]
* pin uio_out[3]
* pin uio_out[4]
* pin uio_out[5]
* pin uio_out[6]
* pin uio_out[7]
* pin uo_out[0]
* pin uo_out[1]
* pin uo_out[2]
* pin uo_out[3]
* pin uo_out[4]
* pin uo_out[5]
* pin uo_out[6]
* pin uo_out[7]
* pin ena
.SUBCKT tt_um_2amlogic_protocol_emulator VGND VPWR clk rst_n ui_in[0] ui_in[1]
+ ui_in[2] ui_in[3] ui_in[4] ui_in[5] ui_in[6] ui_in[7] uio_in[0] uio_in[1]
+ uio_in[2] uio_in[3] uio_in[4] uio_in[5] uio_in[6] uio_in[7] uio_oe[0]
+ uio_oe[1] uio_oe[2] uio_oe[3] uio_oe[4] uio_oe[5] uio_oe[6] uio_oe[7]
+ uio_out[0] uio_out[1] uio_out[2] uio_out[3] uio_out[4] uio_out[5] uio_out[6]
+ uio_out[7] uo_out[0] uo_out[1] uo_out[2] uo_out[3] uo_out[4] uo_out[5]
+ uo_out[6] uo_out[7] ena
* cell instance RM_IHPSG13_1P_256x16_c2_bm_bist_0 r0 *1 0,0
XRM_IHPSG13_1P_256x16_c2_bm_bist_0 \$4011 \$4204 \$4208 \$4018 \$4022 \$4213
+ \$3867 \$4002 \$4830 \$4634 \$4838 \$4834 \$4846 \$4842 \$4470 \$4471 \$4723
+ \$4883 \$4898 \$4914 \$4930 \$4648 \$4959 \$4735 \$4747 \$4760 \$4772 \$4784
+ \$4798 \$4807 \$4858 \$4870 \$4620 \$5076 \$4890 \$4902 \$4918 \$4934 \$4408
+ \$5077 \$4731 \$4743 \$4758 \$4770 \$4782 \$4794 \$4612 \$4862 \$4874 \$5348
+ \$4822 \$4482 \$4478 \$4727 \$4879 \$4894 \$4910 \$4926 \$4942 \$4665 \$4739
+ \$4754 \$4766 \$4778 \$4790 \$4800 \$4815 \$4854 \$4866 \$4819 \$4717 \$4907
+ \$4923 \$4939 \$4653 \$4949 \$4956 \$4812 \$4617 \$4487 \$4635 \$4628 \$4491
+ \$4495 \$4499 \$4876 \$4848 \$2948 \$5037 \$5015 \$1909 \$2273 \$1905 \$2018
+ \$1924 \$2047 \$3301 \$4583 \$1931 \$4150 \$1938 \$3293 \$3306 \$4376 \$4359
+ \$2651 VPWR VPWR VGND RM_IHPSG13_1P_256x16_c2_bm_bist
* cell instance sg13cmos5l_a21o_1_0 r0 *1 0,0
Xsg13cmos5l_a21o_1_0 \$2136 \$2253 \$2138 VPWR VGND \$2135 sg13cmos5l_a21o_1
* cell instance sg13cmos5l_a21o_1_1 r0 *1 0,0
Xsg13cmos5l_a21o_1_1 \$645 \$1530 \$872 VPWR VGND \$1449 sg13cmos5l_a21o_1
* cell instance sg13cmos5l_a21o_1_2 r0 *1 0,0
Xsg13cmos5l_a21o_1_2 \$2754 \$3282 \$3280 VPWR VGND \$2414 sg13cmos5l_a21o_1
* cell instance sg13cmos5l_a21o_1_3 r0 *1 0,0
Xsg13cmos5l_a21o_1_3 \$2753 \$3625 \$3799 VPWR VGND \$3282 sg13cmos5l_a21o_1
* cell instance sg13cmos5l_a21o_1_4 r0 *1 0,0
Xsg13cmos5l_a21o_1_4 \$2025 \$1899 \$2021 VPWR VGND \$2022 sg13cmos5l_a21o_1
* cell instance sg13cmos5l_a21o_1_5 r0 *1 0,0
Xsg13cmos5l_a21o_1_5 \$1783 \$1785 \$2004 VPWR VGND \$1899 sg13cmos5l_a21o_1
* cell instance sg13cmos5l_a21o_1_6 r0 *1 0,0
Xsg13cmos5l_a21o_1_6 \$1337 \$1334 \$899 VPWR VGND \$1338 sg13cmos5l_a21o_1
* cell instance sg13cmos5l_a21o_1_7 r0 *1 0,0
Xsg13cmos5l_a21o_1_7 \$1691 \$1692 \$1135 VPWR VGND \$1554 sg13cmos5l_a21o_1
* cell instance sg13cmos5l_a21o_1_8 r0 *1 0,0
Xsg13cmos5l_a21o_1_8 \$3823 \$2273 \$3602 VPWR VGND \$5007 sg13cmos5l_a21o_1
* cell instance sg13cmos5l_a21o_1_9 r0 *1 0,0
Xsg13cmos5l_a21o_1_9 \$1461 \$1231 \$1464 VPWR VGND \$1357 sg13cmos5l_a21o_1
* cell instance sg13cmos5l_a21o_1_10 r0 *1 0,0
Xsg13cmos5l_a21o_1_10 \$929 \$1139 \$1138 VPWR VGND \$371 sg13cmos5l_a21o_1
* cell instance sg13cmos5l_a21o_1_11 r0 *1 0,0
Xsg13cmos5l_a21o_1_11 \$1145 \$1038 \$931 VPWR VGND \$1146 sg13cmos5l_a21o_1
* cell instance sg13cmos5l_a21o_1_12 r0 *1 0,0
Xsg13cmos5l_a21o_1_12 \$704 \$809 \$701 VPWR VGND \$808 sg13cmos5l_a21o_1
* cell instance sg13cmos5l_a21o_1_13 r0 *1 0,0
Xsg13cmos5l_a21o_1_13 \$1708 \$1597 \$1089 VPWR VGND \$1705 sg13cmos5l_a21o_1
* cell instance sg13cmos5l_a21o_1_14 r0 *1 0,0
Xsg13cmos5l_a21o_1_14 \$1378 \$1374 \$799 VPWR VGND \$1375 sg13cmos5l_a21o_1
* cell instance sg13cmos5l_a21o_1_15 r0 *1 0,0
Xsg13cmos5l_a21o_1_15 \$879 \$936 \$799 VPWR VGND \$937 sg13cmos5l_a21o_1
* cell instance sg13cmos5l_a21o_1_16 r0 *1 0,0
Xsg13cmos5l_a21o_1_16 \$1711 \$1595 \$799 VPWR VGND \$1708 sg13cmos5l_a21o_1
* cell instance sg13cmos5l_a21o_1_17 r0 *1 0,0
Xsg13cmos5l_a21o_1_17 \$937 \$941 \$1089 VPWR VGND \$1042 sg13cmos5l_a21o_1
* cell instance sg13cmos5l_a21o_1_18 r0 *1 0,0
Xsg13cmos5l_a21o_1_18 \$1375 \$1246 \$1089 VPWR VGND \$1379 sg13cmos5l_a21o_1
* cell instance sg13cmos5l_a21o_1_19 r0 *1 0,0
Xsg13cmos5l_a21o_1_19 \$1705 \$1713 \$1603 VPWR VGND \$1601 sg13cmos5l_a21o_1
* cell instance sg13cmos5l_a21o_1_20 r0 *1 0,0
Xsg13cmos5l_a21o_1_20 \$1042 \$1156 \$946 VPWR VGND \$348 sg13cmos5l_a21o_1
* cell instance sg13cmos5l_a21o_1_21 r0 *1 0,0
Xsg13cmos5l_a21o_1_21 \$1239 \$1310 \$1253 VPWR VGND \$1251 sg13cmos5l_a21o_1
* cell instance sg13cmos5l_a21o_1_22 r0 *1 0,0
Xsg13cmos5l_a21o_1_22 \$1136 \$1589 \$1606 VPWR VGND \$1064 sg13cmos5l_a21o_1
* cell instance sg13cmos5l_a21o_1_23 r0 *1 0,0
Xsg13cmos5l_a21o_1_23 \$1379 \$1247 \$1256 VPWR VGND \$1384 sg13cmos5l_a21o_1
* cell instance sg13cmos5l_a21o_1_24 r0 *1 0,0
Xsg13cmos5l_a21o_1_24 \$411 \$641 \$105 VPWR VGND \$585 sg13cmos5l_a21o_1
* cell instance sg13cmos5l_a21o_1_25 r0 *1 0,0
Xsg13cmos5l_a21o_1_25 \$1057 \$953 \$28 VPWR VGND \$344 sg13cmos5l_a21o_1
* cell instance sg13cmos5l_a21o_1_26 r0 *1 0,0
Xsg13cmos5l_a21o_1_26 \$3672 \$2977 \$3670 VPWR VGND \$3668 sg13cmos5l_a21o_1
* cell instance sg13cmos5l_a21o_1_27 r0 *1 0,0
Xsg13cmos5l_a21o_1_27 \$405 \$592 \$829 VPWR VGND \$811 sg13cmos5l_a21o_1
* cell instance sg13cmos5l_a21o_1_28 r0 *1 0,0
Xsg13cmos5l_a21o_1_28 \$169 \$1311 \$420 VPWR VGND \$1276 sg13cmos5l_a21o_1
* cell instance sg13cmos5l_a21o_1_29 r0 *1 0,0
Xsg13cmos5l_a21o_1_29 \$2651 \$2664 \$2662 VPWR VGND \$2660 sg13cmos5l_a21o_1
* cell instance sg13cmos5l_a21o_1_30 r0 *1 0,0
Xsg13cmos5l_a21o_1_30 \$1622 \$381 \$1280 VPWR VGND \$1515 sg13cmos5l_a21o_1
* cell instance sg13cmos5l_a21o_1_31 r0 *1 0,0
Xsg13cmos5l_a21o_1_31 \$3186 \$3007 \$3181 VPWR VGND \$3183 sg13cmos5l_a21o_1
* cell instance sg13cmos5l_a21o_1_32 r0 *1 0,0
Xsg13cmos5l_a21o_1_32 \$835 \$832 \$1410 VPWR VGND \$1408 sg13cmos5l_a21o_1
* cell instance sg13cmos5l_a21o_1_33 r0 *1 0,0
Xsg13cmos5l_a21o_1_33 \$117 \$205 \$22 VPWR VGND \$174 sg13cmos5l_a21o_1
* cell instance sg13cmos5l_a21o_1_34 r0 *1 0,0
Xsg13cmos5l_a21o_1_34 \$18 \$974 \$1636 VPWR VGND \$2111 sg13cmos5l_a21o_1
* cell instance sg13cmos5l_a21o_1_35 r0 *1 0,0
Xsg13cmos5l_a21o_1_35 \$169 \$11 \$9 VPWR VGND \$71 sg13cmos5l_a21o_1
* cell instance sg13cmos5l_a21o_1_36 r0 *1 0,0
Xsg13cmos5l_a21o_1_36 \$30 \$39 \$131 VPWR VGND \$439 sg13cmos5l_a21o_1
* cell instance sg13cmos5l_a21o_1_37 r0 *1 0,0
Xsg13cmos5l_a21o_1_37 \$396 \$445 \$293 VPWR VGND \$467 sg13cmos5l_a21o_1
* cell instance sg13cmos5l_a21o_1_38 r0 *1 0,0
Xsg13cmos5l_a21o_1_38 \$1312 \$437 \$1664 VPWR VGND \$1072 sg13cmos5l_a21o_1
* cell instance sg13cmos5l_a21o_1_39 r0 *1 0,0
Xsg13cmos5l_a21o_1_39 \$532 \$451 \$449 VPWR VGND \$528 sg13cmos5l_a21o_1
* cell instance sg13cmos5l_a21o_1_40 r0 *1 0,0
Xsg13cmos5l_a21o_1_40 \$169 \$7 \$626 VPWR VGND \$749 sg13cmos5l_a21o_1
* cell instance sg13cmos5l_a21oi_1_0 r0 *1 0,0
Xsg13cmos5l_a21oi_1_0 \$2403 \$2258 \$2256 VPWR VGND \$2401 sg13cmos5l_a21oi_1
* cell instance sg13cmos5l_a21oi_1_1 r0 *1 0,0
Xsg13cmos5l_a21oi_1_1 \$3274 \$3277 \$3276 VPWR VGND \$2258 sg13cmos5l_a21oi_1
* cell instance sg13cmos5l_a21oi_1_2 r0 *1 0,0
Xsg13cmos5l_a21oi_1_2 \$4566 \$4567 \$4103 VPWR VGND \$4564 sg13cmos5l_a21oi_1
* cell instance sg13cmos5l_a21oi_1_3 r0 *1 0,0
Xsg13cmos5l_a21oi_1_3 \$4103 \$2400 \$4098 VPWR VGND \$4315 sg13cmos5l_a21oi_1
* cell instance sg13cmos5l_a21oi_1_4 r0 *1 0,0
Xsg13cmos5l_a21oi_1_4 \$3610 \$3615 \$3613 VPWR VGND \$3277 sg13cmos5l_a21oi_1
* cell instance sg13cmos5l_a21oi_1_5 r0 *1 0,0
Xsg13cmos5l_a21oi_1_5 \$3799 \$2755 \$3796 VPWR VGND \$3797 sg13cmos5l_a21oi_1
* cell instance sg13cmos5l_a21oi_1_6 r0 *1 0,0
Xsg13cmos5l_a21oi_1_6 \$4568 \$4431 \$4318 VPWR VGND \$4429 sg13cmos5l_a21oi_1
* cell instance sg13cmos5l_a21oi_1_7 r0 *1 0,0
Xsg13cmos5l_a21oi_1_7 \$4678 \$4675 \$4676 VPWR VGND \$3615 sg13cmos5l_a21oi_1
* cell instance sg13cmos5l_a21oi_1_8 r0 *1 0,0
Xsg13cmos5l_a21oi_1_8 \$1250 \$3116 \$3113 VPWR VGND \$4099 sg13cmos5l_a21oi_1
* cell instance sg13cmos5l_a21oi_1_9 r0 *1 0,0
Xsg13cmos5l_a21oi_1_9 \$1250 \$2930 \$3113 VPWR VGND \$3784 sg13cmos5l_a21oi_1
* cell instance sg13cmos5l_a21oi_1_10 r0 *1 0,0
Xsg13cmos5l_a21oi_1_10 \$2593 \$2414 \$2592 VPWR VGND \$2599 sg13cmos5l_a21oi_1
* cell instance sg13cmos5l_a21oi_1_11 r0 *1 0,0
Xsg13cmos5l_a21oi_1_11 \$3473 \$12461 \$12138 VPWR VGND \$12289
+ sg13cmos5l_a21oi_1
* cell instance sg13cmos5l_a21oi_1_12 r0 *1 0,0
Xsg13cmos5l_a21oi_1_12 \$2419 \$3471 \$3618 VPWR VGND \$3620 sg13cmos5l_a21oi_1
* cell instance sg13cmos5l_a21oi_1_13 r0 *1 0,0
Xsg13cmos5l_a21oi_1_13 \$3473 \$11398 \$11380 VPWR VGND \$11544
+ sg13cmos5l_a21oi_1
* cell instance sg13cmos5l_a21oi_1_14 r0 *1 0,0
Xsg13cmos5l_a21oi_1_14 \$872 \$1219 \$1217 VPWR VGND \$1309 sg13cmos5l_a21oi_1
* cell instance sg13cmos5l_a21oi_1_15 r0 *1 0,0
Xsg13cmos5l_a21oi_1_15 \$4978 \$4980 \$3962 VPWR VGND \$4435 sg13cmos5l_a21oi_1
* cell instance sg13cmos5l_a21oi_1_16 r0 *1 0,0
Xsg13cmos5l_a21oi_1_16 \$2923 \$4434 \$4435 VPWR VGND \$4436 sg13cmos5l_a21oi_1
* cell instance sg13cmos5l_a21oi_1_17 r0 *1 0,0
Xsg13cmos5l_a21oi_1_17 \$4144 uio_out[6] \$16935 VPWR VGND uio_oe[6]
+ sg13cmos5l_a21oi_1
* cell instance sg13cmos5l_a21oi_1_18 r0 *1 0,0
Xsg13cmos5l_a21oi_1_18 \$6018 \$6057 \$6081 VPWR VGND \$6021 sg13cmos5l_a21oi_1
* cell instance sg13cmos5l_a21oi_1_19 r0 *1 0,0
Xsg13cmos5l_a21oi_1_19 uio_out[7] \$3480 \$15562 VPWR VGND uio_oe[7]
+ sg13cmos5l_a21oi_1
* cell instance sg13cmos5l_a21oi_1_20 r0 *1 0,0
Xsg13cmos5l_a21oi_1_20 \$4103 \$4104 \$4097 VPWR VGND \$4101 sg13cmos5l_a21oi_1
* cell instance sg13cmos5l_a21oi_1_21 r0 *1 0,0
Xsg13cmos5l_a21oi_1_21 \$4290 uio_out[5] \$14358 VPWR VGND uio_oe[5]
+ sg13cmos5l_a21oi_1
* cell instance sg13cmos5l_a21oi_1_22 r0 *1 0,0
Xsg13cmos5l_a21oi_1_22 \$2017 \$2246 \$4983 VPWR VGND \$4985 sg13cmos5l_a21oi_1
* cell instance sg13cmos5l_a21oi_1_23 r0 *1 0,0
Xsg13cmos5l_a21oi_1_23 \$5097 \$3260 \$5099 VPWR VGND \$5098 sg13cmos5l_a21oi_1
* cell instance sg13cmos5l_a21oi_1_24 r0 *1 0,0
Xsg13cmos5l_a21oi_1_24 \$896 \$905 \$903 VPWR VGND \$774 sg13cmos5l_a21oi_1
* cell instance sg13cmos5l_a21oi_1_25 r0 *1 0,0
Xsg13cmos5l_a21oi_1_25 \$1585 \$12461 \$12302 VPWR VGND \$13019
+ sg13cmos5l_a21oi_1
* cell instance sg13cmos5l_a21oi_1_26 r0 *1 0,0
Xsg13cmos5l_a21oi_1_26 \$3968 \$12461 \$13336 VPWR VGND \$13929
+ sg13cmos5l_a21oi_1
* cell instance sg13cmos5l_a21oi_1_27 r0 *1 0,0
Xsg13cmos5l_a21oi_1_27 \$2423 \$2263 \$2764 VPWR VGND \$2931 sg13cmos5l_a21oi_1
* cell instance sg13cmos5l_a21oi_1_28 r0 *1 0,0
Xsg13cmos5l_a21oi_1_28 \$1115 \$1337 \$899 VPWR VGND \$1113 sg13cmos5l_a21oi_1
* cell instance sg13cmos5l_a21oi_1_29 r0 *1 0,0
Xsg13cmos5l_a21oi_1_29 \$776 \$907 \$899 VPWR VGND \$905 sg13cmos5l_a21oi_1
* cell instance sg13cmos5l_a21oi_1_30 r0 *1 0,0
Xsg13cmos5l_a21oi_1_30 \$1702 \$5357 \$1691 VPWR VGND \$5342 sg13cmos5l_a21oi_1
* cell instance sg13cmos5l_a21oi_1_31 r0 *1 0,0
Xsg13cmos5l_a21oi_1_31 \$3827 uio_out[3] \$14364 VPWR VGND uio_oe[3]
+ sg13cmos5l_a21oi_1
* cell instance sg13cmos5l_a21oi_1_32 r0 *1 0,0
Xsg13cmos5l_a21oi_1_32 \$2419 \$4687 \$4571 VPWR VGND \$4688 sg13cmos5l_a21oi_1
* cell instance sg13cmos5l_a21oi_1_33 r0 *1 0,0
Xsg13cmos5l_a21oi_1_33 \$1702 \$5103 \$1691 VPWR VGND \$5099 sg13cmos5l_a21oi_1
* cell instance sg13cmos5l_a21oi_1_34 r0 *1 0,0
Xsg13cmos5l_a21oi_1_34 \$1702 \$5418 \$1691 VPWR VGND \$5343 sg13cmos5l_a21oi_1
* cell instance sg13cmos5l_a21oi_1_35 r0 *1 0,0
Xsg13cmos5l_a21oi_1_35 \$4985 \$2285 \$5026 VPWR VGND \$4997 sg13cmos5l_a21oi_1
* cell instance sg13cmos5l_a21oi_1_36 r0 *1 0,0
Xsg13cmos5l_a21oi_1_36 \$6629 \$6057 \$6081 VPWR VGND \$6628 sg13cmos5l_a21oi_1
* cell instance sg13cmos5l_a21oi_1_37 r0 *1 0,0
Xsg13cmos5l_a21oi_1_37 \$3968 \$11398 \$11917 VPWR VGND \$11549
+ sg13cmos5l_a21oi_1
* cell instance sg13cmos5l_a21oi_1_38 r0 *1 0,0
Xsg13cmos5l_a21oi_1_38 \$3275 \$2899 \$3127 VPWR VGND \$3458 sg13cmos5l_a21oi_1
* cell instance sg13cmos5l_a21oi_1_39 r0 *1 0,0
Xsg13cmos5l_a21oi_1_39 \$4426 uio_out[1] \$12303 VPWR VGND uio_oe[1]
+ sg13cmos5l_a21oi_1
* cell instance sg13cmos5l_a21oi_1_40 r0 *1 0,0
Xsg13cmos5l_a21oi_1_40 \$1565 \$1679 \$1326 VPWR VGND \$1563 sg13cmos5l_a21oi_1
* cell instance sg13cmos5l_a21oi_1_41 r0 *1 0,0
Xsg13cmos5l_a21oi_1_41 \$1585 \$9576 \$10878 VPWR VGND \$11921
+ sg13cmos5l_a21oi_1
* cell instance sg13cmos5l_a21oi_1_42 r0 *1 0,0
Xsg13cmos5l_a21oi_1_42 \$1250 \$2755 \$3127 VPWR VGND \$4445 sg13cmos5l_a21oi_1
* cell instance sg13cmos5l_a21oi_1_43 r0 *1 0,0
Xsg13cmos5l_a21oi_1_43 \$3472 \$3478 \$2150 VPWR VGND \$3602 sg13cmos5l_a21oi_1
* cell instance sg13cmos5l_a21oi_1_44 r0 *1 0,0
Xsg13cmos5l_a21oi_1_44 \$1702 \$5345 \$1691 VPWR VGND \$5344 sg13cmos5l_a21oi_1
* cell instance sg13cmos5l_a21oi_1_45 r0 *1 0,0
Xsg13cmos5l_a21oi_1_45 \$1565 \$1679 \$1692 VPWR VGND \$1567 sg13cmos5l_a21oi_1
* cell instance sg13cmos5l_a21oi_1_46 r0 *1 0,0
Xsg13cmos5l_a21oi_1_46 \$3823 \$2173 \$3260 VPWR VGND \$4691 sg13cmos5l_a21oi_1
* cell instance sg13cmos5l_a21oi_1_47 r0 *1 0,0
Xsg13cmos5l_a21oi_1_47 \$3132 \$3133 \$2935 VPWR VGND \$3260 sg13cmos5l_a21oi_1
* cell instance sg13cmos5l_a21oi_1_48 r0 *1 0,0
Xsg13cmos5l_a21oi_1_48 \$4293 uio_out[2] \$13340 VPWR VGND uio_oe[2]
+ sg13cmos5l_a21oi_1
* cell instance sg13cmos5l_a21oi_1_49 r0 *1 0,0
Xsg13cmos5l_a21oi_1_49 uio_out[4] \$4453 \$14975 VPWR VGND uio_oe[4]
+ sg13cmos5l_a21oi_1
* cell instance sg13cmos5l_a21oi_1_50 r0 *1 0,0
Xsg13cmos5l_a21oi_1_50 \$8998 \$9000 \$2152 VPWR VGND \$3601 sg13cmos5l_a21oi_1
* cell instance sg13cmos5l_a21oi_1_51 r0 *1 0,0
Xsg13cmos5l_a21oi_1_51 \$2433 \$2943 \$2277 VPWR VGND \$3133 sg13cmos5l_a21oi_1
* cell instance sg13cmos5l_a21oi_1_52 r0 *1 0,0
Xsg13cmos5l_a21oi_1_52 \$12001 uio_out[0] \$12072 VPWR VGND uio_oe[0]
+ sg13cmos5l_a21oi_1
* cell instance sg13cmos5l_a21oi_1_53 r0 *1 0,0
Xsg13cmos5l_a21oi_1_53 \$1234 \$1231 \$1135 VPWR VGND \$1232 sg13cmos5l_a21oi_1
* cell instance sg13cmos5l_a21oi_1_54 r0 *1 0,0
Xsg13cmos5l_a21oi_1_54 \$4335 \$1913 \$2771 VPWR VGND \$4333 sg13cmos5l_a21oi_1
* cell instance sg13cmos5l_a21oi_1_55 r0 *1 0,0
Xsg13cmos5l_a21oi_1_55 \$1796 \$2428 \$1474 VPWR VGND \$1794 sg13cmos5l_a21oi_1
* cell instance sg13cmos5l_a21oi_1_56 r0 *1 0,0
Xsg13cmos5l_a21oi_1_56 \$3491 \$3638 \$2277 VPWR VGND \$3490 sg13cmos5l_a21oi_1
* cell instance sg13cmos5l_a21oi_1_57 r0 *1 0,0
Xsg13cmos5l_a21oi_1_57 \$11929 \$1117 \$2614 VPWR VGND \$3298 sg13cmos5l_a21oi_1
* cell instance sg13cmos5l_a21oi_1_58 r0 *1 0,0
Xsg13cmos5l_a21oi_1_58 \$1238 \$1235 \$799 VPWR VGND \$1236 sg13cmos5l_a21oi_1
* cell instance sg13cmos5l_a21oi_1_59 r0 *1 0,0
Xsg13cmos5l_a21oi_1_59 \$2277 \$2775 \$2782 VPWR VGND \$2773 sg13cmos5l_a21oi_1
* cell instance sg13cmos5l_a21oi_1_60 r0 *1 0,0
Xsg13cmos5l_a21oi_1_60 \$2003 \$2775 \$3640 VPWR VGND \$3642 sg13cmos5l_a21oi_1
* cell instance sg13cmos5l_a21oi_1_61 r0 *1 0,0
Xsg13cmos5l_a21oi_1_61 \$1585 \$1231 \$1583 VPWR VGND \$1584 sg13cmos5l_a21oi_1
* cell instance sg13cmos5l_a21oi_1_62 r0 *1 0,0
Xsg13cmos5l_a21oi_1_62 \$4135 \$4342 \$2277 VPWR VGND \$4340 sg13cmos5l_a21oi_1
* cell instance sg13cmos5l_a21oi_1_63 r0 *1 0,0
Xsg13cmos5l_a21oi_1_63 \$1590 \$1591 \$799 VPWR VGND \$1588 sg13cmos5l_a21oi_1
* cell instance sg13cmos5l_a21oi_1_64 r0 *1 0,0
Xsg13cmos5l_a21oi_1_64 \$934 \$925 \$932 VPWR VGND \$930 sg13cmos5l_a21oi_1
* cell instance sg13cmos5l_a21oi_1_65 r0 *1 0,0
Xsg13cmos5l_a21oi_1_65 \$2748 \$2159 \$2777 VPWR VGND \$2776 sg13cmos5l_a21oi_1
* cell instance sg13cmos5l_a21oi_1_66 r0 *1 0,0
Xsg13cmos5l_a21oi_1_66 \$2177 \$2175 \$2285 VPWR VGND \$2287 sg13cmos5l_a21oi_1
* cell instance sg13cmos5l_a21oi_1_67 r0 *1 0,0
Xsg13cmos5l_a21oi_1_67 \$2443 \$2622 \$2619 VPWR VGND \$2620 sg13cmos5l_a21oi_1
* cell instance sg13cmos5l_a21oi_1_68 r0 *1 0,0
Xsg13cmos5l_a21oi_1_68 \$2908 \$2942 \$2955 VPWR VGND \$2954 sg13cmos5l_a21oi_1
* cell instance sg13cmos5l_a21oi_1_69 r0 *1 0,0
Xsg13cmos5l_a21oi_1_69 \$1250 \$1940 \$2182 VPWR VGND \$2183 sg13cmos5l_a21oi_1
* cell instance sg13cmos5l_a21oi_1_70 r0 *1 0,0
Xsg13cmos5l_a21oi_1_70 \$2293 \$2183 \$2290 VPWR VGND \$2291 sg13cmos5l_a21oi_1
* cell instance sg13cmos5l_a21oi_1_71 r0 *1 0,0
Xsg13cmos5l_a21oi_1_71 \$2456 \$2775 \$3986 VPWR VGND \$2958 sg13cmos5l_a21oi_1
* cell instance sg13cmos5l_a21oi_1_72 r0 *1 0,0
Xsg13cmos5l_a21oi_1_72 \$673 \$718 \$581 VPWR VGND \$705 sg13cmos5l_a21oi_1
* cell instance sg13cmos5l_a21oi_1_73 r0 *1 0,0
Xsg13cmos5l_a21oi_1_73 \$514 \$375 \$673 VPWR VGND \$581 sg13cmos5l_a21oi_1
* cell instance sg13cmos5l_a21oi_1_74 r0 *1 0,0
Xsg13cmos5l_a21oi_1_74 \$3845 \$3842 \$2952 VPWR VGND \$3843 sg13cmos5l_a21oi_1
* cell instance sg13cmos5l_a21oi_1_75 r0 *1 0,0
Xsg13cmos5l_a21oi_1_75 \$1716 \$2196 \$2636 VPWR VGND \$2786 sg13cmos5l_a21oi_1
* cell instance sg13cmos5l_a21oi_1_76 r0 *1 0,0
Xsg13cmos5l_a21oi_1_76 \$585 \$376 \$583 VPWR VGND \$557 sg13cmos5l_a21oi_1
* cell instance sg13cmos5l_a21oi_1_77 r0 *1 0,0
Xsg13cmos5l_a21oi_1_77 \$1974 \$2568 \$2639 VPWR VGND \$2637 sg13cmos5l_a21oi_1
* cell instance sg13cmos5l_a21oi_1_78 r0 *1 0,0
Xsg13cmos5l_a21oi_1_78 \$1822 \$2786 \$2641 VPWR VGND \$2788 sg13cmos5l_a21oi_1
* cell instance sg13cmos5l_a21oi_1_79 r0 *1 0,0
Xsg13cmos5l_a21oi_1_79 \$158 \$209 \$105 VPWR VGND \$256 sg13cmos5l_a21oi_1
* cell instance sg13cmos5l_a21oi_1_80 r0 *1 0,0
Xsg13cmos5l_a21oi_1_80 \$1815 \$2193 \$2196 VPWR VGND \$2191 sg13cmos5l_a21oi_1
* cell instance sg13cmos5l_a21oi_1_81 r0 *1 0,0
Xsg13cmos5l_a21oi_1_81 \$412 \$209 \$297 VPWR VGND \$413 sg13cmos5l_a21oi_1
* cell instance sg13cmos5l_a21oi_1_82 r0 *1 0,0
Xsg13cmos5l_a21oi_1_82 \$1057 \$1051 \$28 VPWR VGND \$721 sg13cmos5l_a21oi_1
* cell instance sg13cmos5l_a21oi_1_83 r0 *1 0,0
Xsg13cmos5l_a21oi_1_83 \$1822 \$1823 \$1820 VPWR VGND \$1819 sg13cmos5l_a21oi_1
* cell instance sg13cmos5l_a21oi_1_84 r0 *1 0,0
Xsg13cmos5l_a21oi_1_84 \$103 \$39 \$157 VPWR VGND \$160 sg13cmos5l_a21oi_1
* cell instance sg13cmos5l_a21oi_1_85 r0 *1 0,0
Xsg13cmos5l_a21oi_1_85 \$158 \$107 \$105 VPWR VGND \$2 sg13cmos5l_a21oi_1
* cell instance sg13cmos5l_a21oi_1_86 r0 *1 0,0
Xsg13cmos5l_a21oi_1_86 \$299 \$351 \$332 VPWR VGND \$349 sg13cmos5l_a21oi_1
* cell instance sg13cmos5l_a21oi_1_87 r0 *1 0,0
Xsg13cmos5l_a21oi_1_87 \$2177 \$2617 \$2798 VPWR VGND \$2797 sg13cmos5l_a21oi_1
* cell instance sg13cmos5l_a21oi_1_88 r0 *1 0,0
Xsg13cmos5l_a21oi_1_88 \$2200 \$2901 \$2651 VPWR VGND \$2906 sg13cmos5l_a21oi_1
* cell instance sg13cmos5l_a21oi_1_89 r0 *1 0,0
Xsg13cmos5l_a21oi_1_89 \$38 \$39 \$41 VPWR VGND \$40 sg13cmos5l_a21oi_1
* cell instance sg13cmos5l_a21oi_1_90 r0 *1 0,0
Xsg13cmos5l_a21oi_1_90 \$1822 \$2461 \$2470 VPWR VGND \$2646 sg13cmos5l_a21oi_1
* cell instance sg13cmos5l_a21oi_1_91 r0 *1 0,0
Xsg13cmos5l_a21oi_1_91 \$3641 \$1940 \$2309 VPWR VGND \$2310 sg13cmos5l_a21oi_1
* cell instance sg13cmos5l_a21oi_1_92 r0 *1 0,0
Xsg13cmos5l_a21oi_1_92 \$642 \$724 \$719 VPWR VGND \$511 sg13cmos5l_a21oi_1
* cell instance sg13cmos5l_a21oi_1_93 r0 *1 0,0
Xsg13cmos5l_a21oi_1_93 \$2443 \$2645 \$2649 VPWR VGND \$2648 sg13cmos5l_a21oi_1
* cell instance sg13cmos5l_a21oi_1_94 r0 *1 0,0
Xsg13cmos5l_a21oi_1_94 \$387 \$1401 \$418 VPWR VGND \$722 sg13cmos5l_a21oi_1
* cell instance sg13cmos5l_a21oi_1_95 r0 *1 0,0
Xsg13cmos5l_a21oi_1_95 \$1488 \$2196 \$2070 VPWR VGND \$2071 sg13cmos5l_a21oi_1
* cell instance sg13cmos5l_a21oi_1_96 r0 *1 0,0
Xsg13cmos5l_a21oi_1_96 \$1822 \$2071 \$2069 VPWR VGND \$2073 sg13cmos5l_a21oi_1
* cell instance sg13cmos5l_a21oi_1_97 r0 *1 0,0
Xsg13cmos5l_a21oi_1_97 \$726 \$7 \$719 VPWR VGND \$513 sg13cmos5l_a21oi_1
* cell instance sg13cmos5l_a21oi_1_98 r0 *1 0,0
Xsg13cmos5l_a21oi_1_98 \$65 \$279 \$569 VPWR VGND \$1399 sg13cmos5l_a21oi_1
* cell instance sg13cmos5l_a21oi_1_99 r0 *1 0,0
Xsg13cmos5l_a21oi_1_99 \$164 \$300 \$420 VPWR VGND \$50 sg13cmos5l_a21oi_1
* cell instance sg13cmos5l_a21oi_1_100 r0 *1 0,0
Xsg13cmos5l_a21oi_1_100 \$731 \$1051 \$28 VPWR VGND \$1175 sg13cmos5l_a21oi_1
* cell instance sg13cmos5l_a21oi_1_101 r0 *1 0,0
Xsg13cmos5l_a21oi_1_101 \$106 \$157 \$1858 VPWR VGND \$1311 sg13cmos5l_a21oi_1
* cell instance sg13cmos5l_a21oi_1_102 r0 *1 0,0
Xsg13cmos5l_a21oi_1_102 \$153 \$218 \$231 VPWR VGND \$20 sg13cmos5l_a21oi_1
* cell instance sg13cmos5l_a21oi_1_103 r0 *1 0,0
Xsg13cmos5l_a21oi_1_103 \$421 \$881 \$719 VPWR VGND \$727 sg13cmos5l_a21oi_1
* cell instance sg13cmos5l_a21oi_1_104 r0 *1 0,0
Xsg13cmos5l_a21oi_1_104 \$36 \$44 \$302 VPWR VGND \$1283 sg13cmos5l_a21oi_1
* cell instance sg13cmos5l_a21oi_1_105 r0 *1 0,0
Xsg13cmos5l_a21oi_1_105 \$1180 \$1055 \$518 VPWR VGND \$1178 sg13cmos5l_a21oi_1
* cell instance sg13cmos5l_a21oi_1_106 r0 *1 0,0
Xsg13cmos5l_a21oi_1_106 \$118 \$44 \$346 VPWR VGND \$1626 sg13cmos5l_a21oi_1
* cell instance sg13cmos5l_a21oi_1_107 r0 *1 0,0
Xsg13cmos5l_a21oi_1_107 \$843 \$279 \$346 VPWR VGND \$599 sg13cmos5l_a21oi_1
* cell instance sg13cmos5l_a21oi_1_108 r0 *1 0,0
Xsg13cmos5l_a21oi_1_108 \$2664 \$3010 \$3011 VPWR VGND \$3181 sg13cmos5l_a21oi_1
* cell instance sg13cmos5l_a21oi_1_109 r0 *1 0,0
Xsg13cmos5l_a21oi_1_109 \$301 \$220 \$521 VPWR VGND \$515 sg13cmos5l_a21oi_1
* cell instance sg13cmos5l_a21oi_1_110 r0 *1 0,0
Xsg13cmos5l_a21oi_1_110 \$1748 \$1626 \$518 VPWR VGND \$1749 sg13cmos5l_a21oi_1
* cell instance sg13cmos5l_a21oi_1_111 r0 *1 0,0
Xsg13cmos5l_a21oi_1_111 \$1402 \$1404 \$521 VPWR VGND \$1285 sg13cmos5l_a21oi_1
* cell instance sg13cmos5l_a21oi_1_112 r0 *1 0,0
Xsg13cmos5l_a21oi_1_112 \$963 \$964 \$405 VPWR VGND \$829 sg13cmos5l_a21oi_1
* cell instance sg13cmos5l_a21oi_1_113 r0 *1 0,0
Xsg13cmos5l_a21oi_1_113 \$301 \$1404 \$521 VPWR VGND \$728 sg13cmos5l_a21oi_1
* cell instance sg13cmos5l_a21oi_1_114 r0 *1 0,0
Xsg13cmos5l_a21oi_1_114 \$1061 \$967 \$965 VPWR VGND \$964 sg13cmos5l_a21oi_1
* cell instance sg13cmos5l_a21oi_1_115 r0 *1 0,0
Xsg13cmos5l_a21oi_1_115 \$148 \$116 \$57 VPWR VGND \$58 sg13cmos5l_a21oi_1
* cell instance sg13cmos5l_a21oi_1_116 r0 *1 0,0
Xsg13cmos5l_a21oi_1_116 \$731 \$839 \$730 VPWR VGND \$967 sg13cmos5l_a21oi_1
* cell instance sg13cmos5l_a21oi_1_117 r0 *1 0,0
Xsg13cmos5l_a21oi_1_117 \$47 \$1408 \$1058 VPWR VGND \$1406 sg13cmos5l_a21oi_1
* cell instance sg13cmos5l_a21oi_1_118 r0 *1 0,0
Xsg13cmos5l_a21oi_1_118 \$731 \$1060 \$1628 VPWR VGND \$1629 sg13cmos5l_a21oi_1
* cell instance sg13cmos5l_a21oi_1_119 r0 *1 0,0
Xsg13cmos5l_a21oi_1_119 \$173 \$116 \$302 VPWR VGND \$303 sg13cmos5l_a21oi_1
* cell instance sg13cmos5l_a21oi_1_120 r0 *1 0,0
Xsg13cmos5l_a21oi_1_120 \$835 \$832 \$302 VPWR VGND \$839 sg13cmos5l_a21oi_1
* cell instance sg13cmos5l_a21oi_1_121 r0 *1 0,0
Xsg13cmos5l_a21oi_1_121 \$269 \$1055 \$518 VPWR VGND \$1210 sg13cmos5l_a21oi_1
* cell instance sg13cmos5l_a21oi_1_122 r0 *1 0,0
Xsg13cmos5l_a21oi_1_122 \$2397 \$2350 \$2222 VPWR VGND \$2348 sg13cmos5l_a21oi_1
* cell instance sg13cmos5l_a21oi_1_123 r0 *1 0,0
Xsg13cmos5l_a21oi_1_123 \$220 \$524 \$521 VPWR VGND \$522 sg13cmos5l_a21oi_1
* cell instance sg13cmos5l_a21oi_1_124 r0 *1 0,0
Xsg13cmos5l_a21oi_1_124 \$335 \$1406 \$1288 VPWR VGND \$1412 sg13cmos5l_a21oi_1
* cell instance sg13cmos5l_a21oi_1_125 r0 *1 0,0
Xsg13cmos5l_a21oi_1_125 \$169 \$62 \$154 VPWR VGND \$170 sg13cmos5l_a21oi_1
* cell instance sg13cmos5l_a21oi_1_126 r0 *1 0,0
Xsg13cmos5l_a21oi_1_126 \$55 \$64 \$61 VPWR VGND \$62 sg13cmos5l_a21oi_1
* cell instance sg13cmos5l_a21oi_1_127 r0 *1 0,0
Xsg13cmos5l_a21oi_1_127 \$2229 \$2235 \$2226 VPWR VGND \$2233 sg13cmos5l_a21oi_1
* cell instance sg13cmos5l_a21oi_1_128 r0 *1 0,0
Xsg13cmos5l_a21oi_1_128 \$426 \$427 \$422 VPWR VGND \$424 sg13cmos5l_a21oi_1
* cell instance sg13cmos5l_a21oi_1_129 r0 *1 0,0
Xsg13cmos5l_a21oi_1_129 \$169 \$254 \$216 VPWR VGND \$222 sg13cmos5l_a21oi_1
* cell instance sg13cmos5l_a21oi_1_130 r0 *1 0,0
Xsg13cmos5l_a21oi_1_130 \$218 \$360 \$518 VPWR VGND \$427 sg13cmos5l_a21oi_1
* cell instance sg13cmos5l_a21oi_1_131 r0 *1 0,0
Xsg13cmos5l_a21oi_1_131 \$24 \$25 \$8 VPWR VGND \$6 sg13cmos5l_a21oi_1
* cell instance sg13cmos5l_a21oi_1_132 r0 *1 0,0
Xsg13cmos5l_a21oi_1_132 \$1585 \$3034 \$4386 VPWR VGND \$4385 sg13cmos5l_a21oi_1
* cell instance sg13cmos5l_a21oi_1_133 r0 *1 0,0
Xsg13cmos5l_a21oi_1_133 \$388 \$1636 \$883 VPWR VGND \$1185 sg13cmos5l_a21oi_1
* cell instance sg13cmos5l_a21oi_1_134 r0 *1 0,0
Xsg13cmos5l_a21oi_1_134 \$433 \$621 \$1636 VPWR VGND \$1761 sg13cmos5l_a21oi_1
* cell instance sg13cmos5l_a21oi_1_135 r0 *1 0,0
Xsg13cmos5l_a21oi_1_135 \$142 \$1858 \$76 VPWR VGND \$1636 sg13cmos5l_a21oi_1
* cell instance sg13cmos5l_a21oi_1_136 r0 *1 0,0
Xsg13cmos5l_a21oi_1_136 \$1073 \$1188 \$422 VPWR VGND \$1860 sg13cmos5l_a21oi_1
* cell instance sg13cmos5l_a21oi_1_137 r0 *1 0,0
Xsg13cmos5l_a21oi_1_137 \$1640 \$1625 \$737 VPWR VGND \$1641 sg13cmos5l_a21oi_1
* cell instance sg13cmos5l_a21oi_1_138 r0 *1 0,0
Xsg13cmos5l_a21oi_1_138 \$2864 \$2708 \$2866 VPWR VGND \$3047 sg13cmos5l_a21oi_1
* cell instance sg13cmos5l_a21oi_1_139 r0 *1 0,0
Xsg13cmos5l_a21oi_1_139 \$25 \$27 \$28 VPWR VGND \$9 sg13cmos5l_a21oi_1
* cell instance sg13cmos5l_a21oi_1_140 r0 *1 0,0
Xsg13cmos5l_a21oi_1_140 \$52 \$305 \$435 VPWR VGND \$434 sg13cmos5l_a21oi_1
* cell instance sg13cmos5l_a21oi_1_141 r0 *1 0,0
Xsg13cmos5l_a21oi_1_141 \$1769 \$1765 \$730 VPWR VGND \$1865 sg13cmos5l_a21oi_1
* cell instance sg13cmos5l_a21oi_1_142 r0 *1 0,0
Xsg13cmos5l_a21oi_1_142 \$132 \$222 \$183 VPWR VGND \$235 sg13cmos5l_a21oi_1
* cell instance sg13cmos5l_a21oi_1_143 r0 *1 0,0
Xsg13cmos5l_a21oi_1_143 \$279 \$453 \$845 VPWR VGND \$1192 sg13cmos5l_a21oi_1
* cell instance sg13cmos5l_a21oi_1_144 r0 *1 0,0
Xsg13cmos5l_a21oi_1_144 \$353 \$614 \$465 VPWR VGND \$611 sg13cmos5l_a21oi_1
* cell instance sg13cmos5l_a21oi_1_145 r0 *1 0,0
Xsg13cmos5l_a21oi_1_145 \$140 \$142 \$1639 VPWR VGND \$1066 sg13cmos5l_a21oi_1
* cell instance sg13cmos5l_a21oi_1_146 r0 *1 0,0
Xsg13cmos5l_a21oi_1_146 \$76 \$119 \$465 VPWR VGND \$313 sg13cmos5l_a21oi_1
* cell instance sg13cmos5l_a21oi_1_147 r0 *1 0,0
Xsg13cmos5l_a21oi_1_147 \$24 \$52 \$614 VPWR VGND \$615 sg13cmos5l_a21oi_1
* cell instance sg13cmos5l_a21oi_1_148 r0 *1 0,0
Xsg13cmos5l_a21oi_1_148 \$3473 \$3152 \$3583 VPWR VGND \$3753 sg13cmos5l_a21oi_1
* cell instance sg13cmos5l_a21oi_1_149 r0 *1 0,0
Xsg13cmos5l_a21oi_1_149 \$3968 \$3034 \$4401 VPWR VGND \$4398 sg13cmos5l_a21oi_1
* cell instance sg13cmos5l_a21oi_1_150 r0 *1 0,0
Xsg13cmos5l_a21oi_1_150 \$985 \$986 \$76 VPWR VGND \$305 sg13cmos5l_a21oi_1
* cell instance sg13cmos5l_a21oi_1_151 r0 *1 0,0
Xsg13cmos5l_a21oi_1_151 \$135 \$228 \$237 VPWR VGND \$241 sg13cmos5l_a21oi_1
* cell instance sg13cmos5l_a21oi_1_152 r0 *1 0,0
Xsg13cmos5l_a21oi_1_152 \$1067 \$1192 \$976 VPWR VGND \$1070 sg13cmos5l_a21oi_1
* cell instance sg13cmos5l_a21oi_1_153 r0 *1 0,0
Xsg13cmos5l_a21oi_1_153 \$1993 \$1526 \$1648 VPWR VGND \$1423 sg13cmos5l_a21oi_1
* cell instance sg13cmos5l_a21oi_1_154 r0 *1 0,0
Xsg13cmos5l_a21oi_1_154 \$442 \$1312 \$1650 VPWR VGND \$1648 sg13cmos5l_a21oi_1
* cell instance sg13cmos5l_a21oi_1_155 r0 *1 0,0
Xsg13cmos5l_a21oi_1_155 \$355 \$182 \$1650 VPWR VGND \$1870 sg13cmos5l_a21oi_1
* cell instance sg13cmos5l_a21oi_1_156 r0 *1 0,0
Xsg13cmos5l_a21oi_1_156 \$81 \$163 \$1664 VPWR VGND \$1421 sg13cmos5l_a21oi_1
* cell instance sg13cmos5l_a21oi_1_157 r0 *1 0,0
Xsg13cmos5l_a21oi_1_157 \$89 \$421 \$614 VPWR VGND \$983 sg13cmos5l_a21oi_1
* cell instance sg13cmos5l_a21oi_1_158 r0 *1 0,0
Xsg13cmos5l_a21oi_1_158 \$248 \$128 \$446 VPWR VGND \$246 sg13cmos5l_a21oi_1
* cell instance sg13cmos5l_a21oi_1_159 r0 *1 0,0
Xsg13cmos5l_a21oi_1_159 \$189 \$190 \$183 VPWR VGND \$248 sg13cmos5l_a21oi_1
* cell instance sg13cmos5l_a21oi_1_160 r0 *1 0,0
Xsg13cmos5l_a21oi_1_160 \$353 \$614 \$1410 VPWR VGND \$1872 sg13cmos5l_a21oi_1
* cell instance sg13cmos5l_a21oi_1_161 r0 *1 0,0
Xsg13cmos5l_a21oi_1_161 \$856 \$832 \$378 VPWR VGND \$150 sg13cmos5l_a21oi_1
* cell instance sg13cmos5l_a21oi_1_162 r0 *1 0,0
Xsg13cmos5l_a21oi_1_162 \$865 \$433 \$745 VPWR VGND \$860 sg13cmos5l_a21oi_1
* cell instance sg13cmos5l_a21oi_1_163 r0 *1 0,0
Xsg13cmos5l_a21oi_1_163 \$393 \$1079 \$418 VPWR VGND \$1092 sg13cmos5l_a21oi_1
* cell instance sg13cmos5l_a21oi_1_164 r0 *1 0,0
Xsg13cmos5l_a21oi_1_164 \$280 \$205 \$195 VPWR VGND \$282 sg13cmos5l_a21oi_1
* cell instance sg13cmos5l_a21oi_1_165 r0 *1 0,0
Xsg13cmos5l_a21oi_1_165 \$142 \$1655 \$865 VPWR VGND \$621 sg13cmos5l_a21oi_1
* cell instance sg13cmos5l_a21oi_1_166 r0 *1 0,0
Xsg13cmos5l_a21oi_1_166 \$528 \$529 \$482 VPWR VGND \$456 sg13cmos5l_a21oi_1
* cell instance sg13cmos5l_a21oi_1_167 r0 *1 0,0
Xsg13cmos5l_a21oi_1_167 \$78 \$368 \$19 VPWR VGND \$366 sg13cmos5l_a21oi_1
* cell instance sg13cmos5l_a21oi_1_168 r0 *1 0,0
Xsg13cmos5l_a21oi_1_168 \$864 \$747 \$319 VPWR VGND \$862 sg13cmos5l_a21oi_1
* cell instance sg13cmos5l_a21oi_1_169 r0 *1 0,0
Xsg13cmos5l_a21oi_1_169 \$747 \$623 \$976 VPWR VGND \$529 sg13cmos5l_a21oi_1
* cell instance sg13cmos5l_a21oi_1_170 r0 *1 0,0
Xsg13cmos5l_a21oi_1_170 \$986 \$1879 \$985 VPWR VGND \$1307 sg13cmos5l_a21oi_1
* cell instance sg13cmos5l_a21oi_1_171 r0 *1 0,0
Xsg13cmos5l_a21oi_1_171 \$331 \$197 \$319 VPWR VGND \$329 sg13cmos5l_a21oi_1
* cell instance sg13cmos5l_a21oi_1_172 r0 *1 0,0
Xsg13cmos5l_a21oi_1_172 \$81 \$421 \$331 VPWR VGND \$747 sg13cmos5l_a21oi_1
* cell instance sg13cmos5l_a21oi_1_173 r0 *1 0,0
Xsg13cmos5l_a21oi_1_173 \$533 \$84 \$284 VPWR VGND \$190 sg13cmos5l_a21oi_1
* cell instance sg13cmos5l_a21oi_1_174 r0 *1 0,0
Xsg13cmos5l_a21oi_1_174 \$388 \$453 \$449 VPWR VGND \$458 sg13cmos5l_a21oi_1
* cell instance sg13cmos5l_a21oi_1_175 r0 *1 0,0
Xsg13cmos5l_a21oi_1_175 \$433 \$621 \$282 VPWR VGND \$403 sg13cmos5l_a21oi_1
* cell instance sg13cmos5l_a21oi_1_176 r0 *1 0,0
Xsg13cmos5l_a21oi_1_176 \$331 \$1314 \$599 VPWR VGND \$2127 sg13cmos5l_a21oi_1
* cell instance sg13cmos5l_a21oi_1_177 r0 *1 0,0
Xsg13cmos5l_a21oi_1_177 \$19 \$173 \$331 VPWR VGND \$441 sg13cmos5l_a21oi_1
* cell instance sg13cmos5l_a21oi_1_178 r0 *1 0,0
Xsg13cmos5l_a21oi_1_178 \$1079 \$1082 \$8 VPWR VGND \$999 sg13cmos5l_a21oi_1
* cell instance sg13cmos5l_a21oi_1_179 r0 *1 0,0
Xsg13cmos5l_a21oi_1_179 \$1314 \$437 \$159 VPWR VGND \$1000 sg13cmos5l_a21oi_1
* cell instance sg13cmos5l_a221oi_1_0 r0 *1 0,0
Xsg13cmos5l_a221oi_1_0 \$2593 \$2400 \$2266 \$2411 \$2409 VPWR VGND \$2264
+ sg13cmos5l_a221oi_1
* cell instance sg13cmos5l_a221oi_1_1 r0 *1 0,0
Xsg13cmos5l_a221oi_1_1 \$3275 \$2930 \$2565 \$2928 \$2924 VPWR VGND \$2926
+ sg13cmos5l_a221oi_1
* cell instance sg13cmos5l_a221oi_1_2 r0 *1 0,0
Xsg13cmos5l_a221oi_1_2 \$2257 \$3127 \$3116 \$1234 \$3113 VPWR VGND \$3112
+ sg13cmos5l_a221oi_1
* cell instance sg13cmos5l_a221oi_1_3 r0 *1 0,0
Xsg13cmos5l_a221oi_1_3 \$3117 \$3127 \$2930 \$2254 \$3113 VPWR VGND \$3118
+ sg13cmos5l_a221oi_1
* cell instance sg13cmos5l_a221oi_1_4 r0 *1 0,0
Xsg13cmos5l_a221oi_1_4 \$2406 \$2419 \$2415 \$2411 \$2416 VPWR VGND \$2143
+ sg13cmos5l_a221oi_1
* cell instance sg13cmos5l_a221oi_1_5 r0 *1 0,0
Xsg13cmos5l_a221oi_1_5 \$6586 \$4985 \$6057 \$6627 \$6081 VPWR VGND \$6588
+ sg13cmos5l_a221oi_1
* cell instance sg13cmos5l_a221oi_1_6 r0 *1 0,0
Xsg13cmos5l_a221oi_1_6 \$2254 \$3116 \$2930 \$1159 \$3113 VPWR VGND \$3128
+ sg13cmos5l_a221oi_1
* cell instance sg13cmos5l_a221oi_1_7 r0 *1 0,0
Xsg13cmos5l_a221oi_1_7 \$1159 \$3116 \$2930 \$1716 \$3113 VPWR VGND \$4112
+ sg13cmos5l_a221oi_1
* cell instance sg13cmos5l_a221oi_1_8 r0 *1 0,0
Xsg13cmos5l_a221oi_1_8 \$1915 \$1701 \$1565 \$1913 \$2022 VPWR VGND \$920
+ sg13cmos5l_a221oi_1
* cell instance sg13cmos5l_a221oi_1_9 r0 *1 0,0
Xsg13cmos5l_a221oi_1_9 \$874 \$803 \$802 \$686 \$799 VPWR VGND \$798
+ sg13cmos5l_a221oi_1
* cell instance sg13cmos5l_a221oi_1_10 r0 *1 0,0
Xsg13cmos5l_a221oi_1_10 \$2431 \$2426 \$2282 \$2281 \$2428 VPWR VGND \$1701
+ sg13cmos5l_a221oi_1
* cell instance sg13cmos5l_a221oi_1_11 r0 *1 0,0
Xsg13cmos5l_a221oi_1_11 \$646 \$803 \$802 \$632 \$799 VPWR VGND \$926
+ sg13cmos5l_a221oi_1
* cell instance sg13cmos5l_a221oi_1_12 r0 *1 0,0
Xsg13cmos5l_a221oi_1_12 \$2254 \$1231 \$1131 \$1036 \$1135 VPWR VGND \$1139
+ sg13cmos5l_a221oi_1
* cell instance sg13cmos5l_a221oi_1_13 r0 *1 0,0
Xsg13cmos5l_a221oi_1_13 \$3275 \$1240 \$1131 \$805 \$1149 VPWR VGND \$1241
+ sg13cmos5l_a221oi_1
* cell instance sg13cmos5l_a221oi_1_14 r0 *1 0,0
Xsg13cmos5l_a221oi_1_14 \$1041 \$803 \$802 \$701 \$669 VPWR VGND \$1038
+ sg13cmos5l_a221oi_1
* cell instance sg13cmos5l_a221oi_1_15 r0 *1 0,0
Xsg13cmos5l_a221oi_1_15 \$2177 \$2175 \$1934 \$2162 \$2179 VPWR VGND \$2178
+ sg13cmos5l_a221oi_1
* cell instance sg13cmos5l_a221oi_1_16 r0 *1 0,0
Xsg13cmos5l_a221oi_1_16 \$1250 \$1231 \$1131 \$1245 \$1135 VPWR VGND \$1247
+ sg13cmos5l_a221oi_1
* cell instance sg13cmos5l_a221oi_1_17 r0 *1 0,0
Xsg13cmos5l_a221oi_1_17 \$1159 \$1240 \$1131 \$940 \$1149 VPWR VGND \$1156
+ sg13cmos5l_a221oi_1
* cell instance sg13cmos5l_a221oi_1_18 r0 *1 0,0
Xsg13cmos5l_a221oi_1_18 \$1716 \$1231 \$1131 \$1600 \$1135 VPWR VGND \$1713
+ sg13cmos5l_a221oi_1
* cell instance sg13cmos5l_a221oi_1_19 r0 *1 0,0
Xsg13cmos5l_a221oi_1_19 \$1488 \$1231 \$1131 \$1485 \$1135 VPWR VGND \$1310
+ sg13cmos5l_a221oi_1
* cell instance sg13cmos5l_a221oi_1_20 r0 *1 0,0
Xsg13cmos5l_a221oi_1_20 \$209 \$160 \$155 \$18 \$159 VPWR VGND \$206
+ sg13cmos5l_a221oi_1
* cell instance sg13cmos5l_a221oi_1_21 r0 *1 0,0
Xsg13cmos5l_a221oi_1_21 \$1042 \$1156 \$1150 \$947 \$946 VPWR VGND \$340
+ sg13cmos5l_a221oi_1
* cell instance sg13cmos5l_a221oi_1_22 r0 *1 0,0
Xsg13cmos5l_a221oi_1_22 \$17113 \$6644 \$7225 \$17108 \$3843 VPWR VGND \$4693
+ sg13cmos5l_a221oi_1
* cell instance sg13cmos5l_a221oi_1_23 r0 *1 0,0
Xsg13cmos5l_a221oi_1_23 \$3990 \$3840 \$2945 \$3870 \$3978 VPWR VGND \$3987
+ sg13cmos5l_a221oi_1
* cell instance sg13cmos5l_a221oi_1_24 r0 *1 0,0
Xsg13cmos5l_a221oi_1_24 \$1401 \$1192 \$1051 \$1399 \$825 VPWR VGND \$1273
+ sg13cmos5l_a221oi_1
* cell instance sg13cmos5l_a221oi_1_25 r0 *1 0,0
Xsg13cmos5l_a221oi_1_25 \$164 \$300 \$265 \$41 \$216 VPWR VGND \$262
+ sg13cmos5l_a221oi_1
* cell instance sg13cmos5l_a221oi_1_26 r0 *1 0,0
Xsg13cmos5l_a221oi_1_26 \$54 \$835 \$279 \$881 \$832 VPWR VGND \$724
+ sg13cmos5l_a221oi_1
* cell instance sg13cmos5l_a221oi_1_27 r0 *1 0,0
Xsg13cmos5l_a221oi_1_27 \$64 \$300 \$384 \$193 \$335 VPWR VGND \$381
+ sg13cmos5l_a221oi_1
* cell instance sg13cmos5l_a221oi_1_28 r0 *1 0,0
Xsg13cmos5l_a221oi_1_28 \$731 \$1283 \$1192 \$218 \$719 VPWR VGND \$594
+ sg13cmos5l_a221oi_1
* cell instance sg13cmos5l_a221oi_1_29 r0 *1 0,0
Xsg13cmos5l_a221oi_1_29 \$386 \$599 \$595 \$346 \$518 VPWR VGND \$596
+ sg13cmos5l_a221oi_1
* cell instance sg13cmos5l_a221oi_1_30 r0 *1 0,0
Xsg13cmos5l_a221oi_1_30 \$386 \$599 \$174 \$221 \$518 VPWR VGND \$517
+ sg13cmos5l_a221oi_1
* cell instance sg13cmos5l_a221oi_1_31 r0 *1 0,0
Xsg13cmos5l_a221oi_1_31 \$164 \$114 \$39 \$117 \$159 VPWR VGND \$166
+ sg13cmos5l_a221oi_1
* cell instance sg13cmos5l_a221oi_1_32 r0 *1 0,0
Xsg13cmos5l_a221oi_1_32 \$221 \$971 \$599 \$386 \$518 VPWR VGND \$965
+ sg13cmos5l_a221oi_1
* cell instance sg13cmos5l_a221oi_1_33 r0 *1 0,0
Xsg13cmos5l_a221oi_1_33 \$193 \$1183 \$1287 \$100 \$1289 VPWR VGND \$1288
+ sg13cmos5l_a221oi_1
* cell instance sg13cmos5l_a221oi_1_34 r0 *1 0,0
Xsg13cmos5l_a221oi_1_34 \$218 \$361 \$226 \$604 \$730 VPWR VGND \$602
+ sg13cmos5l_a221oi_1
* cell instance sg13cmos5l_a221oi_1_35 r0 *1 0,0
Xsg13cmos5l_a221oi_1_35 \$148 \$164 \$32 \$117 \$465 VPWR VGND \$361
+ sg13cmos5l_a221oi_1
* cell instance sg13cmos5l_a221oi_1_36 r0 *1 0,0
Xsg13cmos5l_a221oi_1_36 \$1993 \$1521 \$2111 \$1519 \$1991 VPWR VGND \$2108
+ sg13cmos5l_a221oi_1
* cell instance sg13cmos5l_a221oi_1_37 r0 *1 0,0
Xsg13cmos5l_a221oi_1_37 \$266 \$278 \$205 \$305 \$231 VPWR VGND \$271
+ sg13cmos5l_a221oi_1
* cell instance sg13cmos5l_a221oi_1_38 r0 *1 0,0
Xsg13cmos5l_a221oi_1_38 \$292 \$123 \$726 \$260 \$526 VPWR VGND \$215
+ sg13cmos5l_a221oi_1
* cell instance sg13cmos5l_a221oi_1_39 r0 *1 0,0
Xsg13cmos5l_a221oi_1_39 \$77 \$433 \$278 \$266 \$307 VPWR VGND \$308
+ sg13cmos5l_a221oi_1
* cell instance sg13cmos5l_a221oi_1_40 r0 *1 0,0
Xsg13cmos5l_a221oi_1_40 \$1401 \$979 \$1063 \$434 \$976 VPWR VGND \$609
+ sg13cmos5l_a221oi_1
* cell instance sg13cmos5l_a221oi_1_41 r0 *1 0,0
Xsg13cmos5l_a221oi_1_41 \$266 \$182 \$41 \$230 \$231 VPWR VGND \$124
+ sg13cmos5l_a221oi_1
* cell instance sg13cmos5l_a221oi_1_42 r0 *1 0,0
Xsg13cmos5l_a221oi_1_42 \$979 \$991 \$360 \$1065 \$521 VPWR VGND \$1189
+ sg13cmos5l_a221oi_1
* cell instance sg13cmos5l_a221oi_1_43 r0 *1 0,0
Xsg13cmos5l_a221oi_1_43 \$193 \$129 \$69 \$126 \$124 VPWR VGND \$128
+ sg13cmos5l_a221oi_1
* cell instance sg13cmos5l_a221oi_1_44 r0 *1 0,0
Xsg13cmos5l_a221oi_1_44 \$465 \$241 \$313 \$25 \$315 VPWR VGND \$311
+ sg13cmos5l_a221oi_1
* cell instance sg13cmos5l_a221oi_1_45 r0 *1 0,0
Xsg13cmos5l_a221oi_1_45 \$135 \$228 \$75 \$237 \$292 VPWR VGND \$238
+ sg13cmos5l_a221oi_1
* cell instance sg13cmos5l_a221oi_1_46 r0 *1 0,0
Xsg13cmos5l_a221oi_1_46 \$292 \$442 \$441 \$439 \$976 VPWR VGND \$373
+ sg13cmos5l_a221oi_1
* cell instance sg13cmos5l_a221oi_1_47 r0 *1 0,0
Xsg13cmos5l_a221oi_1_47 \$318 \$60 \$324 \$322 \$320 VPWR VGND \$293
+ sg13cmos5l_a221oi_1
* cell instance sg13cmos5l_a221oi_1_48 r0 *1 0,0
Xsg13cmos5l_a221oi_1_48 \$1073 \$990 \$1072 \$1070 \$422 VPWR VGND \$982
+ sg13cmos5l_a221oi_1
* cell instance sg13cmos5l_a221oi_1_49 r0 *1 0,0
Xsg13cmos5l_a221oi_1_49 \$189 \$190 \$14 \$126 \$183 VPWR VGND \$186
+ sg13cmos5l_a221oi_1
* cell instance sg13cmos5l_a221oi_1_50 r0 *1 0,0
Xsg13cmos5l_a221oi_1_50 \$183 \$1092 \$983 \$1870 \$2114 VPWR VGND \$1862
+ sg13cmos5l_a221oi_1
* cell instance sg13cmos5l_a221oi_1_51 r0 *1 0,0
Xsg13cmos5l_a221oi_1_51 \$148 \$887 \$852 \$1421 \$319 VPWR VGND \$325
+ sg13cmos5l_a221oi_1
* cell instance sg13cmos5l_a221oi_1_52 r0 *1 0,0
Xsg13cmos5l_a221oi_1_52 \$434 \$451 \$622 \$449 \$447 VPWR VGND \$446
+ sg13cmos5l_a221oi_1
* cell instance sg13cmos5l_a221oi_1_53 r0 *1 0,0
Xsg13cmos5l_a221oi_1_53 \$79 \$148 \$739 \$64 \$418 VPWR VGND \$326
+ sg13cmos5l_a221oi_1
* cell instance sg13cmos5l_a221oi_1_54 r0 *1 0,0
Xsg13cmos5l_a221oi_1_54 \$985 \$281 \$832 \$856 \$449 VPWR VGND \$857
+ sg13cmos5l_a221oi_1
* cell instance sg13cmos5l_a221oi_1_55 r0 *1 0,0
Xsg13cmos5l_a221oi_1_55 \$845 \$182 \$1312 \$1428 \$1162 VPWR VGND \$1429
+ sg13cmos5l_a221oi_1
* cell instance sg13cmos5l_a221oi_1_56 r0 *1 0,0
Xsg13cmos5l_a221oi_1_56 \$1200 \$862 \$1077 \$126 \$364 VPWR VGND \$1074
+ sg13cmos5l_a221oi_1
* cell instance sg13cmos5l_a221oi_1_57 r0 *1 0,0
Xsg13cmos5l_a221oi_1_57 \$195 \$32 \$194 \$366 \$378 VPWR VGND \$364
+ sg13cmos5l_a221oi_1
* cell instance sg13cmos5l_a221oi_1_58 r0 *1 0,0
Xsg13cmos5l_a221oi_1_58 \$1875 \$1658 \$1657 \$726 \$737 VPWR VGND \$1656
+ sg13cmos5l_a221oi_1
* cell instance sg13cmos5l_a221oi_1_59 r0 *1 0,0
Xsg13cmos5l_a221oi_1_59 \$195 \$355 \$358 \$433 \$453 VPWR VGND \$452
+ sg13cmos5l_a221oi_1
* cell instance sg13cmos5l_a221oi_1_60 r0 *1 0,0
Xsg13cmos5l_a221oi_1_60 \$726 \$2124 \$1878 \$974 \$2120 VPWR VGND \$2121
+ sg13cmos5l_a221oi_1
* cell instance sg13cmos5l_a221oi_1_61 r0 *1 0,0
Xsg13cmos5l_a221oi_1_61 \$340 \$1195 \$1301 \$1304 \$322 VPWR VGND \$1302
+ sg13cmos5l_a221oi_1
* cell instance sg13cmos5l_a221oi_1_62 r0 *1 0,0
Xsg13cmos5l_a221oi_1_62 \$353 \$614 \$366 \$388 \$449 VPWR VGND \$889
+ sg13cmos5l_a221oi_1
* cell instance sg13cmos5l_a221oi_1_63 r0 *1 0,0
Xsg13cmos5l_a221oi_1_63 \$449 \$403 \$402 \$458 \$447 VPWR VGND \$400
+ sg13cmos5l_a221oi_1
* cell instance sg13cmos5l_a221oi_1_64 r0 *1 0,0
Xsg13cmos5l_a221oi_1_64 \$1201 \$835 \$198 \$621 \$1664 VPWR VGND \$1663
+ sg13cmos5l_a221oi_1
* cell instance sg13cmos5l_a221oi_1_65 r0 *1 0,0
Xsg13cmos5l_a221oi_1_65 \$25 \$441 \$458 \$604 \$949 VPWR VGND \$626
+ sg13cmos5l_a221oi_1
* cell instance sg13cmos5l_a22oi_1_0 r0 *1 0,0
Xsg13cmos5l_a22oi_1_0 \$4095 \$3127 \$2930 \$3962 VPWR VGND \$4317
+ sg13cmos5l_a22oi_1
* cell instance sg13cmos5l_a22oi_1_1 r0 *1 0,0
Xsg13cmos5l_a22oi_1_1 \$3612 \$2607 \$3116 \$3275 VPWR VGND \$3801
+ sg13cmos5l_a22oi_1
* cell instance sg13cmos5l_a22oi_1_2 r0 *1 0,0
Xsg13cmos5l_a22oi_1_2 \$7204 \$6644 \$7157 \$7176 VPWR VGND \$2257
+ sg13cmos5l_a22oi_1
* cell instance sg13cmos5l_a22oi_1_3 r0 *1 0,0
Xsg13cmos5l_a22oi_1_3 \$1013 \$891 \$1015 \$872 VPWR VGND \$1016
+ sg13cmos5l_a22oi_1
* cell instance sg13cmos5l_a22oi_1_4 r0 *1 0,0
Xsg13cmos5l_a22oi_1_4 \$6626 \$2610 \$6387 \$6388 VPWR VGND \$3612
+ sg13cmos5l_a22oi_1
* cell instance sg13cmos5l_a22oi_1_5 r0 *1 0,0
Xsg13cmos5l_a22oi_1_5 \$2753 \$2400 \$3804 \$2928 VPWR VGND \$3800
+ sg13cmos5l_a22oi_1
* cell instance sg13cmos5l_a22oi_1_6 r0 *1 0,0
Xsg13cmos5l_a22oi_1_6 \$4432 \$2755 \$3127 \$4322 VPWR VGND \$4434
+ sg13cmos5l_a22oi_1
* cell instance sg13cmos5l_a22oi_1_7 r0 *1 0,0
Xsg13cmos5l_a22oi_1_7 \$5865 \$2610 \$5867 \$5896 VPWR VGND \$3117
+ sg13cmos5l_a22oi_1
* cell instance sg13cmos5l_a22oi_1_8 r0 *1 0,0
Xsg13cmos5l_a22oi_1_8 \$7239 \$5024 \$5898 \$7283 VPWR VGND \$7176
+ sg13cmos5l_a22oi_1
* cell instance sg13cmos5l_a22oi_1_9 r0 *1 0,0
Xsg13cmos5l_a22oi_1_9 \$6586 \$2433 \$5898 \$6627 VPWR VGND \$6388
+ sg13cmos5l_a22oi_1
* cell instance sg13cmos5l_a22oi_1_10 r0 *1 0,0
Xsg13cmos5l_a22oi_1_10 \$5868 \$2433 \$5898 \$6018 VPWR VGND \$5896
+ sg13cmos5l_a22oi_1
* cell instance sg13cmos5l_a22oi_1_11 r0 *1 0,0
Xsg13cmos5l_a22oi_1_11 \$2598 \$2400 \$2564 \$2928 VPWR VGND \$2761
+ sg13cmos5l_a22oi_1
* cell instance sg13cmos5l_a22oi_1_12 r0 *1 0,0
Xsg13cmos5l_a22oi_1_12 \$6626 \$6081 \$6337 \$6588 VPWR VGND \$6587
+ sg13cmos5l_a22oi_1
* cell instance sg13cmos5l_a22oi_1_13 r0 *1 0,0
Xsg13cmos5l_a22oi_1_13 \$5865 \$6081 \$6021 \$6027 VPWR VGND \$3806
+ sg13cmos5l_a22oi_1
* cell instance sg13cmos5l_a22oi_1_14 r0 *1 0,0
Xsg13cmos5l_a22oi_1_14 \$1895 \$2148 \$2146 \$2147 VPWR VGND \$1771
+ sg13cmos5l_a22oi_1
* cell instance sg13cmos5l_a22oi_1_15 r0 *1 0,0
Xsg13cmos5l_a22oi_1_15 \$5868 \$6082 \$6389 \$5584 VPWR VGND \$6027
+ sg13cmos5l_a22oi_1
* cell instance sg13cmos5l_a22oi_1_16 r0 *1 0,0
Xsg13cmos5l_a22oi_1_16 \$899 \$1458 \$1330 \$1332 VPWR VGND \$1456
+ sg13cmos5l_a22oi_1
* cell instance sg13cmos5l_a22oi_1_17 r0 *1 0,0
Xsg13cmos5l_a22oi_1_17 \$6390 \$6082 \$6389 \$6863 VPWR VGND \$6391
+ sg13cmos5l_a22oi_1
* cell instance sg13cmos5l_a22oi_1_18 r0 *1 0,0
Xsg13cmos5l_a22oi_1_18 \$899 \$1117 \$907 \$1113 VPWR VGND \$1116
+ sg13cmos5l_a22oi_1
* cell instance sg13cmos5l_a22oi_1_19 r0 *1 0,0
Xsg13cmos5l_a22oi_1_19 \$3815 \$3127 \$3116 \$3962 VPWR VGND \$3818
+ sg13cmos5l_a22oi_1
* cell instance sg13cmos5l_a22oi_1_20 r0 *1 0,0
Xsg13cmos5l_a22oi_1_20 \$7260 \$5898 \$7225 \$7256 VPWR VGND \$7207
+ sg13cmos5l_a22oi_1
* cell instance sg13cmos5l_a22oi_1_21 r0 *1 0,0
Xsg13cmos5l_a22oi_1_21 \$1716 \$3116 \$2930 \$1488 VPWR VGND \$4116
+ sg13cmos5l_a22oi_1
* cell instance sg13cmos5l_a22oi_1_22 r0 *1 0,0
Xsg13cmos5l_a22oi_1_22 \$6629 \$5898 \$7225 \$6863 VPWR VGND \$6592
+ sg13cmos5l_a22oi_1
* cell instance sg13cmos5l_a22oi_1_23 r0 *1 0,0
Xsg13cmos5l_a22oi_1_23 \$796 \$925 \$797 \$918 VPWR VGND \$917
+ sg13cmos5l_a22oi_1
* cell instance sg13cmos5l_a22oi_1_24 r0 *1 0,0
Xsg13cmos5l_a22oi_1_24 \$8861 \$7225 \$4343 \$3452 VPWR VGND \$9000
+ sg13cmos5l_a22oi_1
* cell instance sg13cmos5l_a22oi_1_25 r0 *1 0,0
Xsg13cmos5l_a22oi_1_25 \$4454 \$2782 \$1913 \$9578 VPWR VGND \$3825
+ sg13cmos5l_a22oi_1
* cell instance sg13cmos5l_a22oi_1_26 r0 *1 0,0
Xsg13cmos5l_a22oi_1_26 \$690 \$925 \$923 \$918 VPWR VGND \$924
+ sg13cmos5l_a22oi_1
* cell instance sg13cmos5l_a22oi_1_27 r0 *1 0,0
Xsg13cmos5l_a22oi_1_27 \$1327 \$803 \$802 \$1368 VPWR VGND \$1235
+ sg13cmos5l_a22oi_1
* cell instance sg13cmos5l_a22oi_1_28 r0 *1 0,0
Xsg13cmos5l_a22oi_1_28 \$932 \$1797 \$1691 \$1800 VPWR VGND \$1799
+ sg13cmos5l_a22oi_1
* cell instance sg13cmos5l_a22oi_1_29 r0 *1 0,0
Xsg13cmos5l_a22oi_1_29 \$3973 \$2782 \$1913 \$3976 VPWR VGND \$3975
+ sg13cmos5l_a22oi_1
* cell instance sg13cmos5l_a22oi_1_30 r0 *1 0,0
Xsg13cmos5l_a22oi_1_30 \$4456 \$2782 \$1913 \$11910 VPWR VGND \$4458
+ sg13cmos5l_a22oi_1
* cell instance sg13cmos5l_a22oi_1_31 r0 *1 0,0
Xsg13cmos5l_a22oi_1_31 \$1483 \$925 \$1479 \$918 VPWR VGND \$1476
+ sg13cmos5l_a22oi_1
* cell instance sg13cmos5l_a22oi_1_32 r0 *1 0,0
Xsg13cmos5l_a22oi_1_32 \$4136 \$3840 \$3297 \$4290 VPWR VGND \$4138
+ sg13cmos5l_a22oi_1
* cell instance sg13cmos5l_a22oi_1_33 r0 *1 0,0
Xsg13cmos5l_a22oi_1_33 \$1593 \$803 \$802 \$1483 VPWR VGND \$1591
+ sg13cmos5l_a22oi_1
* cell instance sg13cmos5l_a22oi_1_34 r0 *1 0,0
Xsg13cmos5l_a22oi_1_34 \$1149 \$934 \$1146 \$1241 VPWR VGND \$1150
+ sg13cmos5l_a22oi_1
* cell instance sg13cmos5l_a22oi_1_35 r0 *1 0,0
Xsg13cmos5l_a22oi_1_35 \$1460 \$3298 \$3840 \$3308 VPWR VGND \$3307
+ sg13cmos5l_a22oi_1
* cell instance sg13cmos5l_a22oi_1_36 r0 *1 0,0
Xsg13cmos5l_a22oi_1_36 \$4139 \$2945 \$3297 \$4426 VPWR VGND \$4141
+ sg13cmos5l_a22oi_1
* cell instance sg13cmos5l_a22oi_1_37 r0 *1 0,0
Xsg13cmos5l_a22oi_1_37 \$1373 \$803 \$802 \$1151 VPWR VGND \$1374
+ sg13cmos5l_a22oi_1
* cell instance sg13cmos5l_a22oi_1_38 r0 *1 0,0
Xsg13cmos5l_a22oi_1_38 \$4344 \$2782 \$1913 \$4336 VPWR VGND \$4346
+ sg13cmos5l_a22oi_1
* cell instance sg13cmos5l_a22oi_1_39 r0 *1 0,0
Xsg13cmos5l_a22oi_1_39 \$935 \$803 \$802 \$704 VPWR VGND \$936
+ sg13cmos5l_a22oi_1
* cell instance sg13cmos5l_a22oi_1_40 r0 *1 0,0
Xsg13cmos5l_a22oi_1_40 \$1594 \$803 \$802 \$1596 VPWR VGND \$1595
+ sg13cmos5l_a22oi_1
* cell instance sg13cmos5l_a22oi_1_41 r0 *1 0,0
Xsg13cmos5l_a22oi_1_41 \$1151 \$925 \$1245 \$918 VPWR VGND \$1246
+ sg13cmos5l_a22oi_1
* cell instance sg13cmos5l_a22oi_1_42 r0 *1 0,0
Xsg13cmos5l_a22oi_1_42 \$1596 \$925 \$1600 \$918 VPWR VGND \$1597
+ sg13cmos5l_a22oi_1
* cell instance sg13cmos5l_a22oi_1_43 r0 *1 0,0
Xsg13cmos5l_a22oi_1_43 \$3690 \$3840 \$3297 \$3827 VPWR VGND \$3839
+ sg13cmos5l_a22oi_1
* cell instance sg13cmos5l_a22oi_1_44 r0 *1 0,0
Xsg13cmos5l_a22oi_1_44 \$4025 \$2945 \$3297 \$4144 VPWR VGND \$4143
+ sg13cmos5l_a22oi_1
* cell instance sg13cmos5l_a22oi_1_45 r0 *1 0,0
Xsg13cmos5l_a22oi_1_45 \$704 \$925 \$940 \$918 VPWR VGND \$941
+ sg13cmos5l_a22oi_1
* cell instance sg13cmos5l_a22oi_1_46 r0 *1 0,0
Xsg13cmos5l_a22oi_1_46 \$3499 \$2945 \$3297 \$3480 VPWR VGND \$3459
+ sg13cmos5l_a22oi_1
* cell instance sg13cmos5l_a22oi_1_47 r0 *1 0,0
Xsg13cmos5l_a22oi_1_47 \$3648 \$1913 \$2775 \$2444 VPWR VGND \$3649
+ sg13cmos5l_a22oi_1
* cell instance sg13cmos5l_a22oi_1_48 r0 *1 0,0
Xsg13cmos5l_a22oi_1_48 \$2202 \$2610 \$7183 \$17040 VPWR VGND \$2902
+ sg13cmos5l_a22oi_1
* cell instance sg13cmos5l_a22oi_1_49 r0 *1 0,0
Xsg13cmos5l_a22oi_1_49 \$4145 \$2440 \$1913 \$5004 VPWR VGND \$3984
+ sg13cmos5l_a22oi_1
* cell instance sg13cmos5l_a22oi_1_50 r0 *1 0,0
Xsg13cmos5l_a22oi_1_50 \$339 \$409 \$296 \$408 VPWR VGND \$406
+ sg13cmos5l_a22oi_1
* cell instance sg13cmos5l_a22oi_1_51 r0 *1 0,0
Xsg13cmos5l_a22oi_1_51 \$17105 \$6644 \$7183 \$17099 VPWR VGND \$2904
+ sg13cmos5l_a22oi_1
* cell instance sg13cmos5l_a22oi_1_52 r0 *1 0,0
Xsg13cmos5l_a22oi_1_52 \$17109 \$6644 \$7225 \$17104 VPWR VGND \$3826
+ sg13cmos5l_a22oi_1
* cell instance sg13cmos5l_a22oi_1_53 r0 *1 0,0
Xsg13cmos5l_a22oi_1_53 \$1941 \$1945 \$1943 \$1816 VPWR VGND \$1944
+ sg13cmos5l_a22oi_1
* cell instance sg13cmos5l_a22oi_1_54 r0 *1 0,0
Xsg13cmos5l_a22oi_1_54 \$1974 \$2775 \$2945 \$2961 VPWR VGND \$2960
+ sg13cmos5l_a22oi_1
* cell instance sg13cmos5l_a22oi_1_55 r0 *1 0,0
Xsg13cmos5l_a22oi_1_55 \$3144 \$2197 \$2775 \$2793 VPWR VGND \$3329
+ sg13cmos5l_a22oi_1
* cell instance sg13cmos5l_a22oi_1_56 r0 *1 0,0
Xsg13cmos5l_a22oi_1_56 \$3501 \$2197 \$2945 \$3385 VPWR VGND \$3845
+ sg13cmos5l_a22oi_1
* cell instance sg13cmos5l_a22oi_1_57 r0 *1 0,0
Xsg13cmos5l_a22oi_1_57 \$1967 \$2775 \$2945 \$3151 VPWR VGND \$3141
+ sg13cmos5l_a22oi_1
* cell instance sg13cmos5l_a22oi_1_58 r0 *1 0,0
Xsg13cmos5l_a22oi_1_58 \$3664 \$3840 \$2945 \$3164 VPWR VGND \$3496
+ sg13cmos5l_a22oi_1
* cell instance sg13cmos5l_a22oi_1_59 r0 *1 0,0
Xsg13cmos5l_a22oi_1_59 \$17118 \$6644 \$7225 \$17119 VPWR VGND \$4342
+ sg13cmos5l_a22oi_1
* cell instance sg13cmos5l_a22oi_1_60 r0 *1 0,0
Xsg13cmos5l_a22oi_1_60 \$4165 \$6644 \$7225 \$17117 VPWR VGND \$3638
+ sg13cmos5l_a22oi_1
* cell instance sg13cmos5l_a22oi_1_61 r0 *1 0,0
Xsg13cmos5l_a22oi_1_61 \$169 \$259 \$158 \$353 VPWR VGND \$351
+ sg13cmos5l_a22oi_1
* cell instance sg13cmos5l_a22oi_1_62 r0 *1 0,0
Xsg13cmos5l_a22oi_1_62 \$2197 \$2200 \$2176 \$2177 VPWR VGND \$1983
+ sg13cmos5l_a22oi_1
* cell instance sg13cmos5l_a22oi_1_63 r0 *1 0,0
Xsg13cmos5l_a22oi_1_63 \$65 \$260 \$44 \$36 VPWR VGND \$1053 sg13cmos5l_a22oi_1
* cell instance sg13cmos5l_a22oi_1_64 r0 *1 0,0
Xsg13cmos5l_a22oi_1_64 \$589 \$357 \$591 \$411 VPWR VGND \$592
+ sg13cmos5l_a22oi_1
* cell instance sg13cmos5l_a22oi_1_65 r0 *1 0,0
Xsg13cmos5l_a22oi_1_65 \$881 \$259 \$726 \$7 VPWR VGND \$958 sg13cmos5l_a22oi_1
* cell instance sg13cmos5l_a22oi_1_66 r0 *1 0,0
Xsg13cmos5l_a22oi_1_66 \$569 \$44 \$881 \$1624 VPWR VGND \$1625
+ sg13cmos5l_a22oi_1
* cell instance sg13cmos5l_a22oi_1_67 r0 *1 0,0
Xsg13cmos5l_a22oi_1_67 \$1410 \$1519 \$1853 \$1989 VPWR VGND \$1986
+ sg13cmos5l_a22oi_1
* cell instance sg13cmos5l_a22oi_1_68 r0 *1 0,0
Xsg13cmos5l_a22oi_1_68 \$1635 \$1749 \$1756 \$1633 VPWR VGND \$1757
+ sg13cmos5l_a22oi_1
* cell instance sg13cmos5l_a22oi_1_69 r0 *1 0,0
Xsg13cmos5l_a22oi_1_69 \$422 \$94 \$600 \$424 VPWR VGND \$485 sg13cmos5l_a22oi_1
* cell instance sg13cmos5l_a22oi_1_70 r0 *1 0,0
Xsg13cmos5l_a22oi_1_70 \$2106 \$2108 \$2107 \$1631 VPWR VGND \$2210
+ sg13cmos5l_a22oi_1
* cell instance sg13cmos5l_a22oi_1_71 r0 *1 0,0
Xsg13cmos5l_a22oi_1_71 \$388 \$29 \$305 \$205 VPWR VGND \$255 sg13cmos5l_a22oi_1
* cell instance sg13cmos5l_a22oi_1_72 r0 *1 0,0
Xsg13cmos5l_a22oi_1_72 \$435 \$25 \$1283 \$1522 VPWR VGND \$1521
+ sg13cmos5l_a22oi_1
* cell instance sg13cmos5l_a22oi_1_73 r0 *1 0,0
Xsg13cmos5l_a22oi_1_73 \$1860 \$1757 \$1862 \$1864 VPWR VGND \$1863
+ sg13cmos5l_a22oi_1
* cell instance sg13cmos5l_a22oi_1_74 r0 *1 0,0
Xsg13cmos5l_a22oi_1_74 \$355 \$182 \$278 \$412 VPWR VGND \$392
+ sg13cmos5l_a22oi_1
* cell instance sg13cmos5l_a22oi_1_75 r0 *1 0,0
Xsg13cmos5l_a22oi_1_75 \$1645 \$2115 \$2116 \$312 VPWR VGND \$2000
+ sg13cmos5l_a22oi_1
* cell instance sg13cmos5l_a22oi_1_76 r0 *1 0,0
Xsg13cmos5l_a22oi_1_76 \$980 \$982 \$847 \$610 VPWR VGND \$981
+ sg13cmos5l_a22oi_1
* cell instance sg13cmos5l_a22oi_1_77 r0 *1 0,0
Xsg13cmos5l_a22oi_1_77 \$845 \$1195 \$1184 \$614 VPWR VGND \$1647
+ sg13cmos5l_a22oi_1
* cell instance sg13cmos5l_a22oi_1_78 r0 *1 0,0
Xsg13cmos5l_a22oi_1_78 \$1435 \$329 \$1436 \$189 VPWR VGND \$1304
+ sg13cmos5l_a22oi_1
* cell instance sg13cmos5l_a22oi_1_79 r0 *1 0,0
Xsg13cmos5l_a22oi_1_79 \$145 \$182 \$624 \$1437 VPWR VGND \$1436
+ sg13cmos5l_a22oi_1
* cell instance sg13cmos5l_a22oi_1_80 r0 *1 0,0
Xsg13cmos5l_a22oi_1_80 \$865 \$353 \$182 \$986 VPWR VGND \$1079
+ sg13cmos5l_a22oi_1
* cell instance sg13cmos5l_a22oi_1_81 r0 *1 0,0
Xsg13cmos5l_a22oi_1_81 \$614 \$198 \$453 \$835 VPWR VGND \$1082
+ sg13cmos5l_a22oi_1
* cell instance sg13cmos5l_and2_1_0 r0 *1 0,0
Xsg13cmos5l_and2_1_0 \$2254 \$2257 VPWR VGND \$2592 sg13cmos5l_and2_1
* cell instance sg13cmos5l_and2_1_1 r0 *1 0,0
Xsg13cmos5l_and2_1_1 \$1716 \$4095 VPWR VGND \$4097 sg13cmos5l_and2_1
* cell instance sg13cmos5l_and2_1_2 r0 *1 0,0
Xsg13cmos5l_and2_1_2 \$1159 \$3612 VPWR VGND \$3799 sg13cmos5l_and2_1
* cell instance sg13cmos5l_and2_1_3 r0 *1 0,0
Xsg13cmos5l_and2_1_3 \$1089 \$1905 VPWR VGND \$2138 sg13cmos5l_and2_1
* cell instance sg13cmos5l_and2_1_4 r0 *1 0,0
Xsg13cmos5l_and2_1_4 \$5047 \$5055 VPWR VGND \$6057 sg13cmos5l_and2_1
* cell instance sg13cmos5l_and2_1_5 r0 *1 0,0
Xsg13cmos5l_and2_1_5 \$3473 \$3273 VPWR VGND \$3110 sg13cmos5l_and2_1
* cell instance sg13cmos5l_and2_1_6 r0 *1 0,0
Xsg13cmos5l_and2_1_6 \$6083 \$6058 VPWR VGND \$3275 sg13cmos5l_and2_1
* cell instance sg13cmos5l_and2_1_7 r0 *1 0,0
Xsg13cmos5l_and2_1_7 \$3968 \$3967 VPWR VGND \$3811 sg13cmos5l_and2_1
* cell instance sg13cmos5l_and2_1_8 r0 *1 0,0
Xsg13cmos5l_and2_1_8 \$1326 \$1112 VPWR VGND \$1007 sg13cmos5l_and2_1
* cell instance sg13cmos5l_and2_1_9 r0 *1 0,0
Xsg13cmos5l_and2_1_9 \$5237 \$5238 VPWR VGND \$5345 sg13cmos5l_and2_1
* cell instance sg13cmos5l_and2_1_10 r0 *1 0,0
Xsg13cmos5l_and2_1_10 \$4293 \$3297 VPWR VGND \$3978 sg13cmos5l_and2_1
* cell instance sg13cmos5l_and2_1_11 r0 *1 0,0
Xsg13cmos5l_and2_1_11 \$1136 \$1161 VPWR VGND \$1461 sg13cmos5l_and2_1
* cell instance sg13cmos5l_and2_1_12 r0 *1 0,0
Xsg13cmos5l_and2_1_12 \$3495 \$1702 VPWR VGND \$3312 sg13cmos5l_and2_1
* cell instance sg13cmos5l_and2_1_13 r0 *1 0,0
Xsg13cmos5l_and2_1_13 \$1089 \$1474 VPWR VGND \$1240 sg13cmos5l_and2_1
* cell instance sg13cmos5l_and2_1_14 r0 *1 0,0
Xsg13cmos5l_and2_1_14 \$2431 \$2426 VPWR VGND \$2617 sg13cmos5l_and2_1
* cell instance sg13cmos5l_and2_1_15 r0 *1 0,0
Xsg13cmos5l_and2_1_15 \$689 \$808 VPWR VGND \$805 sg13cmos5l_and2_1
* cell instance sg13cmos5l_and2_1_16 r0 *1 0,0
Xsg13cmos5l_and2_1_16 \$2431 \$2436 VPWR VGND \$1913 sg13cmos5l_and2_1
* cell instance sg13cmos5l_and2_1_17 r0 *1 0,0
Xsg13cmos5l_and2_1_17 \$2174 \$2431 VPWR VGND \$2440 sg13cmos5l_and2_1
* cell instance sg13cmos5l_and2_1_18 r0 *1 0,0
Xsg13cmos5l_and2_1_18 \$3839 \$3649 VPWR VGND \$3842 sg13cmos5l_and2_1
* cell instance sg13cmos5l_and2_1_19 r0 *1 0,0
Xsg13cmos5l_and2_1_19 \$2205 \$2307 VPWR VGND \$2193 sg13cmos5l_and2_1
* cell instance sg13cmos5l_and2_1_20 r0 *1 0,0
Xsg13cmos5l_and2_1_20 \$1617 \$1619 VPWR VGND \$947 sg13cmos5l_and2_1
* cell instance sg13cmos5l_and2_1_21 r0 *1 0,0
Xsg13cmos5l_and2_1_21 \$2651 \$3851 VPWR VGND \$3670 sg13cmos5l_and2_1
* cell instance sg13cmos5l_and2_1_22 r0 *1 0,0
Xsg13cmos5l_and2_1_22 \$3266 \$2977 VPWR VGND \$2662 sg13cmos5l_and2_1
* cell instance sg13cmos5l_and2_1_23 r0 *1 0,0
Xsg13cmos5l_and2_1_23 \$2834 \$3042 VPWR VGND \$2235 sg13cmos5l_and2_1
* cell instance sg13cmos5l_and2_1_24 r0 *1 0,0
Xsg13cmos5l_and2_1_24 \$832 \$260 VPWR VGND \$1414 sg13cmos5l_and2_1
* cell instance sg13cmos5l_and2_1_25 r0 *1 0,0
Xsg13cmos5l_and2_1_25 \$2703 \$2869 VPWR VGND \$2387 sg13cmos5l_and2_1
* cell instance sg13cmos5l_and2_1_26 r0 *1 0,0
Xsg13cmos5l_and2_1_26 \$1066 \$305 VPWR VGND \$1195 sg13cmos5l_and2_1
* cell instance sg13cmos5l_and3_1_0 r0 *1 0,0
Xsg13cmos5l_and3_1_0 \$4976 \$5025 \$4975 VPWR VGND \$4680 sg13cmos5l_and3_1
* cell instance sg13cmos5l_and3_1_1 r0 *1 0,0
Xsg13cmos5l_and3_1_1 \$1974 \$2568 \$2639 VPWR VGND \$2307 sg13cmos5l_and3_1
* cell instance sg13cmos5l_and3_1_2 r0 *1 0,0
Xsg13cmos5l_and3_1_2 \$77 \$83 \$974 VPWR VGND \$736 sg13cmos5l_and3_1
* cell instance sg13cmos5l_and3_1_3 r0 *1 0,0
Xsg13cmos5l_and3_1_3 \$2378 \$2389 \$2703 VPWR VGND \$2705 sg13cmos5l_and3_1
* cell instance sg13cmos5l_and4_1_0 r0 *1 0,0
Xsg13cmos5l_and4_1_0 \$2149 \$1796 \$2282 \$2284 VPWR VGND \$2285
+ sg13cmos5l_and4_1
* cell instance sg13cmos5l_and4_1_1 r0 *1 0,0
Xsg13cmos5l_and4_1_1 \$1327 \$2435 \$1593 \$2436 VPWR VGND \$2281
+ sg13cmos5l_and4_1
* cell instance sg13cmos5l_and4_1_2 r0 *1 0,0
Xsg13cmos5l_and4_1_2 \$1327 \$2435 \$1593 \$2436 VPWR VGND \$2284
+ sg13cmos5l_and4_1
* cell instance sg13cmos5l_and4_1_3 r0 *1 0,0
Xsg13cmos5l_and4_1_3 \$2776 \$2435 \$1593 \$2436 VPWR VGND \$2942
+ sg13cmos5l_and4_1
* cell instance sg13cmos5l_and4_1_4 r0 *1 0,0
Xsg13cmos5l_and4_1_4 \$1073 \$387 \$100 \$1856 VPWR VGND \$1857
+ sg13cmos5l_and4_1
* cell instance sg13cmos5l_antennanp_0 r0 *1 0,0
Xsg13cmos5l_antennanp_0 \$2000 VPWR VGND sg13cmos5l_antennanp
* cell instance sg13cmos5l_antennanp_1 r0 *1 0,0
Xsg13cmos5l_antennanp_1 \$534 VPWR VGND sg13cmos5l_antennanp
* cell instance sg13cmos5l_antennanp_2 r0 *1 0,0
Xsg13cmos5l_antennanp_2 \$306 VPWR VGND sg13cmos5l_antennanp
* cell instance sg13cmos5l_buf_1_0 r0 *1 0,0
Xsg13cmos5l_buf_1_0 \$6085 VPWR VGND \$5231 sg13cmos5l_buf_1
* cell instance sg13cmos5l_buf_1_1 r0 *1 0,0
Xsg13cmos5l_buf_1_1 \$669 VPWR VGND \$1326 sg13cmos5l_buf_1
* cell instance sg13cmos5l_buf_1_2 r0 *1 0,0
Xsg13cmos5l_buf_1_2 \$2610 VPWR VGND \$6644 sg13cmos5l_buf_1
* cell instance sg13cmos5l_buf_1_3 r0 *1 0,0
Xsg13cmos5l_buf_1_3 \$1326 VPWR VGND \$645 sg13cmos5l_buf_1
* cell instance sg13cmos5l_buf_1_4 r0 *1 0,0
Xsg13cmos5l_buf_1_4 \$1666 VPWR VGND \$669 sg13cmos5l_buf_1
* cell instance sg13cmos5l_buf_1_5 r0 *1 0,0
Xsg13cmos5l_buf_1_5 \$3623 VPWR VGND \$1234 sg13cmos5l_buf_1
* cell instance sg13cmos5l_buf_1_6 r0 *1 0,0
Xsg13cmos5l_buf_1_6 \$1542 VPWR VGND \$762 sg13cmos5l_buf_1
* cell instance sg13cmos5l_buf_1_7 r0 *1 0,0
Xsg13cmos5l_buf_1_7 \$3806 VPWR VGND \$3623 sg13cmos5l_buf_1
* cell instance sg13cmos5l_buf_1_8 r0 *1 0,0
Xsg13cmos5l_buf_1_8 \$7410 VPWR VGND \$2610 sg13cmos5l_buf_1
* cell instance sg13cmos5l_buf_1_9 r0 *1 0,0
Xsg13cmos5l_buf_1_9 \$1223 VPWR VGND \$872 sg13cmos5l_buf_1
* cell instance sg13cmos5l_buf_1_10 r0 *1 0,0
Xsg13cmos5l_buf_1_10 \$2771 VPWR VGND \$5023 sg13cmos5l_buf_1
* cell instance sg13cmos5l_buf_1_11 r0 *1 0,0
Xsg13cmos5l_buf_1_11 \$3641 VPWR VGND \$2254 sg13cmos5l_buf_1
* cell instance sg13cmos5l_buf_1_12 r0 *1 0,0
Xsg13cmos5l_buf_1_12 \$7950 VPWR VGND \$7067 sg13cmos5l_buf_1
* cell instance sg13cmos5l_buf_1_13 r0 *1 0,0
Xsg13cmos5l_buf_1_13 \$7243 VPWR VGND \$3641 sg13cmos5l_buf_1
* cell instance sg13cmos5l_buf_1_14 r0 *1 0,0
Xsg13cmos5l_buf_1_14 \$3122 VPWR VGND \$2923 sg13cmos5l_buf_1
* cell instance sg13cmos5l_buf_1_15 r0 *1 0,0
Xsg13cmos5l_buf_1_15 \$6085 VPWR VGND \$7950 sg13cmos5l_buf_1
* cell instance sg13cmos5l_buf_1_16 r0 *1 0,0
Xsg13cmos5l_buf_1_16 \$6939 VPWR VGND \$13502 sg13cmos5l_buf_1
* cell instance sg13cmos5l_buf_1_17 r0 *1 0,0
Xsg13cmos5l_buf_1_17 \$13502 VPWR VGND \$9906 sg13cmos5l_buf_1
* cell instance sg13cmos5l_buf_1_18 r0 *1 0,0
Xsg13cmos5l_buf_1_18 \$4988 VPWR VGND \$5055 sg13cmos5l_buf_1
* cell instance sg13cmos5l_buf_1_19 r0 *1 0,0
Xsg13cmos5l_buf_1_19 \$13502 VPWR VGND \$10514 sg13cmos5l_buf_1
* cell instance sg13cmos5l_buf_1_20 r0 *1 0,0
Xsg13cmos5l_buf_1_20 \$3971 VPWR VGND \$12461 sg13cmos5l_buf_1
* cell instance sg13cmos5l_buf_1_21 r0 *1 0,0
Xsg13cmos5l_buf_1_21 \$7261 VPWR VGND \$14513 sg13cmos5l_buf_1
* cell instance sg13cmos5l_buf_1_22 r0 *1 0,0
Xsg13cmos5l_buf_1_22 \$2607 VPWR VGND \$3127 sg13cmos5l_buf_1
* cell instance sg13cmos5l_buf_1_23 r0 *1 0,0
Xsg13cmos5l_buf_1_23 \$4046 VPWR VGND \$1716 sg13cmos5l_buf_1
* cell instance sg13cmos5l_buf_1_24 r0 *1 0,0
Xsg13cmos5l_buf_1_24 \$1688 VPWR VGND \$1691 sg13cmos5l_buf_1
* cell instance sg13cmos5l_buf_1_25 r0 *1 0,0
Xsg13cmos5l_buf_1_25 \$1694 VPWR VGND \$1135 sg13cmos5l_buf_1
* cell instance sg13cmos5l_buf_1_26 r0 *1 0,0
Xsg13cmos5l_buf_1_26 \$5002 VPWR VGND \$1488 sg13cmos5l_buf_1
* cell instance sg13cmos5l_buf_1_27 r0 *1 0,0
Xsg13cmos5l_buf_1_27 \$2899 VPWR VGND \$2755 sg13cmos5l_buf_1
* cell instance sg13cmos5l_buf_1_28 r0 *1 0,0
Xsg13cmos5l_buf_1_28 \$5018 VPWR VGND \$5047 sg13cmos5l_buf_1
* cell instance sg13cmos5l_buf_1_29 r0 *1 0,0
Xsg13cmos5l_buf_1_29 \$1031 VPWR VGND \$2149 sg13cmos5l_buf_1
* cell instance sg13cmos5l_buf_1_30 r0 *1 0,0
Xsg13cmos5l_buf_1_30 \$6939 VPWR VGND \$6085 sg13cmos5l_buf_1
* cell instance sg13cmos5l_buf_1_31 r0 *1 0,0
Xsg13cmos5l_buf_1_31 \$3427 VPWR VGND \$1159 sg13cmos5l_buf_1
* cell instance sg13cmos5l_buf_1_32 r0 *1 0,0
Xsg13cmos5l_buf_1_32 \$7183 VPWR VGND \$7225 sg13cmos5l_buf_1
* cell instance sg13cmos5l_buf_1_33 r0 *1 0,0
Xsg13cmos5l_buf_1_33 \$320 VPWR VGND \$673 sg13cmos5l_buf_1
* cell instance sg13cmos5l_buf_1_34 r0 *1 0,0
Xsg13cmos5l_buf_1_34 \$8845 VPWR VGND \$4046 sg13cmos5l_buf_1
* cell instance sg13cmos5l_buf_1_35 r0 *1 0,0
Xsg13cmos5l_buf_1_35 \$2770 VPWR VGND \$5024 sg13cmos5l_buf_1
* cell instance sg13cmos5l_buf_1_36 r0 *1 0,0
Xsg13cmos5l_buf_1_36 \$1542 VPWR VGND \$468 sg13cmos5l_buf_1
* cell instance sg13cmos5l_buf_1_37 r0 *1 0,0
Xsg13cmos5l_buf_1_37 \$3633 VPWR VGND \$9576 sg13cmos5l_buf_1
* cell instance sg13cmos5l_buf_1_38 r0 *1 0,0
Xsg13cmos5l_buf_1_38 \$3633 VPWR VGND \$11398 sg13cmos5l_buf_1
* cell instance sg13cmos5l_buf_1_39 r0 *1 0,0
Xsg13cmos5l_buf_1_39 \$2937 VPWR VGND \$2142 sg13cmos5l_buf_1
* cell instance sg13cmos5l_buf_1_40 r0 *1 0,0
Xsg13cmos5l_buf_1_40 \$1007 VPWR VGND \$918 sg13cmos5l_buf_1
* cell instance sg13cmos5l_buf_1_41 r0 *1 0,0
Xsg13cmos5l_buf_1_41 \$1467 VPWR VGND \$1464 sg13cmos5l_buf_1
* cell instance sg13cmos5l_buf_1_42 r0 *1 0,0
Xsg13cmos5l_buf_1_42 \$3294 VPWR VGND \$2770 sg13cmos5l_buf_1
* cell instance sg13cmos5l_buf_1_43 r0 *1 0,0
Xsg13cmos5l_buf_1_43 \$932 VPWR VGND \$3823 sg13cmos5l_buf_1
* cell instance sg13cmos5l_buf_1_44 r0 *1 0,0
Xsg13cmos5l_buf_1_44 \$13939 VPWR VGND \$9912 sg13cmos5l_buf_1
* cell instance sg13cmos5l_buf_1_45 r0 *1 0,0
Xsg13cmos5l_buf_1_45 \$5002 VPWR VGND \$10957 sg13cmos5l_buf_1
* cell instance sg13cmos5l_buf_1_46 r0 *1 0,0
Xsg13cmos5l_buf_1_46 \$2246 VPWR VGND \$1903 sg13cmos5l_buf_1
* cell instance sg13cmos5l_buf_1_47 r0 *1 0,0
Xsg13cmos5l_buf_1_47 \$2152 VPWR VGND \$2277 sg13cmos5l_buf_1
* cell instance sg13cmos5l_buf_1_48 r0 *1 0,0
Xsg13cmos5l_buf_1_48 \$2952 VPWR VGND \$2771 sg13cmos5l_buf_1
* cell instance sg13cmos5l_buf_1_49 r0 *1 0,0
Xsg13cmos5l_buf_1_49 \$6587 VPWR VGND \$3427 sg13cmos5l_buf_1
* cell instance sg13cmos5l_buf_1_50 r0 *1 0,0
Xsg13cmos5l_buf_1_50 \$7168 VPWR VGND \$16985 sg13cmos5l_buf_1
* cell instance sg13cmos5l_buf_1_51 r0 *1 0,0
Xsg13cmos5l_buf_1_51 \$13939 VPWR VGND \$16501 sg13cmos5l_buf_1
* cell instance sg13cmos5l_buf_1_52 r0 *1 0,0
Xsg13cmos5l_buf_1_52 \$1031 VPWR VGND \$1034 sg13cmos5l_buf_1
* cell instance sg13cmos5l_buf_1_53 r0 *1 0,0
Xsg13cmos5l_buf_1_53 \$333 VPWR VGND \$105 sg13cmos5l_buf_1
* cell instance sg13cmos5l_buf_1_54 r0 *1 0,0
Xsg13cmos5l_buf_1_54 \$1916 VPWR VGND \$2159 sg13cmos5l_buf_1
* cell instance sg13cmos5l_buf_1_55 r0 *1 0,0
Xsg13cmos5l_buf_1_55 \$4463 VPWR VGND \$6939 sg13cmos5l_buf_1
* cell instance sg13cmos5l_buf_1_56 r0 *1 0,0
Xsg13cmos5l_buf_1_56 \$2159 VPWR VGND \$2246 sg13cmos5l_buf_1
* cell instance sg13cmos5l_buf_1_57 r0 *1 0,0
Xsg13cmos5l_buf_1_57 \$6939 VPWR VGND \$13939 sg13cmos5l_buf_1
* cell instance sg13cmos5l_buf_1_58 r0 *1 0,0
Xsg13cmos5l_buf_1_58 \$945 VPWR VGND \$1136 sg13cmos5l_buf_1
* cell instance sg13cmos5l_buf_1_59 r0 *1 0,0
Xsg13cmos5l_buf_1_59 \$482 VPWR VGND \$405 sg13cmos5l_buf_1
* cell instance sg13cmos5l_buf_1_60 r0 *1 0,0
Xsg13cmos5l_buf_1_60 \$16975 VPWR VGND \$4463 sg13cmos5l_buf_1
* cell instance sg13cmos5l_buf_1_61 r0 *1 0,0
Xsg13cmos5l_buf_1_61 \$922 VPWR VGND \$482 sg13cmos5l_buf_1
* cell instance sg13cmos5l_buf_1_62 r0 *1 0,0
Xsg13cmos5l_buf_1_62 \$669 VPWR VGND \$799 sg13cmos5l_buf_1
* cell instance sg13cmos5l_buf_1_63 r0 *1 0,0
Xsg13cmos5l_buf_1_63 \$1919 VPWR VGND \$932 sg13cmos5l_buf_1
* cell instance sg13cmos5l_buf_1_64 r0 *1 0,0
Xsg13cmos5l_buf_1_64 \$335 VPWR VGND \$332 sg13cmos5l_buf_1
* cell instance sg13cmos5l_buf_1_65 r0 *1 0,0
Xsg13cmos5l_buf_1_65 \$371 VPWR VGND \$335 sg13cmos5l_buf_1
* cell instance sg13cmos5l_buf_1_66 r0 *1 0,0
Xsg13cmos5l_buf_1_66 \$2942 VPWR VGND \$2775 sg13cmos5l_buf_1
* cell instance sg13cmos5l_buf_1_67 r0 *1 0,0
Xsg13cmos5l_buf_1_67 \$4133 VPWR VGND \$1542 sg13cmos5l_buf_1
* cell instance sg13cmos5l_buf_1_68 r0 *1 0,0
Xsg13cmos5l_buf_1_68 uio_in[7] VPWR VGND \$17040 sg13cmos5l_buf_1
* cell instance sg13cmos5l_buf_1_69 r0 *1 0,0
Xsg13cmos5l_buf_1_69 \$3452 VPWR VGND \$3132 sg13cmos5l_buf_1
* cell instance sg13cmos5l_buf_1_70 r0 *1 0,0
Xsg13cmos5l_buf_1_70 \$1240 VPWR VGND \$1231 sg13cmos5l_buf_1
* cell instance sg13cmos5l_buf_1_71 r0 *1 0,0
Xsg13cmos5l_buf_1_71 \$2159 VPWR VGND \$2043 sg13cmos5l_buf_1
* cell instance sg13cmos5l_buf_1_72 r0 *1 0,0
Xsg13cmos5l_buf_1_72 \$2043 VPWR VGND \$1928 sg13cmos5l_buf_1
* cell instance sg13cmos5l_buf_1_73 r0 *1 0,0
Xsg13cmos5l_buf_1_73 \$3100 VPWR VGND \$1327 sg13cmos5l_buf_1
* cell instance sg13cmos5l_buf_1_74 r0 *1 0,0
Xsg13cmos5l_buf_1_74 \$2441 VPWR VGND \$1940 sg13cmos5l_buf_1
* cell instance sg13cmos5l_buf_1_75 r0 *1 0,0
Xsg13cmos5l_buf_1_75 \$932 VPWR VGND \$1089 sg13cmos5l_buf_1
* cell instance sg13cmos5l_buf_1_76 r0 *1 0,0
Xsg13cmos5l_buf_1_76 \$1812 VPWR VGND \$1790 sg13cmos5l_buf_1
* cell instance sg13cmos5l_buf_1_77 r0 *1 0,0
Xsg13cmos5l_buf_1_77 \$2567 VPWR VGND \$2443 sg13cmos5l_buf_1
* cell instance sg13cmos5l_buf_1_78 r0 *1 0,0
Xsg13cmos5l_buf_1_78 \$2951 VPWR VGND \$2952 sg13cmos5l_buf_1
* cell instance sg13cmos5l_buf_1_79 r0 *1 0,0
Xsg13cmos5l_buf_1_79 uio_in[6] VPWR VGND \$17099 sg13cmos5l_buf_1
* cell instance sg13cmos5l_buf_1_80 r0 *1 0,0
Xsg13cmos5l_buf_1_80 \$1688 VPWR VGND \$2177 sg13cmos5l_buf_1
* cell instance sg13cmos5l_buf_1_81 r0 *1 0,0
Xsg13cmos5l_buf_1_81 uio_in[5] VPWR VGND \$8861 sg13cmos5l_buf_1
* cell instance sg13cmos5l_buf_1_82 r0 *1 0,0
Xsg13cmos5l_buf_1_82 \$2440 VPWR VGND \$2782 sg13cmos5l_buf_1
* cell instance sg13cmos5l_buf_1_83 r0 *1 0,0
Xsg13cmos5l_buf_1_83 uio_in[4] VPWR VGND \$17104 sg13cmos5l_buf_1
* cell instance sg13cmos5l_buf_1_84 r0 *1 0,0
Xsg13cmos5l_buf_1_84 \$1492 VPWR VGND \$488 sg13cmos5l_buf_1
* cell instance sg13cmos5l_buf_1_85 r0 *1 0,0
Xsg13cmos5l_buf_1_85 \$2782 VPWR VGND \$2197 sg13cmos5l_buf_1
* cell instance sg13cmos5l_buf_1_86 r0 *1 0,0
Xsg13cmos5l_buf_1_86 uio_in[3] VPWR VGND \$17108 sg13cmos5l_buf_1
* cell instance sg13cmos5l_buf_1_87 r0 *1 0,0
Xsg13cmos5l_buf_1_87 \$120 VPWR VGND \$33 sg13cmos5l_buf_1
* cell instance sg13cmos5l_buf_1_88 r0 *1 0,0
Xsg13cmos5l_buf_1_88 \$1827 VPWR VGND \$3320 sg13cmos5l_buf_1
* cell instance sg13cmos5l_buf_1_89 r0 *1 0,0
Xsg13cmos5l_buf_1_89 \$340 VPWR VGND \$193 sg13cmos5l_buf_1
* cell instance sg13cmos5l_buf_1_90 r0 *1 0,0
Xsg13cmos5l_buf_1_90 \$947 VPWR VGND \$1161 sg13cmos5l_buf_1
* cell instance sg13cmos5l_buf_1_91 r0 *1 0,0
Xsg13cmos5l_buf_1_91 uio_in[2] VPWR VGND \$17112 sg13cmos5l_buf_1
* cell instance sg13cmos5l_buf_1_92 r0 *1 0,0
Xsg13cmos5l_buf_1_92 \$65 VPWR VGND \$45 sg13cmos5l_buf_1
* cell instance sg13cmos5l_buf_1_93 r0 *1 0,0
Xsg13cmos5l_buf_1_93 \$101 VPWR VGND \$103 sg13cmos5l_buf_1
* cell instance sg13cmos5l_buf_1_94 r0 *1 0,0
Xsg13cmos5l_buf_1_94 \$949 VPWR VGND \$825 sg13cmos5l_buf_1
* cell instance sg13cmos5l_buf_1_95 r0 *1 0,0
Xsg13cmos5l_buf_1_95 \$825 VPWR VGND \$719 sg13cmos5l_buf_1
* cell instance sg13cmos5l_buf_1_96 r0 *1 0,0
Xsg13cmos5l_buf_1_96 \$1162 VPWR VGND \$949 sg13cmos5l_buf_1
* cell instance sg13cmos5l_buf_1_97 r0 *1 0,0
Xsg13cmos5l_buf_1_97 \$720 VPWR VGND \$345 sg13cmos5l_buf_1
* cell instance sg13cmos5l_buf_1_98 r0 *1 0,0
Xsg13cmos5l_buf_1_98 \$2443 VPWR VGND \$1822 sg13cmos5l_buf_1
* cell instance sg13cmos5l_buf_1_99 r0 *1 0,0
Xsg13cmos5l_buf_1_99 uio_in[0] VPWR VGND \$17117 sg13cmos5l_buf_1
* cell instance sg13cmos5l_buf_1_100 r0 *1 0,0
Xsg13cmos5l_buf_1_100 \$1940 VPWR VGND \$2196 sg13cmos5l_buf_1
* cell instance sg13cmos5l_buf_1_101 r0 *1 0,0
Xsg13cmos5l_buf_1_101 \$106 VPWR VGND \$43 sg13cmos5l_buf_1
* cell instance sg13cmos5l_buf_1_102 r0 *1 0,0
Xsg13cmos5l_buf_1_102 \$348 VPWR VGND \$346 sg13cmos5l_buf_1
* cell instance sg13cmos5l_buf_1_103 r0 *1 0,0
Xsg13cmos5l_buf_1_103 \$110 VPWR VGND \$31 sg13cmos5l_buf_1
* cell instance sg13cmos5l_buf_1_104 r0 *1 0,0
Xsg13cmos5l_buf_1_104 \$34 VPWR VGND \$36 sg13cmos5l_buf_1
* cell instance sg13cmos5l_buf_1_105 r0 *1 0,0
Xsg13cmos5l_buf_1_105 \$37 VPWR VGND \$39 sg13cmos5l_buf_1
* cell instance sg13cmos5l_buf_1_106 r0 *1 0,0
Xsg13cmos5l_buf_1_106 \$1 VPWR VGND \$106 sg13cmos5l_buf_1
* cell instance sg13cmos5l_buf_1_107 r0 *1 0,0
Xsg13cmos5l_buf_1_107 ui_in[7] VPWR VGND \$2202 sg13cmos5l_buf_1
* cell instance sg13cmos5l_buf_1_108 r0 *1 0,0
Xsg13cmos5l_buf_1_108 \$1270 VPWR VGND \$120 sg13cmos5l_buf_1
* cell instance sg13cmos5l_buf_1_109 r0 *1 0,0
Xsg13cmos5l_buf_1_109 uio_in[1] VPWR VGND \$17119 sg13cmos5l_buf_1
* cell instance sg13cmos5l_buf_1_110 r0 *1 0,0
Xsg13cmos5l_buf_1_110 \$115 VPWR VGND \$38 sg13cmos5l_buf_1
* cell instance sg13cmos5l_buf_1_111 r0 *1 0,0
Xsg13cmos5l_buf_1_111 ui_in[6] VPWR VGND \$17105 sg13cmos5l_buf_1
* cell instance sg13cmos5l_buf_1_112 r0 *1 0,0
Xsg13cmos5l_buf_1_112 \$2797 VPWR VGND \$3153 sg13cmos5l_buf_1
* cell instance sg13cmos5l_buf_1_113 r0 *1 0,0
Xsg13cmos5l_buf_1_113 \$163 VPWR VGND \$260 sg13cmos5l_buf_1
* cell instance sg13cmos5l_buf_1_114 r0 *1 0,0
Xsg13cmos5l_buf_1_114 \$1064 VPWR VGND \$110 sg13cmos5l_buf_1
* cell instance sg13cmos5l_buf_1_115 r0 *1 0,0
Xsg13cmos5l_buf_1_115 \$1492 VPWR VGND \$815 sg13cmos5l_buf_1
* cell instance sg13cmos5l_buf_1_116 r0 *1 0,0
Xsg13cmos5l_buf_1_116 \$4133 VPWR VGND \$1827 sg13cmos5l_buf_1
* cell instance sg13cmos5l_buf_1_117 r0 *1 0,0
Xsg13cmos5l_buf_1_117 \$1251 VPWR VGND \$1270 sg13cmos5l_buf_1
* cell instance sg13cmos5l_buf_1_118 r0 *1 0,0
Xsg13cmos5l_buf_1_118 \$1827 VPWR VGND \$1492 sg13cmos5l_buf_1
* cell instance sg13cmos5l_buf_1_119 r0 *1 0,0
Xsg13cmos5l_buf_1_119 \$4463 VPWR VGND \$4133 sg13cmos5l_buf_1
* cell instance sg13cmos5l_buf_1_120 r0 *1 0,0
Xsg13cmos5l_buf_1_120 \$2906 VPWR VGND \$2977 sg13cmos5l_buf_1
* cell instance sg13cmos5l_buf_1_121 r0 *1 0,0
Xsg13cmos5l_buf_1_121 ui_in[5] VPWR VGND \$16998 sg13cmos5l_buf_1
* cell instance sg13cmos5l_buf_1_122 r0 *1 0,0
Xsg13cmos5l_buf_1_122 \$378 VPWR VGND \$28 sg13cmos5l_buf_1
* cell instance sg13cmos5l_buf_1_123 r0 *1 0,0
Xsg13cmos5l_buf_1_123 ui_in[4] VPWR VGND \$17109 sg13cmos5l_buf_1
* cell instance sg13cmos5l_buf_1_124 r0 *1 0,0
Xsg13cmos5l_buf_1_124 \$2076 VPWR VGND \$1812 sg13cmos5l_buf_1
* cell instance sg13cmos5l_buf_1_125 r0 *1 0,0
Xsg13cmos5l_buf_1_125 \$843 VPWR VGND \$65 sg13cmos5l_buf_1
* cell instance sg13cmos5l_buf_1_126 r0 *1 0,0
Xsg13cmos5l_buf_1_126 ui_in[3] VPWR VGND \$17113 sg13cmos5l_buf_1
* cell instance sg13cmos5l_buf_1_127 r0 *1 0,0
Xsg13cmos5l_buf_1_127 \$1384 VPWR VGND \$843 sg13cmos5l_buf_1
* cell instance sg13cmos5l_buf_1_128 r0 *1 0,0
Xsg13cmos5l_buf_1_128 ui_in[2] VPWR VGND \$17126 sg13cmos5l_buf_1
* cell instance sg13cmos5l_buf_1_129 r0 *1 0,0
Xsg13cmos5l_buf_1_129 ui_in[1] VPWR VGND \$17118 sg13cmos5l_buf_1
* cell instance sg13cmos5l_buf_1_130 r0 *1 0,0
Xsg13cmos5l_buf_1_130 \$887 VPWR VGND \$726 sg13cmos5l_buf_1
* cell instance sg13cmos5l_buf_1_131 r0 *1 0,0
Xsg13cmos5l_buf_1_131 \$2571 VPWR VGND \$2805 sg13cmos5l_buf_1
* cell instance sg13cmos5l_buf_1_132 r0 *1 0,0
Xsg13cmos5l_buf_1_132 \$4463 VPWR VGND \$2571 sg13cmos5l_buf_1
* cell instance sg13cmos5l_buf_1_133 r0 *1 0,0
Xsg13cmos5l_buf_1_133 ui_in[0] VPWR VGND \$4165 sg13cmos5l_buf_1
* cell instance sg13cmos5l_buf_1_134 r0 *1 0,0
Xsg13cmos5l_buf_1_134 \$4 VPWR VGND \$279 sg13cmos5l_buf_1
* cell instance sg13cmos5l_buf_1_135 r0 *1 0,0
Xsg13cmos5l_buf_1_135 rst_n VPWR VGND \$16975 sg13cmos5l_buf_1
* cell instance sg13cmos5l_buf_1_136 r0 *1 0,0
Xsg13cmos5l_buf_1_136 \$1601 VPWR VGND \$115 sg13cmos5l_buf_1
* cell instance sg13cmos5l_buf_1_137 r0 *1 0,0
Xsg13cmos5l_buf_1_137 \$54 VPWR VGND \$157 sg13cmos5l_buf_1
* cell instance sg13cmos5l_buf_1_138 r0 *1 0,0
Xsg13cmos5l_buf_1_138 \$2571 VPWR VGND \$1835 sg13cmos5l_buf_1
* cell instance sg13cmos5l_buf_1_139 r0 *1 0,0
Xsg13cmos5l_buf_1_139 \$961 VPWR VGND \$8 sg13cmos5l_buf_1
* cell instance sg13cmos5l_buf_1_140 r0 *1 0,0
Xsg13cmos5l_buf_1_140 \$8 VPWR VGND \$231 sg13cmos5l_buf_1
* cell instance sg13cmos5l_buf_1_141 r0 *1 0,0
Xsg13cmos5l_buf_1_141 \$101 VPWR VGND \$121 sg13cmos5l_buf_1
* cell instance sg13cmos5l_buf_1_142 r0 *1 0,0
Xsg13cmos5l_buf_1_142 \$2797 VPWR VGND \$3003 sg13cmos5l_buf_1
* cell instance sg13cmos5l_buf_1_143 r0 *1 0,0
Xsg13cmos5l_buf_1_143 \$2906 VPWR VGND \$3007 sg13cmos5l_buf_1
* cell instance sg13cmos5l_buf_1_144 r0 *1 0,0
Xsg13cmos5l_buf_1_144 \$119 VPWR VGND \$55 sg13cmos5l_buf_1
* cell instance sg13cmos5l_buf_1_145 r0 *1 0,0
Xsg13cmos5l_buf_1_145 \$34 VPWR VGND \$118 sg13cmos5l_buf_1
* cell instance sg13cmos5l_buf_1_146 r0 *1 0,0
Xsg13cmos5l_buf_1_146 \$275 VPWR VGND \$221 sg13cmos5l_buf_1
* cell instance sg13cmos5l_buf_1_147 r0 *1 0,0
Xsg13cmos5l_buf_1_147 \$346 VPWR VGND \$275 sg13cmos5l_buf_1
* cell instance sg13cmos5l_buf_1_148 r0 *1 0,0
Xsg13cmos5l_buf_1_148 \$2571 VPWR VGND \$3022 sg13cmos5l_buf_1
* cell instance sg13cmos5l_buf_1_149 r0 *1 0,0
Xsg13cmos5l_buf_1_149 \$976 VPWR VGND \$518 sg13cmos5l_buf_1
* cell instance sg13cmos5l_buf_1_150 r0 *1 0,0
Xsg13cmos5l_buf_1_150 \$2474 VPWR VGND \$2102 sg13cmos5l_buf_1
* cell instance sg13cmos5l_buf_1_151 r0 *1 0,0
Xsg13cmos5l_buf_1_151 \$1868 VPWR VGND \$569 sg13cmos5l_buf_1
* cell instance sg13cmos5l_buf_1_152 r0 *1 0,0
Xsg13cmos5l_buf_1_152 \$2750 VPWR VGND \$2915 sg13cmos5l_buf_1
* cell instance sg13cmos5l_buf_1_153 r0 *1 0,0
Xsg13cmos5l_buf_1_153 \$569 VPWR VGND \$302 sg13cmos5l_buf_1
* cell instance sg13cmos5l_buf_1_154 r0 *1 0,0
Xsg13cmos5l_buf_1_154 \$2750 VPWR VGND \$2105 sg13cmos5l_buf_1
* cell instance sg13cmos5l_buf_1_155 r0 *1 0,0
Xsg13cmos5l_buf_1_155 \$2915 VPWR VGND \$2474 sg13cmos5l_buf_1
* cell instance sg13cmos5l_buf_1_156 r0 *1 0,0
Xsg13cmos5l_buf_1_156 \$2105 VPWR VGND \$2224 sg13cmos5l_buf_1
* cell instance sg13cmos5l_buf_1_157 r0 *1 0,0
Xsg13cmos5l_buf_1_157 \$105 VPWR VGND \$154 sg13cmos5l_buf_1
* cell instance sg13cmos5l_buf_1_158 r0 *1 0,0
Xsg13cmos5l_buf_1_158 \$482 VPWR VGND \$422 sg13cmos5l_buf_1
* cell instance sg13cmos5l_buf_1_159 r0 *1 0,0
Xsg13cmos5l_buf_1_159 \$335 VPWR VGND \$1073 sg13cmos5l_buf_1
* cell instance sg13cmos5l_buf_1_160 r0 *1 0,0
Xsg13cmos5l_buf_1_160 \$3152 VPWR VGND \$3034 sg13cmos5l_buf_1
* cell instance sg13cmos5l_buf_1_161 r0 *1 0,0
Xsg13cmos5l_buf_1_161 \$345 VPWR VGND \$737 sg13cmos5l_buf_1
* cell instance sg13cmos5l_buf_1_162 r0 *1 0,0
Xsg13cmos5l_buf_1_162 \$12 VPWR VGND \$54 sg13cmos5l_buf_1
* cell instance sg13cmos5l_buf_1_163 r0 *1 0,0
Xsg13cmos5l_buf_1_163 \$54 VPWR VGND \$117 sg13cmos5l_buf_1
* cell instance sg13cmos5l_buf_1_164 r0 *1 0,0
Xsg13cmos5l_buf_1_164 \$101 VPWR VGND \$177 sg13cmos5l_buf_1
* cell instance sg13cmos5l_buf_1_165 r0 *1 0,0
Xsg13cmos5l_buf_1_165 \$2101 VPWR VGND \$3392 sg13cmos5l_buf_1
* cell instance sg13cmos5l_buf_1_166 r0 *1 0,0
Xsg13cmos5l_buf_1_166 \$843 VPWR VGND \$77 sg13cmos5l_buf_1
* cell instance sg13cmos5l_buf_1_167 r0 *1 0,0
Xsg13cmos5l_buf_1_167 \$2518 VPWR VGND \$3725 sg13cmos5l_buf_1
* cell instance sg13cmos5l_buf_1_168 r0 *1 0,0
Xsg13cmos5l_buf_1_168 \$3725 VPWR VGND \$3726 sg13cmos5l_buf_1
* cell instance sg13cmos5l_buf_1_169 r0 *1 0,0
Xsg13cmos5l_buf_1_169 \$4463 VPWR VGND \$2518 sg13cmos5l_buf_1
* cell instance sg13cmos5l_buf_1_170 r0 *1 0,0
Xsg13cmos5l_buf_1_170 \$845 VPWR VGND \$292 sg13cmos5l_buf_1
* cell instance sg13cmos5l_buf_1_171 r0 *1 0,0
Xsg13cmos5l_buf_1_171 \$2224 VPWR VGND \$2376 sg13cmos5l_buf_1
* cell instance sg13cmos5l_buf_1_172 r0 *1 0,0
Xsg13cmos5l_buf_1_172 \$348 VPWR VGND \$845 sg13cmos5l_buf_1
* cell instance sg13cmos5l_buf_1_173 r0 *1 0,0
Xsg13cmos5l_buf_1_173 \$3725 VPWR VGND \$2856 sg13cmos5l_buf_1
* cell instance sg13cmos5l_buf_1_174 r0 *1 0,0
Xsg13cmos5l_buf_1_174 \$2105 VPWR VGND \$3562 sg13cmos5l_buf_1
* cell instance sg13cmos5l_buf_1_175 r0 *1 0,0
Xsg13cmos5l_buf_1_175 \$1601 VPWR VGND \$1639 sg13cmos5l_buf_1
* cell instance sg13cmos5l_buf_1_176 r0 *1 0,0
Xsg13cmos5l_buf_1_176 \$154 VPWR VGND \$183 sg13cmos5l_buf_1
* cell instance sg13cmos5l_buf_1_177 r0 *1 0,0
Xsg13cmos5l_buf_1_177 \$435 VPWR VGND \$465 sg13cmos5l_buf_1
* cell instance sg13cmos5l_buf_1_178 r0 *1 0,0
Xsg13cmos5l_buf_1_178 \$2101 VPWR VGND \$3903 sg13cmos5l_buf_1
* cell instance sg13cmos5l_buf_1_179 r0 *1 0,0
Xsg13cmos5l_buf_1_179 \$1868 VPWR VGND \$435 sg13cmos5l_buf_1
* cell instance sg13cmos5l_buf_1_180 r0 *1 0,0
Xsg13cmos5l_buf_1_180 \$4078 VPWR VGND \$2726 sg13cmos5l_buf_1
* cell instance sg13cmos5l_buf_1_181 r0 *1 0,0
Xsg13cmos5l_buf_1_181 \$3725 VPWR VGND \$4078 sg13cmos5l_buf_1
* cell instance sg13cmos5l_buf_1_182 r0 *1 0,0
Xsg13cmos5l_buf_1_182 \$177 VPWR VGND \$1655 sg13cmos5l_buf_1
* cell instance sg13cmos5l_buf_1_183 r0 *1 0,0
Xsg13cmos5l_buf_1_183 \$1270 VPWR VGND \$985 sg13cmos5l_buf_1
* cell instance sg13cmos5l_buf_1_184 r0 *1 0,0
Xsg13cmos5l_buf_1_184 \$1064 VPWR VGND \$145 sg13cmos5l_buf_1
* cell instance sg13cmos5l_buf_1_185 r0 *1 0,0
Xsg13cmos5l_buf_1_185 \$177 VPWR VGND \$368 sg13cmos5l_buf_1
* cell instance sg13cmos5l_buf_1_186 r0 *1 0,0
Xsg13cmos5l_buf_1_186 \$145 VPWR VGND \$986 sg13cmos5l_buf_1
* cell instance sg13cmos5l_buf_1_187 r0 *1 0,0
Xsg13cmos5l_buf_1_187 \$737 VPWR VGND \$319 sg13cmos5l_buf_1
* cell instance sg13cmos5l_buf_1_188 r0 *1 0,0
Xsg13cmos5l_buf_1_188 \$140 VPWR VGND \$78 sg13cmos5l_buf_1
* cell instance sg13cmos5l_buf_1_189 r0 *1 0,0
Xsg13cmos5l_buf_1_189 \$34 VPWR VGND \$140 sg13cmos5l_buf_1
* cell instance sg13cmos5l_buf_1_190 r0 *1 0,0
Xsg13cmos5l_buf_1_190 \$81 VPWR VGND \$76 sg13cmos5l_buf_1
* cell instance sg13cmos5l_buf_1_191 r0 *1 0,0
Xsg13cmos5l_buf_1_191 \$1 VPWR VGND \$142 sg13cmos5l_buf_1
* cell instance sg13cmos5l_buf_1_192 r0 *1 0,0
Xsg13cmos5l_buf_1_192 \$142 VPWR VGND \$79 sg13cmos5l_buf_1
* cell instance sg13cmos5l_buf_1_193 r0 *1 0,0
Xsg13cmos5l_buf_1_193 \$4078 VPWR VGND \$3092 sg13cmos5l_buf_1
* cell instance sg13cmos5l_buf_1_194 r0 *1 0,0
Xsg13cmos5l_buf_1_194 \$1437 VPWR VGND \$614 sg13cmos5l_buf_1
* cell instance sg13cmos5l_buf_1_195 r0 *1 0,0
Xsg13cmos5l_buf_1_195 \$146 VPWR VGND \$1201 sg13cmos5l_buf_1
* cell instance sg13cmos5l_buf_1_196 r0 *1 0,0
Xsg13cmos5l_buf_1_196 \$843 VPWR VGND \$146 sg13cmos5l_buf_1
* cell instance sg13cmos5l_buf_1_197 r0 *1 0,0
Xsg13cmos5l_buf_1_197 \$335 VPWR VGND \$322 sg13cmos5l_buf_1
* cell instance sg13cmos5l_buf_1_198 r0 *1 0,0
Xsg13cmos5l_buf_1_198 \$1868 VPWR VGND \$449 sg13cmos5l_buf_1
* cell instance sg13cmos5l_buf_1_199 r0 *1 0,0
Xsg13cmos5l_buf_1_199 \$1639 VPWR VGND \$30 sg13cmos5l_buf_1
* cell instance sg13cmos5l_buf_1_200 r0 *1 0,0
Xsg13cmos5l_buf_1_200 \$89 VPWR VGND \$195 sg13cmos5l_buf_1
* cell instance sg13cmos5l_buf_1_201 r0 *1 0,0
Xsg13cmos5l_buf_1_201 \$835 VPWR VGND \$856 sg13cmos5l_buf_1
* cell instance sg13cmos5l_buf_1_202 r0 *1 0,0
Xsg13cmos5l_buf_1_202 \$996 VPWR VGND \$100 sg13cmos5l_buf_1
* cell instance sg13cmos5l_buf_1_203 r0 *1 0,0
Xsg13cmos5l_buf_1_203 \$1313 VPWR VGND \$47 sg13cmos5l_buf_1
* cell instance sg13cmos5l_buf_1_204 r0 *1 0,0
Xsg13cmos5l_buf_1_204 \$47 VPWR VGND \$126 sg13cmos5l_buf_1
* cell instance sg13cmos5l_buf_1_205 r0 *1 0,0
Xsg13cmos5l_buf_1_205 \$1201 VPWR VGND \$865 sg13cmos5l_buf_1
* cell instance sg13cmos5l_buf_1_206 r0 *1 0,0
Xsg13cmos5l_buf_1_206 \$87 VPWR VGND \$179 sg13cmos5l_buf_1
* cell instance sg13cmos5l_buf_1_207 r0 *1 0,0
Xsg13cmos5l_buf_1_207 \$1639 VPWR VGND \$1879 sg13cmos5l_buf_1
* cell instance sg13cmos5l_buf_1_208 r0 *1 0,0
Xsg13cmos5l_buf_1_208 \$12 VPWR VGND \$81 sg13cmos5l_buf_1
* cell instance sg13cmos5l_buf_1_209 r0 *1 0,0
Xsg13cmos5l_buf_1_209 \$845 VPWR VGND \$331 sg13cmos5l_buf_1
* cell instance sg13cmos5l_buf_1_210 r0 *1 0,0
Xsg13cmos5l_buf_1_210 \$89 VPWR VGND \$19 sg13cmos5l_buf_1
* cell instance sg13cmos5l_buf_1_211 r0 *1 0,0
Xsg13cmos5l_buf_1_211 \$81 VPWR VGND \$89 sg13cmos5l_buf_1
* cell instance sg13cmos5l_buf_1_212 r0 *1 0,0
Xsg13cmos5l_buf_1_212 \$996 VPWR VGND \$189 sg13cmos5l_buf_1
* cell instance sg13cmos5l_buf_1_213 r0 *1 0,0
Xsg13cmos5l_buf_1_213 \$1270 VPWR VGND \$136 sg13cmos5l_buf_1
* cell instance sg13cmos5l_buf_1_214 r0 *1 0,0
Xsg13cmos5l_buf_1_214 \$87 VPWR VGND \$198 sg13cmos5l_buf_1
* cell instance sg13cmos5l_buf_1_215 r0 *1 0,0
Xsg13cmos5l_buf_1_215 \$533 VPWR VGND \$388 sg13cmos5l_buf_1
* cell instance sg13cmos5l_buf_1_216 r0 *1 0,0
Xsg13cmos5l_buf_1_216 \$1868 VPWR VGND \$1664 sg13cmos5l_buf_1
* cell instance sg13cmos5l_buf_1_217 r0 *1 0,0
Xsg13cmos5l_buf_1_217 \$2126 VPWR VGND \$1868 sg13cmos5l_buf_1
* cell instance sg13cmos5l_buf_1_218 r0 *1 0,0
Xsg13cmos5l_buf_1_218 \$447 VPWR VGND \$976 sg13cmos5l_buf_1
* cell instance sg13cmos5l_buf_1_219 r0 *1 0,0
Xsg13cmos5l_buf_1_219 \$1528 VPWR VGND \$835 sg13cmos5l_buf_1
* cell instance sg13cmos5l_buf_4_0 r0 *1 0,0
Xsg13cmos5l_buf_4_0 \$2178 VPWR VGND \$4359 sg13cmos5l_buf_4
* cell instance sg13cmos5l_buf_8_0 r0 *1 0,0
Xsg13cmos5l_buf_8_0 \$4993 VPWR VGND \$5033 sg13cmos5l_buf_8
* cell instance sg13cmos5l_buf_8_1 r0 *1 0,0
Xsg13cmos5l_buf_8_1 \$9574 VPWR VGND \$7068 sg13cmos5l_buf_8
* cell instance sg13cmos5l_buf_8_2 r0 *1 0,0
Xsg13cmos5l_buf_8_2 \$9574 VPWR VGND \$7232 sg13cmos5l_buf_8
* cell instance sg13cmos5l_buf_8_3 r0 *1 0,0
Xsg13cmos5l_buf_8_3 \$4993 VPWR VGND \$5417 sg13cmos5l_buf_8
* cell instance sg13cmos5l_buf_8_4 r0 *1 0,0
Xsg13cmos5l_buf_8_4 \$10873 VPWR VGND \$11994 sg13cmos5l_buf_8
* cell instance sg13cmos5l_buf_8_5 r0 *1 0,0
Xsg13cmos5l_buf_8_5 \$2382 VPWR VGND \$4993 sg13cmos5l_buf_8
* cell instance sg13cmos5l_buf_8_6 r0 *1 0,0
Xsg13cmos5l_buf_8_6 \$2382 VPWR VGND \$9574 sg13cmos5l_buf_8
* cell instance sg13cmos5l_buf_8_7 r0 *1 0,0
Xsg13cmos5l_buf_8_7 \$2382 VPWR VGND \$10873 sg13cmos5l_buf_8
* cell instance sg13cmos5l_buf_8_8 r0 *1 0,0
Xsg13cmos5l_buf_8_8 \$2382 VPWR VGND \$4574 sg13cmos5l_buf_8
* cell instance sg13cmos5l_buf_8_9 r0 *1 0,0
Xsg13cmos5l_buf_8_9 \$13344 VPWR VGND \$12305 sg13cmos5l_buf_8
* cell instance sg13cmos5l_buf_8_10 r0 *1 0,0
Xsg13cmos5l_buf_8_10 \$13344 VPWR VGND \$14807 sg13cmos5l_buf_8
* cell instance sg13cmos5l_buf_8_11 r0 *1 0,0
Xsg13cmos5l_buf_8_11 \$2272 VPWR VGND \$1101 sg13cmos5l_buf_8
* cell instance sg13cmos5l_buf_8_12 r0 *1 0,0
Xsg13cmos5l_buf_8_12 \$10873 VPWR VGND \$10517 sg13cmos5l_buf_8
* cell instance sg13cmos5l_buf_8_13 r0 *1 0,0
Xsg13cmos5l_buf_8_13 \$2272 VPWR VGND \$767 sg13cmos5l_buf_8
* cell instance sg13cmos5l_buf_8_14 r0 *1 0,0
Xsg13cmos5l_buf_8_14 \$4574 VPWR VGND \$5109 sg13cmos5l_buf_8
* cell instance sg13cmos5l_buf_8_15 r0 *1 0,0
Xsg13cmos5l_buf_8_15 \$2382 VPWR VGND \$13344 sg13cmos5l_buf_8
* cell instance sg13cmos5l_buf_8_16 r0 *1 0,0
Xsg13cmos5l_buf_8_16 \$2033 VPWR VGND \$681 sg13cmos5l_buf_8
* cell instance sg13cmos5l_buf_8_17 r0 *1 0,0
Xsg13cmos5l_buf_8_17 \$4574 VPWR VGND \$5031 sg13cmos5l_buf_8
* cell instance sg13cmos5l_buf_8_18 r0 *1 0,0
Xsg13cmos5l_buf_8_18 \$2382 VPWR VGND \$12310 sg13cmos5l_buf_8
* cell instance sg13cmos5l_buf_8_19 r0 *1 0,0
Xsg13cmos5l_buf_8_19 \$2382 VPWR VGND \$2272 sg13cmos5l_buf_8
* cell instance sg13cmos5l_buf_8_20 r0 *1 0,0
Xsg13cmos5l_buf_8_20 \$2382 VPWR VGND \$2033 sg13cmos5l_buf_8
* cell instance sg13cmos5l_buf_8_21 r0 *1 0,0
Xsg13cmos5l_buf_8_21 \$12310 VPWR VGND \$14381 sg13cmos5l_buf_8
* cell instance sg13cmos5l_buf_8_22 r0 *1 0,0
Xsg13cmos5l_buf_8_22 \$12310 VPWR VGND \$11554 sg13cmos5l_buf_8
* cell instance sg13cmos5l_buf_8_23 r0 *1 0,0
Xsg13cmos5l_buf_8_23 \$2033 VPWR VGND \$687 sg13cmos5l_buf_8
* cell instance sg13cmos5l_buf_8_24 r0 *1 0,0
Xsg13cmos5l_buf_8_24 \$2190 VPWR VGND \$2781 sg13cmos5l_buf_8
* cell instance sg13cmos5l_buf_8_25 r0 *1 0,0
Xsg13cmos5l_buf_8_25 \$1383 VPWR VGND \$573 sg13cmos5l_buf_8
* cell instance sg13cmos5l_buf_8_26 r0 *1 0,0
Xsg13cmos5l_buf_8_26 \$2382 VPWR VGND \$2190 sg13cmos5l_buf_8
* cell instance sg13cmos5l_buf_8_27 r0 *1 0,0
Xsg13cmos5l_buf_8_27 \$2190 VPWR VGND \$2301 sg13cmos5l_buf_8
* cell instance sg13cmos5l_buf_8_28 r0 *1 0,0
Xsg13cmos5l_buf_8_28 \$2382 VPWR VGND \$1383 sg13cmos5l_buf_8
* cell instance sg13cmos5l_buf_8_29 r0 *1 0,0
Xsg13cmos5l_buf_8_29 \$1383 VPWR VGND \$1264 sg13cmos5l_buf_8
* cell instance sg13cmos5l_buf_8_30 r0 *1 0,0
Xsg13cmos5l_buf_8_30 \$2816 VPWR VGND \$2971 sg13cmos5l_buf_8
* cell instance sg13cmos5l_buf_8_31 r0 *1 0,0
Xsg13cmos5l_buf_8_31 \$4609 VPWR VGND \$2382 sg13cmos5l_buf_8
* cell instance sg13cmos5l_buf_8_32 r0 *1 0,0
Xsg13cmos5l_buf_8_32 clk VPWR VGND \$4609 sg13cmos5l_buf_8
* cell instance sg13cmos5l_buf_8_33 r0 *1 0,0
Xsg13cmos5l_buf_8_33 \$2204 VPWR VGND \$1741 sg13cmos5l_buf_8
* cell instance sg13cmos5l_buf_8_34 r0 *1 0,0
Xsg13cmos5l_buf_8_34 \$2382 VPWR VGND \$2816 sg13cmos5l_buf_8
* cell instance sg13cmos5l_buf_8_35 r0 *1 0,0
Xsg13cmos5l_buf_8_35 clk VPWR VGND \$17140 sg13cmos5l_buf_8
* cell instance sg13cmos5l_buf_8_36 r0 *1 0,0
Xsg13cmos5l_buf_8_36 \$2816 VPWR VGND \$3353 sg13cmos5l_buf_8
* cell instance sg13cmos5l_buf_8_37 r0 *1 0,0
Xsg13cmos5l_buf_8_37 \$4818 VPWR VGND \$4819 sg13cmos5l_buf_8
* cell instance sg13cmos5l_buf_8_38 r0 *1 0,0
Xsg13cmos5l_buf_8_38 \$2382 VPWR VGND \$2204 sg13cmos5l_buf_8
* cell instance sg13cmos5l_buf_8_39 r0 *1 0,0
Xsg13cmos5l_buf_8_39 \$17140 VPWR VGND \$4825 sg13cmos5l_buf_8
* cell instance sg13cmos5l_buf_8_40 r0 *1 0,0
Xsg13cmos5l_buf_8_40 \$4825 VPWR VGND \$4826 sg13cmos5l_buf_8
* cell instance sg13cmos5l_buf_8_41 r0 *1 0,0
Xsg13cmos5l_buf_8_41 \$4826 VPWR VGND \$4630 sg13cmos5l_buf_8
* cell instance sg13cmos5l_buf_8_42 r0 *1 0,0
Xsg13cmos5l_buf_8_42 \$4630 VPWR VGND \$4818 sg13cmos5l_buf_8
* cell instance sg13cmos5l_buf_8_43 r0 *1 0,0
Xsg13cmos5l_buf_8_43 \$2204 VPWR VGND \$2096 sg13cmos5l_buf_8
* cell instance sg13cmos5l_buf_8_44 r0 *1 0,0
Xsg13cmos5l_buf_8_44 \$3046 VPWR VGND \$3217 sg13cmos5l_buf_8
* cell instance sg13cmos5l_buf_8_45 r0 *1 0,0
Xsg13cmos5l_buf_8_45 \$2700 VPWR VGND \$2367 sg13cmos5l_buf_8
* cell instance sg13cmos5l_buf_8_46 r0 *1 0,0
Xsg13cmos5l_buf_8_46 \$2382 VPWR VGND \$2700 sg13cmos5l_buf_8
* cell instance sg13cmos5l_buf_8_47 r0 *1 0,0
Xsg13cmos5l_buf_8_47 \$2382 VPWR VGND \$3046 sg13cmos5l_buf_8
* cell instance sg13cmos5l_buf_8_48 r0 *1 0,0
Xsg13cmos5l_buf_8_48 \$3046 VPWR VGND \$3400 sg13cmos5l_buf_8
* cell instance sg13cmos5l_buf_8_49 r0 *1 0,0
Xsg13cmos5l_buf_8_49 \$2700 VPWR VGND \$3234 sg13cmos5l_buf_8
* cell instance sg13cmos5l_buf_8_50 r0 *1 0,0
Xsg13cmos5l_buf_8_50 \$2382 VPWR VGND \$2391 sg13cmos5l_buf_8
* cell instance sg13cmos5l_buf_8_51 r0 *1 0,0
Xsg13cmos5l_buf_8_51 \$2382 VPWR VGND \$2118 sg13cmos5l_buf_8
* cell instance sg13cmos5l_buf_8_52 r0 *1 0,0
Xsg13cmos5l_buf_8_52 \$2391 VPWR VGND \$3581 sg13cmos5l_buf_8
* cell instance sg13cmos5l_buf_8_53 r0 *1 0,0
Xsg13cmos5l_buf_8_53 \$2391 VPWR VGND \$2883 sg13cmos5l_buf_8
* cell instance sg13cmos5l_buf_8_54 r0 *1 0,0
Xsg13cmos5l_buf_8_54 \$2118 VPWR VGND \$2541 sg13cmos5l_buf_8
* cell instance sg13cmos5l_buf_8_55 r0 *1 0,0
Xsg13cmos5l_buf_8_55 \$2118 VPWR VGND \$2546 sg13cmos5l_buf_8
* cell instance sg13cmos5l_decap_4_0 r0 *1 0,0
Xsg13cmos5l_decap_4_0 VPWR VGND sg13cmos5l_decap_4
* cell instance sg13cmos5l_decap_4_1 r0 *1 0,0
Xsg13cmos5l_decap_4_1 VPWR VGND sg13cmos5l_decap_4
* cell instance sg13cmos5l_decap_4_2 r0 *1 0,0
Xsg13cmos5l_decap_4_2 VPWR VGND sg13cmos5l_decap_4
* cell instance sg13cmos5l_decap_4_3 r0 *1 0,0
Xsg13cmos5l_decap_4_3 VPWR VGND sg13cmos5l_decap_4
* cell instance sg13cmos5l_decap_4_4 r0 *1 0,0
Xsg13cmos5l_decap_4_4 VPWR VGND sg13cmos5l_decap_4
* cell instance sg13cmos5l_decap_4_5 r0 *1 0,0
Xsg13cmos5l_decap_4_5 VPWR VGND sg13cmos5l_decap_4
* cell instance sg13cmos5l_decap_4_6 r0 *1 0,0
Xsg13cmos5l_decap_4_6 VPWR VGND sg13cmos5l_decap_4
* cell instance sg13cmos5l_decap_4_7 r0 *1 0,0
Xsg13cmos5l_decap_4_7 VPWR VGND sg13cmos5l_decap_4
* cell instance sg13cmos5l_decap_4_8 r0 *1 0,0
Xsg13cmos5l_decap_4_8 VPWR VGND sg13cmos5l_decap_4
* cell instance sg13cmos5l_decap_4_9 r0 *1 0,0
Xsg13cmos5l_decap_4_9 VPWR VGND sg13cmos5l_decap_4
* cell instance sg13cmos5l_decap_4_10 r0 *1 0,0
Xsg13cmos5l_decap_4_10 VPWR VGND sg13cmos5l_decap_4
* cell instance sg13cmos5l_decap_4_11 r0 *1 0,0
Xsg13cmos5l_decap_4_11 VPWR VGND sg13cmos5l_decap_4
* cell instance sg13cmos5l_decap_4_12 r0 *1 0,0
Xsg13cmos5l_decap_4_12 VPWR VGND sg13cmos5l_decap_4
* cell instance sg13cmos5l_decap_4_13 r0 *1 0,0
Xsg13cmos5l_decap_4_13 VPWR VGND sg13cmos5l_decap_4
* cell instance sg13cmos5l_decap_4_14 r0 *1 0,0
Xsg13cmos5l_decap_4_14 VPWR VGND sg13cmos5l_decap_4
* cell instance sg13cmos5l_decap_4_15 r0 *1 0,0
Xsg13cmos5l_decap_4_15 VPWR VGND sg13cmos5l_decap_4
* cell instance sg13cmos5l_decap_4_16 r0 *1 0,0
Xsg13cmos5l_decap_4_16 VPWR VGND sg13cmos5l_decap_4
* cell instance sg13cmos5l_decap_4_17 r0 *1 0,0
Xsg13cmos5l_decap_4_17 VPWR VGND sg13cmos5l_decap_4
* cell instance sg13cmos5l_decap_4_18 r0 *1 0,0
Xsg13cmos5l_decap_4_18 VPWR VGND sg13cmos5l_decap_4
* cell instance sg13cmos5l_decap_4_19 r0 *1 0,0
Xsg13cmos5l_decap_4_19 VPWR VGND sg13cmos5l_decap_4
* cell instance sg13cmos5l_decap_4_20 r0 *1 0,0
Xsg13cmos5l_decap_4_20 VPWR VGND sg13cmos5l_decap_4
* cell instance sg13cmos5l_decap_4_21 r0 *1 0,0
Xsg13cmos5l_decap_4_21 VPWR VGND sg13cmos5l_decap_4
* cell instance sg13cmos5l_decap_4_22 r0 *1 0,0
Xsg13cmos5l_decap_4_22 VPWR VGND sg13cmos5l_decap_4
* cell instance sg13cmos5l_decap_4_23 r0 *1 0,0
Xsg13cmos5l_decap_4_23 VPWR VGND sg13cmos5l_decap_4
* cell instance sg13cmos5l_decap_4_24 r0 *1 0,0
Xsg13cmos5l_decap_4_24 VPWR VGND sg13cmos5l_decap_4
* cell instance sg13cmos5l_decap_4_25 r0 *1 0,0
Xsg13cmos5l_decap_4_25 VPWR VGND sg13cmos5l_decap_4
* cell instance sg13cmos5l_decap_4_26 r0 *1 0,0
Xsg13cmos5l_decap_4_26 VPWR VGND sg13cmos5l_decap_4
* cell instance sg13cmos5l_decap_4_27 r0 *1 0,0
Xsg13cmos5l_decap_4_27 VPWR VGND sg13cmos5l_decap_4
* cell instance sg13cmos5l_decap_4_28 r0 *1 0,0
Xsg13cmos5l_decap_4_28 VPWR VGND sg13cmos5l_decap_4
* cell instance sg13cmos5l_decap_4_29 r0 *1 0,0
Xsg13cmos5l_decap_4_29 VPWR VGND sg13cmos5l_decap_4
* cell instance sg13cmos5l_decap_4_30 r0 *1 0,0
Xsg13cmos5l_decap_4_30 VPWR VGND sg13cmos5l_decap_4
* cell instance sg13cmos5l_decap_4_31 r0 *1 0,0
Xsg13cmos5l_decap_4_31 VPWR VGND sg13cmos5l_decap_4
* cell instance sg13cmos5l_decap_4_32 r0 *1 0,0
Xsg13cmos5l_decap_4_32 VPWR VGND sg13cmos5l_decap_4
* cell instance sg13cmos5l_decap_4_33 r0 *1 0,0
Xsg13cmos5l_decap_4_33 VPWR VGND sg13cmos5l_decap_4
* cell instance sg13cmos5l_decap_4_34 r0 *1 0,0
Xsg13cmos5l_decap_4_34 VPWR VGND sg13cmos5l_decap_4
* cell instance sg13cmos5l_decap_4_35 r0 *1 0,0
Xsg13cmos5l_decap_4_35 VPWR VGND sg13cmos5l_decap_4
* cell instance sg13cmos5l_decap_4_36 r0 *1 0,0
Xsg13cmos5l_decap_4_36 VPWR VGND sg13cmos5l_decap_4
* cell instance sg13cmos5l_decap_4_37 r0 *1 0,0
Xsg13cmos5l_decap_4_37 VPWR VGND sg13cmos5l_decap_4
* cell instance sg13cmos5l_decap_4_38 r0 *1 0,0
Xsg13cmos5l_decap_4_38 VPWR VGND sg13cmos5l_decap_4
* cell instance sg13cmos5l_decap_4_39 r0 *1 0,0
Xsg13cmos5l_decap_4_39 VPWR VGND sg13cmos5l_decap_4
* cell instance sg13cmos5l_decap_4_40 r0 *1 0,0
Xsg13cmos5l_decap_4_40 VPWR VGND sg13cmos5l_decap_4
* cell instance sg13cmos5l_decap_4_41 r0 *1 0,0
Xsg13cmos5l_decap_4_41 VPWR VGND sg13cmos5l_decap_4
* cell instance sg13cmos5l_decap_4_42 r0 *1 0,0
Xsg13cmos5l_decap_4_42 VPWR VGND sg13cmos5l_decap_4
* cell instance sg13cmos5l_decap_4_43 r0 *1 0,0
Xsg13cmos5l_decap_4_43 VPWR VGND sg13cmos5l_decap_4
* cell instance sg13cmos5l_decap_4_44 r0 *1 0,0
Xsg13cmos5l_decap_4_44 VPWR VGND sg13cmos5l_decap_4
* cell instance sg13cmos5l_decap_4_45 r0 *1 0,0
Xsg13cmos5l_decap_4_45 VPWR VGND sg13cmos5l_decap_4
* cell instance sg13cmos5l_decap_4_46 r0 *1 0,0
Xsg13cmos5l_decap_4_46 VPWR VGND sg13cmos5l_decap_4
* cell instance sg13cmos5l_decap_4_47 r0 *1 0,0
Xsg13cmos5l_decap_4_47 VPWR VGND sg13cmos5l_decap_4
* cell instance sg13cmos5l_decap_4_48 r0 *1 0,0
Xsg13cmos5l_decap_4_48 VPWR VGND sg13cmos5l_decap_4
* cell instance sg13cmos5l_decap_4_49 r0 *1 0,0
Xsg13cmos5l_decap_4_49 VPWR VGND sg13cmos5l_decap_4
* cell instance sg13cmos5l_decap_4_50 r0 *1 0,0
Xsg13cmos5l_decap_4_50 VPWR VGND sg13cmos5l_decap_4
* cell instance sg13cmos5l_decap_4_51 r0 *1 0,0
Xsg13cmos5l_decap_4_51 VPWR VGND sg13cmos5l_decap_4
* cell instance sg13cmos5l_decap_4_52 r0 *1 0,0
Xsg13cmos5l_decap_4_52 VPWR VGND sg13cmos5l_decap_4
* cell instance sg13cmos5l_decap_4_53 r0 *1 0,0
Xsg13cmos5l_decap_4_53 VPWR VGND sg13cmos5l_decap_4
* cell instance sg13cmos5l_decap_4_54 r0 *1 0,0
Xsg13cmos5l_decap_4_54 VPWR VGND sg13cmos5l_decap_4
* cell instance sg13cmos5l_decap_4_55 r0 *1 0,0
Xsg13cmos5l_decap_4_55 VPWR VGND sg13cmos5l_decap_4
* cell instance sg13cmos5l_decap_4_56 r0 *1 0,0
Xsg13cmos5l_decap_4_56 VPWR VGND sg13cmos5l_decap_4
* cell instance sg13cmos5l_decap_4_57 r0 *1 0,0
Xsg13cmos5l_decap_4_57 VPWR VGND sg13cmos5l_decap_4
* cell instance sg13cmos5l_decap_4_58 r0 *1 0,0
Xsg13cmos5l_decap_4_58 VPWR VGND sg13cmos5l_decap_4
* cell instance sg13cmos5l_decap_4_59 r0 *1 0,0
Xsg13cmos5l_decap_4_59 VPWR VGND sg13cmos5l_decap_4
* cell instance sg13cmos5l_decap_4_60 r0 *1 0,0
Xsg13cmos5l_decap_4_60 VPWR VGND sg13cmos5l_decap_4
* cell instance sg13cmos5l_decap_4_61 r0 *1 0,0
Xsg13cmos5l_decap_4_61 VPWR VGND sg13cmos5l_decap_4
* cell instance sg13cmos5l_decap_4_62 r0 *1 0,0
Xsg13cmos5l_decap_4_62 VPWR VGND sg13cmos5l_decap_4
* cell instance sg13cmos5l_decap_4_63 r0 *1 0,0
Xsg13cmos5l_decap_4_63 VPWR VGND sg13cmos5l_decap_4
* cell instance sg13cmos5l_decap_4_64 r0 *1 0,0
Xsg13cmos5l_decap_4_64 VPWR VGND sg13cmos5l_decap_4
* cell instance sg13cmos5l_decap_4_65 r0 *1 0,0
Xsg13cmos5l_decap_4_65 VPWR VGND sg13cmos5l_decap_4
* cell instance sg13cmos5l_decap_4_66 r0 *1 0,0
Xsg13cmos5l_decap_4_66 VPWR VGND sg13cmos5l_decap_4
* cell instance sg13cmos5l_decap_4_67 r0 *1 0,0
Xsg13cmos5l_decap_4_67 VPWR VGND sg13cmos5l_decap_4
* cell instance sg13cmos5l_decap_4_68 r0 *1 0,0
Xsg13cmos5l_decap_4_68 VPWR VGND sg13cmos5l_decap_4
* cell instance sg13cmos5l_decap_4_69 r0 *1 0,0
Xsg13cmos5l_decap_4_69 VPWR VGND sg13cmos5l_decap_4
* cell instance sg13cmos5l_decap_4_70 r0 *1 0,0
Xsg13cmos5l_decap_4_70 VPWR VGND sg13cmos5l_decap_4
* cell instance sg13cmos5l_decap_4_71 r0 *1 0,0
Xsg13cmos5l_decap_4_71 VPWR VGND sg13cmos5l_decap_4
* cell instance sg13cmos5l_decap_4_72 r0 *1 0,0
Xsg13cmos5l_decap_4_72 VPWR VGND sg13cmos5l_decap_4
* cell instance sg13cmos5l_decap_4_73 r0 *1 0,0
Xsg13cmos5l_decap_4_73 VPWR VGND sg13cmos5l_decap_4
* cell instance sg13cmos5l_decap_4_74 r0 *1 0,0
Xsg13cmos5l_decap_4_74 VPWR VGND sg13cmos5l_decap_4
* cell instance sg13cmos5l_decap_4_75 r0 *1 0,0
Xsg13cmos5l_decap_4_75 VPWR VGND sg13cmos5l_decap_4
* cell instance sg13cmos5l_decap_4_76 r0 *1 0,0
Xsg13cmos5l_decap_4_76 VPWR VGND sg13cmos5l_decap_4
* cell instance sg13cmos5l_decap_4_77 r0 *1 0,0
Xsg13cmos5l_decap_4_77 VPWR VGND sg13cmos5l_decap_4
* cell instance sg13cmos5l_decap_4_78 r0 *1 0,0
Xsg13cmos5l_decap_4_78 VPWR VGND sg13cmos5l_decap_4
* cell instance sg13cmos5l_decap_4_79 r0 *1 0,0
Xsg13cmos5l_decap_4_79 VPWR VGND sg13cmos5l_decap_4
* cell instance sg13cmos5l_decap_4_80 r0 *1 0,0
Xsg13cmos5l_decap_4_80 VPWR VGND sg13cmos5l_decap_4
* cell instance sg13cmos5l_decap_4_81 r0 *1 0,0
Xsg13cmos5l_decap_4_81 VPWR VGND sg13cmos5l_decap_4
* cell instance sg13cmos5l_decap_4_82 r0 *1 0,0
Xsg13cmos5l_decap_4_82 VPWR VGND sg13cmos5l_decap_4
* cell instance sg13cmos5l_decap_4_83 r0 *1 0,0
Xsg13cmos5l_decap_4_83 VPWR VGND sg13cmos5l_decap_4
* cell instance sg13cmos5l_decap_4_84 r0 *1 0,0
Xsg13cmos5l_decap_4_84 VPWR VGND sg13cmos5l_decap_4
* cell instance sg13cmos5l_decap_4_85 r0 *1 0,0
Xsg13cmos5l_decap_4_85 VPWR VGND sg13cmos5l_decap_4
* cell instance sg13cmos5l_decap_4_86 r0 *1 0,0
Xsg13cmos5l_decap_4_86 VPWR VGND sg13cmos5l_decap_4
* cell instance sg13cmos5l_decap_4_87 r0 *1 0,0
Xsg13cmos5l_decap_4_87 VPWR VGND sg13cmos5l_decap_4
* cell instance sg13cmos5l_decap_4_88 r0 *1 0,0
Xsg13cmos5l_decap_4_88 VPWR VGND sg13cmos5l_decap_4
* cell instance sg13cmos5l_decap_4_89 r0 *1 0,0
Xsg13cmos5l_decap_4_89 VPWR VGND sg13cmos5l_decap_4
* cell instance sg13cmos5l_decap_4_90 r0 *1 0,0
Xsg13cmos5l_decap_4_90 VPWR VGND sg13cmos5l_decap_4
* cell instance sg13cmos5l_decap_4_91 r0 *1 0,0
Xsg13cmos5l_decap_4_91 VPWR VGND sg13cmos5l_decap_4
* cell instance sg13cmos5l_decap_4_92 r0 *1 0,0
Xsg13cmos5l_decap_4_92 VPWR VGND sg13cmos5l_decap_4
* cell instance sg13cmos5l_decap_4_93 r0 *1 0,0
Xsg13cmos5l_decap_4_93 VPWR VGND sg13cmos5l_decap_4
* cell instance sg13cmos5l_decap_4_94 r0 *1 0,0
Xsg13cmos5l_decap_4_94 VPWR VGND sg13cmos5l_decap_4
* cell instance sg13cmos5l_decap_4_95 r0 *1 0,0
Xsg13cmos5l_decap_4_95 VPWR VGND sg13cmos5l_decap_4
* cell instance sg13cmos5l_decap_4_96 r0 *1 0,0
Xsg13cmos5l_decap_4_96 VPWR VGND sg13cmos5l_decap_4
* cell instance sg13cmos5l_decap_4_97 r0 *1 0,0
Xsg13cmos5l_decap_4_97 VPWR VGND sg13cmos5l_decap_4
* cell instance sg13cmos5l_decap_4_98 r0 *1 0,0
Xsg13cmos5l_decap_4_98 VPWR VGND sg13cmos5l_decap_4
* cell instance sg13cmos5l_decap_4_99 r0 *1 0,0
Xsg13cmos5l_decap_4_99 VPWR VGND sg13cmos5l_decap_4
* cell instance sg13cmos5l_decap_4_100 r0 *1 0,0
Xsg13cmos5l_decap_4_100 VPWR VGND sg13cmos5l_decap_4
* cell instance sg13cmos5l_decap_4_101 r0 *1 0,0
Xsg13cmos5l_decap_4_101 VPWR VGND sg13cmos5l_decap_4
* cell instance sg13cmos5l_decap_4_102 r0 *1 0,0
Xsg13cmos5l_decap_4_102 VPWR VGND sg13cmos5l_decap_4
* cell instance sg13cmos5l_decap_4_103 r0 *1 0,0
Xsg13cmos5l_decap_4_103 VPWR VGND sg13cmos5l_decap_4
* cell instance sg13cmos5l_decap_4_104 r0 *1 0,0
Xsg13cmos5l_decap_4_104 VPWR VGND sg13cmos5l_decap_4
* cell instance sg13cmos5l_decap_4_105 r0 *1 0,0
Xsg13cmos5l_decap_4_105 VPWR VGND sg13cmos5l_decap_4
* cell instance sg13cmos5l_decap_4_106 r0 *1 0,0
Xsg13cmos5l_decap_4_106 VPWR VGND sg13cmos5l_decap_4
* cell instance sg13cmos5l_decap_4_107 r0 *1 0,0
Xsg13cmos5l_decap_4_107 VPWR VGND sg13cmos5l_decap_4
* cell instance sg13cmos5l_decap_4_108 r0 *1 0,0
Xsg13cmos5l_decap_4_108 VPWR VGND sg13cmos5l_decap_4
* cell instance sg13cmos5l_decap_4_109 r0 *1 0,0
Xsg13cmos5l_decap_4_109 VPWR VGND sg13cmos5l_decap_4
* cell instance sg13cmos5l_decap_4_110 r0 *1 0,0
Xsg13cmos5l_decap_4_110 VPWR VGND sg13cmos5l_decap_4
* cell instance sg13cmos5l_decap_4_111 r0 *1 0,0
Xsg13cmos5l_decap_4_111 VPWR VGND sg13cmos5l_decap_4
* cell instance sg13cmos5l_decap_4_112 r0 *1 0,0
Xsg13cmos5l_decap_4_112 VPWR VGND sg13cmos5l_decap_4
* cell instance sg13cmos5l_decap_4_113 r0 *1 0,0
Xsg13cmos5l_decap_4_113 VPWR VGND sg13cmos5l_decap_4
* cell instance sg13cmos5l_decap_4_114 r0 *1 0,0
Xsg13cmos5l_decap_4_114 VPWR VGND sg13cmos5l_decap_4
* cell instance sg13cmos5l_decap_4_115 r0 *1 0,0
Xsg13cmos5l_decap_4_115 VPWR VGND sg13cmos5l_decap_4
* cell instance sg13cmos5l_decap_4_116 r0 *1 0,0
Xsg13cmos5l_decap_4_116 VPWR VGND sg13cmos5l_decap_4
* cell instance sg13cmos5l_decap_4_117 r0 *1 0,0
Xsg13cmos5l_decap_4_117 VPWR VGND sg13cmos5l_decap_4
* cell instance sg13cmos5l_decap_4_118 r0 *1 0,0
Xsg13cmos5l_decap_4_118 VPWR VGND sg13cmos5l_decap_4
* cell instance sg13cmos5l_decap_4_119 r0 *1 0,0
Xsg13cmos5l_decap_4_119 VPWR VGND sg13cmos5l_decap_4
* cell instance sg13cmos5l_decap_4_120 r0 *1 0,0
Xsg13cmos5l_decap_4_120 VPWR VGND sg13cmos5l_decap_4
* cell instance sg13cmos5l_decap_4_121 r0 *1 0,0
Xsg13cmos5l_decap_4_121 VPWR VGND sg13cmos5l_decap_4
* cell instance sg13cmos5l_decap_4_122 r0 *1 0,0
Xsg13cmos5l_decap_4_122 VPWR VGND sg13cmos5l_decap_4
* cell instance sg13cmos5l_decap_4_123 r0 *1 0,0
Xsg13cmos5l_decap_4_123 VPWR VGND sg13cmos5l_decap_4
* cell instance sg13cmos5l_decap_4_124 r0 *1 0,0
Xsg13cmos5l_decap_4_124 VPWR VGND sg13cmos5l_decap_4
* cell instance sg13cmos5l_decap_4_125 r0 *1 0,0
Xsg13cmos5l_decap_4_125 VPWR VGND sg13cmos5l_decap_4
* cell instance sg13cmos5l_decap_4_126 r0 *1 0,0
Xsg13cmos5l_decap_4_126 VPWR VGND sg13cmos5l_decap_4
* cell instance sg13cmos5l_decap_4_127 r0 *1 0,0
Xsg13cmos5l_decap_4_127 VPWR VGND sg13cmos5l_decap_4
* cell instance sg13cmos5l_decap_4_128 r0 *1 0,0
Xsg13cmos5l_decap_4_128 VPWR VGND sg13cmos5l_decap_4
* cell instance sg13cmos5l_decap_4_129 r0 *1 0,0
Xsg13cmos5l_decap_4_129 VPWR VGND sg13cmos5l_decap_4
* cell instance sg13cmos5l_decap_4_130 r0 *1 0,0
Xsg13cmos5l_decap_4_130 VPWR VGND sg13cmos5l_decap_4
* cell instance sg13cmos5l_decap_4_131 r0 *1 0,0
Xsg13cmos5l_decap_4_131 VPWR VGND sg13cmos5l_decap_4
* cell instance sg13cmos5l_decap_4_132 r0 *1 0,0
Xsg13cmos5l_decap_4_132 VPWR VGND sg13cmos5l_decap_4
* cell instance sg13cmos5l_decap_4_133 r0 *1 0,0
Xsg13cmos5l_decap_4_133 VPWR VGND sg13cmos5l_decap_4
* cell instance sg13cmos5l_decap_4_134 r0 *1 0,0
Xsg13cmos5l_decap_4_134 VPWR VGND sg13cmos5l_decap_4
* cell instance sg13cmos5l_decap_4_135 r0 *1 0,0
Xsg13cmos5l_decap_4_135 VPWR VGND sg13cmos5l_decap_4
* cell instance sg13cmos5l_decap_4_136 r0 *1 0,0
Xsg13cmos5l_decap_4_136 VPWR VGND sg13cmos5l_decap_4
* cell instance sg13cmos5l_decap_4_137 r0 *1 0,0
Xsg13cmos5l_decap_4_137 VPWR VGND sg13cmos5l_decap_4
* cell instance sg13cmos5l_decap_4_138 r0 *1 0,0
Xsg13cmos5l_decap_4_138 VPWR VGND sg13cmos5l_decap_4
* cell instance sg13cmos5l_decap_4_139 r0 *1 0,0
Xsg13cmos5l_decap_4_139 VPWR VGND sg13cmos5l_decap_4
* cell instance sg13cmos5l_decap_4_140 r0 *1 0,0
Xsg13cmos5l_decap_4_140 VPWR VGND sg13cmos5l_decap_4
* cell instance sg13cmos5l_decap_4_141 r0 *1 0,0
Xsg13cmos5l_decap_4_141 VPWR VGND sg13cmos5l_decap_4
* cell instance sg13cmos5l_decap_4_142 r0 *1 0,0
Xsg13cmos5l_decap_4_142 VPWR VGND sg13cmos5l_decap_4
* cell instance sg13cmos5l_decap_4_143 r0 *1 0,0
Xsg13cmos5l_decap_4_143 VPWR VGND sg13cmos5l_decap_4
* cell instance sg13cmos5l_decap_4_144 r0 *1 0,0
Xsg13cmos5l_decap_4_144 VPWR VGND sg13cmos5l_decap_4
* cell instance sg13cmos5l_decap_4_145 r0 *1 0,0
Xsg13cmos5l_decap_4_145 VPWR VGND sg13cmos5l_decap_4
* cell instance sg13cmos5l_decap_4_146 r0 *1 0,0
Xsg13cmos5l_decap_4_146 VPWR VGND sg13cmos5l_decap_4
* cell instance sg13cmos5l_decap_4_147 r0 *1 0,0
Xsg13cmos5l_decap_4_147 VPWR VGND sg13cmos5l_decap_4
* cell instance sg13cmos5l_decap_4_148 r0 *1 0,0
Xsg13cmos5l_decap_4_148 VPWR VGND sg13cmos5l_decap_4
* cell instance sg13cmos5l_decap_4_149 r0 *1 0,0
Xsg13cmos5l_decap_4_149 VPWR VGND sg13cmos5l_decap_4
* cell instance sg13cmos5l_decap_4_150 r0 *1 0,0
Xsg13cmos5l_decap_4_150 VPWR VGND sg13cmos5l_decap_4
* cell instance sg13cmos5l_decap_4_151 r0 *1 0,0
Xsg13cmos5l_decap_4_151 VPWR VGND sg13cmos5l_decap_4
* cell instance sg13cmos5l_decap_4_152 r0 *1 0,0
Xsg13cmos5l_decap_4_152 VPWR VGND sg13cmos5l_decap_4
* cell instance sg13cmos5l_decap_4_153 r0 *1 0,0
Xsg13cmos5l_decap_4_153 VPWR VGND sg13cmos5l_decap_4
* cell instance sg13cmos5l_decap_4_154 r0 *1 0,0
Xsg13cmos5l_decap_4_154 VPWR VGND sg13cmos5l_decap_4
* cell instance sg13cmos5l_decap_4_155 r0 *1 0,0
Xsg13cmos5l_decap_4_155 VPWR VGND sg13cmos5l_decap_4
* cell instance sg13cmos5l_decap_4_156 r0 *1 0,0
Xsg13cmos5l_decap_4_156 VPWR VGND sg13cmos5l_decap_4
* cell instance sg13cmos5l_decap_4_157 r0 *1 0,0
Xsg13cmos5l_decap_4_157 VPWR VGND sg13cmos5l_decap_4
* cell instance sg13cmos5l_decap_4_158 r0 *1 0,0
Xsg13cmos5l_decap_4_158 VPWR VGND sg13cmos5l_decap_4
* cell instance sg13cmos5l_decap_4_159 r0 *1 0,0
Xsg13cmos5l_decap_4_159 VPWR VGND sg13cmos5l_decap_4
* cell instance sg13cmos5l_decap_4_160 r0 *1 0,0
Xsg13cmos5l_decap_4_160 VPWR VGND sg13cmos5l_decap_4
* cell instance sg13cmos5l_decap_4_161 r0 *1 0,0
Xsg13cmos5l_decap_4_161 VPWR VGND sg13cmos5l_decap_4
* cell instance sg13cmos5l_decap_4_162 r0 *1 0,0
Xsg13cmos5l_decap_4_162 VPWR VGND sg13cmos5l_decap_4
* cell instance sg13cmos5l_decap_4_163 r0 *1 0,0
Xsg13cmos5l_decap_4_163 VPWR VGND sg13cmos5l_decap_4
* cell instance sg13cmos5l_decap_4_164 r0 *1 0,0
Xsg13cmos5l_decap_4_164 VPWR VGND sg13cmos5l_decap_4
* cell instance sg13cmos5l_decap_4_165 r0 *1 0,0
Xsg13cmos5l_decap_4_165 VPWR VGND sg13cmos5l_decap_4
* cell instance sg13cmos5l_decap_4_166 r0 *1 0,0
Xsg13cmos5l_decap_4_166 VPWR VGND sg13cmos5l_decap_4
* cell instance sg13cmos5l_decap_4_167 r0 *1 0,0
Xsg13cmos5l_decap_4_167 VPWR VGND sg13cmos5l_decap_4
* cell instance sg13cmos5l_decap_4_168 r0 *1 0,0
Xsg13cmos5l_decap_4_168 VPWR VGND sg13cmos5l_decap_4
* cell instance sg13cmos5l_decap_4_169 r0 *1 0,0
Xsg13cmos5l_decap_4_169 VPWR VGND sg13cmos5l_decap_4
* cell instance sg13cmos5l_decap_4_170 r0 *1 0,0
Xsg13cmos5l_decap_4_170 VPWR VGND sg13cmos5l_decap_4
* cell instance sg13cmos5l_decap_4_171 r0 *1 0,0
Xsg13cmos5l_decap_4_171 VPWR VGND sg13cmos5l_decap_4
* cell instance sg13cmos5l_decap_4_172 r0 *1 0,0
Xsg13cmos5l_decap_4_172 VPWR VGND sg13cmos5l_decap_4
* cell instance sg13cmos5l_decap_4_173 r0 *1 0,0
Xsg13cmos5l_decap_4_173 VPWR VGND sg13cmos5l_decap_4
* cell instance sg13cmos5l_decap_4_174 r0 *1 0,0
Xsg13cmos5l_decap_4_174 VPWR VGND sg13cmos5l_decap_4
* cell instance sg13cmos5l_decap_4_175 r0 *1 0,0
Xsg13cmos5l_decap_4_175 VPWR VGND sg13cmos5l_decap_4
* cell instance sg13cmos5l_decap_4_176 r0 *1 0,0
Xsg13cmos5l_decap_4_176 VPWR VGND sg13cmos5l_decap_4
* cell instance sg13cmos5l_decap_4_177 r0 *1 0,0
Xsg13cmos5l_decap_4_177 VPWR VGND sg13cmos5l_decap_4
* cell instance sg13cmos5l_decap_4_178 r0 *1 0,0
Xsg13cmos5l_decap_4_178 VPWR VGND sg13cmos5l_decap_4
* cell instance sg13cmos5l_decap_4_179 r0 *1 0,0
Xsg13cmos5l_decap_4_179 VPWR VGND sg13cmos5l_decap_4
* cell instance sg13cmos5l_decap_4_180 r0 *1 0,0
Xsg13cmos5l_decap_4_180 VPWR VGND sg13cmos5l_decap_4
* cell instance sg13cmos5l_decap_4_181 r0 *1 0,0
Xsg13cmos5l_decap_4_181 VPWR VGND sg13cmos5l_decap_4
* cell instance sg13cmos5l_decap_4_182 r0 *1 0,0
Xsg13cmos5l_decap_4_182 VPWR VGND sg13cmos5l_decap_4
* cell instance sg13cmos5l_decap_4_183 r0 *1 0,0
Xsg13cmos5l_decap_4_183 VPWR VGND sg13cmos5l_decap_4
* cell instance sg13cmos5l_decap_4_184 r0 *1 0,0
Xsg13cmos5l_decap_4_184 VPWR VGND sg13cmos5l_decap_4
* cell instance sg13cmos5l_decap_4_185 r0 *1 0,0
Xsg13cmos5l_decap_4_185 VPWR VGND sg13cmos5l_decap_4
* cell instance sg13cmos5l_decap_4_186 r0 *1 0,0
Xsg13cmos5l_decap_4_186 VPWR VGND sg13cmos5l_decap_4
* cell instance sg13cmos5l_decap_4_187 r0 *1 0,0
Xsg13cmos5l_decap_4_187 VPWR VGND sg13cmos5l_decap_4
* cell instance sg13cmos5l_decap_4_188 r0 *1 0,0
Xsg13cmos5l_decap_4_188 VPWR VGND sg13cmos5l_decap_4
* cell instance sg13cmos5l_decap_4_189 r0 *1 0,0
Xsg13cmos5l_decap_4_189 VPWR VGND sg13cmos5l_decap_4
* cell instance sg13cmos5l_decap_4_190 r0 *1 0,0
Xsg13cmos5l_decap_4_190 VPWR VGND sg13cmos5l_decap_4
* cell instance sg13cmos5l_decap_4_191 r0 *1 0,0
Xsg13cmos5l_decap_4_191 VPWR VGND sg13cmos5l_decap_4
* cell instance sg13cmos5l_decap_4_192 r0 *1 0,0
Xsg13cmos5l_decap_4_192 VPWR VGND sg13cmos5l_decap_4
* cell instance sg13cmos5l_decap_4_193 r0 *1 0,0
Xsg13cmos5l_decap_4_193 VPWR VGND sg13cmos5l_decap_4
* cell instance sg13cmos5l_decap_4_194 r0 *1 0,0
Xsg13cmos5l_decap_4_194 VPWR VGND sg13cmos5l_decap_4
* cell instance sg13cmos5l_decap_4_195 r0 *1 0,0
Xsg13cmos5l_decap_4_195 VPWR VGND sg13cmos5l_decap_4
* cell instance sg13cmos5l_decap_4_196 r0 *1 0,0
Xsg13cmos5l_decap_4_196 VPWR VGND sg13cmos5l_decap_4
* cell instance sg13cmos5l_decap_4_197 r0 *1 0,0
Xsg13cmos5l_decap_4_197 VPWR VGND sg13cmos5l_decap_4
* cell instance sg13cmos5l_decap_4_198 r0 *1 0,0
Xsg13cmos5l_decap_4_198 VPWR VGND sg13cmos5l_decap_4
* cell instance sg13cmos5l_decap_4_199 r0 *1 0,0
Xsg13cmos5l_decap_4_199 VPWR VGND sg13cmos5l_decap_4
* cell instance sg13cmos5l_decap_4_200 r0 *1 0,0
Xsg13cmos5l_decap_4_200 VPWR VGND sg13cmos5l_decap_4
* cell instance sg13cmos5l_decap_4_201 r0 *1 0,0
Xsg13cmos5l_decap_4_201 VPWR VGND sg13cmos5l_decap_4
* cell instance sg13cmos5l_decap_4_202 r0 *1 0,0
Xsg13cmos5l_decap_4_202 VPWR VGND sg13cmos5l_decap_4
* cell instance sg13cmos5l_decap_4_203 r0 *1 0,0
Xsg13cmos5l_decap_4_203 VPWR VGND sg13cmos5l_decap_4
* cell instance sg13cmos5l_decap_4_204 r0 *1 0,0
Xsg13cmos5l_decap_4_204 VPWR VGND sg13cmos5l_decap_4
* cell instance sg13cmos5l_decap_4_205 r0 *1 0,0
Xsg13cmos5l_decap_4_205 VPWR VGND sg13cmos5l_decap_4
* cell instance sg13cmos5l_decap_4_206 r0 *1 0,0
Xsg13cmos5l_decap_4_206 VPWR VGND sg13cmos5l_decap_4
* cell instance sg13cmos5l_decap_4_207 r0 *1 0,0
Xsg13cmos5l_decap_4_207 VPWR VGND sg13cmos5l_decap_4
* cell instance sg13cmos5l_decap_4_208 r0 *1 0,0
Xsg13cmos5l_decap_4_208 VPWR VGND sg13cmos5l_decap_4
* cell instance sg13cmos5l_decap_4_209 r0 *1 0,0
Xsg13cmos5l_decap_4_209 VPWR VGND sg13cmos5l_decap_4
* cell instance sg13cmos5l_decap_4_210 r0 *1 0,0
Xsg13cmos5l_decap_4_210 VPWR VGND sg13cmos5l_decap_4
* cell instance sg13cmos5l_decap_4_211 r0 *1 0,0
Xsg13cmos5l_decap_4_211 VPWR VGND sg13cmos5l_decap_4
* cell instance sg13cmos5l_decap_4_212 r0 *1 0,0
Xsg13cmos5l_decap_4_212 VPWR VGND sg13cmos5l_decap_4
* cell instance sg13cmos5l_decap_4_213 r0 *1 0,0
Xsg13cmos5l_decap_4_213 VPWR VGND sg13cmos5l_decap_4
* cell instance sg13cmos5l_decap_4_214 r0 *1 0,0
Xsg13cmos5l_decap_4_214 VPWR VGND sg13cmos5l_decap_4
* cell instance sg13cmos5l_decap_4_215 r0 *1 0,0
Xsg13cmos5l_decap_4_215 VPWR VGND sg13cmos5l_decap_4
* cell instance sg13cmos5l_decap_4_216 r0 *1 0,0
Xsg13cmos5l_decap_4_216 VPWR VGND sg13cmos5l_decap_4
* cell instance sg13cmos5l_decap_4_217 r0 *1 0,0
Xsg13cmos5l_decap_4_217 VPWR VGND sg13cmos5l_decap_4
* cell instance sg13cmos5l_decap_4_218 r0 *1 0,0
Xsg13cmos5l_decap_4_218 VPWR VGND sg13cmos5l_decap_4
* cell instance sg13cmos5l_decap_4_219 r0 *1 0,0
Xsg13cmos5l_decap_4_219 VPWR VGND sg13cmos5l_decap_4
* cell instance sg13cmos5l_decap_4_220 r0 *1 0,0
Xsg13cmos5l_decap_4_220 VPWR VGND sg13cmos5l_decap_4
* cell instance sg13cmos5l_decap_4_221 r0 *1 0,0
Xsg13cmos5l_decap_4_221 VPWR VGND sg13cmos5l_decap_4
* cell instance sg13cmos5l_decap_4_222 r0 *1 0,0
Xsg13cmos5l_decap_4_222 VPWR VGND sg13cmos5l_decap_4
* cell instance sg13cmos5l_decap_4_223 r0 *1 0,0
Xsg13cmos5l_decap_4_223 VPWR VGND sg13cmos5l_decap_4
* cell instance sg13cmos5l_decap_4_224 r0 *1 0,0
Xsg13cmos5l_decap_4_224 VPWR VGND sg13cmos5l_decap_4
* cell instance sg13cmos5l_decap_4_225 r0 *1 0,0
Xsg13cmos5l_decap_4_225 VPWR VGND sg13cmos5l_decap_4
* cell instance sg13cmos5l_decap_4_226 r0 *1 0,0
Xsg13cmos5l_decap_4_226 VPWR VGND sg13cmos5l_decap_4
* cell instance sg13cmos5l_decap_4_227 r0 *1 0,0
Xsg13cmos5l_decap_4_227 VPWR VGND sg13cmos5l_decap_4
* cell instance sg13cmos5l_decap_4_228 r0 *1 0,0
Xsg13cmos5l_decap_4_228 VPWR VGND sg13cmos5l_decap_4
* cell instance sg13cmos5l_decap_4_229 r0 *1 0,0
Xsg13cmos5l_decap_4_229 VPWR VGND sg13cmos5l_decap_4
* cell instance sg13cmos5l_decap_4_230 r0 *1 0,0
Xsg13cmos5l_decap_4_230 VPWR VGND sg13cmos5l_decap_4
* cell instance sg13cmos5l_decap_4_231 r0 *1 0,0
Xsg13cmos5l_decap_4_231 VPWR VGND sg13cmos5l_decap_4
* cell instance sg13cmos5l_decap_4_232 r0 *1 0,0
Xsg13cmos5l_decap_4_232 VPWR VGND sg13cmos5l_decap_4
* cell instance sg13cmos5l_decap_4_233 r0 *1 0,0
Xsg13cmos5l_decap_4_233 VPWR VGND sg13cmos5l_decap_4
* cell instance sg13cmos5l_decap_4_234 r0 *1 0,0
Xsg13cmos5l_decap_4_234 VPWR VGND sg13cmos5l_decap_4
* cell instance sg13cmos5l_decap_4_235 r0 *1 0,0
Xsg13cmos5l_decap_4_235 VPWR VGND sg13cmos5l_decap_4
* cell instance sg13cmos5l_decap_4_236 r0 *1 0,0
Xsg13cmos5l_decap_4_236 VPWR VGND sg13cmos5l_decap_4
* cell instance sg13cmos5l_decap_4_237 r0 *1 0,0
Xsg13cmos5l_decap_4_237 VPWR VGND sg13cmos5l_decap_4
* cell instance sg13cmos5l_decap_4_238 r0 *1 0,0
Xsg13cmos5l_decap_4_238 VPWR VGND sg13cmos5l_decap_4
* cell instance sg13cmos5l_decap_4_239 r0 *1 0,0
Xsg13cmos5l_decap_4_239 VPWR VGND sg13cmos5l_decap_4
* cell instance sg13cmos5l_decap_4_240 r0 *1 0,0
Xsg13cmos5l_decap_4_240 VPWR VGND sg13cmos5l_decap_4
* cell instance sg13cmos5l_decap_4_241 r0 *1 0,0
Xsg13cmos5l_decap_4_241 VPWR VGND sg13cmos5l_decap_4
* cell instance sg13cmos5l_decap_4_242 r0 *1 0,0
Xsg13cmos5l_decap_4_242 VPWR VGND sg13cmos5l_decap_4
* cell instance sg13cmos5l_decap_4_243 r0 *1 0,0
Xsg13cmos5l_decap_4_243 VPWR VGND sg13cmos5l_decap_4
* cell instance sg13cmos5l_decap_4_244 r0 *1 0,0
Xsg13cmos5l_decap_4_244 VPWR VGND sg13cmos5l_decap_4
* cell instance sg13cmos5l_decap_4_245 r0 *1 0,0
Xsg13cmos5l_decap_4_245 VPWR VGND sg13cmos5l_decap_4
* cell instance sg13cmos5l_decap_4_246 r0 *1 0,0
Xsg13cmos5l_decap_4_246 VPWR VGND sg13cmos5l_decap_4
* cell instance sg13cmos5l_decap_4_247 r0 *1 0,0
Xsg13cmos5l_decap_4_247 VPWR VGND sg13cmos5l_decap_4
* cell instance sg13cmos5l_decap_4_248 r0 *1 0,0
Xsg13cmos5l_decap_4_248 VPWR VGND sg13cmos5l_decap_4
* cell instance sg13cmos5l_decap_4_249 r0 *1 0,0
Xsg13cmos5l_decap_4_249 VPWR VGND sg13cmos5l_decap_4
* cell instance sg13cmos5l_decap_4_250 r0 *1 0,0
Xsg13cmos5l_decap_4_250 VPWR VGND sg13cmos5l_decap_4
* cell instance sg13cmos5l_decap_4_251 r0 *1 0,0
Xsg13cmos5l_decap_4_251 VPWR VGND sg13cmos5l_decap_4
* cell instance sg13cmos5l_decap_4_252 r0 *1 0,0
Xsg13cmos5l_decap_4_252 VPWR VGND sg13cmos5l_decap_4
* cell instance sg13cmos5l_decap_4_253 r0 *1 0,0
Xsg13cmos5l_decap_4_253 VPWR VGND sg13cmos5l_decap_4
* cell instance sg13cmos5l_decap_4_254 r0 *1 0,0
Xsg13cmos5l_decap_4_254 VPWR VGND sg13cmos5l_decap_4
* cell instance sg13cmos5l_decap_4_255 r0 *1 0,0
Xsg13cmos5l_decap_4_255 VPWR VGND sg13cmos5l_decap_4
* cell instance sg13cmos5l_decap_4_256 r0 *1 0,0
Xsg13cmos5l_decap_4_256 VPWR VGND sg13cmos5l_decap_4
* cell instance sg13cmos5l_decap_4_257 r0 *1 0,0
Xsg13cmos5l_decap_4_257 VPWR VGND sg13cmos5l_decap_4
* cell instance sg13cmos5l_decap_4_258 r0 *1 0,0
Xsg13cmos5l_decap_4_258 VPWR VGND sg13cmos5l_decap_4
* cell instance sg13cmos5l_decap_4_259 r0 *1 0,0
Xsg13cmos5l_decap_4_259 VPWR VGND sg13cmos5l_decap_4
* cell instance sg13cmos5l_decap_4_260 r0 *1 0,0
Xsg13cmos5l_decap_4_260 VPWR VGND sg13cmos5l_decap_4
* cell instance sg13cmos5l_decap_4_261 r0 *1 0,0
Xsg13cmos5l_decap_4_261 VPWR VGND sg13cmos5l_decap_4
* cell instance sg13cmos5l_decap_4_262 r0 *1 0,0
Xsg13cmos5l_decap_4_262 VPWR VGND sg13cmos5l_decap_4
* cell instance sg13cmos5l_decap_4_263 r0 *1 0,0
Xsg13cmos5l_decap_4_263 VPWR VGND sg13cmos5l_decap_4
* cell instance sg13cmos5l_decap_4_264 r0 *1 0,0
Xsg13cmos5l_decap_4_264 VPWR VGND sg13cmos5l_decap_4
* cell instance sg13cmos5l_decap_4_265 r0 *1 0,0
Xsg13cmos5l_decap_4_265 VPWR VGND sg13cmos5l_decap_4
* cell instance sg13cmos5l_decap_4_266 r0 *1 0,0
Xsg13cmos5l_decap_4_266 VPWR VGND sg13cmos5l_decap_4
* cell instance sg13cmos5l_decap_4_267 r0 *1 0,0
Xsg13cmos5l_decap_4_267 VPWR VGND sg13cmos5l_decap_4
* cell instance sg13cmos5l_decap_4_268 r0 *1 0,0
Xsg13cmos5l_decap_4_268 VPWR VGND sg13cmos5l_decap_4
* cell instance sg13cmos5l_decap_4_269 r0 *1 0,0
Xsg13cmos5l_decap_4_269 VPWR VGND sg13cmos5l_decap_4
* cell instance sg13cmos5l_decap_4_270 r0 *1 0,0
Xsg13cmos5l_decap_4_270 VPWR VGND sg13cmos5l_decap_4
* cell instance sg13cmos5l_decap_4_271 r0 *1 0,0
Xsg13cmos5l_decap_4_271 VPWR VGND sg13cmos5l_decap_4
* cell instance sg13cmos5l_decap_4_272 r0 *1 0,0
Xsg13cmos5l_decap_4_272 VPWR VGND sg13cmos5l_decap_4
* cell instance sg13cmos5l_decap_4_273 r0 *1 0,0
Xsg13cmos5l_decap_4_273 VPWR VGND sg13cmos5l_decap_4
* cell instance sg13cmos5l_decap_4_274 r0 *1 0,0
Xsg13cmos5l_decap_4_274 VPWR VGND sg13cmos5l_decap_4
* cell instance sg13cmos5l_decap_4_275 r0 *1 0,0
Xsg13cmos5l_decap_4_275 VPWR VGND sg13cmos5l_decap_4
* cell instance sg13cmos5l_decap_4_276 r0 *1 0,0
Xsg13cmos5l_decap_4_276 VPWR VGND sg13cmos5l_decap_4
* cell instance sg13cmos5l_decap_4_277 r0 *1 0,0
Xsg13cmos5l_decap_4_277 VPWR VGND sg13cmos5l_decap_4
* cell instance sg13cmos5l_decap_4_278 r0 *1 0,0
Xsg13cmos5l_decap_4_278 VPWR VGND sg13cmos5l_decap_4
* cell instance sg13cmos5l_decap_4_279 r0 *1 0,0
Xsg13cmos5l_decap_4_279 VPWR VGND sg13cmos5l_decap_4
* cell instance sg13cmos5l_decap_4_280 r0 *1 0,0
Xsg13cmos5l_decap_4_280 VPWR VGND sg13cmos5l_decap_4
* cell instance sg13cmos5l_decap_4_281 r0 *1 0,0
Xsg13cmos5l_decap_4_281 VPWR VGND sg13cmos5l_decap_4
* cell instance sg13cmos5l_decap_4_282 r0 *1 0,0
Xsg13cmos5l_decap_4_282 VPWR VGND sg13cmos5l_decap_4
* cell instance sg13cmos5l_decap_4_283 r0 *1 0,0
Xsg13cmos5l_decap_4_283 VPWR VGND sg13cmos5l_decap_4
* cell instance sg13cmos5l_decap_4_284 r0 *1 0,0
Xsg13cmos5l_decap_4_284 VPWR VGND sg13cmos5l_decap_4
* cell instance sg13cmos5l_decap_4_285 r0 *1 0,0
Xsg13cmos5l_decap_4_285 VPWR VGND sg13cmos5l_decap_4
* cell instance sg13cmos5l_decap_4_286 r0 *1 0,0
Xsg13cmos5l_decap_4_286 VPWR VGND sg13cmos5l_decap_4
* cell instance sg13cmos5l_decap_4_287 r0 *1 0,0
Xsg13cmos5l_decap_4_287 VPWR VGND sg13cmos5l_decap_4
* cell instance sg13cmos5l_decap_4_288 r0 *1 0,0
Xsg13cmos5l_decap_4_288 VPWR VGND sg13cmos5l_decap_4
* cell instance sg13cmos5l_decap_4_289 r0 *1 0,0
Xsg13cmos5l_decap_4_289 VPWR VGND sg13cmos5l_decap_4
* cell instance sg13cmos5l_decap_4_290 r0 *1 0,0
Xsg13cmos5l_decap_4_290 VPWR VGND sg13cmos5l_decap_4
* cell instance sg13cmos5l_decap_4_291 r0 *1 0,0
Xsg13cmos5l_decap_4_291 VPWR VGND sg13cmos5l_decap_4
* cell instance sg13cmos5l_decap_4_292 r0 *1 0,0
Xsg13cmos5l_decap_4_292 VPWR VGND sg13cmos5l_decap_4
* cell instance sg13cmos5l_decap_4_293 r0 *1 0,0
Xsg13cmos5l_decap_4_293 VPWR VGND sg13cmos5l_decap_4
* cell instance sg13cmos5l_decap_4_294 r0 *1 0,0
Xsg13cmos5l_decap_4_294 VPWR VGND sg13cmos5l_decap_4
* cell instance sg13cmos5l_decap_4_295 r0 *1 0,0
Xsg13cmos5l_decap_4_295 VPWR VGND sg13cmos5l_decap_4
* cell instance sg13cmos5l_decap_4_296 r0 *1 0,0
Xsg13cmos5l_decap_4_296 VPWR VGND sg13cmos5l_decap_4
* cell instance sg13cmos5l_decap_4_297 r0 *1 0,0
Xsg13cmos5l_decap_4_297 VPWR VGND sg13cmos5l_decap_4
* cell instance sg13cmos5l_decap_4_298 r0 *1 0,0
Xsg13cmos5l_decap_4_298 VPWR VGND sg13cmos5l_decap_4
* cell instance sg13cmos5l_decap_4_299 r0 *1 0,0
Xsg13cmos5l_decap_4_299 VPWR VGND sg13cmos5l_decap_4
* cell instance sg13cmos5l_decap_4_300 r0 *1 0,0
Xsg13cmos5l_decap_4_300 VPWR VGND sg13cmos5l_decap_4
* cell instance sg13cmos5l_decap_4_301 r0 *1 0,0
Xsg13cmos5l_decap_4_301 VPWR VGND sg13cmos5l_decap_4
* cell instance sg13cmos5l_decap_4_302 r0 *1 0,0
Xsg13cmos5l_decap_4_302 VPWR VGND sg13cmos5l_decap_4
* cell instance sg13cmos5l_decap_4_303 r0 *1 0,0
Xsg13cmos5l_decap_4_303 VPWR VGND sg13cmos5l_decap_4
* cell instance sg13cmos5l_decap_4_304 r0 *1 0,0
Xsg13cmos5l_decap_4_304 VPWR VGND sg13cmos5l_decap_4
* cell instance sg13cmos5l_decap_4_305 r0 *1 0,0
Xsg13cmos5l_decap_4_305 VPWR VGND sg13cmos5l_decap_4
* cell instance sg13cmos5l_decap_4_306 r0 *1 0,0
Xsg13cmos5l_decap_4_306 VPWR VGND sg13cmos5l_decap_4
* cell instance sg13cmos5l_decap_4_307 r0 *1 0,0
Xsg13cmos5l_decap_4_307 VPWR VGND sg13cmos5l_decap_4
* cell instance sg13cmos5l_decap_4_308 r0 *1 0,0
Xsg13cmos5l_decap_4_308 VPWR VGND sg13cmos5l_decap_4
* cell instance sg13cmos5l_decap_4_309 r0 *1 0,0
Xsg13cmos5l_decap_4_309 VPWR VGND sg13cmos5l_decap_4
* cell instance sg13cmos5l_decap_4_310 r0 *1 0,0
Xsg13cmos5l_decap_4_310 VPWR VGND sg13cmos5l_decap_4
* cell instance sg13cmos5l_decap_4_311 r0 *1 0,0
Xsg13cmos5l_decap_4_311 VPWR VGND sg13cmos5l_decap_4
* cell instance sg13cmos5l_decap_4_312 r0 *1 0,0
Xsg13cmos5l_decap_4_312 VPWR VGND sg13cmos5l_decap_4
* cell instance sg13cmos5l_decap_4_313 r0 *1 0,0
Xsg13cmos5l_decap_4_313 VPWR VGND sg13cmos5l_decap_4
* cell instance sg13cmos5l_decap_4_314 r0 *1 0,0
Xsg13cmos5l_decap_4_314 VPWR VGND sg13cmos5l_decap_4
* cell instance sg13cmos5l_decap_4_315 r0 *1 0,0
Xsg13cmos5l_decap_4_315 VPWR VGND sg13cmos5l_decap_4
* cell instance sg13cmos5l_decap_4_316 r0 *1 0,0
Xsg13cmos5l_decap_4_316 VPWR VGND sg13cmos5l_decap_4
* cell instance sg13cmos5l_decap_4_317 r0 *1 0,0
Xsg13cmos5l_decap_4_317 VPWR VGND sg13cmos5l_decap_4
* cell instance sg13cmos5l_decap_4_318 r0 *1 0,0
Xsg13cmos5l_decap_4_318 VPWR VGND sg13cmos5l_decap_4
* cell instance sg13cmos5l_decap_4_319 r0 *1 0,0
Xsg13cmos5l_decap_4_319 VPWR VGND sg13cmos5l_decap_4
* cell instance sg13cmos5l_decap_4_320 r0 *1 0,0
Xsg13cmos5l_decap_4_320 VPWR VGND sg13cmos5l_decap_4
* cell instance sg13cmos5l_decap_4_321 r0 *1 0,0
Xsg13cmos5l_decap_4_321 VPWR VGND sg13cmos5l_decap_4
* cell instance sg13cmos5l_decap_4_322 r0 *1 0,0
Xsg13cmos5l_decap_4_322 VPWR VGND sg13cmos5l_decap_4
* cell instance sg13cmos5l_decap_4_323 r0 *1 0,0
Xsg13cmos5l_decap_4_323 VPWR VGND sg13cmos5l_decap_4
* cell instance sg13cmos5l_decap_4_324 r0 *1 0,0
Xsg13cmos5l_decap_4_324 VPWR VGND sg13cmos5l_decap_4
* cell instance sg13cmos5l_decap_4_325 r0 *1 0,0
Xsg13cmos5l_decap_4_325 VPWR VGND sg13cmos5l_decap_4
* cell instance sg13cmos5l_decap_4_326 r0 *1 0,0
Xsg13cmos5l_decap_4_326 VPWR VGND sg13cmos5l_decap_4
* cell instance sg13cmos5l_decap_4_327 r0 *1 0,0
Xsg13cmos5l_decap_4_327 VPWR VGND sg13cmos5l_decap_4
* cell instance sg13cmos5l_decap_4_328 r0 *1 0,0
Xsg13cmos5l_decap_4_328 VPWR VGND sg13cmos5l_decap_4
* cell instance sg13cmos5l_decap_4_329 r0 *1 0,0
Xsg13cmos5l_decap_4_329 VPWR VGND sg13cmos5l_decap_4
* cell instance sg13cmos5l_decap_4_330 r0 *1 0,0
Xsg13cmos5l_decap_4_330 VPWR VGND sg13cmos5l_decap_4
* cell instance sg13cmos5l_decap_4_331 r0 *1 0,0
Xsg13cmos5l_decap_4_331 VPWR VGND sg13cmos5l_decap_4
* cell instance sg13cmos5l_decap_4_332 r0 *1 0,0
Xsg13cmos5l_decap_4_332 VPWR VGND sg13cmos5l_decap_4
* cell instance sg13cmos5l_decap_4_333 r0 *1 0,0
Xsg13cmos5l_decap_4_333 VPWR VGND sg13cmos5l_decap_4
* cell instance sg13cmos5l_decap_4_334 r0 *1 0,0
Xsg13cmos5l_decap_4_334 VPWR VGND sg13cmos5l_decap_4
* cell instance sg13cmos5l_decap_4_335 r0 *1 0,0
Xsg13cmos5l_decap_4_335 VPWR VGND sg13cmos5l_decap_4
* cell instance sg13cmos5l_decap_4_336 r0 *1 0,0
Xsg13cmos5l_decap_4_336 VPWR VGND sg13cmos5l_decap_4
* cell instance sg13cmos5l_decap_4_337 r0 *1 0,0
Xsg13cmos5l_decap_4_337 VPWR VGND sg13cmos5l_decap_4
* cell instance sg13cmos5l_decap_4_338 r0 *1 0,0
Xsg13cmos5l_decap_4_338 VPWR VGND sg13cmos5l_decap_4
* cell instance sg13cmos5l_decap_4_339 r0 *1 0,0
Xsg13cmos5l_decap_4_339 VPWR VGND sg13cmos5l_decap_4
* cell instance sg13cmos5l_decap_4_340 r0 *1 0,0
Xsg13cmos5l_decap_4_340 VPWR VGND sg13cmos5l_decap_4
* cell instance sg13cmos5l_decap_4_341 r0 *1 0,0
Xsg13cmos5l_decap_4_341 VPWR VGND sg13cmos5l_decap_4
* cell instance sg13cmos5l_decap_4_342 r0 *1 0,0
Xsg13cmos5l_decap_4_342 VPWR VGND sg13cmos5l_decap_4
* cell instance sg13cmos5l_decap_4_343 r0 *1 0,0
Xsg13cmos5l_decap_4_343 VPWR VGND sg13cmos5l_decap_4
* cell instance sg13cmos5l_decap_4_344 r0 *1 0,0
Xsg13cmos5l_decap_4_344 VPWR VGND sg13cmos5l_decap_4
* cell instance sg13cmos5l_decap_4_345 r0 *1 0,0
Xsg13cmos5l_decap_4_345 VPWR VGND sg13cmos5l_decap_4
* cell instance sg13cmos5l_decap_4_346 r0 *1 0,0
Xsg13cmos5l_decap_4_346 VPWR VGND sg13cmos5l_decap_4
* cell instance sg13cmos5l_decap_4_347 r0 *1 0,0
Xsg13cmos5l_decap_4_347 VPWR VGND sg13cmos5l_decap_4
* cell instance sg13cmos5l_decap_4_348 r0 *1 0,0
Xsg13cmos5l_decap_4_348 VPWR VGND sg13cmos5l_decap_4
* cell instance sg13cmos5l_decap_4_349 r0 *1 0,0
Xsg13cmos5l_decap_4_349 VPWR VGND sg13cmos5l_decap_4
* cell instance sg13cmos5l_decap_4_350 r0 *1 0,0
Xsg13cmos5l_decap_4_350 VPWR VGND sg13cmos5l_decap_4
* cell instance sg13cmos5l_decap_4_351 r0 *1 0,0
Xsg13cmos5l_decap_4_351 VPWR VGND sg13cmos5l_decap_4
* cell instance sg13cmos5l_decap_4_352 r0 *1 0,0
Xsg13cmos5l_decap_4_352 VPWR VGND sg13cmos5l_decap_4
* cell instance sg13cmos5l_decap_4_353 r0 *1 0,0
Xsg13cmos5l_decap_4_353 VPWR VGND sg13cmos5l_decap_4
* cell instance sg13cmos5l_decap_4_354 r0 *1 0,0
Xsg13cmos5l_decap_4_354 VPWR VGND sg13cmos5l_decap_4
* cell instance sg13cmos5l_decap_4_355 r0 *1 0,0
Xsg13cmos5l_decap_4_355 VPWR VGND sg13cmos5l_decap_4
* cell instance sg13cmos5l_decap_4_356 r0 *1 0,0
Xsg13cmos5l_decap_4_356 VPWR VGND sg13cmos5l_decap_4
* cell instance sg13cmos5l_decap_4_357 r0 *1 0,0
Xsg13cmos5l_decap_4_357 VPWR VGND sg13cmos5l_decap_4
* cell instance sg13cmos5l_decap_4_358 r0 *1 0,0
Xsg13cmos5l_decap_4_358 VPWR VGND sg13cmos5l_decap_4
* cell instance sg13cmos5l_decap_4_359 r0 *1 0,0
Xsg13cmos5l_decap_4_359 VPWR VGND sg13cmos5l_decap_4
* cell instance sg13cmos5l_decap_4_360 r0 *1 0,0
Xsg13cmos5l_decap_4_360 VPWR VGND sg13cmos5l_decap_4
* cell instance sg13cmos5l_decap_4_361 r0 *1 0,0
Xsg13cmos5l_decap_4_361 VPWR VGND sg13cmos5l_decap_4
* cell instance sg13cmos5l_decap_4_362 r0 *1 0,0
Xsg13cmos5l_decap_4_362 VPWR VGND sg13cmos5l_decap_4
* cell instance sg13cmos5l_decap_4_363 r0 *1 0,0
Xsg13cmos5l_decap_4_363 VPWR VGND sg13cmos5l_decap_4
* cell instance sg13cmos5l_decap_4_364 r0 *1 0,0
Xsg13cmos5l_decap_4_364 VPWR VGND sg13cmos5l_decap_4
* cell instance sg13cmos5l_decap_4_365 r0 *1 0,0
Xsg13cmos5l_decap_4_365 VPWR VGND sg13cmos5l_decap_4
* cell instance sg13cmos5l_decap_4_366 r0 *1 0,0
Xsg13cmos5l_decap_4_366 VPWR VGND sg13cmos5l_decap_4
* cell instance sg13cmos5l_decap_4_367 r0 *1 0,0
Xsg13cmos5l_decap_4_367 VPWR VGND sg13cmos5l_decap_4
* cell instance sg13cmos5l_decap_4_368 r0 *1 0,0
Xsg13cmos5l_decap_4_368 VPWR VGND sg13cmos5l_decap_4
* cell instance sg13cmos5l_decap_4_369 r0 *1 0,0
Xsg13cmos5l_decap_4_369 VPWR VGND sg13cmos5l_decap_4
* cell instance sg13cmos5l_decap_4_370 r0 *1 0,0
Xsg13cmos5l_decap_4_370 VPWR VGND sg13cmos5l_decap_4
* cell instance sg13cmos5l_decap_4_371 r0 *1 0,0
Xsg13cmos5l_decap_4_371 VPWR VGND sg13cmos5l_decap_4
* cell instance sg13cmos5l_decap_4_372 r0 *1 0,0
Xsg13cmos5l_decap_4_372 VPWR VGND sg13cmos5l_decap_4
* cell instance sg13cmos5l_decap_4_373 r0 *1 0,0
Xsg13cmos5l_decap_4_373 VPWR VGND sg13cmos5l_decap_4
* cell instance sg13cmos5l_decap_4_374 r0 *1 0,0
Xsg13cmos5l_decap_4_374 VPWR VGND sg13cmos5l_decap_4
* cell instance sg13cmos5l_decap_4_375 r0 *1 0,0
Xsg13cmos5l_decap_4_375 VPWR VGND sg13cmos5l_decap_4
* cell instance sg13cmos5l_decap_4_376 r0 *1 0,0
Xsg13cmos5l_decap_4_376 VPWR VGND sg13cmos5l_decap_4
* cell instance sg13cmos5l_decap_4_377 r0 *1 0,0
Xsg13cmos5l_decap_4_377 VPWR VGND sg13cmos5l_decap_4
* cell instance sg13cmos5l_decap_4_378 r0 *1 0,0
Xsg13cmos5l_decap_4_378 VPWR VGND sg13cmos5l_decap_4
* cell instance sg13cmos5l_decap_4_379 r0 *1 0,0
Xsg13cmos5l_decap_4_379 VPWR VGND sg13cmos5l_decap_4
* cell instance sg13cmos5l_decap_4_380 r0 *1 0,0
Xsg13cmos5l_decap_4_380 VPWR VGND sg13cmos5l_decap_4
* cell instance sg13cmos5l_decap_4_381 r0 *1 0,0
Xsg13cmos5l_decap_4_381 VPWR VGND sg13cmos5l_decap_4
* cell instance sg13cmos5l_decap_4_382 r0 *1 0,0
Xsg13cmos5l_decap_4_382 VPWR VGND sg13cmos5l_decap_4
* cell instance sg13cmos5l_decap_4_383 r0 *1 0,0
Xsg13cmos5l_decap_4_383 VPWR VGND sg13cmos5l_decap_4
* cell instance sg13cmos5l_decap_4_384 r0 *1 0,0
Xsg13cmos5l_decap_4_384 VPWR VGND sg13cmos5l_decap_4
* cell instance sg13cmos5l_decap_4_385 r0 *1 0,0
Xsg13cmos5l_decap_4_385 VPWR VGND sg13cmos5l_decap_4
* cell instance sg13cmos5l_decap_4_386 r0 *1 0,0
Xsg13cmos5l_decap_4_386 VPWR VGND sg13cmos5l_decap_4
* cell instance sg13cmos5l_decap_4_387 r0 *1 0,0
Xsg13cmos5l_decap_4_387 VPWR VGND sg13cmos5l_decap_4
* cell instance sg13cmos5l_decap_4_388 r0 *1 0,0
Xsg13cmos5l_decap_4_388 VPWR VGND sg13cmos5l_decap_4
* cell instance sg13cmos5l_decap_4_389 r0 *1 0,0
Xsg13cmos5l_decap_4_389 VPWR VGND sg13cmos5l_decap_4
* cell instance sg13cmos5l_decap_4_390 r0 *1 0,0
Xsg13cmos5l_decap_4_390 VPWR VGND sg13cmos5l_decap_4
* cell instance sg13cmos5l_decap_4_391 r0 *1 0,0
Xsg13cmos5l_decap_4_391 VPWR VGND sg13cmos5l_decap_4
* cell instance sg13cmos5l_decap_4_392 r0 *1 0,0
Xsg13cmos5l_decap_4_392 VPWR VGND sg13cmos5l_decap_4
* cell instance sg13cmos5l_decap_4_393 r0 *1 0,0
Xsg13cmos5l_decap_4_393 VPWR VGND sg13cmos5l_decap_4
* cell instance sg13cmos5l_decap_4_394 r0 *1 0,0
Xsg13cmos5l_decap_4_394 VPWR VGND sg13cmos5l_decap_4
* cell instance sg13cmos5l_decap_4_395 r0 *1 0,0
Xsg13cmos5l_decap_4_395 VPWR VGND sg13cmos5l_decap_4
* cell instance sg13cmos5l_decap_4_396 r0 *1 0,0
Xsg13cmos5l_decap_4_396 VPWR VGND sg13cmos5l_decap_4
* cell instance sg13cmos5l_decap_4_397 r0 *1 0,0
Xsg13cmos5l_decap_4_397 VPWR VGND sg13cmos5l_decap_4
* cell instance sg13cmos5l_decap_4_398 r0 *1 0,0
Xsg13cmos5l_decap_4_398 VPWR VGND sg13cmos5l_decap_4
* cell instance sg13cmos5l_decap_4_399 r0 *1 0,0
Xsg13cmos5l_decap_4_399 VPWR VGND sg13cmos5l_decap_4
* cell instance sg13cmos5l_decap_4_400 r0 *1 0,0
Xsg13cmos5l_decap_4_400 VPWR VGND sg13cmos5l_decap_4
* cell instance sg13cmos5l_decap_4_401 r0 *1 0,0
Xsg13cmos5l_decap_4_401 VPWR VGND sg13cmos5l_decap_4
* cell instance sg13cmos5l_decap_4_402 r0 *1 0,0
Xsg13cmos5l_decap_4_402 VPWR VGND sg13cmos5l_decap_4
* cell instance sg13cmos5l_decap_4_403 r0 *1 0,0
Xsg13cmos5l_decap_4_403 VPWR VGND sg13cmos5l_decap_4
* cell instance sg13cmos5l_decap_4_404 r0 *1 0,0
Xsg13cmos5l_decap_4_404 VPWR VGND sg13cmos5l_decap_4
* cell instance sg13cmos5l_decap_4_405 r0 *1 0,0
Xsg13cmos5l_decap_4_405 VPWR VGND sg13cmos5l_decap_4
* cell instance sg13cmos5l_decap_4_406 r0 *1 0,0
Xsg13cmos5l_decap_4_406 VPWR VGND sg13cmos5l_decap_4
* cell instance sg13cmos5l_decap_4_407 r0 *1 0,0
Xsg13cmos5l_decap_4_407 VPWR VGND sg13cmos5l_decap_4
* cell instance sg13cmos5l_decap_4_408 r0 *1 0,0
Xsg13cmos5l_decap_4_408 VPWR VGND sg13cmos5l_decap_4
* cell instance sg13cmos5l_decap_4_409 r0 *1 0,0
Xsg13cmos5l_decap_4_409 VPWR VGND sg13cmos5l_decap_4
* cell instance sg13cmos5l_decap_4_410 r0 *1 0,0
Xsg13cmos5l_decap_4_410 VPWR VGND sg13cmos5l_decap_4
* cell instance sg13cmos5l_decap_4_411 r0 *1 0,0
Xsg13cmos5l_decap_4_411 VPWR VGND sg13cmos5l_decap_4
* cell instance sg13cmos5l_decap_4_412 r0 *1 0,0
Xsg13cmos5l_decap_4_412 VPWR VGND sg13cmos5l_decap_4
* cell instance sg13cmos5l_decap_4_413 r0 *1 0,0
Xsg13cmos5l_decap_4_413 VPWR VGND sg13cmos5l_decap_4
* cell instance sg13cmos5l_decap_4_414 r0 *1 0,0
Xsg13cmos5l_decap_4_414 VPWR VGND sg13cmos5l_decap_4
* cell instance sg13cmos5l_decap_4_415 r0 *1 0,0
Xsg13cmos5l_decap_4_415 VPWR VGND sg13cmos5l_decap_4
* cell instance sg13cmos5l_decap_4_416 r0 *1 0,0
Xsg13cmos5l_decap_4_416 VPWR VGND sg13cmos5l_decap_4
* cell instance sg13cmos5l_decap_4_417 r0 *1 0,0
Xsg13cmos5l_decap_4_417 VPWR VGND sg13cmos5l_decap_4
* cell instance sg13cmos5l_decap_4_418 r0 *1 0,0
Xsg13cmos5l_decap_4_418 VPWR VGND sg13cmos5l_decap_4
* cell instance sg13cmos5l_decap_4_419 r0 *1 0,0
Xsg13cmos5l_decap_4_419 VPWR VGND sg13cmos5l_decap_4
* cell instance sg13cmos5l_decap_4_420 r0 *1 0,0
Xsg13cmos5l_decap_4_420 VPWR VGND sg13cmos5l_decap_4
* cell instance sg13cmos5l_decap_4_421 r0 *1 0,0
Xsg13cmos5l_decap_4_421 VPWR VGND sg13cmos5l_decap_4
* cell instance sg13cmos5l_decap_4_422 r0 *1 0,0
Xsg13cmos5l_decap_4_422 VPWR VGND sg13cmos5l_decap_4
* cell instance sg13cmos5l_decap_4_423 r0 *1 0,0
Xsg13cmos5l_decap_4_423 VPWR VGND sg13cmos5l_decap_4
* cell instance sg13cmos5l_decap_4_424 r0 *1 0,0
Xsg13cmos5l_decap_4_424 VPWR VGND sg13cmos5l_decap_4
* cell instance sg13cmos5l_decap_4_425 r0 *1 0,0
Xsg13cmos5l_decap_4_425 VPWR VGND sg13cmos5l_decap_4
* cell instance sg13cmos5l_decap_4_426 r0 *1 0,0
Xsg13cmos5l_decap_4_426 VPWR VGND sg13cmos5l_decap_4
* cell instance sg13cmos5l_decap_4_427 r0 *1 0,0
Xsg13cmos5l_decap_4_427 VPWR VGND sg13cmos5l_decap_4
* cell instance sg13cmos5l_decap_4_428 r0 *1 0,0
Xsg13cmos5l_decap_4_428 VPWR VGND sg13cmos5l_decap_4
* cell instance sg13cmos5l_decap_4_429 r0 *1 0,0
Xsg13cmos5l_decap_4_429 VPWR VGND sg13cmos5l_decap_4
* cell instance sg13cmos5l_decap_4_430 r0 *1 0,0
Xsg13cmos5l_decap_4_430 VPWR VGND sg13cmos5l_decap_4
* cell instance sg13cmos5l_decap_4_431 r0 *1 0,0
Xsg13cmos5l_decap_4_431 VPWR VGND sg13cmos5l_decap_4
* cell instance sg13cmos5l_decap_4_432 r0 *1 0,0
Xsg13cmos5l_decap_4_432 VPWR VGND sg13cmos5l_decap_4
* cell instance sg13cmos5l_decap_4_433 r0 *1 0,0
Xsg13cmos5l_decap_4_433 VPWR VGND sg13cmos5l_decap_4
* cell instance sg13cmos5l_decap_4_434 r0 *1 0,0
Xsg13cmos5l_decap_4_434 VPWR VGND sg13cmos5l_decap_4
* cell instance sg13cmos5l_decap_4_435 r0 *1 0,0
Xsg13cmos5l_decap_4_435 VPWR VGND sg13cmos5l_decap_4
* cell instance sg13cmos5l_decap_4_436 r0 *1 0,0
Xsg13cmos5l_decap_4_436 VPWR VGND sg13cmos5l_decap_4
* cell instance sg13cmos5l_decap_4_437 r0 *1 0,0
Xsg13cmos5l_decap_4_437 VPWR VGND sg13cmos5l_decap_4
* cell instance sg13cmos5l_decap_4_438 r0 *1 0,0
Xsg13cmos5l_decap_4_438 VPWR VGND sg13cmos5l_decap_4
* cell instance sg13cmos5l_decap_4_439 r0 *1 0,0
Xsg13cmos5l_decap_4_439 VPWR VGND sg13cmos5l_decap_4
* cell instance sg13cmos5l_decap_4_440 r0 *1 0,0
Xsg13cmos5l_decap_4_440 VPWR VGND sg13cmos5l_decap_4
* cell instance sg13cmos5l_decap_4_441 r0 *1 0,0
Xsg13cmos5l_decap_4_441 VPWR VGND sg13cmos5l_decap_4
* cell instance sg13cmos5l_decap_4_442 r0 *1 0,0
Xsg13cmos5l_decap_4_442 VPWR VGND sg13cmos5l_decap_4
* cell instance sg13cmos5l_decap_4_443 r0 *1 0,0
Xsg13cmos5l_decap_4_443 VPWR VGND sg13cmos5l_decap_4
* cell instance sg13cmos5l_decap_4_444 r0 *1 0,0
Xsg13cmos5l_decap_4_444 VPWR VGND sg13cmos5l_decap_4
* cell instance sg13cmos5l_decap_4_445 r0 *1 0,0
Xsg13cmos5l_decap_4_445 VPWR VGND sg13cmos5l_decap_4
* cell instance sg13cmos5l_decap_4_446 r0 *1 0,0
Xsg13cmos5l_decap_4_446 VPWR VGND sg13cmos5l_decap_4
* cell instance sg13cmos5l_decap_4_447 r0 *1 0,0
Xsg13cmos5l_decap_4_447 VPWR VGND sg13cmos5l_decap_4
* cell instance sg13cmos5l_decap_4_448 r0 *1 0,0
Xsg13cmos5l_decap_4_448 VPWR VGND sg13cmos5l_decap_4
* cell instance sg13cmos5l_decap_4_449 r0 *1 0,0
Xsg13cmos5l_decap_4_449 VPWR VGND sg13cmos5l_decap_4
* cell instance sg13cmos5l_decap_4_450 r0 *1 0,0
Xsg13cmos5l_decap_4_450 VPWR VGND sg13cmos5l_decap_4
* cell instance sg13cmos5l_decap_4_451 r0 *1 0,0
Xsg13cmos5l_decap_4_451 VPWR VGND sg13cmos5l_decap_4
* cell instance sg13cmos5l_decap_4_452 r0 *1 0,0
Xsg13cmos5l_decap_4_452 VPWR VGND sg13cmos5l_decap_4
* cell instance sg13cmos5l_decap_4_453 r0 *1 0,0
Xsg13cmos5l_decap_4_453 VPWR VGND sg13cmos5l_decap_4
* cell instance sg13cmos5l_decap_4_454 r0 *1 0,0
Xsg13cmos5l_decap_4_454 VPWR VGND sg13cmos5l_decap_4
* cell instance sg13cmos5l_decap_4_455 r0 *1 0,0
Xsg13cmos5l_decap_4_455 VPWR VGND sg13cmos5l_decap_4
* cell instance sg13cmos5l_decap_4_456 r0 *1 0,0
Xsg13cmos5l_decap_4_456 VPWR VGND sg13cmos5l_decap_4
* cell instance sg13cmos5l_decap_4_457 r0 *1 0,0
Xsg13cmos5l_decap_4_457 VPWR VGND sg13cmos5l_decap_4
* cell instance sg13cmos5l_decap_4_458 r0 *1 0,0
Xsg13cmos5l_decap_4_458 VPWR VGND sg13cmos5l_decap_4
* cell instance sg13cmos5l_decap_4_459 r0 *1 0,0
Xsg13cmos5l_decap_4_459 VPWR VGND sg13cmos5l_decap_4
* cell instance sg13cmos5l_decap_4_460 r0 *1 0,0
Xsg13cmos5l_decap_4_460 VPWR VGND sg13cmos5l_decap_4
* cell instance sg13cmos5l_decap_4_461 r0 *1 0,0
Xsg13cmos5l_decap_4_461 VPWR VGND sg13cmos5l_decap_4
* cell instance sg13cmos5l_decap_4_462 r0 *1 0,0
Xsg13cmos5l_decap_4_462 VPWR VGND sg13cmos5l_decap_4
* cell instance sg13cmos5l_decap_4_463 r0 *1 0,0
Xsg13cmos5l_decap_4_463 VPWR VGND sg13cmos5l_decap_4
* cell instance sg13cmos5l_decap_4_464 r0 *1 0,0
Xsg13cmos5l_decap_4_464 VPWR VGND sg13cmos5l_decap_4
* cell instance sg13cmos5l_decap_4_465 r0 *1 0,0
Xsg13cmos5l_decap_4_465 VPWR VGND sg13cmos5l_decap_4
* cell instance sg13cmos5l_decap_4_466 r0 *1 0,0
Xsg13cmos5l_decap_4_466 VPWR VGND sg13cmos5l_decap_4
* cell instance sg13cmos5l_decap_4_467 r0 *1 0,0
Xsg13cmos5l_decap_4_467 VPWR VGND sg13cmos5l_decap_4
* cell instance sg13cmos5l_decap_4_468 r0 *1 0,0
Xsg13cmos5l_decap_4_468 VPWR VGND sg13cmos5l_decap_4
* cell instance sg13cmos5l_decap_4_469 r0 *1 0,0
Xsg13cmos5l_decap_4_469 VPWR VGND sg13cmos5l_decap_4
* cell instance sg13cmos5l_decap_4_470 r0 *1 0,0
Xsg13cmos5l_decap_4_470 VPWR VGND sg13cmos5l_decap_4
* cell instance sg13cmos5l_decap_4_471 r0 *1 0,0
Xsg13cmos5l_decap_4_471 VPWR VGND sg13cmos5l_decap_4
* cell instance sg13cmos5l_decap_4_472 r0 *1 0,0
Xsg13cmos5l_decap_4_472 VPWR VGND sg13cmos5l_decap_4
* cell instance sg13cmos5l_decap_4_473 r0 *1 0,0
Xsg13cmos5l_decap_4_473 VPWR VGND sg13cmos5l_decap_4
* cell instance sg13cmos5l_decap_4_474 r0 *1 0,0
Xsg13cmos5l_decap_4_474 VPWR VGND sg13cmos5l_decap_4
* cell instance sg13cmos5l_decap_4_475 r0 *1 0,0
Xsg13cmos5l_decap_4_475 VPWR VGND sg13cmos5l_decap_4
* cell instance sg13cmos5l_decap_4_476 r0 *1 0,0
Xsg13cmos5l_decap_4_476 VPWR VGND sg13cmos5l_decap_4
* cell instance sg13cmos5l_decap_4_477 r0 *1 0,0
Xsg13cmos5l_decap_4_477 VPWR VGND sg13cmos5l_decap_4
* cell instance sg13cmos5l_decap_4_478 r0 *1 0,0
Xsg13cmos5l_decap_4_478 VPWR VGND sg13cmos5l_decap_4
* cell instance sg13cmos5l_decap_8_0 r0 *1 0,0
Xsg13cmos5l_decap_8_0 VPWR VGND sg13cmos5l_decap_8
* cell instance sg13cmos5l_decap_8_1 r0 *1 0,0
Xsg13cmos5l_decap_8_1 VPWR VGND sg13cmos5l_decap_8
* cell instance sg13cmos5l_decap_8_2 r0 *1 0,0
Xsg13cmos5l_decap_8_2 VPWR VGND sg13cmos5l_decap_8
* cell instance sg13cmos5l_decap_8_3 r0 *1 0,0
Xsg13cmos5l_decap_8_3 VPWR VGND sg13cmos5l_decap_8
* cell instance sg13cmos5l_decap_8_4 r0 *1 0,0
Xsg13cmos5l_decap_8_4 VPWR VGND sg13cmos5l_decap_8
* cell instance sg13cmos5l_decap_8_5 r0 *1 0,0
Xsg13cmos5l_decap_8_5 VPWR VGND sg13cmos5l_decap_8
* cell instance sg13cmos5l_decap_8_6 r0 *1 0,0
Xsg13cmos5l_decap_8_6 VPWR VGND sg13cmos5l_decap_8
* cell instance sg13cmos5l_decap_8_7 r0 *1 0,0
Xsg13cmos5l_decap_8_7 VPWR VGND sg13cmos5l_decap_8
* cell instance sg13cmos5l_decap_8_8 r0 *1 0,0
Xsg13cmos5l_decap_8_8 VPWR VGND sg13cmos5l_decap_8
* cell instance sg13cmos5l_decap_8_9 r0 *1 0,0
Xsg13cmos5l_decap_8_9 VPWR VGND sg13cmos5l_decap_8
* cell instance sg13cmos5l_decap_8_10 r0 *1 0,0
Xsg13cmos5l_decap_8_10 VPWR VGND sg13cmos5l_decap_8
* cell instance sg13cmos5l_decap_8_11 r0 *1 0,0
Xsg13cmos5l_decap_8_11 VPWR VGND sg13cmos5l_decap_8
* cell instance sg13cmos5l_decap_8_12 r0 *1 0,0
Xsg13cmos5l_decap_8_12 VPWR VGND sg13cmos5l_decap_8
* cell instance sg13cmos5l_decap_8_13 r0 *1 0,0
Xsg13cmos5l_decap_8_13 VPWR VGND sg13cmos5l_decap_8
* cell instance sg13cmos5l_decap_8_14 r0 *1 0,0
Xsg13cmos5l_decap_8_14 VPWR VGND sg13cmos5l_decap_8
* cell instance sg13cmos5l_decap_8_15 r0 *1 0,0
Xsg13cmos5l_decap_8_15 VPWR VGND sg13cmos5l_decap_8
* cell instance sg13cmos5l_decap_8_16 r0 *1 0,0
Xsg13cmos5l_decap_8_16 VPWR VGND sg13cmos5l_decap_8
* cell instance sg13cmos5l_decap_8_17 r0 *1 0,0
Xsg13cmos5l_decap_8_17 VPWR VGND sg13cmos5l_decap_8
* cell instance sg13cmos5l_decap_8_18 r0 *1 0,0
Xsg13cmos5l_decap_8_18 VPWR VGND sg13cmos5l_decap_8
* cell instance sg13cmos5l_decap_8_19 r0 *1 0,0
Xsg13cmos5l_decap_8_19 VPWR VGND sg13cmos5l_decap_8
* cell instance sg13cmos5l_decap_8_20 r0 *1 0,0
Xsg13cmos5l_decap_8_20 VPWR VGND sg13cmos5l_decap_8
* cell instance sg13cmos5l_decap_8_21 r0 *1 0,0
Xsg13cmos5l_decap_8_21 VPWR VGND sg13cmos5l_decap_8
* cell instance sg13cmos5l_decap_8_22 r0 *1 0,0
Xsg13cmos5l_decap_8_22 VPWR VGND sg13cmos5l_decap_8
* cell instance sg13cmos5l_decap_8_23 r0 *1 0,0
Xsg13cmos5l_decap_8_23 VPWR VGND sg13cmos5l_decap_8
* cell instance sg13cmos5l_decap_8_24 r0 *1 0,0
Xsg13cmos5l_decap_8_24 VPWR VGND sg13cmos5l_decap_8
* cell instance sg13cmos5l_decap_8_25 r0 *1 0,0
Xsg13cmos5l_decap_8_25 VPWR VGND sg13cmos5l_decap_8
* cell instance sg13cmos5l_decap_8_26 r0 *1 0,0
Xsg13cmos5l_decap_8_26 VPWR VGND sg13cmos5l_decap_8
* cell instance sg13cmos5l_decap_8_27 r0 *1 0,0
Xsg13cmos5l_decap_8_27 VPWR VGND sg13cmos5l_decap_8
* cell instance sg13cmos5l_decap_8_28 r0 *1 0,0
Xsg13cmos5l_decap_8_28 VPWR VGND sg13cmos5l_decap_8
* cell instance sg13cmos5l_decap_8_29 r0 *1 0,0
Xsg13cmos5l_decap_8_29 VPWR VGND sg13cmos5l_decap_8
* cell instance sg13cmos5l_decap_8_30 r0 *1 0,0
Xsg13cmos5l_decap_8_30 VPWR VGND sg13cmos5l_decap_8
* cell instance sg13cmos5l_decap_8_31 r0 *1 0,0
Xsg13cmos5l_decap_8_31 VPWR VGND sg13cmos5l_decap_8
* cell instance sg13cmos5l_decap_8_32 r0 *1 0,0
Xsg13cmos5l_decap_8_32 VPWR VGND sg13cmos5l_decap_8
* cell instance sg13cmos5l_decap_8_33 r0 *1 0,0
Xsg13cmos5l_decap_8_33 VPWR VGND sg13cmos5l_decap_8
* cell instance sg13cmos5l_decap_8_34 r0 *1 0,0
Xsg13cmos5l_decap_8_34 VPWR VGND sg13cmos5l_decap_8
* cell instance sg13cmos5l_decap_8_35 r0 *1 0,0
Xsg13cmos5l_decap_8_35 VPWR VGND sg13cmos5l_decap_8
* cell instance sg13cmos5l_decap_8_36 r0 *1 0,0
Xsg13cmos5l_decap_8_36 VPWR VGND sg13cmos5l_decap_8
* cell instance sg13cmos5l_decap_8_37 r0 *1 0,0
Xsg13cmos5l_decap_8_37 VPWR VGND sg13cmos5l_decap_8
* cell instance sg13cmos5l_decap_8_38 r0 *1 0,0
Xsg13cmos5l_decap_8_38 VPWR VGND sg13cmos5l_decap_8
* cell instance sg13cmos5l_decap_8_39 r0 *1 0,0
Xsg13cmos5l_decap_8_39 VPWR VGND sg13cmos5l_decap_8
* cell instance sg13cmos5l_decap_8_40 r0 *1 0,0
Xsg13cmos5l_decap_8_40 VPWR VGND sg13cmos5l_decap_8
* cell instance sg13cmos5l_decap_8_41 r0 *1 0,0
Xsg13cmos5l_decap_8_41 VPWR VGND sg13cmos5l_decap_8
* cell instance sg13cmos5l_decap_8_42 r0 *1 0,0
Xsg13cmos5l_decap_8_42 VPWR VGND sg13cmos5l_decap_8
* cell instance sg13cmos5l_decap_8_43 r0 *1 0,0
Xsg13cmos5l_decap_8_43 VPWR VGND sg13cmos5l_decap_8
* cell instance sg13cmos5l_decap_8_44 r0 *1 0,0
Xsg13cmos5l_decap_8_44 VPWR VGND sg13cmos5l_decap_8
* cell instance sg13cmos5l_decap_8_45 r0 *1 0,0
Xsg13cmos5l_decap_8_45 VPWR VGND sg13cmos5l_decap_8
* cell instance sg13cmos5l_decap_8_46 r0 *1 0,0
Xsg13cmos5l_decap_8_46 VPWR VGND sg13cmos5l_decap_8
* cell instance sg13cmos5l_decap_8_47 r0 *1 0,0
Xsg13cmos5l_decap_8_47 VPWR VGND sg13cmos5l_decap_8
* cell instance sg13cmos5l_decap_8_48 r0 *1 0,0
Xsg13cmos5l_decap_8_48 VPWR VGND sg13cmos5l_decap_8
* cell instance sg13cmos5l_decap_8_49 r0 *1 0,0
Xsg13cmos5l_decap_8_49 VPWR VGND sg13cmos5l_decap_8
* cell instance sg13cmos5l_decap_8_50 r0 *1 0,0
Xsg13cmos5l_decap_8_50 VPWR VGND sg13cmos5l_decap_8
* cell instance sg13cmos5l_decap_8_51 r0 *1 0,0
Xsg13cmos5l_decap_8_51 VPWR VGND sg13cmos5l_decap_8
* cell instance sg13cmos5l_decap_8_52 r0 *1 0,0
Xsg13cmos5l_decap_8_52 VPWR VGND sg13cmos5l_decap_8
* cell instance sg13cmos5l_decap_8_53 r0 *1 0,0
Xsg13cmos5l_decap_8_53 VPWR VGND sg13cmos5l_decap_8
* cell instance sg13cmos5l_decap_8_54 r0 *1 0,0
Xsg13cmos5l_decap_8_54 VPWR VGND sg13cmos5l_decap_8
* cell instance sg13cmos5l_decap_8_55 r0 *1 0,0
Xsg13cmos5l_decap_8_55 VPWR VGND sg13cmos5l_decap_8
* cell instance sg13cmos5l_decap_8_56 r0 *1 0,0
Xsg13cmos5l_decap_8_56 VPWR VGND sg13cmos5l_decap_8
* cell instance sg13cmos5l_decap_8_57 r0 *1 0,0
Xsg13cmos5l_decap_8_57 VPWR VGND sg13cmos5l_decap_8
* cell instance sg13cmos5l_decap_8_58 r0 *1 0,0
Xsg13cmos5l_decap_8_58 VPWR VGND sg13cmos5l_decap_8
* cell instance sg13cmos5l_decap_8_59 r0 *1 0,0
Xsg13cmos5l_decap_8_59 VPWR VGND sg13cmos5l_decap_8
* cell instance sg13cmos5l_decap_8_60 r0 *1 0,0
Xsg13cmos5l_decap_8_60 VPWR VGND sg13cmos5l_decap_8
* cell instance sg13cmos5l_decap_8_61 r0 *1 0,0
Xsg13cmos5l_decap_8_61 VPWR VGND sg13cmos5l_decap_8
* cell instance sg13cmos5l_decap_8_62 r0 *1 0,0
Xsg13cmos5l_decap_8_62 VPWR VGND sg13cmos5l_decap_8
* cell instance sg13cmos5l_decap_8_63 r0 *1 0,0
Xsg13cmos5l_decap_8_63 VPWR VGND sg13cmos5l_decap_8
* cell instance sg13cmos5l_decap_8_64 r0 *1 0,0
Xsg13cmos5l_decap_8_64 VPWR VGND sg13cmos5l_decap_8
* cell instance sg13cmos5l_decap_8_65 r0 *1 0,0
Xsg13cmos5l_decap_8_65 VPWR VGND sg13cmos5l_decap_8
* cell instance sg13cmos5l_decap_8_66 r0 *1 0,0
Xsg13cmos5l_decap_8_66 VPWR VGND sg13cmos5l_decap_8
* cell instance sg13cmos5l_decap_8_67 r0 *1 0,0
Xsg13cmos5l_decap_8_67 VPWR VGND sg13cmos5l_decap_8
* cell instance sg13cmos5l_decap_8_68 r0 *1 0,0
Xsg13cmos5l_decap_8_68 VPWR VGND sg13cmos5l_decap_8
* cell instance sg13cmos5l_decap_8_69 r0 *1 0,0
Xsg13cmos5l_decap_8_69 VPWR VGND sg13cmos5l_decap_8
* cell instance sg13cmos5l_decap_8_70 r0 *1 0,0
Xsg13cmos5l_decap_8_70 VPWR VGND sg13cmos5l_decap_8
* cell instance sg13cmos5l_decap_8_71 r0 *1 0,0
Xsg13cmos5l_decap_8_71 VPWR VGND sg13cmos5l_decap_8
* cell instance sg13cmos5l_decap_8_72 r0 *1 0,0
Xsg13cmos5l_decap_8_72 VPWR VGND sg13cmos5l_decap_8
* cell instance sg13cmos5l_decap_8_73 r0 *1 0,0
Xsg13cmos5l_decap_8_73 VPWR VGND sg13cmos5l_decap_8
* cell instance sg13cmos5l_decap_8_74 r0 *1 0,0
Xsg13cmos5l_decap_8_74 VPWR VGND sg13cmos5l_decap_8
* cell instance sg13cmos5l_decap_8_75 r0 *1 0,0
Xsg13cmos5l_decap_8_75 VPWR VGND sg13cmos5l_decap_8
* cell instance sg13cmos5l_decap_8_76 r0 *1 0,0
Xsg13cmos5l_decap_8_76 VPWR VGND sg13cmos5l_decap_8
* cell instance sg13cmos5l_decap_8_77 r0 *1 0,0
Xsg13cmos5l_decap_8_77 VPWR VGND sg13cmos5l_decap_8
* cell instance sg13cmos5l_decap_8_78 r0 *1 0,0
Xsg13cmos5l_decap_8_78 VPWR VGND sg13cmos5l_decap_8
* cell instance sg13cmos5l_decap_8_79 r0 *1 0,0
Xsg13cmos5l_decap_8_79 VPWR VGND sg13cmos5l_decap_8
* cell instance sg13cmos5l_decap_8_80 r0 *1 0,0
Xsg13cmos5l_decap_8_80 VPWR VGND sg13cmos5l_decap_8
* cell instance sg13cmos5l_decap_8_81 r0 *1 0,0
Xsg13cmos5l_decap_8_81 VPWR VGND sg13cmos5l_decap_8
* cell instance sg13cmos5l_decap_8_82 r0 *1 0,0
Xsg13cmos5l_decap_8_82 VPWR VGND sg13cmos5l_decap_8
* cell instance sg13cmos5l_decap_8_83 r0 *1 0,0
Xsg13cmos5l_decap_8_83 VPWR VGND sg13cmos5l_decap_8
* cell instance sg13cmos5l_decap_8_84 r0 *1 0,0
Xsg13cmos5l_decap_8_84 VPWR VGND sg13cmos5l_decap_8
* cell instance sg13cmos5l_decap_8_85 r0 *1 0,0
Xsg13cmos5l_decap_8_85 VPWR VGND sg13cmos5l_decap_8
* cell instance sg13cmos5l_decap_8_86 r0 *1 0,0
Xsg13cmos5l_decap_8_86 VPWR VGND sg13cmos5l_decap_8
* cell instance sg13cmos5l_decap_8_87 r0 *1 0,0
Xsg13cmos5l_decap_8_87 VPWR VGND sg13cmos5l_decap_8
* cell instance sg13cmos5l_decap_8_88 r0 *1 0,0
Xsg13cmos5l_decap_8_88 VPWR VGND sg13cmos5l_decap_8
* cell instance sg13cmos5l_decap_8_89 r0 *1 0,0
Xsg13cmos5l_decap_8_89 VPWR VGND sg13cmos5l_decap_8
* cell instance sg13cmos5l_decap_8_90 r0 *1 0,0
Xsg13cmos5l_decap_8_90 VPWR VGND sg13cmos5l_decap_8
* cell instance sg13cmos5l_decap_8_91 r0 *1 0,0
Xsg13cmos5l_decap_8_91 VPWR VGND sg13cmos5l_decap_8
* cell instance sg13cmos5l_decap_8_92 r0 *1 0,0
Xsg13cmos5l_decap_8_92 VPWR VGND sg13cmos5l_decap_8
* cell instance sg13cmos5l_decap_8_93 r0 *1 0,0
Xsg13cmos5l_decap_8_93 VPWR VGND sg13cmos5l_decap_8
* cell instance sg13cmos5l_decap_8_94 r0 *1 0,0
Xsg13cmos5l_decap_8_94 VPWR VGND sg13cmos5l_decap_8
* cell instance sg13cmos5l_decap_8_95 r0 *1 0,0
Xsg13cmos5l_decap_8_95 VPWR VGND sg13cmos5l_decap_8
* cell instance sg13cmos5l_decap_8_96 r0 *1 0,0
Xsg13cmos5l_decap_8_96 VPWR VGND sg13cmos5l_decap_8
* cell instance sg13cmos5l_decap_8_97 r0 *1 0,0
Xsg13cmos5l_decap_8_97 VPWR VGND sg13cmos5l_decap_8
* cell instance sg13cmos5l_decap_8_98 r0 *1 0,0
Xsg13cmos5l_decap_8_98 VPWR VGND sg13cmos5l_decap_8
* cell instance sg13cmos5l_decap_8_99 r0 *1 0,0
Xsg13cmos5l_decap_8_99 VPWR VGND sg13cmos5l_decap_8
* cell instance sg13cmos5l_decap_8_100 r0 *1 0,0
Xsg13cmos5l_decap_8_100 VPWR VGND sg13cmos5l_decap_8
* cell instance sg13cmos5l_decap_8_101 r0 *1 0,0
Xsg13cmos5l_decap_8_101 VPWR VGND sg13cmos5l_decap_8
* cell instance sg13cmos5l_decap_8_102 r0 *1 0,0
Xsg13cmos5l_decap_8_102 VPWR VGND sg13cmos5l_decap_8
* cell instance sg13cmos5l_decap_8_103 r0 *1 0,0
Xsg13cmos5l_decap_8_103 VPWR VGND sg13cmos5l_decap_8
* cell instance sg13cmos5l_decap_8_104 r0 *1 0,0
Xsg13cmos5l_decap_8_104 VPWR VGND sg13cmos5l_decap_8
* cell instance sg13cmos5l_decap_8_105 r0 *1 0,0
Xsg13cmos5l_decap_8_105 VPWR VGND sg13cmos5l_decap_8
* cell instance sg13cmos5l_decap_8_106 r0 *1 0,0
Xsg13cmos5l_decap_8_106 VPWR VGND sg13cmos5l_decap_8
* cell instance sg13cmos5l_decap_8_107 r0 *1 0,0
Xsg13cmos5l_decap_8_107 VPWR VGND sg13cmos5l_decap_8
* cell instance sg13cmos5l_decap_8_108 r0 *1 0,0
Xsg13cmos5l_decap_8_108 VPWR VGND sg13cmos5l_decap_8
* cell instance sg13cmos5l_decap_8_109 r0 *1 0,0
Xsg13cmos5l_decap_8_109 VPWR VGND sg13cmos5l_decap_8
* cell instance sg13cmos5l_decap_8_110 r0 *1 0,0
Xsg13cmos5l_decap_8_110 VPWR VGND sg13cmos5l_decap_8
* cell instance sg13cmos5l_decap_8_111 r0 *1 0,0
Xsg13cmos5l_decap_8_111 VPWR VGND sg13cmos5l_decap_8
* cell instance sg13cmos5l_decap_8_112 r0 *1 0,0
Xsg13cmos5l_decap_8_112 VPWR VGND sg13cmos5l_decap_8
* cell instance sg13cmos5l_decap_8_113 r0 *1 0,0
Xsg13cmos5l_decap_8_113 VPWR VGND sg13cmos5l_decap_8
* cell instance sg13cmos5l_decap_8_114 r0 *1 0,0
Xsg13cmos5l_decap_8_114 VPWR VGND sg13cmos5l_decap_8
* cell instance sg13cmos5l_decap_8_115 r0 *1 0,0
Xsg13cmos5l_decap_8_115 VPWR VGND sg13cmos5l_decap_8
* cell instance sg13cmos5l_decap_8_116 r0 *1 0,0
Xsg13cmos5l_decap_8_116 VPWR VGND sg13cmos5l_decap_8
* cell instance sg13cmos5l_decap_8_117 r0 *1 0,0
Xsg13cmos5l_decap_8_117 VPWR VGND sg13cmos5l_decap_8
* cell instance sg13cmos5l_decap_8_118 r0 *1 0,0
Xsg13cmos5l_decap_8_118 VPWR VGND sg13cmos5l_decap_8
* cell instance sg13cmos5l_decap_8_119 r0 *1 0,0
Xsg13cmos5l_decap_8_119 VPWR VGND sg13cmos5l_decap_8
* cell instance sg13cmos5l_decap_8_120 r0 *1 0,0
Xsg13cmos5l_decap_8_120 VPWR VGND sg13cmos5l_decap_8
* cell instance sg13cmos5l_decap_8_121 r0 *1 0,0
Xsg13cmos5l_decap_8_121 VPWR VGND sg13cmos5l_decap_8
* cell instance sg13cmos5l_decap_8_122 r0 *1 0,0
Xsg13cmos5l_decap_8_122 VPWR VGND sg13cmos5l_decap_8
* cell instance sg13cmos5l_decap_8_123 r0 *1 0,0
Xsg13cmos5l_decap_8_123 VPWR VGND sg13cmos5l_decap_8
* cell instance sg13cmos5l_decap_8_124 r0 *1 0,0
Xsg13cmos5l_decap_8_124 VPWR VGND sg13cmos5l_decap_8
* cell instance sg13cmos5l_decap_8_125 r0 *1 0,0
Xsg13cmos5l_decap_8_125 VPWR VGND sg13cmos5l_decap_8
* cell instance sg13cmos5l_decap_8_126 r0 *1 0,0
Xsg13cmos5l_decap_8_126 VPWR VGND sg13cmos5l_decap_8
* cell instance sg13cmos5l_decap_8_127 r0 *1 0,0
Xsg13cmos5l_decap_8_127 VPWR VGND sg13cmos5l_decap_8
* cell instance sg13cmos5l_decap_8_128 r0 *1 0,0
Xsg13cmos5l_decap_8_128 VPWR VGND sg13cmos5l_decap_8
* cell instance sg13cmos5l_decap_8_129 r0 *1 0,0
Xsg13cmos5l_decap_8_129 VPWR VGND sg13cmos5l_decap_8
* cell instance sg13cmos5l_decap_8_130 r0 *1 0,0
Xsg13cmos5l_decap_8_130 VPWR VGND sg13cmos5l_decap_8
* cell instance sg13cmos5l_decap_8_131 r0 *1 0,0
Xsg13cmos5l_decap_8_131 VPWR VGND sg13cmos5l_decap_8
* cell instance sg13cmos5l_decap_8_132 r0 *1 0,0
Xsg13cmos5l_decap_8_132 VPWR VGND sg13cmos5l_decap_8
* cell instance sg13cmos5l_decap_8_133 r0 *1 0,0
Xsg13cmos5l_decap_8_133 VPWR VGND sg13cmos5l_decap_8
* cell instance sg13cmos5l_decap_8_134 r0 *1 0,0
Xsg13cmos5l_decap_8_134 VPWR VGND sg13cmos5l_decap_8
* cell instance sg13cmos5l_decap_8_135 r0 *1 0,0
Xsg13cmos5l_decap_8_135 VPWR VGND sg13cmos5l_decap_8
* cell instance sg13cmos5l_decap_8_136 r0 *1 0,0
Xsg13cmos5l_decap_8_136 VPWR VGND sg13cmos5l_decap_8
* cell instance sg13cmos5l_decap_8_137 r0 *1 0,0
Xsg13cmos5l_decap_8_137 VPWR VGND sg13cmos5l_decap_8
* cell instance sg13cmos5l_decap_8_138 r0 *1 0,0
Xsg13cmos5l_decap_8_138 VPWR VGND sg13cmos5l_decap_8
* cell instance sg13cmos5l_decap_8_139 r0 *1 0,0
Xsg13cmos5l_decap_8_139 VPWR VGND sg13cmos5l_decap_8
* cell instance sg13cmos5l_decap_8_140 r0 *1 0,0
Xsg13cmos5l_decap_8_140 VPWR VGND sg13cmos5l_decap_8
* cell instance sg13cmos5l_decap_8_141 r0 *1 0,0
Xsg13cmos5l_decap_8_141 VPWR VGND sg13cmos5l_decap_8
* cell instance sg13cmos5l_decap_8_142 r0 *1 0,0
Xsg13cmos5l_decap_8_142 VPWR VGND sg13cmos5l_decap_8
* cell instance sg13cmos5l_decap_8_143 r0 *1 0,0
Xsg13cmos5l_decap_8_143 VPWR VGND sg13cmos5l_decap_8
* cell instance sg13cmos5l_decap_8_144 r0 *1 0,0
Xsg13cmos5l_decap_8_144 VPWR VGND sg13cmos5l_decap_8
* cell instance sg13cmos5l_decap_8_145 r0 *1 0,0
Xsg13cmos5l_decap_8_145 VPWR VGND sg13cmos5l_decap_8
* cell instance sg13cmos5l_decap_8_146 r0 *1 0,0
Xsg13cmos5l_decap_8_146 VPWR VGND sg13cmos5l_decap_8
* cell instance sg13cmos5l_decap_8_147 r0 *1 0,0
Xsg13cmos5l_decap_8_147 VPWR VGND sg13cmos5l_decap_8
* cell instance sg13cmos5l_decap_8_148 r0 *1 0,0
Xsg13cmos5l_decap_8_148 VPWR VGND sg13cmos5l_decap_8
* cell instance sg13cmos5l_decap_8_149 r0 *1 0,0
Xsg13cmos5l_decap_8_149 VPWR VGND sg13cmos5l_decap_8
* cell instance sg13cmos5l_decap_8_150 r0 *1 0,0
Xsg13cmos5l_decap_8_150 VPWR VGND sg13cmos5l_decap_8
* cell instance sg13cmos5l_decap_8_151 r0 *1 0,0
Xsg13cmos5l_decap_8_151 VPWR VGND sg13cmos5l_decap_8
* cell instance sg13cmos5l_decap_8_152 r0 *1 0,0
Xsg13cmos5l_decap_8_152 VPWR VGND sg13cmos5l_decap_8
* cell instance sg13cmos5l_decap_8_153 r0 *1 0,0
Xsg13cmos5l_decap_8_153 VPWR VGND sg13cmos5l_decap_8
* cell instance sg13cmos5l_decap_8_154 r0 *1 0,0
Xsg13cmos5l_decap_8_154 VPWR VGND sg13cmos5l_decap_8
* cell instance sg13cmos5l_decap_8_155 r0 *1 0,0
Xsg13cmos5l_decap_8_155 VPWR VGND sg13cmos5l_decap_8
* cell instance sg13cmos5l_decap_8_156 r0 *1 0,0
Xsg13cmos5l_decap_8_156 VPWR VGND sg13cmos5l_decap_8
* cell instance sg13cmos5l_decap_8_157 r0 *1 0,0
Xsg13cmos5l_decap_8_157 VPWR VGND sg13cmos5l_decap_8
* cell instance sg13cmos5l_decap_8_158 r0 *1 0,0
Xsg13cmos5l_decap_8_158 VPWR VGND sg13cmos5l_decap_8
* cell instance sg13cmos5l_decap_8_159 r0 *1 0,0
Xsg13cmos5l_decap_8_159 VPWR VGND sg13cmos5l_decap_8
* cell instance sg13cmos5l_decap_8_160 r0 *1 0,0
Xsg13cmos5l_decap_8_160 VPWR VGND sg13cmos5l_decap_8
* cell instance sg13cmos5l_decap_8_161 r0 *1 0,0
Xsg13cmos5l_decap_8_161 VPWR VGND sg13cmos5l_decap_8
* cell instance sg13cmos5l_decap_8_162 r0 *1 0,0
Xsg13cmos5l_decap_8_162 VPWR VGND sg13cmos5l_decap_8
* cell instance sg13cmos5l_decap_8_163 r0 *1 0,0
Xsg13cmos5l_decap_8_163 VPWR VGND sg13cmos5l_decap_8
* cell instance sg13cmos5l_decap_8_164 r0 *1 0,0
Xsg13cmos5l_decap_8_164 VPWR VGND sg13cmos5l_decap_8
* cell instance sg13cmos5l_decap_8_165 r0 *1 0,0
Xsg13cmos5l_decap_8_165 VPWR VGND sg13cmos5l_decap_8
* cell instance sg13cmos5l_decap_8_166 r0 *1 0,0
Xsg13cmos5l_decap_8_166 VPWR VGND sg13cmos5l_decap_8
* cell instance sg13cmos5l_decap_8_167 r0 *1 0,0
Xsg13cmos5l_decap_8_167 VPWR VGND sg13cmos5l_decap_8
* cell instance sg13cmos5l_decap_8_168 r0 *1 0,0
Xsg13cmos5l_decap_8_168 VPWR VGND sg13cmos5l_decap_8
* cell instance sg13cmos5l_decap_8_169 r0 *1 0,0
Xsg13cmos5l_decap_8_169 VPWR VGND sg13cmos5l_decap_8
* cell instance sg13cmos5l_decap_8_170 r0 *1 0,0
Xsg13cmos5l_decap_8_170 VPWR VGND sg13cmos5l_decap_8
* cell instance sg13cmos5l_decap_8_171 r0 *1 0,0
Xsg13cmos5l_decap_8_171 VPWR VGND sg13cmos5l_decap_8
* cell instance sg13cmos5l_decap_8_172 r0 *1 0,0
Xsg13cmos5l_decap_8_172 VPWR VGND sg13cmos5l_decap_8
* cell instance sg13cmos5l_decap_8_173 r0 *1 0,0
Xsg13cmos5l_decap_8_173 VPWR VGND sg13cmos5l_decap_8
* cell instance sg13cmos5l_decap_8_174 r0 *1 0,0
Xsg13cmos5l_decap_8_174 VPWR VGND sg13cmos5l_decap_8
* cell instance sg13cmos5l_decap_8_175 r0 *1 0,0
Xsg13cmos5l_decap_8_175 VPWR VGND sg13cmos5l_decap_8
* cell instance sg13cmos5l_decap_8_176 r0 *1 0,0
Xsg13cmos5l_decap_8_176 VPWR VGND sg13cmos5l_decap_8
* cell instance sg13cmos5l_decap_8_177 r0 *1 0,0
Xsg13cmos5l_decap_8_177 VPWR VGND sg13cmos5l_decap_8
* cell instance sg13cmos5l_decap_8_178 r0 *1 0,0
Xsg13cmos5l_decap_8_178 VPWR VGND sg13cmos5l_decap_8
* cell instance sg13cmos5l_decap_8_179 r0 *1 0,0
Xsg13cmos5l_decap_8_179 VPWR VGND sg13cmos5l_decap_8
* cell instance sg13cmos5l_decap_8_180 r0 *1 0,0
Xsg13cmos5l_decap_8_180 VPWR VGND sg13cmos5l_decap_8
* cell instance sg13cmos5l_decap_8_181 r0 *1 0,0
Xsg13cmos5l_decap_8_181 VPWR VGND sg13cmos5l_decap_8
* cell instance sg13cmos5l_decap_8_182 r0 *1 0,0
Xsg13cmos5l_decap_8_182 VPWR VGND sg13cmos5l_decap_8
* cell instance sg13cmos5l_decap_8_183 r0 *1 0,0
Xsg13cmos5l_decap_8_183 VPWR VGND sg13cmos5l_decap_8
* cell instance sg13cmos5l_decap_8_184 r0 *1 0,0
Xsg13cmos5l_decap_8_184 VPWR VGND sg13cmos5l_decap_8
* cell instance sg13cmos5l_decap_8_185 r0 *1 0,0
Xsg13cmos5l_decap_8_185 VPWR VGND sg13cmos5l_decap_8
* cell instance sg13cmos5l_decap_8_186 r0 *1 0,0
Xsg13cmos5l_decap_8_186 VPWR VGND sg13cmos5l_decap_8
* cell instance sg13cmos5l_decap_8_187 r0 *1 0,0
Xsg13cmos5l_decap_8_187 VPWR VGND sg13cmos5l_decap_8
* cell instance sg13cmos5l_decap_8_188 r0 *1 0,0
Xsg13cmos5l_decap_8_188 VPWR VGND sg13cmos5l_decap_8
* cell instance sg13cmos5l_decap_8_189 r0 *1 0,0
Xsg13cmos5l_decap_8_189 VPWR VGND sg13cmos5l_decap_8
* cell instance sg13cmos5l_decap_8_190 r0 *1 0,0
Xsg13cmos5l_decap_8_190 VPWR VGND sg13cmos5l_decap_8
* cell instance sg13cmos5l_decap_8_191 r0 *1 0,0
Xsg13cmos5l_decap_8_191 VPWR VGND sg13cmos5l_decap_8
* cell instance sg13cmos5l_decap_8_192 r0 *1 0,0
Xsg13cmos5l_decap_8_192 VPWR VGND sg13cmos5l_decap_8
* cell instance sg13cmos5l_decap_8_193 r0 *1 0,0
Xsg13cmos5l_decap_8_193 VPWR VGND sg13cmos5l_decap_8
* cell instance sg13cmos5l_decap_8_194 r0 *1 0,0
Xsg13cmos5l_decap_8_194 VPWR VGND sg13cmos5l_decap_8
* cell instance sg13cmos5l_decap_8_195 r0 *1 0,0
Xsg13cmos5l_decap_8_195 VPWR VGND sg13cmos5l_decap_8
* cell instance sg13cmos5l_decap_8_196 r0 *1 0,0
Xsg13cmos5l_decap_8_196 VPWR VGND sg13cmos5l_decap_8
* cell instance sg13cmos5l_decap_8_197 r0 *1 0,0
Xsg13cmos5l_decap_8_197 VPWR VGND sg13cmos5l_decap_8
* cell instance sg13cmos5l_decap_8_198 r0 *1 0,0
Xsg13cmos5l_decap_8_198 VPWR VGND sg13cmos5l_decap_8
* cell instance sg13cmos5l_decap_8_199 r0 *1 0,0
Xsg13cmos5l_decap_8_199 VPWR VGND sg13cmos5l_decap_8
* cell instance sg13cmos5l_decap_8_200 r0 *1 0,0
Xsg13cmos5l_decap_8_200 VPWR VGND sg13cmos5l_decap_8
* cell instance sg13cmos5l_decap_8_201 r0 *1 0,0
Xsg13cmos5l_decap_8_201 VPWR VGND sg13cmos5l_decap_8
* cell instance sg13cmos5l_decap_8_202 r0 *1 0,0
Xsg13cmos5l_decap_8_202 VPWR VGND sg13cmos5l_decap_8
* cell instance sg13cmos5l_decap_8_203 r0 *1 0,0
Xsg13cmos5l_decap_8_203 VPWR VGND sg13cmos5l_decap_8
* cell instance sg13cmos5l_decap_8_204 r0 *1 0,0
Xsg13cmos5l_decap_8_204 VPWR VGND sg13cmos5l_decap_8
* cell instance sg13cmos5l_decap_8_205 r0 *1 0,0
Xsg13cmos5l_decap_8_205 VPWR VGND sg13cmos5l_decap_8
* cell instance sg13cmos5l_decap_8_206 r0 *1 0,0
Xsg13cmos5l_decap_8_206 VPWR VGND sg13cmos5l_decap_8
* cell instance sg13cmos5l_decap_8_207 r0 *1 0,0
Xsg13cmos5l_decap_8_207 VPWR VGND sg13cmos5l_decap_8
* cell instance sg13cmos5l_decap_8_208 r0 *1 0,0
Xsg13cmos5l_decap_8_208 VPWR VGND sg13cmos5l_decap_8
* cell instance sg13cmos5l_decap_8_209 r0 *1 0,0
Xsg13cmos5l_decap_8_209 VPWR VGND sg13cmos5l_decap_8
* cell instance sg13cmos5l_decap_8_210 r0 *1 0,0
Xsg13cmos5l_decap_8_210 VPWR VGND sg13cmos5l_decap_8
* cell instance sg13cmos5l_decap_8_211 r0 *1 0,0
Xsg13cmos5l_decap_8_211 VPWR VGND sg13cmos5l_decap_8
* cell instance sg13cmos5l_decap_8_212 r0 *1 0,0
Xsg13cmos5l_decap_8_212 VPWR VGND sg13cmos5l_decap_8
* cell instance sg13cmos5l_decap_8_213 r0 *1 0,0
Xsg13cmos5l_decap_8_213 VPWR VGND sg13cmos5l_decap_8
* cell instance sg13cmos5l_decap_8_214 r0 *1 0,0
Xsg13cmos5l_decap_8_214 VPWR VGND sg13cmos5l_decap_8
* cell instance sg13cmos5l_decap_8_215 r0 *1 0,0
Xsg13cmos5l_decap_8_215 VPWR VGND sg13cmos5l_decap_8
* cell instance sg13cmos5l_decap_8_216 r0 *1 0,0
Xsg13cmos5l_decap_8_216 VPWR VGND sg13cmos5l_decap_8
* cell instance sg13cmos5l_decap_8_217 r0 *1 0,0
Xsg13cmos5l_decap_8_217 VPWR VGND sg13cmos5l_decap_8
* cell instance sg13cmos5l_decap_8_218 r0 *1 0,0
Xsg13cmos5l_decap_8_218 VPWR VGND sg13cmos5l_decap_8
* cell instance sg13cmos5l_decap_8_219 r0 *1 0,0
Xsg13cmos5l_decap_8_219 VPWR VGND sg13cmos5l_decap_8
* cell instance sg13cmos5l_decap_8_220 r0 *1 0,0
Xsg13cmos5l_decap_8_220 VPWR VGND sg13cmos5l_decap_8
* cell instance sg13cmos5l_decap_8_221 r0 *1 0,0
Xsg13cmos5l_decap_8_221 VPWR VGND sg13cmos5l_decap_8
* cell instance sg13cmos5l_decap_8_222 r0 *1 0,0
Xsg13cmos5l_decap_8_222 VPWR VGND sg13cmos5l_decap_8
* cell instance sg13cmos5l_decap_8_223 r0 *1 0,0
Xsg13cmos5l_decap_8_223 VPWR VGND sg13cmos5l_decap_8
* cell instance sg13cmos5l_decap_8_224 r0 *1 0,0
Xsg13cmos5l_decap_8_224 VPWR VGND sg13cmos5l_decap_8
* cell instance sg13cmos5l_decap_8_225 r0 *1 0,0
Xsg13cmos5l_decap_8_225 VPWR VGND sg13cmos5l_decap_8
* cell instance sg13cmos5l_decap_8_226 r0 *1 0,0
Xsg13cmos5l_decap_8_226 VPWR VGND sg13cmos5l_decap_8
* cell instance sg13cmos5l_decap_8_227 r0 *1 0,0
Xsg13cmos5l_decap_8_227 VPWR VGND sg13cmos5l_decap_8
* cell instance sg13cmos5l_decap_8_228 r0 *1 0,0
Xsg13cmos5l_decap_8_228 VPWR VGND sg13cmos5l_decap_8
* cell instance sg13cmos5l_decap_8_229 r0 *1 0,0
Xsg13cmos5l_decap_8_229 VPWR VGND sg13cmos5l_decap_8
* cell instance sg13cmos5l_decap_8_230 r0 *1 0,0
Xsg13cmos5l_decap_8_230 VPWR VGND sg13cmos5l_decap_8
* cell instance sg13cmos5l_decap_8_231 r0 *1 0,0
Xsg13cmos5l_decap_8_231 VPWR VGND sg13cmos5l_decap_8
* cell instance sg13cmos5l_decap_8_232 r0 *1 0,0
Xsg13cmos5l_decap_8_232 VPWR VGND sg13cmos5l_decap_8
* cell instance sg13cmos5l_decap_8_233 r0 *1 0,0
Xsg13cmos5l_decap_8_233 VPWR VGND sg13cmos5l_decap_8
* cell instance sg13cmos5l_decap_8_234 r0 *1 0,0
Xsg13cmos5l_decap_8_234 VPWR VGND sg13cmos5l_decap_8
* cell instance sg13cmos5l_decap_8_235 r0 *1 0,0
Xsg13cmos5l_decap_8_235 VPWR VGND sg13cmos5l_decap_8
* cell instance sg13cmos5l_decap_8_236 r0 *1 0,0
Xsg13cmos5l_decap_8_236 VPWR VGND sg13cmos5l_decap_8
* cell instance sg13cmos5l_decap_8_237 r0 *1 0,0
Xsg13cmos5l_decap_8_237 VPWR VGND sg13cmos5l_decap_8
* cell instance sg13cmos5l_decap_8_238 r0 *1 0,0
Xsg13cmos5l_decap_8_238 VPWR VGND sg13cmos5l_decap_8
* cell instance sg13cmos5l_decap_8_239 r0 *1 0,0
Xsg13cmos5l_decap_8_239 VPWR VGND sg13cmos5l_decap_8
* cell instance sg13cmos5l_decap_8_240 r0 *1 0,0
Xsg13cmos5l_decap_8_240 VPWR VGND sg13cmos5l_decap_8
* cell instance sg13cmos5l_decap_8_241 r0 *1 0,0
Xsg13cmos5l_decap_8_241 VPWR VGND sg13cmos5l_decap_8
* cell instance sg13cmos5l_decap_8_242 r0 *1 0,0
Xsg13cmos5l_decap_8_242 VPWR VGND sg13cmos5l_decap_8
* cell instance sg13cmos5l_decap_8_243 r0 *1 0,0
Xsg13cmos5l_decap_8_243 VPWR VGND sg13cmos5l_decap_8
* cell instance sg13cmos5l_decap_8_244 r0 *1 0,0
Xsg13cmos5l_decap_8_244 VPWR VGND sg13cmos5l_decap_8
* cell instance sg13cmos5l_decap_8_245 r0 *1 0,0
Xsg13cmos5l_decap_8_245 VPWR VGND sg13cmos5l_decap_8
* cell instance sg13cmos5l_decap_8_246 r0 *1 0,0
Xsg13cmos5l_decap_8_246 VPWR VGND sg13cmos5l_decap_8
* cell instance sg13cmos5l_decap_8_247 r0 *1 0,0
Xsg13cmos5l_decap_8_247 VPWR VGND sg13cmos5l_decap_8
* cell instance sg13cmos5l_decap_8_248 r0 *1 0,0
Xsg13cmos5l_decap_8_248 VPWR VGND sg13cmos5l_decap_8
* cell instance sg13cmos5l_decap_8_249 r0 *1 0,0
Xsg13cmos5l_decap_8_249 VPWR VGND sg13cmos5l_decap_8
* cell instance sg13cmos5l_decap_8_250 r0 *1 0,0
Xsg13cmos5l_decap_8_250 VPWR VGND sg13cmos5l_decap_8
* cell instance sg13cmos5l_decap_8_251 r0 *1 0,0
Xsg13cmos5l_decap_8_251 VPWR VGND sg13cmos5l_decap_8
* cell instance sg13cmos5l_decap_8_252 r0 *1 0,0
Xsg13cmos5l_decap_8_252 VPWR VGND sg13cmos5l_decap_8
* cell instance sg13cmos5l_decap_8_253 r0 *1 0,0
Xsg13cmos5l_decap_8_253 VPWR VGND sg13cmos5l_decap_8
* cell instance sg13cmos5l_decap_8_254 r0 *1 0,0
Xsg13cmos5l_decap_8_254 VPWR VGND sg13cmos5l_decap_8
* cell instance sg13cmos5l_decap_8_255 r0 *1 0,0
Xsg13cmos5l_decap_8_255 VPWR VGND sg13cmos5l_decap_8
* cell instance sg13cmos5l_decap_8_256 r0 *1 0,0
Xsg13cmos5l_decap_8_256 VPWR VGND sg13cmos5l_decap_8
* cell instance sg13cmos5l_decap_8_257 r0 *1 0,0
Xsg13cmos5l_decap_8_257 VPWR VGND sg13cmos5l_decap_8
* cell instance sg13cmos5l_decap_8_258 r0 *1 0,0
Xsg13cmos5l_decap_8_258 VPWR VGND sg13cmos5l_decap_8
* cell instance sg13cmos5l_decap_8_259 r0 *1 0,0
Xsg13cmos5l_decap_8_259 VPWR VGND sg13cmos5l_decap_8
* cell instance sg13cmos5l_decap_8_260 r0 *1 0,0
Xsg13cmos5l_decap_8_260 VPWR VGND sg13cmos5l_decap_8
* cell instance sg13cmos5l_decap_8_261 r0 *1 0,0
Xsg13cmos5l_decap_8_261 VPWR VGND sg13cmos5l_decap_8
* cell instance sg13cmos5l_decap_8_262 r0 *1 0,0
Xsg13cmos5l_decap_8_262 VPWR VGND sg13cmos5l_decap_8
* cell instance sg13cmos5l_decap_8_263 r0 *1 0,0
Xsg13cmos5l_decap_8_263 VPWR VGND sg13cmos5l_decap_8
* cell instance sg13cmos5l_decap_8_264 r0 *1 0,0
Xsg13cmos5l_decap_8_264 VPWR VGND sg13cmos5l_decap_8
* cell instance sg13cmos5l_decap_8_265 r0 *1 0,0
Xsg13cmos5l_decap_8_265 VPWR VGND sg13cmos5l_decap_8
* cell instance sg13cmos5l_decap_8_266 r0 *1 0,0
Xsg13cmos5l_decap_8_266 VPWR VGND sg13cmos5l_decap_8
* cell instance sg13cmos5l_decap_8_267 r0 *1 0,0
Xsg13cmos5l_decap_8_267 VPWR VGND sg13cmos5l_decap_8
* cell instance sg13cmos5l_decap_8_268 r0 *1 0,0
Xsg13cmos5l_decap_8_268 VPWR VGND sg13cmos5l_decap_8
* cell instance sg13cmos5l_decap_8_269 r0 *1 0,0
Xsg13cmos5l_decap_8_269 VPWR VGND sg13cmos5l_decap_8
* cell instance sg13cmos5l_decap_8_270 r0 *1 0,0
Xsg13cmos5l_decap_8_270 VPWR VGND sg13cmos5l_decap_8
* cell instance sg13cmos5l_decap_8_271 r0 *1 0,0
Xsg13cmos5l_decap_8_271 VPWR VGND sg13cmos5l_decap_8
* cell instance sg13cmos5l_decap_8_272 r0 *1 0,0
Xsg13cmos5l_decap_8_272 VPWR VGND sg13cmos5l_decap_8
* cell instance sg13cmos5l_decap_8_273 r0 *1 0,0
Xsg13cmos5l_decap_8_273 VPWR VGND sg13cmos5l_decap_8
* cell instance sg13cmos5l_decap_8_274 r0 *1 0,0
Xsg13cmos5l_decap_8_274 VPWR VGND sg13cmos5l_decap_8
* cell instance sg13cmos5l_decap_8_275 r0 *1 0,0
Xsg13cmos5l_decap_8_275 VPWR VGND sg13cmos5l_decap_8
* cell instance sg13cmos5l_decap_8_276 r0 *1 0,0
Xsg13cmos5l_decap_8_276 VPWR VGND sg13cmos5l_decap_8
* cell instance sg13cmos5l_decap_8_277 r0 *1 0,0
Xsg13cmos5l_decap_8_277 VPWR VGND sg13cmos5l_decap_8
* cell instance sg13cmos5l_decap_8_278 r0 *1 0,0
Xsg13cmos5l_decap_8_278 VPWR VGND sg13cmos5l_decap_8
* cell instance sg13cmos5l_decap_8_279 r0 *1 0,0
Xsg13cmos5l_decap_8_279 VPWR VGND sg13cmos5l_decap_8
* cell instance sg13cmos5l_decap_8_280 r0 *1 0,0
Xsg13cmos5l_decap_8_280 VPWR VGND sg13cmos5l_decap_8
* cell instance sg13cmos5l_decap_8_281 r0 *1 0,0
Xsg13cmos5l_decap_8_281 VPWR VGND sg13cmos5l_decap_8
* cell instance sg13cmos5l_decap_8_282 r0 *1 0,0
Xsg13cmos5l_decap_8_282 VPWR VGND sg13cmos5l_decap_8
* cell instance sg13cmos5l_decap_8_283 r0 *1 0,0
Xsg13cmos5l_decap_8_283 VPWR VGND sg13cmos5l_decap_8
* cell instance sg13cmos5l_decap_8_284 r0 *1 0,0
Xsg13cmos5l_decap_8_284 VPWR VGND sg13cmos5l_decap_8
* cell instance sg13cmos5l_decap_8_285 r0 *1 0,0
Xsg13cmos5l_decap_8_285 VPWR VGND sg13cmos5l_decap_8
* cell instance sg13cmos5l_decap_8_286 r0 *1 0,0
Xsg13cmos5l_decap_8_286 VPWR VGND sg13cmos5l_decap_8
* cell instance sg13cmos5l_decap_8_287 r0 *1 0,0
Xsg13cmos5l_decap_8_287 VPWR VGND sg13cmos5l_decap_8
* cell instance sg13cmos5l_decap_8_288 r0 *1 0,0
Xsg13cmos5l_decap_8_288 VPWR VGND sg13cmos5l_decap_8
* cell instance sg13cmos5l_decap_8_289 r0 *1 0,0
Xsg13cmos5l_decap_8_289 VPWR VGND sg13cmos5l_decap_8
* cell instance sg13cmos5l_decap_8_290 r0 *1 0,0
Xsg13cmos5l_decap_8_290 VPWR VGND sg13cmos5l_decap_8
* cell instance sg13cmos5l_decap_8_291 r0 *1 0,0
Xsg13cmos5l_decap_8_291 VPWR VGND sg13cmos5l_decap_8
* cell instance sg13cmos5l_decap_8_292 r0 *1 0,0
Xsg13cmos5l_decap_8_292 VPWR VGND sg13cmos5l_decap_8
* cell instance sg13cmos5l_decap_8_293 r0 *1 0,0
Xsg13cmos5l_decap_8_293 VPWR VGND sg13cmos5l_decap_8
* cell instance sg13cmos5l_decap_8_294 r0 *1 0,0
Xsg13cmos5l_decap_8_294 VPWR VGND sg13cmos5l_decap_8
* cell instance sg13cmos5l_decap_8_295 r0 *1 0,0
Xsg13cmos5l_decap_8_295 VPWR VGND sg13cmos5l_decap_8
* cell instance sg13cmos5l_decap_8_296 r0 *1 0,0
Xsg13cmos5l_decap_8_296 VPWR VGND sg13cmos5l_decap_8
* cell instance sg13cmos5l_decap_8_297 r0 *1 0,0
Xsg13cmos5l_decap_8_297 VPWR VGND sg13cmos5l_decap_8
* cell instance sg13cmos5l_decap_8_298 r0 *1 0,0
Xsg13cmos5l_decap_8_298 VPWR VGND sg13cmos5l_decap_8
* cell instance sg13cmos5l_decap_8_299 r0 *1 0,0
Xsg13cmos5l_decap_8_299 VPWR VGND sg13cmos5l_decap_8
* cell instance sg13cmos5l_decap_8_300 r0 *1 0,0
Xsg13cmos5l_decap_8_300 VPWR VGND sg13cmos5l_decap_8
* cell instance sg13cmos5l_decap_8_301 r0 *1 0,0
Xsg13cmos5l_decap_8_301 VPWR VGND sg13cmos5l_decap_8
* cell instance sg13cmos5l_decap_8_302 r0 *1 0,0
Xsg13cmos5l_decap_8_302 VPWR VGND sg13cmos5l_decap_8
* cell instance sg13cmos5l_decap_8_303 r0 *1 0,0
Xsg13cmos5l_decap_8_303 VPWR VGND sg13cmos5l_decap_8
* cell instance sg13cmos5l_decap_8_304 r0 *1 0,0
Xsg13cmos5l_decap_8_304 VPWR VGND sg13cmos5l_decap_8
* cell instance sg13cmos5l_decap_8_305 r0 *1 0,0
Xsg13cmos5l_decap_8_305 VPWR VGND sg13cmos5l_decap_8
* cell instance sg13cmos5l_decap_8_306 r0 *1 0,0
Xsg13cmos5l_decap_8_306 VPWR VGND sg13cmos5l_decap_8
* cell instance sg13cmos5l_decap_8_307 r0 *1 0,0
Xsg13cmos5l_decap_8_307 VPWR VGND sg13cmos5l_decap_8
* cell instance sg13cmos5l_decap_8_308 r0 *1 0,0
Xsg13cmos5l_decap_8_308 VPWR VGND sg13cmos5l_decap_8
* cell instance sg13cmos5l_decap_8_309 r0 *1 0,0
Xsg13cmos5l_decap_8_309 VPWR VGND sg13cmos5l_decap_8
* cell instance sg13cmos5l_decap_8_310 r0 *1 0,0
Xsg13cmos5l_decap_8_310 VPWR VGND sg13cmos5l_decap_8
* cell instance sg13cmos5l_decap_8_311 r0 *1 0,0
Xsg13cmos5l_decap_8_311 VPWR VGND sg13cmos5l_decap_8
* cell instance sg13cmos5l_decap_8_312 r0 *1 0,0
Xsg13cmos5l_decap_8_312 VPWR VGND sg13cmos5l_decap_8
* cell instance sg13cmos5l_decap_8_313 r0 *1 0,0
Xsg13cmos5l_decap_8_313 VPWR VGND sg13cmos5l_decap_8
* cell instance sg13cmos5l_decap_8_314 r0 *1 0,0
Xsg13cmos5l_decap_8_314 VPWR VGND sg13cmos5l_decap_8
* cell instance sg13cmos5l_decap_8_315 r0 *1 0,0
Xsg13cmos5l_decap_8_315 VPWR VGND sg13cmos5l_decap_8
* cell instance sg13cmos5l_decap_8_316 r0 *1 0,0
Xsg13cmos5l_decap_8_316 VPWR VGND sg13cmos5l_decap_8
* cell instance sg13cmos5l_decap_8_317 r0 *1 0,0
Xsg13cmos5l_decap_8_317 VPWR VGND sg13cmos5l_decap_8
* cell instance sg13cmos5l_decap_8_318 r0 *1 0,0
Xsg13cmos5l_decap_8_318 VPWR VGND sg13cmos5l_decap_8
* cell instance sg13cmos5l_decap_8_319 r0 *1 0,0
Xsg13cmos5l_decap_8_319 VPWR VGND sg13cmos5l_decap_8
* cell instance sg13cmos5l_decap_8_320 r0 *1 0,0
Xsg13cmos5l_decap_8_320 VPWR VGND sg13cmos5l_decap_8
* cell instance sg13cmos5l_decap_8_321 r0 *1 0,0
Xsg13cmos5l_decap_8_321 VPWR VGND sg13cmos5l_decap_8
* cell instance sg13cmos5l_decap_8_322 r0 *1 0,0
Xsg13cmos5l_decap_8_322 VPWR VGND sg13cmos5l_decap_8
* cell instance sg13cmos5l_decap_8_323 r0 *1 0,0
Xsg13cmos5l_decap_8_323 VPWR VGND sg13cmos5l_decap_8
* cell instance sg13cmos5l_decap_8_324 r0 *1 0,0
Xsg13cmos5l_decap_8_324 VPWR VGND sg13cmos5l_decap_8
* cell instance sg13cmos5l_decap_8_325 r0 *1 0,0
Xsg13cmos5l_decap_8_325 VPWR VGND sg13cmos5l_decap_8
* cell instance sg13cmos5l_decap_8_326 r0 *1 0,0
Xsg13cmos5l_decap_8_326 VPWR VGND sg13cmos5l_decap_8
* cell instance sg13cmos5l_decap_8_327 r0 *1 0,0
Xsg13cmos5l_decap_8_327 VPWR VGND sg13cmos5l_decap_8
* cell instance sg13cmos5l_decap_8_328 r0 *1 0,0
Xsg13cmos5l_decap_8_328 VPWR VGND sg13cmos5l_decap_8
* cell instance sg13cmos5l_decap_8_329 r0 *1 0,0
Xsg13cmos5l_decap_8_329 VPWR VGND sg13cmos5l_decap_8
* cell instance sg13cmos5l_decap_8_330 r0 *1 0,0
Xsg13cmos5l_decap_8_330 VPWR VGND sg13cmos5l_decap_8
* cell instance sg13cmos5l_decap_8_331 r0 *1 0,0
Xsg13cmos5l_decap_8_331 VPWR VGND sg13cmos5l_decap_8
* cell instance sg13cmos5l_decap_8_332 r0 *1 0,0
Xsg13cmos5l_decap_8_332 VPWR VGND sg13cmos5l_decap_8
* cell instance sg13cmos5l_decap_8_333 r0 *1 0,0
Xsg13cmos5l_decap_8_333 VPWR VGND sg13cmos5l_decap_8
* cell instance sg13cmos5l_decap_8_334 r0 *1 0,0
Xsg13cmos5l_decap_8_334 VPWR VGND sg13cmos5l_decap_8
* cell instance sg13cmos5l_decap_8_335 r0 *1 0,0
Xsg13cmos5l_decap_8_335 VPWR VGND sg13cmos5l_decap_8
* cell instance sg13cmos5l_decap_8_336 r0 *1 0,0
Xsg13cmos5l_decap_8_336 VPWR VGND sg13cmos5l_decap_8
* cell instance sg13cmos5l_decap_8_337 r0 *1 0,0
Xsg13cmos5l_decap_8_337 VPWR VGND sg13cmos5l_decap_8
* cell instance sg13cmos5l_decap_8_338 r0 *1 0,0
Xsg13cmos5l_decap_8_338 VPWR VGND sg13cmos5l_decap_8
* cell instance sg13cmos5l_decap_8_339 r0 *1 0,0
Xsg13cmos5l_decap_8_339 VPWR VGND sg13cmos5l_decap_8
* cell instance sg13cmos5l_decap_8_340 r0 *1 0,0
Xsg13cmos5l_decap_8_340 VPWR VGND sg13cmos5l_decap_8
* cell instance sg13cmos5l_decap_8_341 r0 *1 0,0
Xsg13cmos5l_decap_8_341 VPWR VGND sg13cmos5l_decap_8
* cell instance sg13cmos5l_decap_8_342 r0 *1 0,0
Xsg13cmos5l_decap_8_342 VPWR VGND sg13cmos5l_decap_8
* cell instance sg13cmos5l_decap_8_343 r0 *1 0,0
Xsg13cmos5l_decap_8_343 VPWR VGND sg13cmos5l_decap_8
* cell instance sg13cmos5l_decap_8_344 r0 *1 0,0
Xsg13cmos5l_decap_8_344 VPWR VGND sg13cmos5l_decap_8
* cell instance sg13cmos5l_decap_8_345 r0 *1 0,0
Xsg13cmos5l_decap_8_345 VPWR VGND sg13cmos5l_decap_8
* cell instance sg13cmos5l_decap_8_346 r0 *1 0,0
Xsg13cmos5l_decap_8_346 VPWR VGND sg13cmos5l_decap_8
* cell instance sg13cmos5l_decap_8_347 r0 *1 0,0
Xsg13cmos5l_decap_8_347 VPWR VGND sg13cmos5l_decap_8
* cell instance sg13cmos5l_decap_8_348 r0 *1 0,0
Xsg13cmos5l_decap_8_348 VPWR VGND sg13cmos5l_decap_8
* cell instance sg13cmos5l_decap_8_349 r0 *1 0,0
Xsg13cmos5l_decap_8_349 VPWR VGND sg13cmos5l_decap_8
* cell instance sg13cmos5l_decap_8_350 r0 *1 0,0
Xsg13cmos5l_decap_8_350 VPWR VGND sg13cmos5l_decap_8
* cell instance sg13cmos5l_decap_8_351 r0 *1 0,0
Xsg13cmos5l_decap_8_351 VPWR VGND sg13cmos5l_decap_8
* cell instance sg13cmos5l_decap_8_352 r0 *1 0,0
Xsg13cmos5l_decap_8_352 VPWR VGND sg13cmos5l_decap_8
* cell instance sg13cmos5l_decap_8_353 r0 *1 0,0
Xsg13cmos5l_decap_8_353 VPWR VGND sg13cmos5l_decap_8
* cell instance sg13cmos5l_decap_8_354 r0 *1 0,0
Xsg13cmos5l_decap_8_354 VPWR VGND sg13cmos5l_decap_8
* cell instance sg13cmos5l_decap_8_355 r0 *1 0,0
Xsg13cmos5l_decap_8_355 VPWR VGND sg13cmos5l_decap_8
* cell instance sg13cmos5l_decap_8_356 r0 *1 0,0
Xsg13cmos5l_decap_8_356 VPWR VGND sg13cmos5l_decap_8
* cell instance sg13cmos5l_decap_8_357 r0 *1 0,0
Xsg13cmos5l_decap_8_357 VPWR VGND sg13cmos5l_decap_8
* cell instance sg13cmos5l_decap_8_358 r0 *1 0,0
Xsg13cmos5l_decap_8_358 VPWR VGND sg13cmos5l_decap_8
* cell instance sg13cmos5l_decap_8_359 r0 *1 0,0
Xsg13cmos5l_decap_8_359 VPWR VGND sg13cmos5l_decap_8
* cell instance sg13cmos5l_decap_8_360 r0 *1 0,0
Xsg13cmos5l_decap_8_360 VPWR VGND sg13cmos5l_decap_8
* cell instance sg13cmos5l_decap_8_361 r0 *1 0,0
Xsg13cmos5l_decap_8_361 VPWR VGND sg13cmos5l_decap_8
* cell instance sg13cmos5l_decap_8_362 r0 *1 0,0
Xsg13cmos5l_decap_8_362 VPWR VGND sg13cmos5l_decap_8
* cell instance sg13cmos5l_decap_8_363 r0 *1 0,0
Xsg13cmos5l_decap_8_363 VPWR VGND sg13cmos5l_decap_8
* cell instance sg13cmos5l_decap_8_364 r0 *1 0,0
Xsg13cmos5l_decap_8_364 VPWR VGND sg13cmos5l_decap_8
* cell instance sg13cmos5l_decap_8_365 r0 *1 0,0
Xsg13cmos5l_decap_8_365 VPWR VGND sg13cmos5l_decap_8
* cell instance sg13cmos5l_decap_8_366 r0 *1 0,0
Xsg13cmos5l_decap_8_366 VPWR VGND sg13cmos5l_decap_8
* cell instance sg13cmos5l_decap_8_367 r0 *1 0,0
Xsg13cmos5l_decap_8_367 VPWR VGND sg13cmos5l_decap_8
* cell instance sg13cmos5l_decap_8_368 r0 *1 0,0
Xsg13cmos5l_decap_8_368 VPWR VGND sg13cmos5l_decap_8
* cell instance sg13cmos5l_decap_8_369 r0 *1 0,0
Xsg13cmos5l_decap_8_369 VPWR VGND sg13cmos5l_decap_8
* cell instance sg13cmos5l_decap_8_370 r0 *1 0,0
Xsg13cmos5l_decap_8_370 VPWR VGND sg13cmos5l_decap_8
* cell instance sg13cmos5l_decap_8_371 r0 *1 0,0
Xsg13cmos5l_decap_8_371 VPWR VGND sg13cmos5l_decap_8
* cell instance sg13cmos5l_decap_8_372 r0 *1 0,0
Xsg13cmos5l_decap_8_372 VPWR VGND sg13cmos5l_decap_8
* cell instance sg13cmos5l_decap_8_373 r0 *1 0,0
Xsg13cmos5l_decap_8_373 VPWR VGND sg13cmos5l_decap_8
* cell instance sg13cmos5l_decap_8_374 r0 *1 0,0
Xsg13cmos5l_decap_8_374 VPWR VGND sg13cmos5l_decap_8
* cell instance sg13cmos5l_decap_8_375 r0 *1 0,0
Xsg13cmos5l_decap_8_375 VPWR VGND sg13cmos5l_decap_8
* cell instance sg13cmos5l_decap_8_376 r0 *1 0,0
Xsg13cmos5l_decap_8_376 VPWR VGND sg13cmos5l_decap_8
* cell instance sg13cmos5l_decap_8_377 r0 *1 0,0
Xsg13cmos5l_decap_8_377 VPWR VGND sg13cmos5l_decap_8
* cell instance sg13cmos5l_decap_8_378 r0 *1 0,0
Xsg13cmos5l_decap_8_378 VPWR VGND sg13cmos5l_decap_8
* cell instance sg13cmos5l_decap_8_379 r0 *1 0,0
Xsg13cmos5l_decap_8_379 VPWR VGND sg13cmos5l_decap_8
* cell instance sg13cmos5l_decap_8_380 r0 *1 0,0
Xsg13cmos5l_decap_8_380 VPWR VGND sg13cmos5l_decap_8
* cell instance sg13cmos5l_decap_8_381 r0 *1 0,0
Xsg13cmos5l_decap_8_381 VPWR VGND sg13cmos5l_decap_8
* cell instance sg13cmos5l_decap_8_382 r0 *1 0,0
Xsg13cmos5l_decap_8_382 VPWR VGND sg13cmos5l_decap_8
* cell instance sg13cmos5l_decap_8_383 r0 *1 0,0
Xsg13cmos5l_decap_8_383 VPWR VGND sg13cmos5l_decap_8
* cell instance sg13cmos5l_decap_8_384 r0 *1 0,0
Xsg13cmos5l_decap_8_384 VPWR VGND sg13cmos5l_decap_8
* cell instance sg13cmos5l_decap_8_385 r0 *1 0,0
Xsg13cmos5l_decap_8_385 VPWR VGND sg13cmos5l_decap_8
* cell instance sg13cmos5l_decap_8_386 r0 *1 0,0
Xsg13cmos5l_decap_8_386 VPWR VGND sg13cmos5l_decap_8
* cell instance sg13cmos5l_decap_8_387 r0 *1 0,0
Xsg13cmos5l_decap_8_387 VPWR VGND sg13cmos5l_decap_8
* cell instance sg13cmos5l_decap_8_388 r0 *1 0,0
Xsg13cmos5l_decap_8_388 VPWR VGND sg13cmos5l_decap_8
* cell instance sg13cmos5l_decap_8_389 r0 *1 0,0
Xsg13cmos5l_decap_8_389 VPWR VGND sg13cmos5l_decap_8
* cell instance sg13cmos5l_decap_8_390 r0 *1 0,0
Xsg13cmos5l_decap_8_390 VPWR VGND sg13cmos5l_decap_8
* cell instance sg13cmos5l_decap_8_391 r0 *1 0,0
Xsg13cmos5l_decap_8_391 VPWR VGND sg13cmos5l_decap_8
* cell instance sg13cmos5l_decap_8_392 r0 *1 0,0
Xsg13cmos5l_decap_8_392 VPWR VGND sg13cmos5l_decap_8
* cell instance sg13cmos5l_decap_8_393 r0 *1 0,0
Xsg13cmos5l_decap_8_393 VPWR VGND sg13cmos5l_decap_8
* cell instance sg13cmos5l_decap_8_394 r0 *1 0,0
Xsg13cmos5l_decap_8_394 VPWR VGND sg13cmos5l_decap_8
* cell instance sg13cmos5l_decap_8_395 r0 *1 0,0
Xsg13cmos5l_decap_8_395 VPWR VGND sg13cmos5l_decap_8
* cell instance sg13cmos5l_decap_8_396 r0 *1 0,0
Xsg13cmos5l_decap_8_396 VPWR VGND sg13cmos5l_decap_8
* cell instance sg13cmos5l_decap_8_397 r0 *1 0,0
Xsg13cmos5l_decap_8_397 VPWR VGND sg13cmos5l_decap_8
* cell instance sg13cmos5l_decap_8_398 r0 *1 0,0
Xsg13cmos5l_decap_8_398 VPWR VGND sg13cmos5l_decap_8
* cell instance sg13cmos5l_decap_8_399 r0 *1 0,0
Xsg13cmos5l_decap_8_399 VPWR VGND sg13cmos5l_decap_8
* cell instance sg13cmos5l_decap_8_400 r0 *1 0,0
Xsg13cmos5l_decap_8_400 VPWR VGND sg13cmos5l_decap_8
* cell instance sg13cmos5l_decap_8_401 r0 *1 0,0
Xsg13cmos5l_decap_8_401 VPWR VGND sg13cmos5l_decap_8
* cell instance sg13cmos5l_decap_8_402 r0 *1 0,0
Xsg13cmos5l_decap_8_402 VPWR VGND sg13cmos5l_decap_8
* cell instance sg13cmos5l_decap_8_403 r0 *1 0,0
Xsg13cmos5l_decap_8_403 VPWR VGND sg13cmos5l_decap_8
* cell instance sg13cmos5l_decap_8_404 r0 *1 0,0
Xsg13cmos5l_decap_8_404 VPWR VGND sg13cmos5l_decap_8
* cell instance sg13cmos5l_decap_8_405 r0 *1 0,0
Xsg13cmos5l_decap_8_405 VPWR VGND sg13cmos5l_decap_8
* cell instance sg13cmos5l_decap_8_406 r0 *1 0,0
Xsg13cmos5l_decap_8_406 VPWR VGND sg13cmos5l_decap_8
* cell instance sg13cmos5l_decap_8_407 r0 *1 0,0
Xsg13cmos5l_decap_8_407 VPWR VGND sg13cmos5l_decap_8
* cell instance sg13cmos5l_decap_8_408 r0 *1 0,0
Xsg13cmos5l_decap_8_408 VPWR VGND sg13cmos5l_decap_8
* cell instance sg13cmos5l_decap_8_409 r0 *1 0,0
Xsg13cmos5l_decap_8_409 VPWR VGND sg13cmos5l_decap_8
* cell instance sg13cmos5l_decap_8_410 r0 *1 0,0
Xsg13cmos5l_decap_8_410 VPWR VGND sg13cmos5l_decap_8
* cell instance sg13cmos5l_decap_8_411 r0 *1 0,0
Xsg13cmos5l_decap_8_411 VPWR VGND sg13cmos5l_decap_8
* cell instance sg13cmos5l_decap_8_412 r0 *1 0,0
Xsg13cmos5l_decap_8_412 VPWR VGND sg13cmos5l_decap_8
* cell instance sg13cmos5l_decap_8_413 r0 *1 0,0
Xsg13cmos5l_decap_8_413 VPWR VGND sg13cmos5l_decap_8
* cell instance sg13cmos5l_decap_8_414 r0 *1 0,0
Xsg13cmos5l_decap_8_414 VPWR VGND sg13cmos5l_decap_8
* cell instance sg13cmos5l_decap_8_415 r0 *1 0,0
Xsg13cmos5l_decap_8_415 VPWR VGND sg13cmos5l_decap_8
* cell instance sg13cmos5l_decap_8_416 r0 *1 0,0
Xsg13cmos5l_decap_8_416 VPWR VGND sg13cmos5l_decap_8
* cell instance sg13cmos5l_decap_8_417 r0 *1 0,0
Xsg13cmos5l_decap_8_417 VPWR VGND sg13cmos5l_decap_8
* cell instance sg13cmos5l_decap_8_418 r0 *1 0,0
Xsg13cmos5l_decap_8_418 VPWR VGND sg13cmos5l_decap_8
* cell instance sg13cmos5l_decap_8_419 r0 *1 0,0
Xsg13cmos5l_decap_8_419 VPWR VGND sg13cmos5l_decap_8
* cell instance sg13cmos5l_decap_8_420 r0 *1 0,0
Xsg13cmos5l_decap_8_420 VPWR VGND sg13cmos5l_decap_8
* cell instance sg13cmos5l_decap_8_421 r0 *1 0,0
Xsg13cmos5l_decap_8_421 VPWR VGND sg13cmos5l_decap_8
* cell instance sg13cmos5l_decap_8_422 r0 *1 0,0
Xsg13cmos5l_decap_8_422 VPWR VGND sg13cmos5l_decap_8
* cell instance sg13cmos5l_decap_8_423 r0 *1 0,0
Xsg13cmos5l_decap_8_423 VPWR VGND sg13cmos5l_decap_8
* cell instance sg13cmos5l_decap_8_424 r0 *1 0,0
Xsg13cmos5l_decap_8_424 VPWR VGND sg13cmos5l_decap_8
* cell instance sg13cmos5l_decap_8_425 r0 *1 0,0
Xsg13cmos5l_decap_8_425 VPWR VGND sg13cmos5l_decap_8
* cell instance sg13cmos5l_decap_8_426 r0 *1 0,0
Xsg13cmos5l_decap_8_426 VPWR VGND sg13cmos5l_decap_8
* cell instance sg13cmos5l_decap_8_427 r0 *1 0,0
Xsg13cmos5l_decap_8_427 VPWR VGND sg13cmos5l_decap_8
* cell instance sg13cmos5l_decap_8_428 r0 *1 0,0
Xsg13cmos5l_decap_8_428 VPWR VGND sg13cmos5l_decap_8
* cell instance sg13cmos5l_decap_8_429 r0 *1 0,0
Xsg13cmos5l_decap_8_429 VPWR VGND sg13cmos5l_decap_8
* cell instance sg13cmos5l_decap_8_430 r0 *1 0,0
Xsg13cmos5l_decap_8_430 VPWR VGND sg13cmos5l_decap_8
* cell instance sg13cmos5l_decap_8_431 r0 *1 0,0
Xsg13cmos5l_decap_8_431 VPWR VGND sg13cmos5l_decap_8
* cell instance sg13cmos5l_decap_8_432 r0 *1 0,0
Xsg13cmos5l_decap_8_432 VPWR VGND sg13cmos5l_decap_8
* cell instance sg13cmos5l_decap_8_433 r0 *1 0,0
Xsg13cmos5l_decap_8_433 VPWR VGND sg13cmos5l_decap_8
* cell instance sg13cmos5l_decap_8_434 r0 *1 0,0
Xsg13cmos5l_decap_8_434 VPWR VGND sg13cmos5l_decap_8
* cell instance sg13cmos5l_decap_8_435 r0 *1 0,0
Xsg13cmos5l_decap_8_435 VPWR VGND sg13cmos5l_decap_8
* cell instance sg13cmos5l_decap_8_436 r0 *1 0,0
Xsg13cmos5l_decap_8_436 VPWR VGND sg13cmos5l_decap_8
* cell instance sg13cmos5l_decap_8_437 r0 *1 0,0
Xsg13cmos5l_decap_8_437 VPWR VGND sg13cmos5l_decap_8
* cell instance sg13cmos5l_decap_8_438 r0 *1 0,0
Xsg13cmos5l_decap_8_438 VPWR VGND sg13cmos5l_decap_8
* cell instance sg13cmos5l_decap_8_439 r0 *1 0,0
Xsg13cmos5l_decap_8_439 VPWR VGND sg13cmos5l_decap_8
* cell instance sg13cmos5l_decap_8_440 r0 *1 0,0
Xsg13cmos5l_decap_8_440 VPWR VGND sg13cmos5l_decap_8
* cell instance sg13cmos5l_decap_8_441 r0 *1 0,0
Xsg13cmos5l_decap_8_441 VPWR VGND sg13cmos5l_decap_8
* cell instance sg13cmos5l_decap_8_442 r0 *1 0,0
Xsg13cmos5l_decap_8_442 VPWR VGND sg13cmos5l_decap_8
* cell instance sg13cmos5l_decap_8_443 r0 *1 0,0
Xsg13cmos5l_decap_8_443 VPWR VGND sg13cmos5l_decap_8
* cell instance sg13cmos5l_decap_8_444 r0 *1 0,0
Xsg13cmos5l_decap_8_444 VPWR VGND sg13cmos5l_decap_8
* cell instance sg13cmos5l_decap_8_445 r0 *1 0,0
Xsg13cmos5l_decap_8_445 VPWR VGND sg13cmos5l_decap_8
* cell instance sg13cmos5l_decap_8_446 r0 *1 0,0
Xsg13cmos5l_decap_8_446 VPWR VGND sg13cmos5l_decap_8
* cell instance sg13cmos5l_decap_8_447 r0 *1 0,0
Xsg13cmos5l_decap_8_447 VPWR VGND sg13cmos5l_decap_8
* cell instance sg13cmos5l_decap_8_448 r0 *1 0,0
Xsg13cmos5l_decap_8_448 VPWR VGND sg13cmos5l_decap_8
* cell instance sg13cmos5l_decap_8_449 r0 *1 0,0
Xsg13cmos5l_decap_8_449 VPWR VGND sg13cmos5l_decap_8
* cell instance sg13cmos5l_decap_8_450 r0 *1 0,0
Xsg13cmos5l_decap_8_450 VPWR VGND sg13cmos5l_decap_8
* cell instance sg13cmos5l_decap_8_451 r0 *1 0,0
Xsg13cmos5l_decap_8_451 VPWR VGND sg13cmos5l_decap_8
* cell instance sg13cmos5l_decap_8_452 r0 *1 0,0
Xsg13cmos5l_decap_8_452 VPWR VGND sg13cmos5l_decap_8
* cell instance sg13cmos5l_decap_8_453 r0 *1 0,0
Xsg13cmos5l_decap_8_453 VPWR VGND sg13cmos5l_decap_8
* cell instance sg13cmos5l_decap_8_454 r0 *1 0,0
Xsg13cmos5l_decap_8_454 VPWR VGND sg13cmos5l_decap_8
* cell instance sg13cmos5l_decap_8_455 r0 *1 0,0
Xsg13cmos5l_decap_8_455 VPWR VGND sg13cmos5l_decap_8
* cell instance sg13cmos5l_decap_8_456 r0 *1 0,0
Xsg13cmos5l_decap_8_456 VPWR VGND sg13cmos5l_decap_8
* cell instance sg13cmos5l_decap_8_457 r0 *1 0,0
Xsg13cmos5l_decap_8_457 VPWR VGND sg13cmos5l_decap_8
* cell instance sg13cmos5l_decap_8_458 r0 *1 0,0
Xsg13cmos5l_decap_8_458 VPWR VGND sg13cmos5l_decap_8
* cell instance sg13cmos5l_decap_8_459 r0 *1 0,0
Xsg13cmos5l_decap_8_459 VPWR VGND sg13cmos5l_decap_8
* cell instance sg13cmos5l_decap_8_460 r0 *1 0,0
Xsg13cmos5l_decap_8_460 VPWR VGND sg13cmos5l_decap_8
* cell instance sg13cmos5l_decap_8_461 r0 *1 0,0
Xsg13cmos5l_decap_8_461 VPWR VGND sg13cmos5l_decap_8
* cell instance sg13cmos5l_decap_8_462 r0 *1 0,0
Xsg13cmos5l_decap_8_462 VPWR VGND sg13cmos5l_decap_8
* cell instance sg13cmos5l_decap_8_463 r0 *1 0,0
Xsg13cmos5l_decap_8_463 VPWR VGND sg13cmos5l_decap_8
* cell instance sg13cmos5l_decap_8_464 r0 *1 0,0
Xsg13cmos5l_decap_8_464 VPWR VGND sg13cmos5l_decap_8
* cell instance sg13cmos5l_decap_8_465 r0 *1 0,0
Xsg13cmos5l_decap_8_465 VPWR VGND sg13cmos5l_decap_8
* cell instance sg13cmos5l_decap_8_466 r0 *1 0,0
Xsg13cmos5l_decap_8_466 VPWR VGND sg13cmos5l_decap_8
* cell instance sg13cmos5l_decap_8_467 r0 *1 0,0
Xsg13cmos5l_decap_8_467 VPWR VGND sg13cmos5l_decap_8
* cell instance sg13cmos5l_decap_8_468 r0 *1 0,0
Xsg13cmos5l_decap_8_468 VPWR VGND sg13cmos5l_decap_8
* cell instance sg13cmos5l_decap_8_469 r0 *1 0,0
Xsg13cmos5l_decap_8_469 VPWR VGND sg13cmos5l_decap_8
* cell instance sg13cmos5l_decap_8_470 r0 *1 0,0
Xsg13cmos5l_decap_8_470 VPWR VGND sg13cmos5l_decap_8
* cell instance sg13cmos5l_decap_8_471 r0 *1 0,0
Xsg13cmos5l_decap_8_471 VPWR VGND sg13cmos5l_decap_8
* cell instance sg13cmos5l_decap_8_472 r0 *1 0,0
Xsg13cmos5l_decap_8_472 VPWR VGND sg13cmos5l_decap_8
* cell instance sg13cmos5l_decap_8_473 r0 *1 0,0
Xsg13cmos5l_decap_8_473 VPWR VGND sg13cmos5l_decap_8
* cell instance sg13cmos5l_decap_8_474 r0 *1 0,0
Xsg13cmos5l_decap_8_474 VPWR VGND sg13cmos5l_decap_8
* cell instance sg13cmos5l_decap_8_475 r0 *1 0,0
Xsg13cmos5l_decap_8_475 VPWR VGND sg13cmos5l_decap_8
* cell instance sg13cmos5l_decap_8_476 r0 *1 0,0
Xsg13cmos5l_decap_8_476 VPWR VGND sg13cmos5l_decap_8
* cell instance sg13cmos5l_decap_8_477 r0 *1 0,0
Xsg13cmos5l_decap_8_477 VPWR VGND sg13cmos5l_decap_8
* cell instance sg13cmos5l_decap_8_478 r0 *1 0,0
Xsg13cmos5l_decap_8_478 VPWR VGND sg13cmos5l_decap_8
* cell instance sg13cmos5l_decap_8_479 r0 *1 0,0
Xsg13cmos5l_decap_8_479 VPWR VGND sg13cmos5l_decap_8
* cell instance sg13cmos5l_decap_8_480 r0 *1 0,0
Xsg13cmos5l_decap_8_480 VPWR VGND sg13cmos5l_decap_8
* cell instance sg13cmos5l_decap_8_481 r0 *1 0,0
Xsg13cmos5l_decap_8_481 VPWR VGND sg13cmos5l_decap_8
* cell instance sg13cmos5l_decap_8_482 r0 *1 0,0
Xsg13cmos5l_decap_8_482 VPWR VGND sg13cmos5l_decap_8
* cell instance sg13cmos5l_decap_8_483 r0 *1 0,0
Xsg13cmos5l_decap_8_483 VPWR VGND sg13cmos5l_decap_8
* cell instance sg13cmos5l_decap_8_484 r0 *1 0,0
Xsg13cmos5l_decap_8_484 VPWR VGND sg13cmos5l_decap_8
* cell instance sg13cmos5l_decap_8_485 r0 *1 0,0
Xsg13cmos5l_decap_8_485 VPWR VGND sg13cmos5l_decap_8
* cell instance sg13cmos5l_decap_8_486 r0 *1 0,0
Xsg13cmos5l_decap_8_486 VPWR VGND sg13cmos5l_decap_8
* cell instance sg13cmos5l_decap_8_487 r0 *1 0,0
Xsg13cmos5l_decap_8_487 VPWR VGND sg13cmos5l_decap_8
* cell instance sg13cmos5l_decap_8_488 r0 *1 0,0
Xsg13cmos5l_decap_8_488 VPWR VGND sg13cmos5l_decap_8
* cell instance sg13cmos5l_decap_8_489 r0 *1 0,0
Xsg13cmos5l_decap_8_489 VPWR VGND sg13cmos5l_decap_8
* cell instance sg13cmos5l_decap_8_490 r0 *1 0,0
Xsg13cmos5l_decap_8_490 VPWR VGND sg13cmos5l_decap_8
* cell instance sg13cmos5l_decap_8_491 r0 *1 0,0
Xsg13cmos5l_decap_8_491 VPWR VGND sg13cmos5l_decap_8
* cell instance sg13cmos5l_decap_8_492 r0 *1 0,0
Xsg13cmos5l_decap_8_492 VPWR VGND sg13cmos5l_decap_8
* cell instance sg13cmos5l_decap_8_493 r0 *1 0,0
Xsg13cmos5l_decap_8_493 VPWR VGND sg13cmos5l_decap_8
* cell instance sg13cmos5l_decap_8_494 r0 *1 0,0
Xsg13cmos5l_decap_8_494 VPWR VGND sg13cmos5l_decap_8
* cell instance sg13cmos5l_decap_8_495 r0 *1 0,0
Xsg13cmos5l_decap_8_495 VPWR VGND sg13cmos5l_decap_8
* cell instance sg13cmos5l_decap_8_496 r0 *1 0,0
Xsg13cmos5l_decap_8_496 VPWR VGND sg13cmos5l_decap_8
* cell instance sg13cmos5l_decap_8_497 r0 *1 0,0
Xsg13cmos5l_decap_8_497 VPWR VGND sg13cmos5l_decap_8
* cell instance sg13cmos5l_decap_8_498 r0 *1 0,0
Xsg13cmos5l_decap_8_498 VPWR VGND sg13cmos5l_decap_8
* cell instance sg13cmos5l_decap_8_499 r0 *1 0,0
Xsg13cmos5l_decap_8_499 VPWR VGND sg13cmos5l_decap_8
* cell instance sg13cmos5l_decap_8_500 r0 *1 0,0
Xsg13cmos5l_decap_8_500 VPWR VGND sg13cmos5l_decap_8
* cell instance sg13cmos5l_decap_8_501 r0 *1 0,0
Xsg13cmos5l_decap_8_501 VPWR VGND sg13cmos5l_decap_8
* cell instance sg13cmos5l_decap_8_502 r0 *1 0,0
Xsg13cmos5l_decap_8_502 VPWR VGND sg13cmos5l_decap_8
* cell instance sg13cmos5l_decap_8_503 r0 *1 0,0
Xsg13cmos5l_decap_8_503 VPWR VGND sg13cmos5l_decap_8
* cell instance sg13cmos5l_decap_8_504 r0 *1 0,0
Xsg13cmos5l_decap_8_504 VPWR VGND sg13cmos5l_decap_8
* cell instance sg13cmos5l_decap_8_505 r0 *1 0,0
Xsg13cmos5l_decap_8_505 VPWR VGND sg13cmos5l_decap_8
* cell instance sg13cmos5l_decap_8_506 r0 *1 0,0
Xsg13cmos5l_decap_8_506 VPWR VGND sg13cmos5l_decap_8
* cell instance sg13cmos5l_decap_8_507 r0 *1 0,0
Xsg13cmos5l_decap_8_507 VPWR VGND sg13cmos5l_decap_8
* cell instance sg13cmos5l_decap_8_508 r0 *1 0,0
Xsg13cmos5l_decap_8_508 VPWR VGND sg13cmos5l_decap_8
* cell instance sg13cmos5l_decap_8_509 r0 *1 0,0
Xsg13cmos5l_decap_8_509 VPWR VGND sg13cmos5l_decap_8
* cell instance sg13cmos5l_decap_8_510 r0 *1 0,0
Xsg13cmos5l_decap_8_510 VPWR VGND sg13cmos5l_decap_8
* cell instance sg13cmos5l_decap_8_511 r0 *1 0,0
Xsg13cmos5l_decap_8_511 VPWR VGND sg13cmos5l_decap_8
* cell instance sg13cmos5l_decap_8_512 r0 *1 0,0
Xsg13cmos5l_decap_8_512 VPWR VGND sg13cmos5l_decap_8
* cell instance sg13cmos5l_decap_8_513 r0 *1 0,0
Xsg13cmos5l_decap_8_513 VPWR VGND sg13cmos5l_decap_8
* cell instance sg13cmos5l_decap_8_514 r0 *1 0,0
Xsg13cmos5l_decap_8_514 VPWR VGND sg13cmos5l_decap_8
* cell instance sg13cmos5l_decap_8_515 r0 *1 0,0
Xsg13cmos5l_decap_8_515 VPWR VGND sg13cmos5l_decap_8
* cell instance sg13cmos5l_decap_8_516 r0 *1 0,0
Xsg13cmos5l_decap_8_516 VPWR VGND sg13cmos5l_decap_8
* cell instance sg13cmos5l_decap_8_517 r0 *1 0,0
Xsg13cmos5l_decap_8_517 VPWR VGND sg13cmos5l_decap_8
* cell instance sg13cmos5l_decap_8_518 r0 *1 0,0
Xsg13cmos5l_decap_8_518 VPWR VGND sg13cmos5l_decap_8
* cell instance sg13cmos5l_decap_8_519 r0 *1 0,0
Xsg13cmos5l_decap_8_519 VPWR VGND sg13cmos5l_decap_8
* cell instance sg13cmos5l_decap_8_520 r0 *1 0,0
Xsg13cmos5l_decap_8_520 VPWR VGND sg13cmos5l_decap_8
* cell instance sg13cmos5l_decap_8_521 r0 *1 0,0
Xsg13cmos5l_decap_8_521 VPWR VGND sg13cmos5l_decap_8
* cell instance sg13cmos5l_decap_8_522 r0 *1 0,0
Xsg13cmos5l_decap_8_522 VPWR VGND sg13cmos5l_decap_8
* cell instance sg13cmos5l_decap_8_523 r0 *1 0,0
Xsg13cmos5l_decap_8_523 VPWR VGND sg13cmos5l_decap_8
* cell instance sg13cmos5l_decap_8_524 r0 *1 0,0
Xsg13cmos5l_decap_8_524 VPWR VGND sg13cmos5l_decap_8
* cell instance sg13cmos5l_decap_8_525 r0 *1 0,0
Xsg13cmos5l_decap_8_525 VPWR VGND sg13cmos5l_decap_8
* cell instance sg13cmos5l_decap_8_526 r0 *1 0,0
Xsg13cmos5l_decap_8_526 VPWR VGND sg13cmos5l_decap_8
* cell instance sg13cmos5l_decap_8_527 r0 *1 0,0
Xsg13cmos5l_decap_8_527 VPWR VGND sg13cmos5l_decap_8
* cell instance sg13cmos5l_decap_8_528 r0 *1 0,0
Xsg13cmos5l_decap_8_528 VPWR VGND sg13cmos5l_decap_8
* cell instance sg13cmos5l_decap_8_529 r0 *1 0,0
Xsg13cmos5l_decap_8_529 VPWR VGND sg13cmos5l_decap_8
* cell instance sg13cmos5l_decap_8_530 r0 *1 0,0
Xsg13cmos5l_decap_8_530 VPWR VGND sg13cmos5l_decap_8
* cell instance sg13cmos5l_decap_8_531 r0 *1 0,0
Xsg13cmos5l_decap_8_531 VPWR VGND sg13cmos5l_decap_8
* cell instance sg13cmos5l_decap_8_532 r0 *1 0,0
Xsg13cmos5l_decap_8_532 VPWR VGND sg13cmos5l_decap_8
* cell instance sg13cmos5l_decap_8_533 r0 *1 0,0
Xsg13cmos5l_decap_8_533 VPWR VGND sg13cmos5l_decap_8
* cell instance sg13cmos5l_decap_8_534 r0 *1 0,0
Xsg13cmos5l_decap_8_534 VPWR VGND sg13cmos5l_decap_8
* cell instance sg13cmos5l_decap_8_535 r0 *1 0,0
Xsg13cmos5l_decap_8_535 VPWR VGND sg13cmos5l_decap_8
* cell instance sg13cmos5l_decap_8_536 r0 *1 0,0
Xsg13cmos5l_decap_8_536 VPWR VGND sg13cmos5l_decap_8
* cell instance sg13cmos5l_decap_8_537 r0 *1 0,0
Xsg13cmos5l_decap_8_537 VPWR VGND sg13cmos5l_decap_8
* cell instance sg13cmos5l_decap_8_538 r0 *1 0,0
Xsg13cmos5l_decap_8_538 VPWR VGND sg13cmos5l_decap_8
* cell instance sg13cmos5l_decap_8_539 r0 *1 0,0
Xsg13cmos5l_decap_8_539 VPWR VGND sg13cmos5l_decap_8
* cell instance sg13cmos5l_decap_8_540 r0 *1 0,0
Xsg13cmos5l_decap_8_540 VPWR VGND sg13cmos5l_decap_8
* cell instance sg13cmos5l_decap_8_541 r0 *1 0,0
Xsg13cmos5l_decap_8_541 VPWR VGND sg13cmos5l_decap_8
* cell instance sg13cmos5l_decap_8_542 r0 *1 0,0
Xsg13cmos5l_decap_8_542 VPWR VGND sg13cmos5l_decap_8
* cell instance sg13cmos5l_decap_8_543 r0 *1 0,0
Xsg13cmos5l_decap_8_543 VPWR VGND sg13cmos5l_decap_8
* cell instance sg13cmos5l_decap_8_544 r0 *1 0,0
Xsg13cmos5l_decap_8_544 VPWR VGND sg13cmos5l_decap_8
* cell instance sg13cmos5l_decap_8_545 r0 *1 0,0
Xsg13cmos5l_decap_8_545 VPWR VGND sg13cmos5l_decap_8
* cell instance sg13cmos5l_decap_8_546 r0 *1 0,0
Xsg13cmos5l_decap_8_546 VPWR VGND sg13cmos5l_decap_8
* cell instance sg13cmos5l_decap_8_547 r0 *1 0,0
Xsg13cmos5l_decap_8_547 VPWR VGND sg13cmos5l_decap_8
* cell instance sg13cmos5l_decap_8_548 r0 *1 0,0
Xsg13cmos5l_decap_8_548 VPWR VGND sg13cmos5l_decap_8
* cell instance sg13cmos5l_decap_8_549 r0 *1 0,0
Xsg13cmos5l_decap_8_549 VPWR VGND sg13cmos5l_decap_8
* cell instance sg13cmos5l_decap_8_550 r0 *1 0,0
Xsg13cmos5l_decap_8_550 VPWR VGND sg13cmos5l_decap_8
* cell instance sg13cmos5l_decap_8_551 r0 *1 0,0
Xsg13cmos5l_decap_8_551 VPWR VGND sg13cmos5l_decap_8
* cell instance sg13cmos5l_decap_8_552 r0 *1 0,0
Xsg13cmos5l_decap_8_552 VPWR VGND sg13cmos5l_decap_8
* cell instance sg13cmos5l_decap_8_553 r0 *1 0,0
Xsg13cmos5l_decap_8_553 VPWR VGND sg13cmos5l_decap_8
* cell instance sg13cmos5l_decap_8_554 r0 *1 0,0
Xsg13cmos5l_decap_8_554 VPWR VGND sg13cmos5l_decap_8
* cell instance sg13cmos5l_decap_8_555 r0 *1 0,0
Xsg13cmos5l_decap_8_555 VPWR VGND sg13cmos5l_decap_8
* cell instance sg13cmos5l_decap_8_556 r0 *1 0,0
Xsg13cmos5l_decap_8_556 VPWR VGND sg13cmos5l_decap_8
* cell instance sg13cmos5l_decap_8_557 r0 *1 0,0
Xsg13cmos5l_decap_8_557 VPWR VGND sg13cmos5l_decap_8
* cell instance sg13cmos5l_decap_8_558 r0 *1 0,0
Xsg13cmos5l_decap_8_558 VPWR VGND sg13cmos5l_decap_8
* cell instance sg13cmos5l_decap_8_559 r0 *1 0,0
Xsg13cmos5l_decap_8_559 VPWR VGND sg13cmos5l_decap_8
* cell instance sg13cmos5l_decap_8_560 r0 *1 0,0
Xsg13cmos5l_decap_8_560 VPWR VGND sg13cmos5l_decap_8
* cell instance sg13cmos5l_decap_8_561 r0 *1 0,0
Xsg13cmos5l_decap_8_561 VPWR VGND sg13cmos5l_decap_8
* cell instance sg13cmos5l_decap_8_562 r0 *1 0,0
Xsg13cmos5l_decap_8_562 VPWR VGND sg13cmos5l_decap_8
* cell instance sg13cmos5l_decap_8_563 r0 *1 0,0
Xsg13cmos5l_decap_8_563 VPWR VGND sg13cmos5l_decap_8
* cell instance sg13cmos5l_decap_8_564 r0 *1 0,0
Xsg13cmos5l_decap_8_564 VPWR VGND sg13cmos5l_decap_8
* cell instance sg13cmos5l_decap_8_565 r0 *1 0,0
Xsg13cmos5l_decap_8_565 VPWR VGND sg13cmos5l_decap_8
* cell instance sg13cmos5l_decap_8_566 r0 *1 0,0
Xsg13cmos5l_decap_8_566 VPWR VGND sg13cmos5l_decap_8
* cell instance sg13cmos5l_decap_8_567 r0 *1 0,0
Xsg13cmos5l_decap_8_567 VPWR VGND sg13cmos5l_decap_8
* cell instance sg13cmos5l_decap_8_568 r0 *1 0,0
Xsg13cmos5l_decap_8_568 VPWR VGND sg13cmos5l_decap_8
* cell instance sg13cmos5l_decap_8_569 r0 *1 0,0
Xsg13cmos5l_decap_8_569 VPWR VGND sg13cmos5l_decap_8
* cell instance sg13cmos5l_decap_8_570 r0 *1 0,0
Xsg13cmos5l_decap_8_570 VPWR VGND sg13cmos5l_decap_8
* cell instance sg13cmos5l_decap_8_571 r0 *1 0,0
Xsg13cmos5l_decap_8_571 VPWR VGND sg13cmos5l_decap_8
* cell instance sg13cmos5l_decap_8_572 r0 *1 0,0
Xsg13cmos5l_decap_8_572 VPWR VGND sg13cmos5l_decap_8
* cell instance sg13cmos5l_decap_8_573 r0 *1 0,0
Xsg13cmos5l_decap_8_573 VPWR VGND sg13cmos5l_decap_8
* cell instance sg13cmos5l_decap_8_574 r0 *1 0,0
Xsg13cmos5l_decap_8_574 VPWR VGND sg13cmos5l_decap_8
* cell instance sg13cmos5l_decap_8_575 r0 *1 0,0
Xsg13cmos5l_decap_8_575 VPWR VGND sg13cmos5l_decap_8
* cell instance sg13cmos5l_decap_8_576 r0 *1 0,0
Xsg13cmos5l_decap_8_576 VPWR VGND sg13cmos5l_decap_8
* cell instance sg13cmos5l_decap_8_577 r0 *1 0,0
Xsg13cmos5l_decap_8_577 VPWR VGND sg13cmos5l_decap_8
* cell instance sg13cmos5l_decap_8_578 r0 *1 0,0
Xsg13cmos5l_decap_8_578 VPWR VGND sg13cmos5l_decap_8
* cell instance sg13cmos5l_decap_8_579 r0 *1 0,0
Xsg13cmos5l_decap_8_579 VPWR VGND sg13cmos5l_decap_8
* cell instance sg13cmos5l_decap_8_580 r0 *1 0,0
Xsg13cmos5l_decap_8_580 VPWR VGND sg13cmos5l_decap_8
* cell instance sg13cmos5l_decap_8_581 r0 *1 0,0
Xsg13cmos5l_decap_8_581 VPWR VGND sg13cmos5l_decap_8
* cell instance sg13cmos5l_decap_8_582 r0 *1 0,0
Xsg13cmos5l_decap_8_582 VPWR VGND sg13cmos5l_decap_8
* cell instance sg13cmos5l_decap_8_583 r0 *1 0,0
Xsg13cmos5l_decap_8_583 VPWR VGND sg13cmos5l_decap_8
* cell instance sg13cmos5l_decap_8_584 r0 *1 0,0
Xsg13cmos5l_decap_8_584 VPWR VGND sg13cmos5l_decap_8
* cell instance sg13cmos5l_decap_8_585 r0 *1 0,0
Xsg13cmos5l_decap_8_585 VPWR VGND sg13cmos5l_decap_8
* cell instance sg13cmos5l_decap_8_586 r0 *1 0,0
Xsg13cmos5l_decap_8_586 VPWR VGND sg13cmos5l_decap_8
* cell instance sg13cmos5l_decap_8_587 r0 *1 0,0
Xsg13cmos5l_decap_8_587 VPWR VGND sg13cmos5l_decap_8
* cell instance sg13cmos5l_decap_8_588 r0 *1 0,0
Xsg13cmos5l_decap_8_588 VPWR VGND sg13cmos5l_decap_8
* cell instance sg13cmos5l_decap_8_589 r0 *1 0,0
Xsg13cmos5l_decap_8_589 VPWR VGND sg13cmos5l_decap_8
* cell instance sg13cmos5l_decap_8_590 r0 *1 0,0
Xsg13cmos5l_decap_8_590 VPWR VGND sg13cmos5l_decap_8
* cell instance sg13cmos5l_decap_8_591 r0 *1 0,0
Xsg13cmos5l_decap_8_591 VPWR VGND sg13cmos5l_decap_8
* cell instance sg13cmos5l_decap_8_592 r0 *1 0,0
Xsg13cmos5l_decap_8_592 VPWR VGND sg13cmos5l_decap_8
* cell instance sg13cmos5l_decap_8_593 r0 *1 0,0
Xsg13cmos5l_decap_8_593 VPWR VGND sg13cmos5l_decap_8
* cell instance sg13cmos5l_decap_8_594 r0 *1 0,0
Xsg13cmos5l_decap_8_594 VPWR VGND sg13cmos5l_decap_8
* cell instance sg13cmos5l_decap_8_595 r0 *1 0,0
Xsg13cmos5l_decap_8_595 VPWR VGND sg13cmos5l_decap_8
* cell instance sg13cmos5l_decap_8_596 r0 *1 0,0
Xsg13cmos5l_decap_8_596 VPWR VGND sg13cmos5l_decap_8
* cell instance sg13cmos5l_decap_8_597 r0 *1 0,0
Xsg13cmos5l_decap_8_597 VPWR VGND sg13cmos5l_decap_8
* cell instance sg13cmos5l_decap_8_598 r0 *1 0,0
Xsg13cmos5l_decap_8_598 VPWR VGND sg13cmos5l_decap_8
* cell instance sg13cmos5l_decap_8_599 r0 *1 0,0
Xsg13cmos5l_decap_8_599 VPWR VGND sg13cmos5l_decap_8
* cell instance sg13cmos5l_decap_8_600 r0 *1 0,0
Xsg13cmos5l_decap_8_600 VPWR VGND sg13cmos5l_decap_8
* cell instance sg13cmos5l_decap_8_601 r0 *1 0,0
Xsg13cmos5l_decap_8_601 VPWR VGND sg13cmos5l_decap_8
* cell instance sg13cmos5l_decap_8_602 r0 *1 0,0
Xsg13cmos5l_decap_8_602 VPWR VGND sg13cmos5l_decap_8
* cell instance sg13cmos5l_decap_8_603 r0 *1 0,0
Xsg13cmos5l_decap_8_603 VPWR VGND sg13cmos5l_decap_8
* cell instance sg13cmos5l_decap_8_604 r0 *1 0,0
Xsg13cmos5l_decap_8_604 VPWR VGND sg13cmos5l_decap_8
* cell instance sg13cmos5l_decap_8_605 r0 *1 0,0
Xsg13cmos5l_decap_8_605 VPWR VGND sg13cmos5l_decap_8
* cell instance sg13cmos5l_decap_8_606 r0 *1 0,0
Xsg13cmos5l_decap_8_606 VPWR VGND sg13cmos5l_decap_8
* cell instance sg13cmos5l_decap_8_607 r0 *1 0,0
Xsg13cmos5l_decap_8_607 VPWR VGND sg13cmos5l_decap_8
* cell instance sg13cmos5l_decap_8_608 r0 *1 0,0
Xsg13cmos5l_decap_8_608 VPWR VGND sg13cmos5l_decap_8
* cell instance sg13cmos5l_decap_8_609 r0 *1 0,0
Xsg13cmos5l_decap_8_609 VPWR VGND sg13cmos5l_decap_8
* cell instance sg13cmos5l_decap_8_610 r0 *1 0,0
Xsg13cmos5l_decap_8_610 VPWR VGND sg13cmos5l_decap_8
* cell instance sg13cmos5l_decap_8_611 r0 *1 0,0
Xsg13cmos5l_decap_8_611 VPWR VGND sg13cmos5l_decap_8
* cell instance sg13cmos5l_decap_8_612 r0 *1 0,0
Xsg13cmos5l_decap_8_612 VPWR VGND sg13cmos5l_decap_8
* cell instance sg13cmos5l_decap_8_613 r0 *1 0,0
Xsg13cmos5l_decap_8_613 VPWR VGND sg13cmos5l_decap_8
* cell instance sg13cmos5l_decap_8_614 r0 *1 0,0
Xsg13cmos5l_decap_8_614 VPWR VGND sg13cmos5l_decap_8
* cell instance sg13cmos5l_decap_8_615 r0 *1 0,0
Xsg13cmos5l_decap_8_615 VPWR VGND sg13cmos5l_decap_8
* cell instance sg13cmos5l_decap_8_616 r0 *1 0,0
Xsg13cmos5l_decap_8_616 VPWR VGND sg13cmos5l_decap_8
* cell instance sg13cmos5l_decap_8_617 r0 *1 0,0
Xsg13cmos5l_decap_8_617 VPWR VGND sg13cmos5l_decap_8
* cell instance sg13cmos5l_decap_8_618 r0 *1 0,0
Xsg13cmos5l_decap_8_618 VPWR VGND sg13cmos5l_decap_8
* cell instance sg13cmos5l_decap_8_619 r0 *1 0,0
Xsg13cmos5l_decap_8_619 VPWR VGND sg13cmos5l_decap_8
* cell instance sg13cmos5l_decap_8_620 r0 *1 0,0
Xsg13cmos5l_decap_8_620 VPWR VGND sg13cmos5l_decap_8
* cell instance sg13cmos5l_decap_8_621 r0 *1 0,0
Xsg13cmos5l_decap_8_621 VPWR VGND sg13cmos5l_decap_8
* cell instance sg13cmos5l_decap_8_622 r0 *1 0,0
Xsg13cmos5l_decap_8_622 VPWR VGND sg13cmos5l_decap_8
* cell instance sg13cmos5l_decap_8_623 r0 *1 0,0
Xsg13cmos5l_decap_8_623 VPWR VGND sg13cmos5l_decap_8
* cell instance sg13cmos5l_decap_8_624 r0 *1 0,0
Xsg13cmos5l_decap_8_624 VPWR VGND sg13cmos5l_decap_8
* cell instance sg13cmos5l_decap_8_625 r0 *1 0,0
Xsg13cmos5l_decap_8_625 VPWR VGND sg13cmos5l_decap_8
* cell instance sg13cmos5l_decap_8_626 r0 *1 0,0
Xsg13cmos5l_decap_8_626 VPWR VGND sg13cmos5l_decap_8
* cell instance sg13cmos5l_decap_8_627 r0 *1 0,0
Xsg13cmos5l_decap_8_627 VPWR VGND sg13cmos5l_decap_8
* cell instance sg13cmos5l_decap_8_628 r0 *1 0,0
Xsg13cmos5l_decap_8_628 VPWR VGND sg13cmos5l_decap_8
* cell instance sg13cmos5l_decap_8_629 r0 *1 0,0
Xsg13cmos5l_decap_8_629 VPWR VGND sg13cmos5l_decap_8
* cell instance sg13cmos5l_decap_8_630 r0 *1 0,0
Xsg13cmos5l_decap_8_630 VPWR VGND sg13cmos5l_decap_8
* cell instance sg13cmos5l_decap_8_631 r0 *1 0,0
Xsg13cmos5l_decap_8_631 VPWR VGND sg13cmos5l_decap_8
* cell instance sg13cmos5l_decap_8_632 r0 *1 0,0
Xsg13cmos5l_decap_8_632 VPWR VGND sg13cmos5l_decap_8
* cell instance sg13cmos5l_decap_8_633 r0 *1 0,0
Xsg13cmos5l_decap_8_633 VPWR VGND sg13cmos5l_decap_8
* cell instance sg13cmos5l_decap_8_634 r0 *1 0,0
Xsg13cmos5l_decap_8_634 VPWR VGND sg13cmos5l_decap_8
* cell instance sg13cmos5l_decap_8_635 r0 *1 0,0
Xsg13cmos5l_decap_8_635 VPWR VGND sg13cmos5l_decap_8
* cell instance sg13cmos5l_decap_8_636 r0 *1 0,0
Xsg13cmos5l_decap_8_636 VPWR VGND sg13cmos5l_decap_8
* cell instance sg13cmos5l_decap_8_637 r0 *1 0,0
Xsg13cmos5l_decap_8_637 VPWR VGND sg13cmos5l_decap_8
* cell instance sg13cmos5l_decap_8_638 r0 *1 0,0
Xsg13cmos5l_decap_8_638 VPWR VGND sg13cmos5l_decap_8
* cell instance sg13cmos5l_decap_8_639 r0 *1 0,0
Xsg13cmos5l_decap_8_639 VPWR VGND sg13cmos5l_decap_8
* cell instance sg13cmos5l_decap_8_640 r0 *1 0,0
Xsg13cmos5l_decap_8_640 VPWR VGND sg13cmos5l_decap_8
* cell instance sg13cmos5l_decap_8_641 r0 *1 0,0
Xsg13cmos5l_decap_8_641 VPWR VGND sg13cmos5l_decap_8
* cell instance sg13cmos5l_decap_8_642 r0 *1 0,0
Xsg13cmos5l_decap_8_642 VPWR VGND sg13cmos5l_decap_8
* cell instance sg13cmos5l_decap_8_643 r0 *1 0,0
Xsg13cmos5l_decap_8_643 VPWR VGND sg13cmos5l_decap_8
* cell instance sg13cmos5l_decap_8_644 r0 *1 0,0
Xsg13cmos5l_decap_8_644 VPWR VGND sg13cmos5l_decap_8
* cell instance sg13cmos5l_decap_8_645 r0 *1 0,0
Xsg13cmos5l_decap_8_645 VPWR VGND sg13cmos5l_decap_8
* cell instance sg13cmos5l_decap_8_646 r0 *1 0,0
Xsg13cmos5l_decap_8_646 VPWR VGND sg13cmos5l_decap_8
* cell instance sg13cmos5l_decap_8_647 r0 *1 0,0
Xsg13cmos5l_decap_8_647 VPWR VGND sg13cmos5l_decap_8
* cell instance sg13cmos5l_decap_8_648 r0 *1 0,0
Xsg13cmos5l_decap_8_648 VPWR VGND sg13cmos5l_decap_8
* cell instance sg13cmos5l_decap_8_649 r0 *1 0,0
Xsg13cmos5l_decap_8_649 VPWR VGND sg13cmos5l_decap_8
* cell instance sg13cmos5l_decap_8_650 r0 *1 0,0
Xsg13cmos5l_decap_8_650 VPWR VGND sg13cmos5l_decap_8
* cell instance sg13cmos5l_decap_8_651 r0 *1 0,0
Xsg13cmos5l_decap_8_651 VPWR VGND sg13cmos5l_decap_8
* cell instance sg13cmos5l_decap_8_652 r0 *1 0,0
Xsg13cmos5l_decap_8_652 VPWR VGND sg13cmos5l_decap_8
* cell instance sg13cmos5l_decap_8_653 r0 *1 0,0
Xsg13cmos5l_decap_8_653 VPWR VGND sg13cmos5l_decap_8
* cell instance sg13cmos5l_decap_8_654 r0 *1 0,0
Xsg13cmos5l_decap_8_654 VPWR VGND sg13cmos5l_decap_8
* cell instance sg13cmos5l_decap_8_655 r0 *1 0,0
Xsg13cmos5l_decap_8_655 VPWR VGND sg13cmos5l_decap_8
* cell instance sg13cmos5l_decap_8_656 r0 *1 0,0
Xsg13cmos5l_decap_8_656 VPWR VGND sg13cmos5l_decap_8
* cell instance sg13cmos5l_decap_8_657 r0 *1 0,0
Xsg13cmos5l_decap_8_657 VPWR VGND sg13cmos5l_decap_8
* cell instance sg13cmos5l_decap_8_658 r0 *1 0,0
Xsg13cmos5l_decap_8_658 VPWR VGND sg13cmos5l_decap_8
* cell instance sg13cmos5l_decap_8_659 r0 *1 0,0
Xsg13cmos5l_decap_8_659 VPWR VGND sg13cmos5l_decap_8
* cell instance sg13cmos5l_decap_8_660 r0 *1 0,0
Xsg13cmos5l_decap_8_660 VPWR VGND sg13cmos5l_decap_8
* cell instance sg13cmos5l_decap_8_661 r0 *1 0,0
Xsg13cmos5l_decap_8_661 VPWR VGND sg13cmos5l_decap_8
* cell instance sg13cmos5l_decap_8_662 r0 *1 0,0
Xsg13cmos5l_decap_8_662 VPWR VGND sg13cmos5l_decap_8
* cell instance sg13cmos5l_decap_8_663 r0 *1 0,0
Xsg13cmos5l_decap_8_663 VPWR VGND sg13cmos5l_decap_8
* cell instance sg13cmos5l_decap_8_664 r0 *1 0,0
Xsg13cmos5l_decap_8_664 VPWR VGND sg13cmos5l_decap_8
* cell instance sg13cmos5l_decap_8_665 r0 *1 0,0
Xsg13cmos5l_decap_8_665 VPWR VGND sg13cmos5l_decap_8
* cell instance sg13cmos5l_decap_8_666 r0 *1 0,0
Xsg13cmos5l_decap_8_666 VPWR VGND sg13cmos5l_decap_8
* cell instance sg13cmos5l_decap_8_667 r0 *1 0,0
Xsg13cmos5l_decap_8_667 VPWR VGND sg13cmos5l_decap_8
* cell instance sg13cmos5l_decap_8_668 r0 *1 0,0
Xsg13cmos5l_decap_8_668 VPWR VGND sg13cmos5l_decap_8
* cell instance sg13cmos5l_decap_8_669 r0 *1 0,0
Xsg13cmos5l_decap_8_669 VPWR VGND sg13cmos5l_decap_8
* cell instance sg13cmos5l_decap_8_670 r0 *1 0,0
Xsg13cmos5l_decap_8_670 VPWR VGND sg13cmos5l_decap_8
* cell instance sg13cmos5l_decap_8_671 r0 *1 0,0
Xsg13cmos5l_decap_8_671 VPWR VGND sg13cmos5l_decap_8
* cell instance sg13cmos5l_decap_8_672 r0 *1 0,0
Xsg13cmos5l_decap_8_672 VPWR VGND sg13cmos5l_decap_8
* cell instance sg13cmos5l_decap_8_673 r0 *1 0,0
Xsg13cmos5l_decap_8_673 VPWR VGND sg13cmos5l_decap_8
* cell instance sg13cmos5l_decap_8_674 r0 *1 0,0
Xsg13cmos5l_decap_8_674 VPWR VGND sg13cmos5l_decap_8
* cell instance sg13cmos5l_decap_8_675 r0 *1 0,0
Xsg13cmos5l_decap_8_675 VPWR VGND sg13cmos5l_decap_8
* cell instance sg13cmos5l_decap_8_676 r0 *1 0,0
Xsg13cmos5l_decap_8_676 VPWR VGND sg13cmos5l_decap_8
* cell instance sg13cmos5l_decap_8_677 r0 *1 0,0
Xsg13cmos5l_decap_8_677 VPWR VGND sg13cmos5l_decap_8
* cell instance sg13cmos5l_decap_8_678 r0 *1 0,0
Xsg13cmos5l_decap_8_678 VPWR VGND sg13cmos5l_decap_8
* cell instance sg13cmos5l_decap_8_679 r0 *1 0,0
Xsg13cmos5l_decap_8_679 VPWR VGND sg13cmos5l_decap_8
* cell instance sg13cmos5l_decap_8_680 r0 *1 0,0
Xsg13cmos5l_decap_8_680 VPWR VGND sg13cmos5l_decap_8
* cell instance sg13cmos5l_decap_8_681 r0 *1 0,0
Xsg13cmos5l_decap_8_681 VPWR VGND sg13cmos5l_decap_8
* cell instance sg13cmos5l_decap_8_682 r0 *1 0,0
Xsg13cmos5l_decap_8_682 VPWR VGND sg13cmos5l_decap_8
* cell instance sg13cmos5l_decap_8_683 r0 *1 0,0
Xsg13cmos5l_decap_8_683 VPWR VGND sg13cmos5l_decap_8
* cell instance sg13cmos5l_decap_8_684 r0 *1 0,0
Xsg13cmos5l_decap_8_684 VPWR VGND sg13cmos5l_decap_8
* cell instance sg13cmos5l_decap_8_685 r0 *1 0,0
Xsg13cmos5l_decap_8_685 VPWR VGND sg13cmos5l_decap_8
* cell instance sg13cmos5l_decap_8_686 r0 *1 0,0
Xsg13cmos5l_decap_8_686 VPWR VGND sg13cmos5l_decap_8
* cell instance sg13cmos5l_decap_8_687 r0 *1 0,0
Xsg13cmos5l_decap_8_687 VPWR VGND sg13cmos5l_decap_8
* cell instance sg13cmos5l_decap_8_688 r0 *1 0,0
Xsg13cmos5l_decap_8_688 VPWR VGND sg13cmos5l_decap_8
* cell instance sg13cmos5l_decap_8_689 r0 *1 0,0
Xsg13cmos5l_decap_8_689 VPWR VGND sg13cmos5l_decap_8
* cell instance sg13cmos5l_decap_8_690 r0 *1 0,0
Xsg13cmos5l_decap_8_690 VPWR VGND sg13cmos5l_decap_8
* cell instance sg13cmos5l_decap_8_691 r0 *1 0,0
Xsg13cmos5l_decap_8_691 VPWR VGND sg13cmos5l_decap_8
* cell instance sg13cmos5l_decap_8_692 r0 *1 0,0
Xsg13cmos5l_decap_8_692 VPWR VGND sg13cmos5l_decap_8
* cell instance sg13cmos5l_decap_8_693 r0 *1 0,0
Xsg13cmos5l_decap_8_693 VPWR VGND sg13cmos5l_decap_8
* cell instance sg13cmos5l_decap_8_694 r0 *1 0,0
Xsg13cmos5l_decap_8_694 VPWR VGND sg13cmos5l_decap_8
* cell instance sg13cmos5l_decap_8_695 r0 *1 0,0
Xsg13cmos5l_decap_8_695 VPWR VGND sg13cmos5l_decap_8
* cell instance sg13cmos5l_decap_8_696 r0 *1 0,0
Xsg13cmos5l_decap_8_696 VPWR VGND sg13cmos5l_decap_8
* cell instance sg13cmos5l_decap_8_697 r0 *1 0,0
Xsg13cmos5l_decap_8_697 VPWR VGND sg13cmos5l_decap_8
* cell instance sg13cmos5l_decap_8_698 r0 *1 0,0
Xsg13cmos5l_decap_8_698 VPWR VGND sg13cmos5l_decap_8
* cell instance sg13cmos5l_decap_8_699 r0 *1 0,0
Xsg13cmos5l_decap_8_699 VPWR VGND sg13cmos5l_decap_8
* cell instance sg13cmos5l_decap_8_700 r0 *1 0,0
Xsg13cmos5l_decap_8_700 VPWR VGND sg13cmos5l_decap_8
* cell instance sg13cmos5l_decap_8_701 r0 *1 0,0
Xsg13cmos5l_decap_8_701 VPWR VGND sg13cmos5l_decap_8
* cell instance sg13cmos5l_decap_8_702 r0 *1 0,0
Xsg13cmos5l_decap_8_702 VPWR VGND sg13cmos5l_decap_8
* cell instance sg13cmos5l_decap_8_703 r0 *1 0,0
Xsg13cmos5l_decap_8_703 VPWR VGND sg13cmos5l_decap_8
* cell instance sg13cmos5l_decap_8_704 r0 *1 0,0
Xsg13cmos5l_decap_8_704 VPWR VGND sg13cmos5l_decap_8
* cell instance sg13cmos5l_decap_8_705 r0 *1 0,0
Xsg13cmos5l_decap_8_705 VPWR VGND sg13cmos5l_decap_8
* cell instance sg13cmos5l_decap_8_706 r0 *1 0,0
Xsg13cmos5l_decap_8_706 VPWR VGND sg13cmos5l_decap_8
* cell instance sg13cmos5l_decap_8_707 r0 *1 0,0
Xsg13cmos5l_decap_8_707 VPWR VGND sg13cmos5l_decap_8
* cell instance sg13cmos5l_decap_8_708 r0 *1 0,0
Xsg13cmos5l_decap_8_708 VPWR VGND sg13cmos5l_decap_8
* cell instance sg13cmos5l_decap_8_709 r0 *1 0,0
Xsg13cmos5l_decap_8_709 VPWR VGND sg13cmos5l_decap_8
* cell instance sg13cmos5l_decap_8_710 r0 *1 0,0
Xsg13cmos5l_decap_8_710 VPWR VGND sg13cmos5l_decap_8
* cell instance sg13cmos5l_decap_8_711 r0 *1 0,0
Xsg13cmos5l_decap_8_711 VPWR VGND sg13cmos5l_decap_8
* cell instance sg13cmos5l_decap_8_712 r0 *1 0,0
Xsg13cmos5l_decap_8_712 VPWR VGND sg13cmos5l_decap_8
* cell instance sg13cmos5l_decap_8_713 r0 *1 0,0
Xsg13cmos5l_decap_8_713 VPWR VGND sg13cmos5l_decap_8
* cell instance sg13cmos5l_decap_8_714 r0 *1 0,0
Xsg13cmos5l_decap_8_714 VPWR VGND sg13cmos5l_decap_8
* cell instance sg13cmos5l_decap_8_715 r0 *1 0,0
Xsg13cmos5l_decap_8_715 VPWR VGND sg13cmos5l_decap_8
* cell instance sg13cmos5l_decap_8_716 r0 *1 0,0
Xsg13cmos5l_decap_8_716 VPWR VGND sg13cmos5l_decap_8
* cell instance sg13cmos5l_decap_8_717 r0 *1 0,0
Xsg13cmos5l_decap_8_717 VPWR VGND sg13cmos5l_decap_8
* cell instance sg13cmos5l_decap_8_718 r0 *1 0,0
Xsg13cmos5l_decap_8_718 VPWR VGND sg13cmos5l_decap_8
* cell instance sg13cmos5l_decap_8_719 r0 *1 0,0
Xsg13cmos5l_decap_8_719 VPWR VGND sg13cmos5l_decap_8
* cell instance sg13cmos5l_decap_8_720 r0 *1 0,0
Xsg13cmos5l_decap_8_720 VPWR VGND sg13cmos5l_decap_8
* cell instance sg13cmos5l_decap_8_721 r0 *1 0,0
Xsg13cmos5l_decap_8_721 VPWR VGND sg13cmos5l_decap_8
* cell instance sg13cmos5l_decap_8_722 r0 *1 0,0
Xsg13cmos5l_decap_8_722 VPWR VGND sg13cmos5l_decap_8
* cell instance sg13cmos5l_decap_8_723 r0 *1 0,0
Xsg13cmos5l_decap_8_723 VPWR VGND sg13cmos5l_decap_8
* cell instance sg13cmos5l_decap_8_724 r0 *1 0,0
Xsg13cmos5l_decap_8_724 VPWR VGND sg13cmos5l_decap_8
* cell instance sg13cmos5l_decap_8_725 r0 *1 0,0
Xsg13cmos5l_decap_8_725 VPWR VGND sg13cmos5l_decap_8
* cell instance sg13cmos5l_decap_8_726 r0 *1 0,0
Xsg13cmos5l_decap_8_726 VPWR VGND sg13cmos5l_decap_8
* cell instance sg13cmos5l_decap_8_727 r0 *1 0,0
Xsg13cmos5l_decap_8_727 VPWR VGND sg13cmos5l_decap_8
* cell instance sg13cmos5l_decap_8_728 r0 *1 0,0
Xsg13cmos5l_decap_8_728 VPWR VGND sg13cmos5l_decap_8
* cell instance sg13cmos5l_decap_8_729 r0 *1 0,0
Xsg13cmos5l_decap_8_729 VPWR VGND sg13cmos5l_decap_8
* cell instance sg13cmos5l_decap_8_730 r0 *1 0,0
Xsg13cmos5l_decap_8_730 VPWR VGND sg13cmos5l_decap_8
* cell instance sg13cmos5l_decap_8_731 r0 *1 0,0
Xsg13cmos5l_decap_8_731 VPWR VGND sg13cmos5l_decap_8
* cell instance sg13cmos5l_decap_8_732 r0 *1 0,0
Xsg13cmos5l_decap_8_732 VPWR VGND sg13cmos5l_decap_8
* cell instance sg13cmos5l_decap_8_733 r0 *1 0,0
Xsg13cmos5l_decap_8_733 VPWR VGND sg13cmos5l_decap_8
* cell instance sg13cmos5l_decap_8_734 r0 *1 0,0
Xsg13cmos5l_decap_8_734 VPWR VGND sg13cmos5l_decap_8
* cell instance sg13cmos5l_decap_8_735 r0 *1 0,0
Xsg13cmos5l_decap_8_735 VPWR VGND sg13cmos5l_decap_8
* cell instance sg13cmos5l_decap_8_736 r0 *1 0,0
Xsg13cmos5l_decap_8_736 VPWR VGND sg13cmos5l_decap_8
* cell instance sg13cmos5l_decap_8_737 r0 *1 0,0
Xsg13cmos5l_decap_8_737 VPWR VGND sg13cmos5l_decap_8
* cell instance sg13cmos5l_decap_8_738 r0 *1 0,0
Xsg13cmos5l_decap_8_738 VPWR VGND sg13cmos5l_decap_8
* cell instance sg13cmos5l_decap_8_739 r0 *1 0,0
Xsg13cmos5l_decap_8_739 VPWR VGND sg13cmos5l_decap_8
* cell instance sg13cmos5l_decap_8_740 r0 *1 0,0
Xsg13cmos5l_decap_8_740 VPWR VGND sg13cmos5l_decap_8
* cell instance sg13cmos5l_decap_8_741 r0 *1 0,0
Xsg13cmos5l_decap_8_741 VPWR VGND sg13cmos5l_decap_8
* cell instance sg13cmos5l_decap_8_742 r0 *1 0,0
Xsg13cmos5l_decap_8_742 VPWR VGND sg13cmos5l_decap_8
* cell instance sg13cmos5l_decap_8_743 r0 *1 0,0
Xsg13cmos5l_decap_8_743 VPWR VGND sg13cmos5l_decap_8
* cell instance sg13cmos5l_decap_8_744 r0 *1 0,0
Xsg13cmos5l_decap_8_744 VPWR VGND sg13cmos5l_decap_8
* cell instance sg13cmos5l_decap_8_745 r0 *1 0,0
Xsg13cmos5l_decap_8_745 VPWR VGND sg13cmos5l_decap_8
* cell instance sg13cmos5l_decap_8_746 r0 *1 0,0
Xsg13cmos5l_decap_8_746 VPWR VGND sg13cmos5l_decap_8
* cell instance sg13cmos5l_decap_8_747 r0 *1 0,0
Xsg13cmos5l_decap_8_747 VPWR VGND sg13cmos5l_decap_8
* cell instance sg13cmos5l_decap_8_748 r0 *1 0,0
Xsg13cmos5l_decap_8_748 VPWR VGND sg13cmos5l_decap_8
* cell instance sg13cmos5l_decap_8_749 r0 *1 0,0
Xsg13cmos5l_decap_8_749 VPWR VGND sg13cmos5l_decap_8
* cell instance sg13cmos5l_decap_8_750 r0 *1 0,0
Xsg13cmos5l_decap_8_750 VPWR VGND sg13cmos5l_decap_8
* cell instance sg13cmos5l_decap_8_751 r0 *1 0,0
Xsg13cmos5l_decap_8_751 VPWR VGND sg13cmos5l_decap_8
* cell instance sg13cmos5l_decap_8_752 r0 *1 0,0
Xsg13cmos5l_decap_8_752 VPWR VGND sg13cmos5l_decap_8
* cell instance sg13cmos5l_decap_8_753 r0 *1 0,0
Xsg13cmos5l_decap_8_753 VPWR VGND sg13cmos5l_decap_8
* cell instance sg13cmos5l_decap_8_754 r0 *1 0,0
Xsg13cmos5l_decap_8_754 VPWR VGND sg13cmos5l_decap_8
* cell instance sg13cmos5l_decap_8_755 r0 *1 0,0
Xsg13cmos5l_decap_8_755 VPWR VGND sg13cmos5l_decap_8
* cell instance sg13cmos5l_decap_8_756 r0 *1 0,0
Xsg13cmos5l_decap_8_756 VPWR VGND sg13cmos5l_decap_8
* cell instance sg13cmos5l_decap_8_757 r0 *1 0,0
Xsg13cmos5l_decap_8_757 VPWR VGND sg13cmos5l_decap_8
* cell instance sg13cmos5l_decap_8_758 r0 *1 0,0
Xsg13cmos5l_decap_8_758 VPWR VGND sg13cmos5l_decap_8
* cell instance sg13cmos5l_decap_8_759 r0 *1 0,0
Xsg13cmos5l_decap_8_759 VPWR VGND sg13cmos5l_decap_8
* cell instance sg13cmos5l_decap_8_760 r0 *1 0,0
Xsg13cmos5l_decap_8_760 VPWR VGND sg13cmos5l_decap_8
* cell instance sg13cmos5l_decap_8_761 r0 *1 0,0
Xsg13cmos5l_decap_8_761 VPWR VGND sg13cmos5l_decap_8
* cell instance sg13cmos5l_decap_8_762 r0 *1 0,0
Xsg13cmos5l_decap_8_762 VPWR VGND sg13cmos5l_decap_8
* cell instance sg13cmos5l_decap_8_763 r0 *1 0,0
Xsg13cmos5l_decap_8_763 VPWR VGND sg13cmos5l_decap_8
* cell instance sg13cmos5l_decap_8_764 r0 *1 0,0
Xsg13cmos5l_decap_8_764 VPWR VGND sg13cmos5l_decap_8
* cell instance sg13cmos5l_decap_8_765 r0 *1 0,0
Xsg13cmos5l_decap_8_765 VPWR VGND sg13cmos5l_decap_8
* cell instance sg13cmos5l_decap_8_766 r0 *1 0,0
Xsg13cmos5l_decap_8_766 VPWR VGND sg13cmos5l_decap_8
* cell instance sg13cmos5l_decap_8_767 r0 *1 0,0
Xsg13cmos5l_decap_8_767 VPWR VGND sg13cmos5l_decap_8
* cell instance sg13cmos5l_decap_8_768 r0 *1 0,0
Xsg13cmos5l_decap_8_768 VPWR VGND sg13cmos5l_decap_8
* cell instance sg13cmos5l_decap_8_769 r0 *1 0,0
Xsg13cmos5l_decap_8_769 VPWR VGND sg13cmos5l_decap_8
* cell instance sg13cmos5l_decap_8_770 r0 *1 0,0
Xsg13cmos5l_decap_8_770 VPWR VGND sg13cmos5l_decap_8
* cell instance sg13cmos5l_decap_8_771 r0 *1 0,0
Xsg13cmos5l_decap_8_771 VPWR VGND sg13cmos5l_decap_8
* cell instance sg13cmos5l_decap_8_772 r0 *1 0,0
Xsg13cmos5l_decap_8_772 VPWR VGND sg13cmos5l_decap_8
* cell instance sg13cmos5l_decap_8_773 r0 *1 0,0
Xsg13cmos5l_decap_8_773 VPWR VGND sg13cmos5l_decap_8
* cell instance sg13cmos5l_decap_8_774 r0 *1 0,0
Xsg13cmos5l_decap_8_774 VPWR VGND sg13cmos5l_decap_8
* cell instance sg13cmos5l_decap_8_775 r0 *1 0,0
Xsg13cmos5l_decap_8_775 VPWR VGND sg13cmos5l_decap_8
* cell instance sg13cmos5l_decap_8_776 r0 *1 0,0
Xsg13cmos5l_decap_8_776 VPWR VGND sg13cmos5l_decap_8
* cell instance sg13cmos5l_decap_8_777 r0 *1 0,0
Xsg13cmos5l_decap_8_777 VPWR VGND sg13cmos5l_decap_8
* cell instance sg13cmos5l_decap_8_778 r0 *1 0,0
Xsg13cmos5l_decap_8_778 VPWR VGND sg13cmos5l_decap_8
* cell instance sg13cmos5l_decap_8_779 r0 *1 0,0
Xsg13cmos5l_decap_8_779 VPWR VGND sg13cmos5l_decap_8
* cell instance sg13cmos5l_decap_8_780 r0 *1 0,0
Xsg13cmos5l_decap_8_780 VPWR VGND sg13cmos5l_decap_8
* cell instance sg13cmos5l_decap_8_781 r0 *1 0,0
Xsg13cmos5l_decap_8_781 VPWR VGND sg13cmos5l_decap_8
* cell instance sg13cmos5l_decap_8_782 r0 *1 0,0
Xsg13cmos5l_decap_8_782 VPWR VGND sg13cmos5l_decap_8
* cell instance sg13cmos5l_decap_8_783 r0 *1 0,0
Xsg13cmos5l_decap_8_783 VPWR VGND sg13cmos5l_decap_8
* cell instance sg13cmos5l_decap_8_784 r0 *1 0,0
Xsg13cmos5l_decap_8_784 VPWR VGND sg13cmos5l_decap_8
* cell instance sg13cmos5l_decap_8_785 r0 *1 0,0
Xsg13cmos5l_decap_8_785 VPWR VGND sg13cmos5l_decap_8
* cell instance sg13cmos5l_decap_8_786 r0 *1 0,0
Xsg13cmos5l_decap_8_786 VPWR VGND sg13cmos5l_decap_8
* cell instance sg13cmos5l_decap_8_787 r0 *1 0,0
Xsg13cmos5l_decap_8_787 VPWR VGND sg13cmos5l_decap_8
* cell instance sg13cmos5l_decap_8_788 r0 *1 0,0
Xsg13cmos5l_decap_8_788 VPWR VGND sg13cmos5l_decap_8
* cell instance sg13cmos5l_decap_8_789 r0 *1 0,0
Xsg13cmos5l_decap_8_789 VPWR VGND sg13cmos5l_decap_8
* cell instance sg13cmos5l_decap_8_790 r0 *1 0,0
Xsg13cmos5l_decap_8_790 VPWR VGND sg13cmos5l_decap_8
* cell instance sg13cmos5l_decap_8_791 r0 *1 0,0
Xsg13cmos5l_decap_8_791 VPWR VGND sg13cmos5l_decap_8
* cell instance sg13cmos5l_decap_8_792 r0 *1 0,0
Xsg13cmos5l_decap_8_792 VPWR VGND sg13cmos5l_decap_8
* cell instance sg13cmos5l_decap_8_793 r0 *1 0,0
Xsg13cmos5l_decap_8_793 VPWR VGND sg13cmos5l_decap_8
* cell instance sg13cmos5l_decap_8_794 r0 *1 0,0
Xsg13cmos5l_decap_8_794 VPWR VGND sg13cmos5l_decap_8
* cell instance sg13cmos5l_decap_8_795 r0 *1 0,0
Xsg13cmos5l_decap_8_795 VPWR VGND sg13cmos5l_decap_8
* cell instance sg13cmos5l_decap_8_796 r0 *1 0,0
Xsg13cmos5l_decap_8_796 VPWR VGND sg13cmos5l_decap_8
* cell instance sg13cmos5l_decap_8_797 r0 *1 0,0
Xsg13cmos5l_decap_8_797 VPWR VGND sg13cmos5l_decap_8
* cell instance sg13cmos5l_decap_8_798 r0 *1 0,0
Xsg13cmos5l_decap_8_798 VPWR VGND sg13cmos5l_decap_8
* cell instance sg13cmos5l_decap_8_799 r0 *1 0,0
Xsg13cmos5l_decap_8_799 VPWR VGND sg13cmos5l_decap_8
* cell instance sg13cmos5l_decap_8_800 r0 *1 0,0
Xsg13cmos5l_decap_8_800 VPWR VGND sg13cmos5l_decap_8
* cell instance sg13cmos5l_decap_8_801 r0 *1 0,0
Xsg13cmos5l_decap_8_801 VPWR VGND sg13cmos5l_decap_8
* cell instance sg13cmos5l_decap_8_802 r0 *1 0,0
Xsg13cmos5l_decap_8_802 VPWR VGND sg13cmos5l_decap_8
* cell instance sg13cmos5l_decap_8_803 r0 *1 0,0
Xsg13cmos5l_decap_8_803 VPWR VGND sg13cmos5l_decap_8
* cell instance sg13cmos5l_decap_8_804 r0 *1 0,0
Xsg13cmos5l_decap_8_804 VPWR VGND sg13cmos5l_decap_8
* cell instance sg13cmos5l_decap_8_805 r0 *1 0,0
Xsg13cmos5l_decap_8_805 VPWR VGND sg13cmos5l_decap_8
* cell instance sg13cmos5l_decap_8_806 r0 *1 0,0
Xsg13cmos5l_decap_8_806 VPWR VGND sg13cmos5l_decap_8
* cell instance sg13cmos5l_decap_8_807 r0 *1 0,0
Xsg13cmos5l_decap_8_807 VPWR VGND sg13cmos5l_decap_8
* cell instance sg13cmos5l_decap_8_808 r0 *1 0,0
Xsg13cmos5l_decap_8_808 VPWR VGND sg13cmos5l_decap_8
* cell instance sg13cmos5l_decap_8_809 r0 *1 0,0
Xsg13cmos5l_decap_8_809 VPWR VGND sg13cmos5l_decap_8
* cell instance sg13cmos5l_decap_8_810 r0 *1 0,0
Xsg13cmos5l_decap_8_810 VPWR VGND sg13cmos5l_decap_8
* cell instance sg13cmos5l_decap_8_811 r0 *1 0,0
Xsg13cmos5l_decap_8_811 VPWR VGND sg13cmos5l_decap_8
* cell instance sg13cmos5l_decap_8_812 r0 *1 0,0
Xsg13cmos5l_decap_8_812 VPWR VGND sg13cmos5l_decap_8
* cell instance sg13cmos5l_decap_8_813 r0 *1 0,0
Xsg13cmos5l_decap_8_813 VPWR VGND sg13cmos5l_decap_8
* cell instance sg13cmos5l_decap_8_814 r0 *1 0,0
Xsg13cmos5l_decap_8_814 VPWR VGND sg13cmos5l_decap_8
* cell instance sg13cmos5l_decap_8_815 r0 *1 0,0
Xsg13cmos5l_decap_8_815 VPWR VGND sg13cmos5l_decap_8
* cell instance sg13cmos5l_decap_8_816 r0 *1 0,0
Xsg13cmos5l_decap_8_816 VPWR VGND sg13cmos5l_decap_8
* cell instance sg13cmos5l_decap_8_817 r0 *1 0,0
Xsg13cmos5l_decap_8_817 VPWR VGND sg13cmos5l_decap_8
* cell instance sg13cmos5l_decap_8_818 r0 *1 0,0
Xsg13cmos5l_decap_8_818 VPWR VGND sg13cmos5l_decap_8
* cell instance sg13cmos5l_decap_8_819 r0 *1 0,0
Xsg13cmos5l_decap_8_819 VPWR VGND sg13cmos5l_decap_8
* cell instance sg13cmos5l_decap_8_820 r0 *1 0,0
Xsg13cmos5l_decap_8_820 VPWR VGND sg13cmos5l_decap_8
* cell instance sg13cmos5l_decap_8_821 r0 *1 0,0
Xsg13cmos5l_decap_8_821 VPWR VGND sg13cmos5l_decap_8
* cell instance sg13cmos5l_decap_8_822 r0 *1 0,0
Xsg13cmos5l_decap_8_822 VPWR VGND sg13cmos5l_decap_8
* cell instance sg13cmos5l_decap_8_823 r0 *1 0,0
Xsg13cmos5l_decap_8_823 VPWR VGND sg13cmos5l_decap_8
* cell instance sg13cmos5l_decap_8_824 r0 *1 0,0
Xsg13cmos5l_decap_8_824 VPWR VGND sg13cmos5l_decap_8
* cell instance sg13cmos5l_decap_8_825 r0 *1 0,0
Xsg13cmos5l_decap_8_825 VPWR VGND sg13cmos5l_decap_8
* cell instance sg13cmos5l_decap_8_826 r0 *1 0,0
Xsg13cmos5l_decap_8_826 VPWR VGND sg13cmos5l_decap_8
* cell instance sg13cmos5l_decap_8_827 r0 *1 0,0
Xsg13cmos5l_decap_8_827 VPWR VGND sg13cmos5l_decap_8
* cell instance sg13cmos5l_decap_8_828 r0 *1 0,0
Xsg13cmos5l_decap_8_828 VPWR VGND sg13cmos5l_decap_8
* cell instance sg13cmos5l_decap_8_829 r0 *1 0,0
Xsg13cmos5l_decap_8_829 VPWR VGND sg13cmos5l_decap_8
* cell instance sg13cmos5l_decap_8_830 r0 *1 0,0
Xsg13cmos5l_decap_8_830 VPWR VGND sg13cmos5l_decap_8
* cell instance sg13cmos5l_decap_8_831 r0 *1 0,0
Xsg13cmos5l_decap_8_831 VPWR VGND sg13cmos5l_decap_8
* cell instance sg13cmos5l_decap_8_832 r0 *1 0,0
Xsg13cmos5l_decap_8_832 VPWR VGND sg13cmos5l_decap_8
* cell instance sg13cmos5l_decap_8_833 r0 *1 0,0
Xsg13cmos5l_decap_8_833 VPWR VGND sg13cmos5l_decap_8
* cell instance sg13cmos5l_decap_8_834 r0 *1 0,0
Xsg13cmos5l_decap_8_834 VPWR VGND sg13cmos5l_decap_8
* cell instance sg13cmos5l_decap_8_835 r0 *1 0,0
Xsg13cmos5l_decap_8_835 VPWR VGND sg13cmos5l_decap_8
* cell instance sg13cmos5l_decap_8_836 r0 *1 0,0
Xsg13cmos5l_decap_8_836 VPWR VGND sg13cmos5l_decap_8
* cell instance sg13cmos5l_decap_8_837 r0 *1 0,0
Xsg13cmos5l_decap_8_837 VPWR VGND sg13cmos5l_decap_8
* cell instance sg13cmos5l_decap_8_838 r0 *1 0,0
Xsg13cmos5l_decap_8_838 VPWR VGND sg13cmos5l_decap_8
* cell instance sg13cmos5l_decap_8_839 r0 *1 0,0
Xsg13cmos5l_decap_8_839 VPWR VGND sg13cmos5l_decap_8
* cell instance sg13cmos5l_decap_8_840 r0 *1 0,0
Xsg13cmos5l_decap_8_840 VPWR VGND sg13cmos5l_decap_8
* cell instance sg13cmos5l_decap_8_841 r0 *1 0,0
Xsg13cmos5l_decap_8_841 VPWR VGND sg13cmos5l_decap_8
* cell instance sg13cmos5l_decap_8_842 r0 *1 0,0
Xsg13cmos5l_decap_8_842 VPWR VGND sg13cmos5l_decap_8
* cell instance sg13cmos5l_decap_8_843 r0 *1 0,0
Xsg13cmos5l_decap_8_843 VPWR VGND sg13cmos5l_decap_8
* cell instance sg13cmos5l_decap_8_844 r0 *1 0,0
Xsg13cmos5l_decap_8_844 VPWR VGND sg13cmos5l_decap_8
* cell instance sg13cmos5l_decap_8_845 r0 *1 0,0
Xsg13cmos5l_decap_8_845 VPWR VGND sg13cmos5l_decap_8
* cell instance sg13cmos5l_decap_8_846 r0 *1 0,0
Xsg13cmos5l_decap_8_846 VPWR VGND sg13cmos5l_decap_8
* cell instance sg13cmos5l_decap_8_847 r0 *1 0,0
Xsg13cmos5l_decap_8_847 VPWR VGND sg13cmos5l_decap_8
* cell instance sg13cmos5l_decap_8_848 r0 *1 0,0
Xsg13cmos5l_decap_8_848 VPWR VGND sg13cmos5l_decap_8
* cell instance sg13cmos5l_decap_8_849 r0 *1 0,0
Xsg13cmos5l_decap_8_849 VPWR VGND sg13cmos5l_decap_8
* cell instance sg13cmos5l_decap_8_850 r0 *1 0,0
Xsg13cmos5l_decap_8_850 VPWR VGND sg13cmos5l_decap_8
* cell instance sg13cmos5l_decap_8_851 r0 *1 0,0
Xsg13cmos5l_decap_8_851 VPWR VGND sg13cmos5l_decap_8
* cell instance sg13cmos5l_decap_8_852 r0 *1 0,0
Xsg13cmos5l_decap_8_852 VPWR VGND sg13cmos5l_decap_8
* cell instance sg13cmos5l_decap_8_853 r0 *1 0,0
Xsg13cmos5l_decap_8_853 VPWR VGND sg13cmos5l_decap_8
* cell instance sg13cmos5l_decap_8_854 r0 *1 0,0
Xsg13cmos5l_decap_8_854 VPWR VGND sg13cmos5l_decap_8
* cell instance sg13cmos5l_decap_8_855 r0 *1 0,0
Xsg13cmos5l_decap_8_855 VPWR VGND sg13cmos5l_decap_8
* cell instance sg13cmos5l_decap_8_856 r0 *1 0,0
Xsg13cmos5l_decap_8_856 VPWR VGND sg13cmos5l_decap_8
* cell instance sg13cmos5l_decap_8_857 r0 *1 0,0
Xsg13cmos5l_decap_8_857 VPWR VGND sg13cmos5l_decap_8
* cell instance sg13cmos5l_decap_8_858 r0 *1 0,0
Xsg13cmos5l_decap_8_858 VPWR VGND sg13cmos5l_decap_8
* cell instance sg13cmos5l_decap_8_859 r0 *1 0,0
Xsg13cmos5l_decap_8_859 VPWR VGND sg13cmos5l_decap_8
* cell instance sg13cmos5l_decap_8_860 r0 *1 0,0
Xsg13cmos5l_decap_8_860 VPWR VGND sg13cmos5l_decap_8
* cell instance sg13cmos5l_decap_8_861 r0 *1 0,0
Xsg13cmos5l_decap_8_861 VPWR VGND sg13cmos5l_decap_8
* cell instance sg13cmos5l_decap_8_862 r0 *1 0,0
Xsg13cmos5l_decap_8_862 VPWR VGND sg13cmos5l_decap_8
* cell instance sg13cmos5l_decap_8_863 r0 *1 0,0
Xsg13cmos5l_decap_8_863 VPWR VGND sg13cmos5l_decap_8
* cell instance sg13cmos5l_decap_8_864 r0 *1 0,0
Xsg13cmos5l_decap_8_864 VPWR VGND sg13cmos5l_decap_8
* cell instance sg13cmos5l_decap_8_865 r0 *1 0,0
Xsg13cmos5l_decap_8_865 VPWR VGND sg13cmos5l_decap_8
* cell instance sg13cmos5l_decap_8_866 r0 *1 0,0
Xsg13cmos5l_decap_8_866 VPWR VGND sg13cmos5l_decap_8
* cell instance sg13cmos5l_decap_8_867 r0 *1 0,0
Xsg13cmos5l_decap_8_867 VPWR VGND sg13cmos5l_decap_8
* cell instance sg13cmos5l_decap_8_868 r0 *1 0,0
Xsg13cmos5l_decap_8_868 VPWR VGND sg13cmos5l_decap_8
* cell instance sg13cmos5l_decap_8_869 r0 *1 0,0
Xsg13cmos5l_decap_8_869 VPWR VGND sg13cmos5l_decap_8
* cell instance sg13cmos5l_decap_8_870 r0 *1 0,0
Xsg13cmos5l_decap_8_870 VPWR VGND sg13cmos5l_decap_8
* cell instance sg13cmos5l_decap_8_871 r0 *1 0,0
Xsg13cmos5l_decap_8_871 VPWR VGND sg13cmos5l_decap_8
* cell instance sg13cmos5l_decap_8_872 r0 *1 0,0
Xsg13cmos5l_decap_8_872 VPWR VGND sg13cmos5l_decap_8
* cell instance sg13cmos5l_decap_8_873 r0 *1 0,0
Xsg13cmos5l_decap_8_873 VPWR VGND sg13cmos5l_decap_8
* cell instance sg13cmos5l_decap_8_874 r0 *1 0,0
Xsg13cmos5l_decap_8_874 VPWR VGND sg13cmos5l_decap_8
* cell instance sg13cmos5l_decap_8_875 r0 *1 0,0
Xsg13cmos5l_decap_8_875 VPWR VGND sg13cmos5l_decap_8
* cell instance sg13cmos5l_decap_8_876 r0 *1 0,0
Xsg13cmos5l_decap_8_876 VPWR VGND sg13cmos5l_decap_8
* cell instance sg13cmos5l_decap_8_877 r0 *1 0,0
Xsg13cmos5l_decap_8_877 VPWR VGND sg13cmos5l_decap_8
* cell instance sg13cmos5l_decap_8_878 r0 *1 0,0
Xsg13cmos5l_decap_8_878 VPWR VGND sg13cmos5l_decap_8
* cell instance sg13cmos5l_decap_8_879 r0 *1 0,0
Xsg13cmos5l_decap_8_879 VPWR VGND sg13cmos5l_decap_8
* cell instance sg13cmos5l_decap_8_880 r0 *1 0,0
Xsg13cmos5l_decap_8_880 VPWR VGND sg13cmos5l_decap_8
* cell instance sg13cmos5l_decap_8_881 r0 *1 0,0
Xsg13cmos5l_decap_8_881 VPWR VGND sg13cmos5l_decap_8
* cell instance sg13cmos5l_decap_8_882 r0 *1 0,0
Xsg13cmos5l_decap_8_882 VPWR VGND sg13cmos5l_decap_8
* cell instance sg13cmos5l_decap_8_883 r0 *1 0,0
Xsg13cmos5l_decap_8_883 VPWR VGND sg13cmos5l_decap_8
* cell instance sg13cmos5l_decap_8_884 r0 *1 0,0
Xsg13cmos5l_decap_8_884 VPWR VGND sg13cmos5l_decap_8
* cell instance sg13cmos5l_decap_8_885 r0 *1 0,0
Xsg13cmos5l_decap_8_885 VPWR VGND sg13cmos5l_decap_8
* cell instance sg13cmos5l_decap_8_886 r0 *1 0,0
Xsg13cmos5l_decap_8_886 VPWR VGND sg13cmos5l_decap_8
* cell instance sg13cmos5l_decap_8_887 r0 *1 0,0
Xsg13cmos5l_decap_8_887 VPWR VGND sg13cmos5l_decap_8
* cell instance sg13cmos5l_decap_8_888 r0 *1 0,0
Xsg13cmos5l_decap_8_888 VPWR VGND sg13cmos5l_decap_8
* cell instance sg13cmos5l_decap_8_889 r0 *1 0,0
Xsg13cmos5l_decap_8_889 VPWR VGND sg13cmos5l_decap_8
* cell instance sg13cmos5l_decap_8_890 r0 *1 0,0
Xsg13cmos5l_decap_8_890 VPWR VGND sg13cmos5l_decap_8
* cell instance sg13cmos5l_decap_8_891 r0 *1 0,0
Xsg13cmos5l_decap_8_891 VPWR VGND sg13cmos5l_decap_8
* cell instance sg13cmos5l_decap_8_892 r0 *1 0,0
Xsg13cmos5l_decap_8_892 VPWR VGND sg13cmos5l_decap_8
* cell instance sg13cmos5l_decap_8_893 r0 *1 0,0
Xsg13cmos5l_decap_8_893 VPWR VGND sg13cmos5l_decap_8
* cell instance sg13cmos5l_decap_8_894 r0 *1 0,0
Xsg13cmos5l_decap_8_894 VPWR VGND sg13cmos5l_decap_8
* cell instance sg13cmos5l_decap_8_895 r0 *1 0,0
Xsg13cmos5l_decap_8_895 VPWR VGND sg13cmos5l_decap_8
* cell instance sg13cmos5l_decap_8_896 r0 *1 0,0
Xsg13cmos5l_decap_8_896 VPWR VGND sg13cmos5l_decap_8
* cell instance sg13cmos5l_decap_8_897 r0 *1 0,0
Xsg13cmos5l_decap_8_897 VPWR VGND sg13cmos5l_decap_8
* cell instance sg13cmos5l_decap_8_898 r0 *1 0,0
Xsg13cmos5l_decap_8_898 VPWR VGND sg13cmos5l_decap_8
* cell instance sg13cmos5l_decap_8_899 r0 *1 0,0
Xsg13cmos5l_decap_8_899 VPWR VGND sg13cmos5l_decap_8
* cell instance sg13cmos5l_decap_8_900 r0 *1 0,0
Xsg13cmos5l_decap_8_900 VPWR VGND sg13cmos5l_decap_8
* cell instance sg13cmos5l_decap_8_901 r0 *1 0,0
Xsg13cmos5l_decap_8_901 VPWR VGND sg13cmos5l_decap_8
* cell instance sg13cmos5l_decap_8_902 r0 *1 0,0
Xsg13cmos5l_decap_8_902 VPWR VGND sg13cmos5l_decap_8
* cell instance sg13cmos5l_decap_8_903 r0 *1 0,0
Xsg13cmos5l_decap_8_903 VPWR VGND sg13cmos5l_decap_8
* cell instance sg13cmos5l_decap_8_904 r0 *1 0,0
Xsg13cmos5l_decap_8_904 VPWR VGND sg13cmos5l_decap_8
* cell instance sg13cmos5l_decap_8_905 r0 *1 0,0
Xsg13cmos5l_decap_8_905 VPWR VGND sg13cmos5l_decap_8
* cell instance sg13cmos5l_decap_8_906 r0 *1 0,0
Xsg13cmos5l_decap_8_906 VPWR VGND sg13cmos5l_decap_8
* cell instance sg13cmos5l_decap_8_907 r0 *1 0,0
Xsg13cmos5l_decap_8_907 VPWR VGND sg13cmos5l_decap_8
* cell instance sg13cmos5l_decap_8_908 r0 *1 0,0
Xsg13cmos5l_decap_8_908 VPWR VGND sg13cmos5l_decap_8
* cell instance sg13cmos5l_decap_8_909 r0 *1 0,0
Xsg13cmos5l_decap_8_909 VPWR VGND sg13cmos5l_decap_8
* cell instance sg13cmos5l_decap_8_910 r0 *1 0,0
Xsg13cmos5l_decap_8_910 VPWR VGND sg13cmos5l_decap_8
* cell instance sg13cmos5l_decap_8_911 r0 *1 0,0
Xsg13cmos5l_decap_8_911 VPWR VGND sg13cmos5l_decap_8
* cell instance sg13cmos5l_decap_8_912 r0 *1 0,0
Xsg13cmos5l_decap_8_912 VPWR VGND sg13cmos5l_decap_8
* cell instance sg13cmos5l_decap_8_913 r0 *1 0,0
Xsg13cmos5l_decap_8_913 VPWR VGND sg13cmos5l_decap_8
* cell instance sg13cmos5l_decap_8_914 r0 *1 0,0
Xsg13cmos5l_decap_8_914 VPWR VGND sg13cmos5l_decap_8
* cell instance sg13cmos5l_decap_8_915 r0 *1 0,0
Xsg13cmos5l_decap_8_915 VPWR VGND sg13cmos5l_decap_8
* cell instance sg13cmos5l_decap_8_916 r0 *1 0,0
Xsg13cmos5l_decap_8_916 VPWR VGND sg13cmos5l_decap_8
* cell instance sg13cmos5l_decap_8_917 r0 *1 0,0
Xsg13cmos5l_decap_8_917 VPWR VGND sg13cmos5l_decap_8
* cell instance sg13cmos5l_decap_8_918 r0 *1 0,0
Xsg13cmos5l_decap_8_918 VPWR VGND sg13cmos5l_decap_8
* cell instance sg13cmos5l_decap_8_919 r0 *1 0,0
Xsg13cmos5l_decap_8_919 VPWR VGND sg13cmos5l_decap_8
* cell instance sg13cmos5l_decap_8_920 r0 *1 0,0
Xsg13cmos5l_decap_8_920 VPWR VGND sg13cmos5l_decap_8
* cell instance sg13cmos5l_decap_8_921 r0 *1 0,0
Xsg13cmos5l_decap_8_921 VPWR VGND sg13cmos5l_decap_8
* cell instance sg13cmos5l_decap_8_922 r0 *1 0,0
Xsg13cmos5l_decap_8_922 VPWR VGND sg13cmos5l_decap_8
* cell instance sg13cmos5l_decap_8_923 r0 *1 0,0
Xsg13cmos5l_decap_8_923 VPWR VGND sg13cmos5l_decap_8
* cell instance sg13cmos5l_decap_8_924 r0 *1 0,0
Xsg13cmos5l_decap_8_924 VPWR VGND sg13cmos5l_decap_8
* cell instance sg13cmos5l_decap_8_925 r0 *1 0,0
Xsg13cmos5l_decap_8_925 VPWR VGND sg13cmos5l_decap_8
* cell instance sg13cmos5l_decap_8_926 r0 *1 0,0
Xsg13cmos5l_decap_8_926 VPWR VGND sg13cmos5l_decap_8
* cell instance sg13cmos5l_decap_8_927 r0 *1 0,0
Xsg13cmos5l_decap_8_927 VPWR VGND sg13cmos5l_decap_8
* cell instance sg13cmos5l_decap_8_928 r0 *1 0,0
Xsg13cmos5l_decap_8_928 VPWR VGND sg13cmos5l_decap_8
* cell instance sg13cmos5l_decap_8_929 r0 *1 0,0
Xsg13cmos5l_decap_8_929 VPWR VGND sg13cmos5l_decap_8
* cell instance sg13cmos5l_decap_8_930 r0 *1 0,0
Xsg13cmos5l_decap_8_930 VPWR VGND sg13cmos5l_decap_8
* cell instance sg13cmos5l_decap_8_931 r0 *1 0,0
Xsg13cmos5l_decap_8_931 VPWR VGND sg13cmos5l_decap_8
* cell instance sg13cmos5l_decap_8_932 r0 *1 0,0
Xsg13cmos5l_decap_8_932 VPWR VGND sg13cmos5l_decap_8
* cell instance sg13cmos5l_decap_8_933 r0 *1 0,0
Xsg13cmos5l_decap_8_933 VPWR VGND sg13cmos5l_decap_8
* cell instance sg13cmos5l_decap_8_934 r0 *1 0,0
Xsg13cmos5l_decap_8_934 VPWR VGND sg13cmos5l_decap_8
* cell instance sg13cmos5l_decap_8_935 r0 *1 0,0
Xsg13cmos5l_decap_8_935 VPWR VGND sg13cmos5l_decap_8
* cell instance sg13cmos5l_decap_8_936 r0 *1 0,0
Xsg13cmos5l_decap_8_936 VPWR VGND sg13cmos5l_decap_8
* cell instance sg13cmos5l_decap_8_937 r0 *1 0,0
Xsg13cmos5l_decap_8_937 VPWR VGND sg13cmos5l_decap_8
* cell instance sg13cmos5l_decap_8_938 r0 *1 0,0
Xsg13cmos5l_decap_8_938 VPWR VGND sg13cmos5l_decap_8
* cell instance sg13cmos5l_decap_8_939 r0 *1 0,0
Xsg13cmos5l_decap_8_939 VPWR VGND sg13cmos5l_decap_8
* cell instance sg13cmos5l_decap_8_940 r0 *1 0,0
Xsg13cmos5l_decap_8_940 VPWR VGND sg13cmos5l_decap_8
* cell instance sg13cmos5l_decap_8_941 r0 *1 0,0
Xsg13cmos5l_decap_8_941 VPWR VGND sg13cmos5l_decap_8
* cell instance sg13cmos5l_decap_8_942 r0 *1 0,0
Xsg13cmos5l_decap_8_942 VPWR VGND sg13cmos5l_decap_8
* cell instance sg13cmos5l_decap_8_943 r0 *1 0,0
Xsg13cmos5l_decap_8_943 VPWR VGND sg13cmos5l_decap_8
* cell instance sg13cmos5l_decap_8_944 r0 *1 0,0
Xsg13cmos5l_decap_8_944 VPWR VGND sg13cmos5l_decap_8
* cell instance sg13cmos5l_decap_8_945 r0 *1 0,0
Xsg13cmos5l_decap_8_945 VPWR VGND sg13cmos5l_decap_8
* cell instance sg13cmos5l_decap_8_946 r0 *1 0,0
Xsg13cmos5l_decap_8_946 VPWR VGND sg13cmos5l_decap_8
* cell instance sg13cmos5l_decap_8_947 r0 *1 0,0
Xsg13cmos5l_decap_8_947 VPWR VGND sg13cmos5l_decap_8
* cell instance sg13cmos5l_decap_8_948 r0 *1 0,0
Xsg13cmos5l_decap_8_948 VPWR VGND sg13cmos5l_decap_8
* cell instance sg13cmos5l_decap_8_949 r0 *1 0,0
Xsg13cmos5l_decap_8_949 VPWR VGND sg13cmos5l_decap_8
* cell instance sg13cmos5l_decap_8_950 r0 *1 0,0
Xsg13cmos5l_decap_8_950 VPWR VGND sg13cmos5l_decap_8
* cell instance sg13cmos5l_decap_8_951 r0 *1 0,0
Xsg13cmos5l_decap_8_951 VPWR VGND sg13cmos5l_decap_8
* cell instance sg13cmos5l_decap_8_952 r0 *1 0,0
Xsg13cmos5l_decap_8_952 VPWR VGND sg13cmos5l_decap_8
* cell instance sg13cmos5l_decap_8_953 r0 *1 0,0
Xsg13cmos5l_decap_8_953 VPWR VGND sg13cmos5l_decap_8
* cell instance sg13cmos5l_decap_8_954 r0 *1 0,0
Xsg13cmos5l_decap_8_954 VPWR VGND sg13cmos5l_decap_8
* cell instance sg13cmos5l_decap_8_955 r0 *1 0,0
Xsg13cmos5l_decap_8_955 VPWR VGND sg13cmos5l_decap_8
* cell instance sg13cmos5l_decap_8_956 r0 *1 0,0
Xsg13cmos5l_decap_8_956 VPWR VGND sg13cmos5l_decap_8
* cell instance sg13cmos5l_decap_8_957 r0 *1 0,0
Xsg13cmos5l_decap_8_957 VPWR VGND sg13cmos5l_decap_8
* cell instance sg13cmos5l_decap_8_958 r0 *1 0,0
Xsg13cmos5l_decap_8_958 VPWR VGND sg13cmos5l_decap_8
* cell instance sg13cmos5l_decap_8_959 r0 *1 0,0
Xsg13cmos5l_decap_8_959 VPWR VGND sg13cmos5l_decap_8
* cell instance sg13cmos5l_decap_8_960 r0 *1 0,0
Xsg13cmos5l_decap_8_960 VPWR VGND sg13cmos5l_decap_8
* cell instance sg13cmos5l_decap_8_961 r0 *1 0,0
Xsg13cmos5l_decap_8_961 VPWR VGND sg13cmos5l_decap_8
* cell instance sg13cmos5l_decap_8_962 r0 *1 0,0
Xsg13cmos5l_decap_8_962 VPWR VGND sg13cmos5l_decap_8
* cell instance sg13cmos5l_decap_8_963 r0 *1 0,0
Xsg13cmos5l_decap_8_963 VPWR VGND sg13cmos5l_decap_8
* cell instance sg13cmos5l_decap_8_964 r0 *1 0,0
Xsg13cmos5l_decap_8_964 VPWR VGND sg13cmos5l_decap_8
* cell instance sg13cmos5l_decap_8_965 r0 *1 0,0
Xsg13cmos5l_decap_8_965 VPWR VGND sg13cmos5l_decap_8
* cell instance sg13cmos5l_decap_8_966 r0 *1 0,0
Xsg13cmos5l_decap_8_966 VPWR VGND sg13cmos5l_decap_8
* cell instance sg13cmos5l_decap_8_967 r0 *1 0,0
Xsg13cmos5l_decap_8_967 VPWR VGND sg13cmos5l_decap_8
* cell instance sg13cmos5l_decap_8_968 r0 *1 0,0
Xsg13cmos5l_decap_8_968 VPWR VGND sg13cmos5l_decap_8
* cell instance sg13cmos5l_decap_8_969 r0 *1 0,0
Xsg13cmos5l_decap_8_969 VPWR VGND sg13cmos5l_decap_8
* cell instance sg13cmos5l_decap_8_970 r0 *1 0,0
Xsg13cmos5l_decap_8_970 VPWR VGND sg13cmos5l_decap_8
* cell instance sg13cmos5l_decap_8_971 r0 *1 0,0
Xsg13cmos5l_decap_8_971 VPWR VGND sg13cmos5l_decap_8
* cell instance sg13cmos5l_decap_8_972 r0 *1 0,0
Xsg13cmos5l_decap_8_972 VPWR VGND sg13cmos5l_decap_8
* cell instance sg13cmos5l_decap_8_973 r0 *1 0,0
Xsg13cmos5l_decap_8_973 VPWR VGND sg13cmos5l_decap_8
* cell instance sg13cmos5l_decap_8_974 r0 *1 0,0
Xsg13cmos5l_decap_8_974 VPWR VGND sg13cmos5l_decap_8
* cell instance sg13cmos5l_decap_8_975 r0 *1 0,0
Xsg13cmos5l_decap_8_975 VPWR VGND sg13cmos5l_decap_8
* cell instance sg13cmos5l_decap_8_976 r0 *1 0,0
Xsg13cmos5l_decap_8_976 VPWR VGND sg13cmos5l_decap_8
* cell instance sg13cmos5l_decap_8_977 r0 *1 0,0
Xsg13cmos5l_decap_8_977 VPWR VGND sg13cmos5l_decap_8
* cell instance sg13cmos5l_decap_8_978 r0 *1 0,0
Xsg13cmos5l_decap_8_978 VPWR VGND sg13cmos5l_decap_8
* cell instance sg13cmos5l_decap_8_979 r0 *1 0,0
Xsg13cmos5l_decap_8_979 VPWR VGND sg13cmos5l_decap_8
* cell instance sg13cmos5l_decap_8_980 r0 *1 0,0
Xsg13cmos5l_decap_8_980 VPWR VGND sg13cmos5l_decap_8
* cell instance sg13cmos5l_decap_8_981 r0 *1 0,0
Xsg13cmos5l_decap_8_981 VPWR VGND sg13cmos5l_decap_8
* cell instance sg13cmos5l_decap_8_982 r0 *1 0,0
Xsg13cmos5l_decap_8_982 VPWR VGND sg13cmos5l_decap_8
* cell instance sg13cmos5l_decap_8_983 r0 *1 0,0
Xsg13cmos5l_decap_8_983 VPWR VGND sg13cmos5l_decap_8
* cell instance sg13cmos5l_decap_8_984 r0 *1 0,0
Xsg13cmos5l_decap_8_984 VPWR VGND sg13cmos5l_decap_8
* cell instance sg13cmos5l_decap_8_985 r0 *1 0,0
Xsg13cmos5l_decap_8_985 VPWR VGND sg13cmos5l_decap_8
* cell instance sg13cmos5l_decap_8_986 r0 *1 0,0
Xsg13cmos5l_decap_8_986 VPWR VGND sg13cmos5l_decap_8
* cell instance sg13cmos5l_decap_8_987 r0 *1 0,0
Xsg13cmos5l_decap_8_987 VPWR VGND sg13cmos5l_decap_8
* cell instance sg13cmos5l_decap_8_988 r0 *1 0,0
Xsg13cmos5l_decap_8_988 VPWR VGND sg13cmos5l_decap_8
* cell instance sg13cmos5l_decap_8_989 r0 *1 0,0
Xsg13cmos5l_decap_8_989 VPWR VGND sg13cmos5l_decap_8
* cell instance sg13cmos5l_decap_8_990 r0 *1 0,0
Xsg13cmos5l_decap_8_990 VPWR VGND sg13cmos5l_decap_8
* cell instance sg13cmos5l_decap_8_991 r0 *1 0,0
Xsg13cmos5l_decap_8_991 VPWR VGND sg13cmos5l_decap_8
* cell instance sg13cmos5l_decap_8_992 r0 *1 0,0
Xsg13cmos5l_decap_8_992 VPWR VGND sg13cmos5l_decap_8
* cell instance sg13cmos5l_decap_8_993 r0 *1 0,0
Xsg13cmos5l_decap_8_993 VPWR VGND sg13cmos5l_decap_8
* cell instance sg13cmos5l_decap_8_994 r0 *1 0,0
Xsg13cmos5l_decap_8_994 VPWR VGND sg13cmos5l_decap_8
* cell instance sg13cmos5l_decap_8_995 r0 *1 0,0
Xsg13cmos5l_decap_8_995 VPWR VGND sg13cmos5l_decap_8
* cell instance sg13cmos5l_decap_8_996 r0 *1 0,0
Xsg13cmos5l_decap_8_996 VPWR VGND sg13cmos5l_decap_8
* cell instance sg13cmos5l_decap_8_997 r0 *1 0,0
Xsg13cmos5l_decap_8_997 VPWR VGND sg13cmos5l_decap_8
* cell instance sg13cmos5l_decap_8_998 r0 *1 0,0
Xsg13cmos5l_decap_8_998 VPWR VGND sg13cmos5l_decap_8
* cell instance sg13cmos5l_decap_8_999 r0 *1 0,0
Xsg13cmos5l_decap_8_999 VPWR VGND sg13cmos5l_decap_8
* cell instance sg13cmos5l_decap_8_1000 r0 *1 0,0
Xsg13cmos5l_decap_8_1000 VPWR VGND sg13cmos5l_decap_8
* cell instance sg13cmos5l_decap_8_1001 r0 *1 0,0
Xsg13cmos5l_decap_8_1001 VPWR VGND sg13cmos5l_decap_8
* cell instance sg13cmos5l_decap_8_1002 r0 *1 0,0
Xsg13cmos5l_decap_8_1002 VPWR VGND sg13cmos5l_decap_8
* cell instance sg13cmos5l_decap_8_1003 r0 *1 0,0
Xsg13cmos5l_decap_8_1003 VPWR VGND sg13cmos5l_decap_8
* cell instance sg13cmos5l_decap_8_1004 r0 *1 0,0
Xsg13cmos5l_decap_8_1004 VPWR VGND sg13cmos5l_decap_8
* cell instance sg13cmos5l_decap_8_1005 r0 *1 0,0
Xsg13cmos5l_decap_8_1005 VPWR VGND sg13cmos5l_decap_8
* cell instance sg13cmos5l_decap_8_1006 r0 *1 0,0
Xsg13cmos5l_decap_8_1006 VPWR VGND sg13cmos5l_decap_8
* cell instance sg13cmos5l_decap_8_1007 r0 *1 0,0
Xsg13cmos5l_decap_8_1007 VPWR VGND sg13cmos5l_decap_8
* cell instance sg13cmos5l_decap_8_1008 r0 *1 0,0
Xsg13cmos5l_decap_8_1008 VPWR VGND sg13cmos5l_decap_8
* cell instance sg13cmos5l_decap_8_1009 r0 *1 0,0
Xsg13cmos5l_decap_8_1009 VPWR VGND sg13cmos5l_decap_8
* cell instance sg13cmos5l_decap_8_1010 r0 *1 0,0
Xsg13cmos5l_decap_8_1010 VPWR VGND sg13cmos5l_decap_8
* cell instance sg13cmos5l_decap_8_1011 r0 *1 0,0
Xsg13cmos5l_decap_8_1011 VPWR VGND sg13cmos5l_decap_8
* cell instance sg13cmos5l_decap_8_1012 r0 *1 0,0
Xsg13cmos5l_decap_8_1012 VPWR VGND sg13cmos5l_decap_8
* cell instance sg13cmos5l_decap_8_1013 r0 *1 0,0
Xsg13cmos5l_decap_8_1013 VPWR VGND sg13cmos5l_decap_8
* cell instance sg13cmos5l_decap_8_1014 r0 *1 0,0
Xsg13cmos5l_decap_8_1014 VPWR VGND sg13cmos5l_decap_8
* cell instance sg13cmos5l_decap_8_1015 r0 *1 0,0
Xsg13cmos5l_decap_8_1015 VPWR VGND sg13cmos5l_decap_8
* cell instance sg13cmos5l_decap_8_1016 r0 *1 0,0
Xsg13cmos5l_decap_8_1016 VPWR VGND sg13cmos5l_decap_8
* cell instance sg13cmos5l_decap_8_1017 r0 *1 0,0
Xsg13cmos5l_decap_8_1017 VPWR VGND sg13cmos5l_decap_8
* cell instance sg13cmos5l_decap_8_1018 r0 *1 0,0
Xsg13cmos5l_decap_8_1018 VPWR VGND sg13cmos5l_decap_8
* cell instance sg13cmos5l_decap_8_1019 r0 *1 0,0
Xsg13cmos5l_decap_8_1019 VPWR VGND sg13cmos5l_decap_8
* cell instance sg13cmos5l_decap_8_1020 r0 *1 0,0
Xsg13cmos5l_decap_8_1020 VPWR VGND sg13cmos5l_decap_8
* cell instance sg13cmos5l_decap_8_1021 r0 *1 0,0
Xsg13cmos5l_decap_8_1021 VPWR VGND sg13cmos5l_decap_8
* cell instance sg13cmos5l_decap_8_1022 r0 *1 0,0
Xsg13cmos5l_decap_8_1022 VPWR VGND sg13cmos5l_decap_8
* cell instance sg13cmos5l_decap_8_1023 r0 *1 0,0
Xsg13cmos5l_decap_8_1023 VPWR VGND sg13cmos5l_decap_8
* cell instance sg13cmos5l_decap_8_1024 r0 *1 0,0
Xsg13cmos5l_decap_8_1024 VPWR VGND sg13cmos5l_decap_8
* cell instance sg13cmos5l_decap_8_1025 r0 *1 0,0
Xsg13cmos5l_decap_8_1025 VPWR VGND sg13cmos5l_decap_8
* cell instance sg13cmos5l_decap_8_1026 r0 *1 0,0
Xsg13cmos5l_decap_8_1026 VPWR VGND sg13cmos5l_decap_8
* cell instance sg13cmos5l_decap_8_1027 r0 *1 0,0
Xsg13cmos5l_decap_8_1027 VPWR VGND sg13cmos5l_decap_8
* cell instance sg13cmos5l_decap_8_1028 r0 *1 0,0
Xsg13cmos5l_decap_8_1028 VPWR VGND sg13cmos5l_decap_8
* cell instance sg13cmos5l_decap_8_1029 r0 *1 0,0
Xsg13cmos5l_decap_8_1029 VPWR VGND sg13cmos5l_decap_8
* cell instance sg13cmos5l_decap_8_1030 r0 *1 0,0
Xsg13cmos5l_decap_8_1030 VPWR VGND sg13cmos5l_decap_8
* cell instance sg13cmos5l_decap_8_1031 r0 *1 0,0
Xsg13cmos5l_decap_8_1031 VPWR VGND sg13cmos5l_decap_8
* cell instance sg13cmos5l_decap_8_1032 r0 *1 0,0
Xsg13cmos5l_decap_8_1032 VPWR VGND sg13cmos5l_decap_8
* cell instance sg13cmos5l_decap_8_1033 r0 *1 0,0
Xsg13cmos5l_decap_8_1033 VPWR VGND sg13cmos5l_decap_8
* cell instance sg13cmos5l_decap_8_1034 r0 *1 0,0
Xsg13cmos5l_decap_8_1034 VPWR VGND sg13cmos5l_decap_8
* cell instance sg13cmos5l_decap_8_1035 r0 *1 0,0
Xsg13cmos5l_decap_8_1035 VPWR VGND sg13cmos5l_decap_8
* cell instance sg13cmos5l_decap_8_1036 r0 *1 0,0
Xsg13cmos5l_decap_8_1036 VPWR VGND sg13cmos5l_decap_8
* cell instance sg13cmos5l_decap_8_1037 r0 *1 0,0
Xsg13cmos5l_decap_8_1037 VPWR VGND sg13cmos5l_decap_8
* cell instance sg13cmos5l_decap_8_1038 r0 *1 0,0
Xsg13cmos5l_decap_8_1038 VPWR VGND sg13cmos5l_decap_8
* cell instance sg13cmos5l_decap_8_1039 r0 *1 0,0
Xsg13cmos5l_decap_8_1039 VPWR VGND sg13cmos5l_decap_8
* cell instance sg13cmos5l_decap_8_1040 r0 *1 0,0
Xsg13cmos5l_decap_8_1040 VPWR VGND sg13cmos5l_decap_8
* cell instance sg13cmos5l_decap_8_1041 r0 *1 0,0
Xsg13cmos5l_decap_8_1041 VPWR VGND sg13cmos5l_decap_8
* cell instance sg13cmos5l_decap_8_1042 r0 *1 0,0
Xsg13cmos5l_decap_8_1042 VPWR VGND sg13cmos5l_decap_8
* cell instance sg13cmos5l_decap_8_1043 r0 *1 0,0
Xsg13cmos5l_decap_8_1043 VPWR VGND sg13cmos5l_decap_8
* cell instance sg13cmos5l_decap_8_1044 r0 *1 0,0
Xsg13cmos5l_decap_8_1044 VPWR VGND sg13cmos5l_decap_8
* cell instance sg13cmos5l_decap_8_1045 r0 *1 0,0
Xsg13cmos5l_decap_8_1045 VPWR VGND sg13cmos5l_decap_8
* cell instance sg13cmos5l_decap_8_1046 r0 *1 0,0
Xsg13cmos5l_decap_8_1046 VPWR VGND sg13cmos5l_decap_8
* cell instance sg13cmos5l_decap_8_1047 r0 *1 0,0
Xsg13cmos5l_decap_8_1047 VPWR VGND sg13cmos5l_decap_8
* cell instance sg13cmos5l_decap_8_1048 r0 *1 0,0
Xsg13cmos5l_decap_8_1048 VPWR VGND sg13cmos5l_decap_8
* cell instance sg13cmos5l_decap_8_1049 r0 *1 0,0
Xsg13cmos5l_decap_8_1049 VPWR VGND sg13cmos5l_decap_8
* cell instance sg13cmos5l_decap_8_1050 r0 *1 0,0
Xsg13cmos5l_decap_8_1050 VPWR VGND sg13cmos5l_decap_8
* cell instance sg13cmos5l_decap_8_1051 r0 *1 0,0
Xsg13cmos5l_decap_8_1051 VPWR VGND sg13cmos5l_decap_8
* cell instance sg13cmos5l_decap_8_1052 r0 *1 0,0
Xsg13cmos5l_decap_8_1052 VPWR VGND sg13cmos5l_decap_8
* cell instance sg13cmos5l_decap_8_1053 r0 *1 0,0
Xsg13cmos5l_decap_8_1053 VPWR VGND sg13cmos5l_decap_8
* cell instance sg13cmos5l_decap_8_1054 r0 *1 0,0
Xsg13cmos5l_decap_8_1054 VPWR VGND sg13cmos5l_decap_8
* cell instance sg13cmos5l_decap_8_1055 r0 *1 0,0
Xsg13cmos5l_decap_8_1055 VPWR VGND sg13cmos5l_decap_8
* cell instance sg13cmos5l_decap_8_1056 r0 *1 0,0
Xsg13cmos5l_decap_8_1056 VPWR VGND sg13cmos5l_decap_8
* cell instance sg13cmos5l_decap_8_1057 r0 *1 0,0
Xsg13cmos5l_decap_8_1057 VPWR VGND sg13cmos5l_decap_8
* cell instance sg13cmos5l_decap_8_1058 r0 *1 0,0
Xsg13cmos5l_decap_8_1058 VPWR VGND sg13cmos5l_decap_8
* cell instance sg13cmos5l_decap_8_1059 r0 *1 0,0
Xsg13cmos5l_decap_8_1059 VPWR VGND sg13cmos5l_decap_8
* cell instance sg13cmos5l_decap_8_1060 r0 *1 0,0
Xsg13cmos5l_decap_8_1060 VPWR VGND sg13cmos5l_decap_8
* cell instance sg13cmos5l_decap_8_1061 r0 *1 0,0
Xsg13cmos5l_decap_8_1061 VPWR VGND sg13cmos5l_decap_8
* cell instance sg13cmos5l_decap_8_1062 r0 *1 0,0
Xsg13cmos5l_decap_8_1062 VPWR VGND sg13cmos5l_decap_8
* cell instance sg13cmos5l_decap_8_1063 r0 *1 0,0
Xsg13cmos5l_decap_8_1063 VPWR VGND sg13cmos5l_decap_8
* cell instance sg13cmos5l_decap_8_1064 r0 *1 0,0
Xsg13cmos5l_decap_8_1064 VPWR VGND sg13cmos5l_decap_8
* cell instance sg13cmos5l_decap_8_1065 r0 *1 0,0
Xsg13cmos5l_decap_8_1065 VPWR VGND sg13cmos5l_decap_8
* cell instance sg13cmos5l_decap_8_1066 r0 *1 0,0
Xsg13cmos5l_decap_8_1066 VPWR VGND sg13cmos5l_decap_8
* cell instance sg13cmos5l_decap_8_1067 r0 *1 0,0
Xsg13cmos5l_decap_8_1067 VPWR VGND sg13cmos5l_decap_8
* cell instance sg13cmos5l_decap_8_1068 r0 *1 0,0
Xsg13cmos5l_decap_8_1068 VPWR VGND sg13cmos5l_decap_8
* cell instance sg13cmos5l_decap_8_1069 r0 *1 0,0
Xsg13cmos5l_decap_8_1069 VPWR VGND sg13cmos5l_decap_8
* cell instance sg13cmos5l_decap_8_1070 r0 *1 0,0
Xsg13cmos5l_decap_8_1070 VPWR VGND sg13cmos5l_decap_8
* cell instance sg13cmos5l_decap_8_1071 r0 *1 0,0
Xsg13cmos5l_decap_8_1071 VPWR VGND sg13cmos5l_decap_8
* cell instance sg13cmos5l_decap_8_1072 r0 *1 0,0
Xsg13cmos5l_decap_8_1072 VPWR VGND sg13cmos5l_decap_8
* cell instance sg13cmos5l_decap_8_1073 r0 *1 0,0
Xsg13cmos5l_decap_8_1073 VPWR VGND sg13cmos5l_decap_8
* cell instance sg13cmos5l_decap_8_1074 r0 *1 0,0
Xsg13cmos5l_decap_8_1074 VPWR VGND sg13cmos5l_decap_8
* cell instance sg13cmos5l_decap_8_1075 r0 *1 0,0
Xsg13cmos5l_decap_8_1075 VPWR VGND sg13cmos5l_decap_8
* cell instance sg13cmos5l_decap_8_1076 r0 *1 0,0
Xsg13cmos5l_decap_8_1076 VPWR VGND sg13cmos5l_decap_8
* cell instance sg13cmos5l_decap_8_1077 r0 *1 0,0
Xsg13cmos5l_decap_8_1077 VPWR VGND sg13cmos5l_decap_8
* cell instance sg13cmos5l_decap_8_1078 r0 *1 0,0
Xsg13cmos5l_decap_8_1078 VPWR VGND sg13cmos5l_decap_8
* cell instance sg13cmos5l_decap_8_1079 r0 *1 0,0
Xsg13cmos5l_decap_8_1079 VPWR VGND sg13cmos5l_decap_8
* cell instance sg13cmos5l_decap_8_1080 r0 *1 0,0
Xsg13cmos5l_decap_8_1080 VPWR VGND sg13cmos5l_decap_8
* cell instance sg13cmos5l_decap_8_1081 r0 *1 0,0
Xsg13cmos5l_decap_8_1081 VPWR VGND sg13cmos5l_decap_8
* cell instance sg13cmos5l_decap_8_1082 r0 *1 0,0
Xsg13cmos5l_decap_8_1082 VPWR VGND sg13cmos5l_decap_8
* cell instance sg13cmos5l_decap_8_1083 r0 *1 0,0
Xsg13cmos5l_decap_8_1083 VPWR VGND sg13cmos5l_decap_8
* cell instance sg13cmos5l_decap_8_1084 r0 *1 0,0
Xsg13cmos5l_decap_8_1084 VPWR VGND sg13cmos5l_decap_8
* cell instance sg13cmos5l_decap_8_1085 r0 *1 0,0
Xsg13cmos5l_decap_8_1085 VPWR VGND sg13cmos5l_decap_8
* cell instance sg13cmos5l_decap_8_1086 r0 *1 0,0
Xsg13cmos5l_decap_8_1086 VPWR VGND sg13cmos5l_decap_8
* cell instance sg13cmos5l_decap_8_1087 r0 *1 0,0
Xsg13cmos5l_decap_8_1087 VPWR VGND sg13cmos5l_decap_8
* cell instance sg13cmos5l_decap_8_1088 r0 *1 0,0
Xsg13cmos5l_decap_8_1088 VPWR VGND sg13cmos5l_decap_8
* cell instance sg13cmos5l_decap_8_1089 r0 *1 0,0
Xsg13cmos5l_decap_8_1089 VPWR VGND sg13cmos5l_decap_8
* cell instance sg13cmos5l_decap_8_1090 r0 *1 0,0
Xsg13cmos5l_decap_8_1090 VPWR VGND sg13cmos5l_decap_8
* cell instance sg13cmos5l_decap_8_1091 r0 *1 0,0
Xsg13cmos5l_decap_8_1091 VPWR VGND sg13cmos5l_decap_8
* cell instance sg13cmos5l_decap_8_1092 r0 *1 0,0
Xsg13cmos5l_decap_8_1092 VPWR VGND sg13cmos5l_decap_8
* cell instance sg13cmos5l_decap_8_1093 r0 *1 0,0
Xsg13cmos5l_decap_8_1093 VPWR VGND sg13cmos5l_decap_8
* cell instance sg13cmos5l_decap_8_1094 r0 *1 0,0
Xsg13cmos5l_decap_8_1094 VPWR VGND sg13cmos5l_decap_8
* cell instance sg13cmos5l_decap_8_1095 r0 *1 0,0
Xsg13cmos5l_decap_8_1095 VPWR VGND sg13cmos5l_decap_8
* cell instance sg13cmos5l_decap_8_1096 r0 *1 0,0
Xsg13cmos5l_decap_8_1096 VPWR VGND sg13cmos5l_decap_8
* cell instance sg13cmos5l_decap_8_1097 r0 *1 0,0
Xsg13cmos5l_decap_8_1097 VPWR VGND sg13cmos5l_decap_8
* cell instance sg13cmos5l_decap_8_1098 r0 *1 0,0
Xsg13cmos5l_decap_8_1098 VPWR VGND sg13cmos5l_decap_8
* cell instance sg13cmos5l_decap_8_1099 r0 *1 0,0
Xsg13cmos5l_decap_8_1099 VPWR VGND sg13cmos5l_decap_8
* cell instance sg13cmos5l_decap_8_1100 r0 *1 0,0
Xsg13cmos5l_decap_8_1100 VPWR VGND sg13cmos5l_decap_8
* cell instance sg13cmos5l_decap_8_1101 r0 *1 0,0
Xsg13cmos5l_decap_8_1101 VPWR VGND sg13cmos5l_decap_8
* cell instance sg13cmos5l_decap_8_1102 r0 *1 0,0
Xsg13cmos5l_decap_8_1102 VPWR VGND sg13cmos5l_decap_8
* cell instance sg13cmos5l_decap_8_1103 r0 *1 0,0
Xsg13cmos5l_decap_8_1103 VPWR VGND sg13cmos5l_decap_8
* cell instance sg13cmos5l_decap_8_1104 r0 *1 0,0
Xsg13cmos5l_decap_8_1104 VPWR VGND sg13cmos5l_decap_8
* cell instance sg13cmos5l_decap_8_1105 r0 *1 0,0
Xsg13cmos5l_decap_8_1105 VPWR VGND sg13cmos5l_decap_8
* cell instance sg13cmos5l_decap_8_1106 r0 *1 0,0
Xsg13cmos5l_decap_8_1106 VPWR VGND sg13cmos5l_decap_8
* cell instance sg13cmos5l_decap_8_1107 r0 *1 0,0
Xsg13cmos5l_decap_8_1107 VPWR VGND sg13cmos5l_decap_8
* cell instance sg13cmos5l_decap_8_1108 r0 *1 0,0
Xsg13cmos5l_decap_8_1108 VPWR VGND sg13cmos5l_decap_8
* cell instance sg13cmos5l_decap_8_1109 r0 *1 0,0
Xsg13cmos5l_decap_8_1109 VPWR VGND sg13cmos5l_decap_8
* cell instance sg13cmos5l_decap_8_1110 r0 *1 0,0
Xsg13cmos5l_decap_8_1110 VPWR VGND sg13cmos5l_decap_8
* cell instance sg13cmos5l_decap_8_1111 r0 *1 0,0
Xsg13cmos5l_decap_8_1111 VPWR VGND sg13cmos5l_decap_8
* cell instance sg13cmos5l_decap_8_1112 r0 *1 0,0
Xsg13cmos5l_decap_8_1112 VPWR VGND sg13cmos5l_decap_8
* cell instance sg13cmos5l_decap_8_1113 r0 *1 0,0
Xsg13cmos5l_decap_8_1113 VPWR VGND sg13cmos5l_decap_8
* cell instance sg13cmos5l_decap_8_1114 r0 *1 0,0
Xsg13cmos5l_decap_8_1114 VPWR VGND sg13cmos5l_decap_8
* cell instance sg13cmos5l_decap_8_1115 r0 *1 0,0
Xsg13cmos5l_decap_8_1115 VPWR VGND sg13cmos5l_decap_8
* cell instance sg13cmos5l_decap_8_1116 r0 *1 0,0
Xsg13cmos5l_decap_8_1116 VPWR VGND sg13cmos5l_decap_8
* cell instance sg13cmos5l_decap_8_1117 r0 *1 0,0
Xsg13cmos5l_decap_8_1117 VPWR VGND sg13cmos5l_decap_8
* cell instance sg13cmos5l_decap_8_1118 r0 *1 0,0
Xsg13cmos5l_decap_8_1118 VPWR VGND sg13cmos5l_decap_8
* cell instance sg13cmos5l_decap_8_1119 r0 *1 0,0
Xsg13cmos5l_decap_8_1119 VPWR VGND sg13cmos5l_decap_8
* cell instance sg13cmos5l_decap_8_1120 r0 *1 0,0
Xsg13cmos5l_decap_8_1120 VPWR VGND sg13cmos5l_decap_8
* cell instance sg13cmos5l_decap_8_1121 r0 *1 0,0
Xsg13cmos5l_decap_8_1121 VPWR VGND sg13cmos5l_decap_8
* cell instance sg13cmos5l_decap_8_1122 r0 *1 0,0
Xsg13cmos5l_decap_8_1122 VPWR VGND sg13cmos5l_decap_8
* cell instance sg13cmos5l_decap_8_1123 r0 *1 0,0
Xsg13cmos5l_decap_8_1123 VPWR VGND sg13cmos5l_decap_8
* cell instance sg13cmos5l_decap_8_1124 r0 *1 0,0
Xsg13cmos5l_decap_8_1124 VPWR VGND sg13cmos5l_decap_8
* cell instance sg13cmos5l_decap_8_1125 r0 *1 0,0
Xsg13cmos5l_decap_8_1125 VPWR VGND sg13cmos5l_decap_8
* cell instance sg13cmos5l_decap_8_1126 r0 *1 0,0
Xsg13cmos5l_decap_8_1126 VPWR VGND sg13cmos5l_decap_8
* cell instance sg13cmos5l_decap_8_1127 r0 *1 0,0
Xsg13cmos5l_decap_8_1127 VPWR VGND sg13cmos5l_decap_8
* cell instance sg13cmos5l_decap_8_1128 r0 *1 0,0
Xsg13cmos5l_decap_8_1128 VPWR VGND sg13cmos5l_decap_8
* cell instance sg13cmos5l_decap_8_1129 r0 *1 0,0
Xsg13cmos5l_decap_8_1129 VPWR VGND sg13cmos5l_decap_8
* cell instance sg13cmos5l_decap_8_1130 r0 *1 0,0
Xsg13cmos5l_decap_8_1130 VPWR VGND sg13cmos5l_decap_8
* cell instance sg13cmos5l_decap_8_1131 r0 *1 0,0
Xsg13cmos5l_decap_8_1131 VPWR VGND sg13cmos5l_decap_8
* cell instance sg13cmos5l_decap_8_1132 r0 *1 0,0
Xsg13cmos5l_decap_8_1132 VPWR VGND sg13cmos5l_decap_8
* cell instance sg13cmos5l_decap_8_1133 r0 *1 0,0
Xsg13cmos5l_decap_8_1133 VPWR VGND sg13cmos5l_decap_8
* cell instance sg13cmos5l_decap_8_1134 r0 *1 0,0
Xsg13cmos5l_decap_8_1134 VPWR VGND sg13cmos5l_decap_8
* cell instance sg13cmos5l_decap_8_1135 r0 *1 0,0
Xsg13cmos5l_decap_8_1135 VPWR VGND sg13cmos5l_decap_8
* cell instance sg13cmos5l_decap_8_1136 r0 *1 0,0
Xsg13cmos5l_decap_8_1136 VPWR VGND sg13cmos5l_decap_8
* cell instance sg13cmos5l_decap_8_1137 r0 *1 0,0
Xsg13cmos5l_decap_8_1137 VPWR VGND sg13cmos5l_decap_8
* cell instance sg13cmos5l_decap_8_1138 r0 *1 0,0
Xsg13cmos5l_decap_8_1138 VPWR VGND sg13cmos5l_decap_8
* cell instance sg13cmos5l_decap_8_1139 r0 *1 0,0
Xsg13cmos5l_decap_8_1139 VPWR VGND sg13cmos5l_decap_8
* cell instance sg13cmos5l_decap_8_1140 r0 *1 0,0
Xsg13cmos5l_decap_8_1140 VPWR VGND sg13cmos5l_decap_8
* cell instance sg13cmos5l_decap_8_1141 r0 *1 0,0
Xsg13cmos5l_decap_8_1141 VPWR VGND sg13cmos5l_decap_8
* cell instance sg13cmos5l_decap_8_1142 r0 *1 0,0
Xsg13cmos5l_decap_8_1142 VPWR VGND sg13cmos5l_decap_8
* cell instance sg13cmos5l_decap_8_1143 r0 *1 0,0
Xsg13cmos5l_decap_8_1143 VPWR VGND sg13cmos5l_decap_8
* cell instance sg13cmos5l_decap_8_1144 r0 *1 0,0
Xsg13cmos5l_decap_8_1144 VPWR VGND sg13cmos5l_decap_8
* cell instance sg13cmos5l_decap_8_1145 r0 *1 0,0
Xsg13cmos5l_decap_8_1145 VPWR VGND sg13cmos5l_decap_8
* cell instance sg13cmos5l_decap_8_1146 r0 *1 0,0
Xsg13cmos5l_decap_8_1146 VPWR VGND sg13cmos5l_decap_8
* cell instance sg13cmos5l_decap_8_1147 r0 *1 0,0
Xsg13cmos5l_decap_8_1147 VPWR VGND sg13cmos5l_decap_8
* cell instance sg13cmos5l_decap_8_1148 r0 *1 0,0
Xsg13cmos5l_decap_8_1148 VPWR VGND sg13cmos5l_decap_8
* cell instance sg13cmos5l_decap_8_1149 r0 *1 0,0
Xsg13cmos5l_decap_8_1149 VPWR VGND sg13cmos5l_decap_8
* cell instance sg13cmos5l_decap_8_1150 r0 *1 0,0
Xsg13cmos5l_decap_8_1150 VPWR VGND sg13cmos5l_decap_8
* cell instance sg13cmos5l_decap_8_1151 r0 *1 0,0
Xsg13cmos5l_decap_8_1151 VPWR VGND sg13cmos5l_decap_8
* cell instance sg13cmos5l_decap_8_1152 r0 *1 0,0
Xsg13cmos5l_decap_8_1152 VPWR VGND sg13cmos5l_decap_8
* cell instance sg13cmos5l_decap_8_1153 r0 *1 0,0
Xsg13cmos5l_decap_8_1153 VPWR VGND sg13cmos5l_decap_8
* cell instance sg13cmos5l_decap_8_1154 r0 *1 0,0
Xsg13cmos5l_decap_8_1154 VPWR VGND sg13cmos5l_decap_8
* cell instance sg13cmos5l_decap_8_1155 r0 *1 0,0
Xsg13cmos5l_decap_8_1155 VPWR VGND sg13cmos5l_decap_8
* cell instance sg13cmos5l_decap_8_1156 r0 *1 0,0
Xsg13cmos5l_decap_8_1156 VPWR VGND sg13cmos5l_decap_8
* cell instance sg13cmos5l_decap_8_1157 r0 *1 0,0
Xsg13cmos5l_decap_8_1157 VPWR VGND sg13cmos5l_decap_8
* cell instance sg13cmos5l_decap_8_1158 r0 *1 0,0
Xsg13cmos5l_decap_8_1158 VPWR VGND sg13cmos5l_decap_8
* cell instance sg13cmos5l_decap_8_1159 r0 *1 0,0
Xsg13cmos5l_decap_8_1159 VPWR VGND sg13cmos5l_decap_8
* cell instance sg13cmos5l_decap_8_1160 r0 *1 0,0
Xsg13cmos5l_decap_8_1160 VPWR VGND sg13cmos5l_decap_8
* cell instance sg13cmos5l_decap_8_1161 r0 *1 0,0
Xsg13cmos5l_decap_8_1161 VPWR VGND sg13cmos5l_decap_8
* cell instance sg13cmos5l_decap_8_1162 r0 *1 0,0
Xsg13cmos5l_decap_8_1162 VPWR VGND sg13cmos5l_decap_8
* cell instance sg13cmos5l_decap_8_1163 r0 *1 0,0
Xsg13cmos5l_decap_8_1163 VPWR VGND sg13cmos5l_decap_8
* cell instance sg13cmos5l_decap_8_1164 r0 *1 0,0
Xsg13cmos5l_decap_8_1164 VPWR VGND sg13cmos5l_decap_8
* cell instance sg13cmos5l_decap_8_1165 r0 *1 0,0
Xsg13cmos5l_decap_8_1165 VPWR VGND sg13cmos5l_decap_8
* cell instance sg13cmos5l_decap_8_1166 r0 *1 0,0
Xsg13cmos5l_decap_8_1166 VPWR VGND sg13cmos5l_decap_8
* cell instance sg13cmos5l_decap_8_1167 r0 *1 0,0
Xsg13cmos5l_decap_8_1167 VPWR VGND sg13cmos5l_decap_8
* cell instance sg13cmos5l_decap_8_1168 r0 *1 0,0
Xsg13cmos5l_decap_8_1168 VPWR VGND sg13cmos5l_decap_8
* cell instance sg13cmos5l_decap_8_1169 r0 *1 0,0
Xsg13cmos5l_decap_8_1169 VPWR VGND sg13cmos5l_decap_8
* cell instance sg13cmos5l_decap_8_1170 r0 *1 0,0
Xsg13cmos5l_decap_8_1170 VPWR VGND sg13cmos5l_decap_8
* cell instance sg13cmos5l_decap_8_1171 r0 *1 0,0
Xsg13cmos5l_decap_8_1171 VPWR VGND sg13cmos5l_decap_8
* cell instance sg13cmos5l_decap_8_1172 r0 *1 0,0
Xsg13cmos5l_decap_8_1172 VPWR VGND sg13cmos5l_decap_8
* cell instance sg13cmos5l_decap_8_1173 r0 *1 0,0
Xsg13cmos5l_decap_8_1173 VPWR VGND sg13cmos5l_decap_8
* cell instance sg13cmos5l_decap_8_1174 r0 *1 0,0
Xsg13cmos5l_decap_8_1174 VPWR VGND sg13cmos5l_decap_8
* cell instance sg13cmos5l_decap_8_1175 r0 *1 0,0
Xsg13cmos5l_decap_8_1175 VPWR VGND sg13cmos5l_decap_8
* cell instance sg13cmos5l_decap_8_1176 r0 *1 0,0
Xsg13cmos5l_decap_8_1176 VPWR VGND sg13cmos5l_decap_8
* cell instance sg13cmos5l_decap_8_1177 r0 *1 0,0
Xsg13cmos5l_decap_8_1177 VPWR VGND sg13cmos5l_decap_8
* cell instance sg13cmos5l_decap_8_1178 r0 *1 0,0
Xsg13cmos5l_decap_8_1178 VPWR VGND sg13cmos5l_decap_8
* cell instance sg13cmos5l_decap_8_1179 r0 *1 0,0
Xsg13cmos5l_decap_8_1179 VPWR VGND sg13cmos5l_decap_8
* cell instance sg13cmos5l_decap_8_1180 r0 *1 0,0
Xsg13cmos5l_decap_8_1180 VPWR VGND sg13cmos5l_decap_8
* cell instance sg13cmos5l_decap_8_1181 r0 *1 0,0
Xsg13cmos5l_decap_8_1181 VPWR VGND sg13cmos5l_decap_8
* cell instance sg13cmos5l_decap_8_1182 r0 *1 0,0
Xsg13cmos5l_decap_8_1182 VPWR VGND sg13cmos5l_decap_8
* cell instance sg13cmos5l_decap_8_1183 r0 *1 0,0
Xsg13cmos5l_decap_8_1183 VPWR VGND sg13cmos5l_decap_8
* cell instance sg13cmos5l_decap_8_1184 r0 *1 0,0
Xsg13cmos5l_decap_8_1184 VPWR VGND sg13cmos5l_decap_8
* cell instance sg13cmos5l_decap_8_1185 r0 *1 0,0
Xsg13cmos5l_decap_8_1185 VPWR VGND sg13cmos5l_decap_8
* cell instance sg13cmos5l_decap_8_1186 r0 *1 0,0
Xsg13cmos5l_decap_8_1186 VPWR VGND sg13cmos5l_decap_8
* cell instance sg13cmos5l_decap_8_1187 r0 *1 0,0
Xsg13cmos5l_decap_8_1187 VPWR VGND sg13cmos5l_decap_8
* cell instance sg13cmos5l_decap_8_1188 r0 *1 0,0
Xsg13cmos5l_decap_8_1188 VPWR VGND sg13cmos5l_decap_8
* cell instance sg13cmos5l_decap_8_1189 r0 *1 0,0
Xsg13cmos5l_decap_8_1189 VPWR VGND sg13cmos5l_decap_8
* cell instance sg13cmos5l_decap_8_1190 r0 *1 0,0
Xsg13cmos5l_decap_8_1190 VPWR VGND sg13cmos5l_decap_8
* cell instance sg13cmos5l_decap_8_1191 r0 *1 0,0
Xsg13cmos5l_decap_8_1191 VPWR VGND sg13cmos5l_decap_8
* cell instance sg13cmos5l_decap_8_1192 r0 *1 0,0
Xsg13cmos5l_decap_8_1192 VPWR VGND sg13cmos5l_decap_8
* cell instance sg13cmos5l_decap_8_1193 r0 *1 0,0
Xsg13cmos5l_decap_8_1193 VPWR VGND sg13cmos5l_decap_8
* cell instance sg13cmos5l_decap_8_1194 r0 *1 0,0
Xsg13cmos5l_decap_8_1194 VPWR VGND sg13cmos5l_decap_8
* cell instance sg13cmos5l_decap_8_1195 r0 *1 0,0
Xsg13cmos5l_decap_8_1195 VPWR VGND sg13cmos5l_decap_8
* cell instance sg13cmos5l_decap_8_1196 r0 *1 0,0
Xsg13cmos5l_decap_8_1196 VPWR VGND sg13cmos5l_decap_8
* cell instance sg13cmos5l_decap_8_1197 r0 *1 0,0
Xsg13cmos5l_decap_8_1197 VPWR VGND sg13cmos5l_decap_8
* cell instance sg13cmos5l_decap_8_1198 r0 *1 0,0
Xsg13cmos5l_decap_8_1198 VPWR VGND sg13cmos5l_decap_8
* cell instance sg13cmos5l_decap_8_1199 r0 *1 0,0
Xsg13cmos5l_decap_8_1199 VPWR VGND sg13cmos5l_decap_8
* cell instance sg13cmos5l_decap_8_1200 r0 *1 0,0
Xsg13cmos5l_decap_8_1200 VPWR VGND sg13cmos5l_decap_8
* cell instance sg13cmos5l_decap_8_1201 r0 *1 0,0
Xsg13cmos5l_decap_8_1201 VPWR VGND sg13cmos5l_decap_8
* cell instance sg13cmos5l_decap_8_1202 r0 *1 0,0
Xsg13cmos5l_decap_8_1202 VPWR VGND sg13cmos5l_decap_8
* cell instance sg13cmos5l_decap_8_1203 r0 *1 0,0
Xsg13cmos5l_decap_8_1203 VPWR VGND sg13cmos5l_decap_8
* cell instance sg13cmos5l_decap_8_1204 r0 *1 0,0
Xsg13cmos5l_decap_8_1204 VPWR VGND sg13cmos5l_decap_8
* cell instance sg13cmos5l_decap_8_1205 r0 *1 0,0
Xsg13cmos5l_decap_8_1205 VPWR VGND sg13cmos5l_decap_8
* cell instance sg13cmos5l_decap_8_1206 r0 *1 0,0
Xsg13cmos5l_decap_8_1206 VPWR VGND sg13cmos5l_decap_8
* cell instance sg13cmos5l_decap_8_1207 r0 *1 0,0
Xsg13cmos5l_decap_8_1207 VPWR VGND sg13cmos5l_decap_8
* cell instance sg13cmos5l_decap_8_1208 r0 *1 0,0
Xsg13cmos5l_decap_8_1208 VPWR VGND sg13cmos5l_decap_8
* cell instance sg13cmos5l_decap_8_1209 r0 *1 0,0
Xsg13cmos5l_decap_8_1209 VPWR VGND sg13cmos5l_decap_8
* cell instance sg13cmos5l_decap_8_1210 r0 *1 0,0
Xsg13cmos5l_decap_8_1210 VPWR VGND sg13cmos5l_decap_8
* cell instance sg13cmos5l_decap_8_1211 r0 *1 0,0
Xsg13cmos5l_decap_8_1211 VPWR VGND sg13cmos5l_decap_8
* cell instance sg13cmos5l_decap_8_1212 r0 *1 0,0
Xsg13cmos5l_decap_8_1212 VPWR VGND sg13cmos5l_decap_8
* cell instance sg13cmos5l_decap_8_1213 r0 *1 0,0
Xsg13cmos5l_decap_8_1213 VPWR VGND sg13cmos5l_decap_8
* cell instance sg13cmos5l_decap_8_1214 r0 *1 0,0
Xsg13cmos5l_decap_8_1214 VPWR VGND sg13cmos5l_decap_8
* cell instance sg13cmos5l_decap_8_1215 r0 *1 0,0
Xsg13cmos5l_decap_8_1215 VPWR VGND sg13cmos5l_decap_8
* cell instance sg13cmos5l_decap_8_1216 r0 *1 0,0
Xsg13cmos5l_decap_8_1216 VPWR VGND sg13cmos5l_decap_8
* cell instance sg13cmos5l_decap_8_1217 r0 *1 0,0
Xsg13cmos5l_decap_8_1217 VPWR VGND sg13cmos5l_decap_8
* cell instance sg13cmos5l_decap_8_1218 r0 *1 0,0
Xsg13cmos5l_decap_8_1218 VPWR VGND sg13cmos5l_decap_8
* cell instance sg13cmos5l_decap_8_1219 r0 *1 0,0
Xsg13cmos5l_decap_8_1219 VPWR VGND sg13cmos5l_decap_8
* cell instance sg13cmos5l_decap_8_1220 r0 *1 0,0
Xsg13cmos5l_decap_8_1220 VPWR VGND sg13cmos5l_decap_8
* cell instance sg13cmos5l_decap_8_1221 r0 *1 0,0
Xsg13cmos5l_decap_8_1221 VPWR VGND sg13cmos5l_decap_8
* cell instance sg13cmos5l_decap_8_1222 r0 *1 0,0
Xsg13cmos5l_decap_8_1222 VPWR VGND sg13cmos5l_decap_8
* cell instance sg13cmos5l_decap_8_1223 r0 *1 0,0
Xsg13cmos5l_decap_8_1223 VPWR VGND sg13cmos5l_decap_8
* cell instance sg13cmos5l_decap_8_1224 r0 *1 0,0
Xsg13cmos5l_decap_8_1224 VPWR VGND sg13cmos5l_decap_8
* cell instance sg13cmos5l_decap_8_1225 r0 *1 0,0
Xsg13cmos5l_decap_8_1225 VPWR VGND sg13cmos5l_decap_8
* cell instance sg13cmos5l_decap_8_1226 r0 *1 0,0
Xsg13cmos5l_decap_8_1226 VPWR VGND sg13cmos5l_decap_8
* cell instance sg13cmos5l_decap_8_1227 r0 *1 0,0
Xsg13cmos5l_decap_8_1227 VPWR VGND sg13cmos5l_decap_8
* cell instance sg13cmos5l_decap_8_1228 r0 *1 0,0
Xsg13cmos5l_decap_8_1228 VPWR VGND sg13cmos5l_decap_8
* cell instance sg13cmos5l_decap_8_1229 r0 *1 0,0
Xsg13cmos5l_decap_8_1229 VPWR VGND sg13cmos5l_decap_8
* cell instance sg13cmos5l_decap_8_1230 r0 *1 0,0
Xsg13cmos5l_decap_8_1230 VPWR VGND sg13cmos5l_decap_8
* cell instance sg13cmos5l_decap_8_1231 r0 *1 0,0
Xsg13cmos5l_decap_8_1231 VPWR VGND sg13cmos5l_decap_8
* cell instance sg13cmos5l_decap_8_1232 r0 *1 0,0
Xsg13cmos5l_decap_8_1232 VPWR VGND sg13cmos5l_decap_8
* cell instance sg13cmos5l_decap_8_1233 r0 *1 0,0
Xsg13cmos5l_decap_8_1233 VPWR VGND sg13cmos5l_decap_8
* cell instance sg13cmos5l_decap_8_1234 r0 *1 0,0
Xsg13cmos5l_decap_8_1234 VPWR VGND sg13cmos5l_decap_8
* cell instance sg13cmos5l_decap_8_1235 r0 *1 0,0
Xsg13cmos5l_decap_8_1235 VPWR VGND sg13cmos5l_decap_8
* cell instance sg13cmos5l_decap_8_1236 r0 *1 0,0
Xsg13cmos5l_decap_8_1236 VPWR VGND sg13cmos5l_decap_8
* cell instance sg13cmos5l_decap_8_1237 r0 *1 0,0
Xsg13cmos5l_decap_8_1237 VPWR VGND sg13cmos5l_decap_8
* cell instance sg13cmos5l_decap_8_1238 r0 *1 0,0
Xsg13cmos5l_decap_8_1238 VPWR VGND sg13cmos5l_decap_8
* cell instance sg13cmos5l_decap_8_1239 r0 *1 0,0
Xsg13cmos5l_decap_8_1239 VPWR VGND sg13cmos5l_decap_8
* cell instance sg13cmos5l_decap_8_1240 r0 *1 0,0
Xsg13cmos5l_decap_8_1240 VPWR VGND sg13cmos5l_decap_8
* cell instance sg13cmos5l_decap_8_1241 r0 *1 0,0
Xsg13cmos5l_decap_8_1241 VPWR VGND sg13cmos5l_decap_8
* cell instance sg13cmos5l_decap_8_1242 r0 *1 0,0
Xsg13cmos5l_decap_8_1242 VPWR VGND sg13cmos5l_decap_8
* cell instance sg13cmos5l_decap_8_1243 r0 *1 0,0
Xsg13cmos5l_decap_8_1243 VPWR VGND sg13cmos5l_decap_8
* cell instance sg13cmos5l_decap_8_1244 r0 *1 0,0
Xsg13cmos5l_decap_8_1244 VPWR VGND sg13cmos5l_decap_8
* cell instance sg13cmos5l_decap_8_1245 r0 *1 0,0
Xsg13cmos5l_decap_8_1245 VPWR VGND sg13cmos5l_decap_8
* cell instance sg13cmos5l_decap_8_1246 r0 *1 0,0
Xsg13cmos5l_decap_8_1246 VPWR VGND sg13cmos5l_decap_8
* cell instance sg13cmos5l_decap_8_1247 r0 *1 0,0
Xsg13cmos5l_decap_8_1247 VPWR VGND sg13cmos5l_decap_8
* cell instance sg13cmos5l_decap_8_1248 r0 *1 0,0
Xsg13cmos5l_decap_8_1248 VPWR VGND sg13cmos5l_decap_8
* cell instance sg13cmos5l_decap_8_1249 r0 *1 0,0
Xsg13cmos5l_decap_8_1249 VPWR VGND sg13cmos5l_decap_8
* cell instance sg13cmos5l_decap_8_1250 r0 *1 0,0
Xsg13cmos5l_decap_8_1250 VPWR VGND sg13cmos5l_decap_8
* cell instance sg13cmos5l_decap_8_1251 r0 *1 0,0
Xsg13cmos5l_decap_8_1251 VPWR VGND sg13cmos5l_decap_8
* cell instance sg13cmos5l_decap_8_1252 r0 *1 0,0
Xsg13cmos5l_decap_8_1252 VPWR VGND sg13cmos5l_decap_8
* cell instance sg13cmos5l_decap_8_1253 r0 *1 0,0
Xsg13cmos5l_decap_8_1253 VPWR VGND sg13cmos5l_decap_8
* cell instance sg13cmos5l_decap_8_1254 r0 *1 0,0
Xsg13cmos5l_decap_8_1254 VPWR VGND sg13cmos5l_decap_8
* cell instance sg13cmos5l_decap_8_1255 r0 *1 0,0
Xsg13cmos5l_decap_8_1255 VPWR VGND sg13cmos5l_decap_8
* cell instance sg13cmos5l_decap_8_1256 r0 *1 0,0
Xsg13cmos5l_decap_8_1256 VPWR VGND sg13cmos5l_decap_8
* cell instance sg13cmos5l_decap_8_1257 r0 *1 0,0
Xsg13cmos5l_decap_8_1257 VPWR VGND sg13cmos5l_decap_8
* cell instance sg13cmos5l_decap_8_1258 r0 *1 0,0
Xsg13cmos5l_decap_8_1258 VPWR VGND sg13cmos5l_decap_8
* cell instance sg13cmos5l_decap_8_1259 r0 *1 0,0
Xsg13cmos5l_decap_8_1259 VPWR VGND sg13cmos5l_decap_8
* cell instance sg13cmos5l_decap_8_1260 r0 *1 0,0
Xsg13cmos5l_decap_8_1260 VPWR VGND sg13cmos5l_decap_8
* cell instance sg13cmos5l_decap_8_1261 r0 *1 0,0
Xsg13cmos5l_decap_8_1261 VPWR VGND sg13cmos5l_decap_8
* cell instance sg13cmos5l_decap_8_1262 r0 *1 0,0
Xsg13cmos5l_decap_8_1262 VPWR VGND sg13cmos5l_decap_8
* cell instance sg13cmos5l_decap_8_1263 r0 *1 0,0
Xsg13cmos5l_decap_8_1263 VPWR VGND sg13cmos5l_decap_8
* cell instance sg13cmos5l_decap_8_1264 r0 *1 0,0
Xsg13cmos5l_decap_8_1264 VPWR VGND sg13cmos5l_decap_8
* cell instance sg13cmos5l_decap_8_1265 r0 *1 0,0
Xsg13cmos5l_decap_8_1265 VPWR VGND sg13cmos5l_decap_8
* cell instance sg13cmos5l_decap_8_1266 r0 *1 0,0
Xsg13cmos5l_decap_8_1266 VPWR VGND sg13cmos5l_decap_8
* cell instance sg13cmos5l_decap_8_1267 r0 *1 0,0
Xsg13cmos5l_decap_8_1267 VPWR VGND sg13cmos5l_decap_8
* cell instance sg13cmos5l_decap_8_1268 r0 *1 0,0
Xsg13cmos5l_decap_8_1268 VPWR VGND sg13cmos5l_decap_8
* cell instance sg13cmos5l_decap_8_1269 r0 *1 0,0
Xsg13cmos5l_decap_8_1269 VPWR VGND sg13cmos5l_decap_8
* cell instance sg13cmos5l_decap_8_1270 r0 *1 0,0
Xsg13cmos5l_decap_8_1270 VPWR VGND sg13cmos5l_decap_8
* cell instance sg13cmos5l_decap_8_1271 r0 *1 0,0
Xsg13cmos5l_decap_8_1271 VPWR VGND sg13cmos5l_decap_8
* cell instance sg13cmos5l_decap_8_1272 r0 *1 0,0
Xsg13cmos5l_decap_8_1272 VPWR VGND sg13cmos5l_decap_8
* cell instance sg13cmos5l_decap_8_1273 r0 *1 0,0
Xsg13cmos5l_decap_8_1273 VPWR VGND sg13cmos5l_decap_8
* cell instance sg13cmos5l_decap_8_1274 r0 *1 0,0
Xsg13cmos5l_decap_8_1274 VPWR VGND sg13cmos5l_decap_8
* cell instance sg13cmos5l_decap_8_1275 r0 *1 0,0
Xsg13cmos5l_decap_8_1275 VPWR VGND sg13cmos5l_decap_8
* cell instance sg13cmos5l_decap_8_1276 r0 *1 0,0
Xsg13cmos5l_decap_8_1276 VPWR VGND sg13cmos5l_decap_8
* cell instance sg13cmos5l_decap_8_1277 r0 *1 0,0
Xsg13cmos5l_decap_8_1277 VPWR VGND sg13cmos5l_decap_8
* cell instance sg13cmos5l_decap_8_1278 r0 *1 0,0
Xsg13cmos5l_decap_8_1278 VPWR VGND sg13cmos5l_decap_8
* cell instance sg13cmos5l_decap_8_1279 r0 *1 0,0
Xsg13cmos5l_decap_8_1279 VPWR VGND sg13cmos5l_decap_8
* cell instance sg13cmos5l_decap_8_1280 r0 *1 0,0
Xsg13cmos5l_decap_8_1280 VPWR VGND sg13cmos5l_decap_8
* cell instance sg13cmos5l_decap_8_1281 r0 *1 0,0
Xsg13cmos5l_decap_8_1281 VPWR VGND sg13cmos5l_decap_8
* cell instance sg13cmos5l_decap_8_1282 r0 *1 0,0
Xsg13cmos5l_decap_8_1282 VPWR VGND sg13cmos5l_decap_8
* cell instance sg13cmos5l_decap_8_1283 r0 *1 0,0
Xsg13cmos5l_decap_8_1283 VPWR VGND sg13cmos5l_decap_8
* cell instance sg13cmos5l_decap_8_1284 r0 *1 0,0
Xsg13cmos5l_decap_8_1284 VPWR VGND sg13cmos5l_decap_8
* cell instance sg13cmos5l_decap_8_1285 r0 *1 0,0
Xsg13cmos5l_decap_8_1285 VPWR VGND sg13cmos5l_decap_8
* cell instance sg13cmos5l_decap_8_1286 r0 *1 0,0
Xsg13cmos5l_decap_8_1286 VPWR VGND sg13cmos5l_decap_8
* cell instance sg13cmos5l_decap_8_1287 r0 *1 0,0
Xsg13cmos5l_decap_8_1287 VPWR VGND sg13cmos5l_decap_8
* cell instance sg13cmos5l_decap_8_1288 r0 *1 0,0
Xsg13cmos5l_decap_8_1288 VPWR VGND sg13cmos5l_decap_8
* cell instance sg13cmos5l_decap_8_1289 r0 *1 0,0
Xsg13cmos5l_decap_8_1289 VPWR VGND sg13cmos5l_decap_8
* cell instance sg13cmos5l_decap_8_1290 r0 *1 0,0
Xsg13cmos5l_decap_8_1290 VPWR VGND sg13cmos5l_decap_8
* cell instance sg13cmos5l_decap_8_1291 r0 *1 0,0
Xsg13cmos5l_decap_8_1291 VPWR VGND sg13cmos5l_decap_8
* cell instance sg13cmos5l_decap_8_1292 r0 *1 0,0
Xsg13cmos5l_decap_8_1292 VPWR VGND sg13cmos5l_decap_8
* cell instance sg13cmos5l_decap_8_1293 r0 *1 0,0
Xsg13cmos5l_decap_8_1293 VPWR VGND sg13cmos5l_decap_8
* cell instance sg13cmos5l_decap_8_1294 r0 *1 0,0
Xsg13cmos5l_decap_8_1294 VPWR VGND sg13cmos5l_decap_8
* cell instance sg13cmos5l_decap_8_1295 r0 *1 0,0
Xsg13cmos5l_decap_8_1295 VPWR VGND sg13cmos5l_decap_8
* cell instance sg13cmos5l_decap_8_1296 r0 *1 0,0
Xsg13cmos5l_decap_8_1296 VPWR VGND sg13cmos5l_decap_8
* cell instance sg13cmos5l_decap_8_1297 r0 *1 0,0
Xsg13cmos5l_decap_8_1297 VPWR VGND sg13cmos5l_decap_8
* cell instance sg13cmos5l_decap_8_1298 r0 *1 0,0
Xsg13cmos5l_decap_8_1298 VPWR VGND sg13cmos5l_decap_8
* cell instance sg13cmos5l_decap_8_1299 r0 *1 0,0
Xsg13cmos5l_decap_8_1299 VPWR VGND sg13cmos5l_decap_8
* cell instance sg13cmos5l_decap_8_1300 r0 *1 0,0
Xsg13cmos5l_decap_8_1300 VPWR VGND sg13cmos5l_decap_8
* cell instance sg13cmos5l_decap_8_1301 r0 *1 0,0
Xsg13cmos5l_decap_8_1301 VPWR VGND sg13cmos5l_decap_8
* cell instance sg13cmos5l_decap_8_1302 r0 *1 0,0
Xsg13cmos5l_decap_8_1302 VPWR VGND sg13cmos5l_decap_8
* cell instance sg13cmos5l_decap_8_1303 r0 *1 0,0
Xsg13cmos5l_decap_8_1303 VPWR VGND sg13cmos5l_decap_8
* cell instance sg13cmos5l_decap_8_1304 r0 *1 0,0
Xsg13cmos5l_decap_8_1304 VPWR VGND sg13cmos5l_decap_8
* cell instance sg13cmos5l_decap_8_1305 r0 *1 0,0
Xsg13cmos5l_decap_8_1305 VPWR VGND sg13cmos5l_decap_8
* cell instance sg13cmos5l_decap_8_1306 r0 *1 0,0
Xsg13cmos5l_decap_8_1306 VPWR VGND sg13cmos5l_decap_8
* cell instance sg13cmos5l_decap_8_1307 r0 *1 0,0
Xsg13cmos5l_decap_8_1307 VPWR VGND sg13cmos5l_decap_8
* cell instance sg13cmos5l_decap_8_1308 r0 *1 0,0
Xsg13cmos5l_decap_8_1308 VPWR VGND sg13cmos5l_decap_8
* cell instance sg13cmos5l_decap_8_1309 r0 *1 0,0
Xsg13cmos5l_decap_8_1309 VPWR VGND sg13cmos5l_decap_8
* cell instance sg13cmos5l_decap_8_1310 r0 *1 0,0
Xsg13cmos5l_decap_8_1310 VPWR VGND sg13cmos5l_decap_8
* cell instance sg13cmos5l_decap_8_1311 r0 *1 0,0
Xsg13cmos5l_decap_8_1311 VPWR VGND sg13cmos5l_decap_8
* cell instance sg13cmos5l_decap_8_1312 r0 *1 0,0
Xsg13cmos5l_decap_8_1312 VPWR VGND sg13cmos5l_decap_8
* cell instance sg13cmos5l_decap_8_1313 r0 *1 0,0
Xsg13cmos5l_decap_8_1313 VPWR VGND sg13cmos5l_decap_8
* cell instance sg13cmos5l_decap_8_1314 r0 *1 0,0
Xsg13cmos5l_decap_8_1314 VPWR VGND sg13cmos5l_decap_8
* cell instance sg13cmos5l_decap_8_1315 r0 *1 0,0
Xsg13cmos5l_decap_8_1315 VPWR VGND sg13cmos5l_decap_8
* cell instance sg13cmos5l_decap_8_1316 r0 *1 0,0
Xsg13cmos5l_decap_8_1316 VPWR VGND sg13cmos5l_decap_8
* cell instance sg13cmos5l_decap_8_1317 r0 *1 0,0
Xsg13cmos5l_decap_8_1317 VPWR VGND sg13cmos5l_decap_8
* cell instance sg13cmos5l_decap_8_1318 r0 *1 0,0
Xsg13cmos5l_decap_8_1318 VPWR VGND sg13cmos5l_decap_8
* cell instance sg13cmos5l_decap_8_1319 r0 *1 0,0
Xsg13cmos5l_decap_8_1319 VPWR VGND sg13cmos5l_decap_8
* cell instance sg13cmos5l_decap_8_1320 r0 *1 0,0
Xsg13cmos5l_decap_8_1320 VPWR VGND sg13cmos5l_decap_8
* cell instance sg13cmos5l_decap_8_1321 r0 *1 0,0
Xsg13cmos5l_decap_8_1321 VPWR VGND sg13cmos5l_decap_8
* cell instance sg13cmos5l_decap_8_1322 r0 *1 0,0
Xsg13cmos5l_decap_8_1322 VPWR VGND sg13cmos5l_decap_8
* cell instance sg13cmos5l_decap_8_1323 r0 *1 0,0
Xsg13cmos5l_decap_8_1323 VPWR VGND sg13cmos5l_decap_8
* cell instance sg13cmos5l_decap_8_1324 r0 *1 0,0
Xsg13cmos5l_decap_8_1324 VPWR VGND sg13cmos5l_decap_8
* cell instance sg13cmos5l_decap_8_1325 r0 *1 0,0
Xsg13cmos5l_decap_8_1325 VPWR VGND sg13cmos5l_decap_8
* cell instance sg13cmos5l_decap_8_1326 r0 *1 0,0
Xsg13cmos5l_decap_8_1326 VPWR VGND sg13cmos5l_decap_8
* cell instance sg13cmos5l_decap_8_1327 r0 *1 0,0
Xsg13cmos5l_decap_8_1327 VPWR VGND sg13cmos5l_decap_8
* cell instance sg13cmos5l_decap_8_1328 r0 *1 0,0
Xsg13cmos5l_decap_8_1328 VPWR VGND sg13cmos5l_decap_8
* cell instance sg13cmos5l_decap_8_1329 r0 *1 0,0
Xsg13cmos5l_decap_8_1329 VPWR VGND sg13cmos5l_decap_8
* cell instance sg13cmos5l_decap_8_1330 r0 *1 0,0
Xsg13cmos5l_decap_8_1330 VPWR VGND sg13cmos5l_decap_8
* cell instance sg13cmos5l_decap_8_1331 r0 *1 0,0
Xsg13cmos5l_decap_8_1331 VPWR VGND sg13cmos5l_decap_8
* cell instance sg13cmos5l_decap_8_1332 r0 *1 0,0
Xsg13cmos5l_decap_8_1332 VPWR VGND sg13cmos5l_decap_8
* cell instance sg13cmos5l_decap_8_1333 r0 *1 0,0
Xsg13cmos5l_decap_8_1333 VPWR VGND sg13cmos5l_decap_8
* cell instance sg13cmos5l_decap_8_1334 r0 *1 0,0
Xsg13cmos5l_decap_8_1334 VPWR VGND sg13cmos5l_decap_8
* cell instance sg13cmos5l_decap_8_1335 r0 *1 0,0
Xsg13cmos5l_decap_8_1335 VPWR VGND sg13cmos5l_decap_8
* cell instance sg13cmos5l_decap_8_1336 r0 *1 0,0
Xsg13cmos5l_decap_8_1336 VPWR VGND sg13cmos5l_decap_8
* cell instance sg13cmos5l_decap_8_1337 r0 *1 0,0
Xsg13cmos5l_decap_8_1337 VPWR VGND sg13cmos5l_decap_8
* cell instance sg13cmos5l_decap_8_1338 r0 *1 0,0
Xsg13cmos5l_decap_8_1338 VPWR VGND sg13cmos5l_decap_8
* cell instance sg13cmos5l_decap_8_1339 r0 *1 0,0
Xsg13cmos5l_decap_8_1339 VPWR VGND sg13cmos5l_decap_8
* cell instance sg13cmos5l_decap_8_1340 r0 *1 0,0
Xsg13cmos5l_decap_8_1340 VPWR VGND sg13cmos5l_decap_8
* cell instance sg13cmos5l_decap_8_1341 r0 *1 0,0
Xsg13cmos5l_decap_8_1341 VPWR VGND sg13cmos5l_decap_8
* cell instance sg13cmos5l_decap_8_1342 r0 *1 0,0
Xsg13cmos5l_decap_8_1342 VPWR VGND sg13cmos5l_decap_8
* cell instance sg13cmos5l_decap_8_1343 r0 *1 0,0
Xsg13cmos5l_decap_8_1343 VPWR VGND sg13cmos5l_decap_8
* cell instance sg13cmos5l_decap_8_1344 r0 *1 0,0
Xsg13cmos5l_decap_8_1344 VPWR VGND sg13cmos5l_decap_8
* cell instance sg13cmos5l_decap_8_1345 r0 *1 0,0
Xsg13cmos5l_decap_8_1345 VPWR VGND sg13cmos5l_decap_8
* cell instance sg13cmos5l_decap_8_1346 r0 *1 0,0
Xsg13cmos5l_decap_8_1346 VPWR VGND sg13cmos5l_decap_8
* cell instance sg13cmos5l_decap_8_1347 r0 *1 0,0
Xsg13cmos5l_decap_8_1347 VPWR VGND sg13cmos5l_decap_8
* cell instance sg13cmos5l_decap_8_1348 r0 *1 0,0
Xsg13cmos5l_decap_8_1348 VPWR VGND sg13cmos5l_decap_8
* cell instance sg13cmos5l_decap_8_1349 r0 *1 0,0
Xsg13cmos5l_decap_8_1349 VPWR VGND sg13cmos5l_decap_8
* cell instance sg13cmos5l_decap_8_1350 r0 *1 0,0
Xsg13cmos5l_decap_8_1350 VPWR VGND sg13cmos5l_decap_8
* cell instance sg13cmos5l_decap_8_1351 r0 *1 0,0
Xsg13cmos5l_decap_8_1351 VPWR VGND sg13cmos5l_decap_8
* cell instance sg13cmos5l_decap_8_1352 r0 *1 0,0
Xsg13cmos5l_decap_8_1352 VPWR VGND sg13cmos5l_decap_8
* cell instance sg13cmos5l_decap_8_1353 r0 *1 0,0
Xsg13cmos5l_decap_8_1353 VPWR VGND sg13cmos5l_decap_8
* cell instance sg13cmos5l_decap_8_1354 r0 *1 0,0
Xsg13cmos5l_decap_8_1354 VPWR VGND sg13cmos5l_decap_8
* cell instance sg13cmos5l_decap_8_1355 r0 *1 0,0
Xsg13cmos5l_decap_8_1355 VPWR VGND sg13cmos5l_decap_8
* cell instance sg13cmos5l_decap_8_1356 r0 *1 0,0
Xsg13cmos5l_decap_8_1356 VPWR VGND sg13cmos5l_decap_8
* cell instance sg13cmos5l_decap_8_1357 r0 *1 0,0
Xsg13cmos5l_decap_8_1357 VPWR VGND sg13cmos5l_decap_8
* cell instance sg13cmos5l_decap_8_1358 r0 *1 0,0
Xsg13cmos5l_decap_8_1358 VPWR VGND sg13cmos5l_decap_8
* cell instance sg13cmos5l_decap_8_1359 r0 *1 0,0
Xsg13cmos5l_decap_8_1359 VPWR VGND sg13cmos5l_decap_8
* cell instance sg13cmos5l_decap_8_1360 r0 *1 0,0
Xsg13cmos5l_decap_8_1360 VPWR VGND sg13cmos5l_decap_8
* cell instance sg13cmos5l_decap_8_1361 r0 *1 0,0
Xsg13cmos5l_decap_8_1361 VPWR VGND sg13cmos5l_decap_8
* cell instance sg13cmos5l_decap_8_1362 r0 *1 0,0
Xsg13cmos5l_decap_8_1362 VPWR VGND sg13cmos5l_decap_8
* cell instance sg13cmos5l_decap_8_1363 r0 *1 0,0
Xsg13cmos5l_decap_8_1363 VPWR VGND sg13cmos5l_decap_8
* cell instance sg13cmos5l_decap_8_1364 r0 *1 0,0
Xsg13cmos5l_decap_8_1364 VPWR VGND sg13cmos5l_decap_8
* cell instance sg13cmos5l_decap_8_1365 r0 *1 0,0
Xsg13cmos5l_decap_8_1365 VPWR VGND sg13cmos5l_decap_8
* cell instance sg13cmos5l_decap_8_1366 r0 *1 0,0
Xsg13cmos5l_decap_8_1366 VPWR VGND sg13cmos5l_decap_8
* cell instance sg13cmos5l_decap_8_1367 r0 *1 0,0
Xsg13cmos5l_decap_8_1367 VPWR VGND sg13cmos5l_decap_8
* cell instance sg13cmos5l_decap_8_1368 r0 *1 0,0
Xsg13cmos5l_decap_8_1368 VPWR VGND sg13cmos5l_decap_8
* cell instance sg13cmos5l_decap_8_1369 r0 *1 0,0
Xsg13cmos5l_decap_8_1369 VPWR VGND sg13cmos5l_decap_8
* cell instance sg13cmos5l_decap_8_1370 r0 *1 0,0
Xsg13cmos5l_decap_8_1370 VPWR VGND sg13cmos5l_decap_8
* cell instance sg13cmos5l_decap_8_1371 r0 *1 0,0
Xsg13cmos5l_decap_8_1371 VPWR VGND sg13cmos5l_decap_8
* cell instance sg13cmos5l_decap_8_1372 r0 *1 0,0
Xsg13cmos5l_decap_8_1372 VPWR VGND sg13cmos5l_decap_8
* cell instance sg13cmos5l_decap_8_1373 r0 *1 0,0
Xsg13cmos5l_decap_8_1373 VPWR VGND sg13cmos5l_decap_8
* cell instance sg13cmos5l_decap_8_1374 r0 *1 0,0
Xsg13cmos5l_decap_8_1374 VPWR VGND sg13cmos5l_decap_8
* cell instance sg13cmos5l_decap_8_1375 r0 *1 0,0
Xsg13cmos5l_decap_8_1375 VPWR VGND sg13cmos5l_decap_8
* cell instance sg13cmos5l_decap_8_1376 r0 *1 0,0
Xsg13cmos5l_decap_8_1376 VPWR VGND sg13cmos5l_decap_8
* cell instance sg13cmos5l_decap_8_1377 r0 *1 0,0
Xsg13cmos5l_decap_8_1377 VPWR VGND sg13cmos5l_decap_8
* cell instance sg13cmos5l_decap_8_1378 r0 *1 0,0
Xsg13cmos5l_decap_8_1378 VPWR VGND sg13cmos5l_decap_8
* cell instance sg13cmos5l_decap_8_1379 r0 *1 0,0
Xsg13cmos5l_decap_8_1379 VPWR VGND sg13cmos5l_decap_8
* cell instance sg13cmos5l_decap_8_1380 r0 *1 0,0
Xsg13cmos5l_decap_8_1380 VPWR VGND sg13cmos5l_decap_8
* cell instance sg13cmos5l_decap_8_1381 r0 *1 0,0
Xsg13cmos5l_decap_8_1381 VPWR VGND sg13cmos5l_decap_8
* cell instance sg13cmos5l_decap_8_1382 r0 *1 0,0
Xsg13cmos5l_decap_8_1382 VPWR VGND sg13cmos5l_decap_8
* cell instance sg13cmos5l_decap_8_1383 r0 *1 0,0
Xsg13cmos5l_decap_8_1383 VPWR VGND sg13cmos5l_decap_8
* cell instance sg13cmos5l_decap_8_1384 r0 *1 0,0
Xsg13cmos5l_decap_8_1384 VPWR VGND sg13cmos5l_decap_8
* cell instance sg13cmos5l_decap_8_1385 r0 *1 0,0
Xsg13cmos5l_decap_8_1385 VPWR VGND sg13cmos5l_decap_8
* cell instance sg13cmos5l_decap_8_1386 r0 *1 0,0
Xsg13cmos5l_decap_8_1386 VPWR VGND sg13cmos5l_decap_8
* cell instance sg13cmos5l_decap_8_1387 r0 *1 0,0
Xsg13cmos5l_decap_8_1387 VPWR VGND sg13cmos5l_decap_8
* cell instance sg13cmos5l_decap_8_1388 r0 *1 0,0
Xsg13cmos5l_decap_8_1388 VPWR VGND sg13cmos5l_decap_8
* cell instance sg13cmos5l_decap_8_1389 r0 *1 0,0
Xsg13cmos5l_decap_8_1389 VPWR VGND sg13cmos5l_decap_8
* cell instance sg13cmos5l_decap_8_1390 r0 *1 0,0
Xsg13cmos5l_decap_8_1390 VPWR VGND sg13cmos5l_decap_8
* cell instance sg13cmos5l_decap_8_1391 r0 *1 0,0
Xsg13cmos5l_decap_8_1391 VPWR VGND sg13cmos5l_decap_8
* cell instance sg13cmos5l_decap_8_1392 r0 *1 0,0
Xsg13cmos5l_decap_8_1392 VPWR VGND sg13cmos5l_decap_8
* cell instance sg13cmos5l_decap_8_1393 r0 *1 0,0
Xsg13cmos5l_decap_8_1393 VPWR VGND sg13cmos5l_decap_8
* cell instance sg13cmos5l_decap_8_1394 r0 *1 0,0
Xsg13cmos5l_decap_8_1394 VPWR VGND sg13cmos5l_decap_8
* cell instance sg13cmos5l_decap_8_1395 r0 *1 0,0
Xsg13cmos5l_decap_8_1395 VPWR VGND sg13cmos5l_decap_8
* cell instance sg13cmos5l_decap_8_1396 r0 *1 0,0
Xsg13cmos5l_decap_8_1396 VPWR VGND sg13cmos5l_decap_8
* cell instance sg13cmos5l_decap_8_1397 r0 *1 0,0
Xsg13cmos5l_decap_8_1397 VPWR VGND sg13cmos5l_decap_8
* cell instance sg13cmos5l_decap_8_1398 r0 *1 0,0
Xsg13cmos5l_decap_8_1398 VPWR VGND sg13cmos5l_decap_8
* cell instance sg13cmos5l_decap_8_1399 r0 *1 0,0
Xsg13cmos5l_decap_8_1399 VPWR VGND sg13cmos5l_decap_8
* cell instance sg13cmos5l_decap_8_1400 r0 *1 0,0
Xsg13cmos5l_decap_8_1400 VPWR VGND sg13cmos5l_decap_8
* cell instance sg13cmos5l_decap_8_1401 r0 *1 0,0
Xsg13cmos5l_decap_8_1401 VPWR VGND sg13cmos5l_decap_8
* cell instance sg13cmos5l_decap_8_1402 r0 *1 0,0
Xsg13cmos5l_decap_8_1402 VPWR VGND sg13cmos5l_decap_8
* cell instance sg13cmos5l_decap_8_1403 r0 *1 0,0
Xsg13cmos5l_decap_8_1403 VPWR VGND sg13cmos5l_decap_8
* cell instance sg13cmos5l_decap_8_1404 r0 *1 0,0
Xsg13cmos5l_decap_8_1404 VPWR VGND sg13cmos5l_decap_8
* cell instance sg13cmos5l_decap_8_1405 r0 *1 0,0
Xsg13cmos5l_decap_8_1405 VPWR VGND sg13cmos5l_decap_8
* cell instance sg13cmos5l_decap_8_1406 r0 *1 0,0
Xsg13cmos5l_decap_8_1406 VPWR VGND sg13cmos5l_decap_8
* cell instance sg13cmos5l_decap_8_1407 r0 *1 0,0
Xsg13cmos5l_decap_8_1407 VPWR VGND sg13cmos5l_decap_8
* cell instance sg13cmos5l_decap_8_1408 r0 *1 0,0
Xsg13cmos5l_decap_8_1408 VPWR VGND sg13cmos5l_decap_8
* cell instance sg13cmos5l_decap_8_1409 r0 *1 0,0
Xsg13cmos5l_decap_8_1409 VPWR VGND sg13cmos5l_decap_8
* cell instance sg13cmos5l_decap_8_1410 r0 *1 0,0
Xsg13cmos5l_decap_8_1410 VPWR VGND sg13cmos5l_decap_8
* cell instance sg13cmos5l_decap_8_1411 r0 *1 0,0
Xsg13cmos5l_decap_8_1411 VPWR VGND sg13cmos5l_decap_8
* cell instance sg13cmos5l_decap_8_1412 r0 *1 0,0
Xsg13cmos5l_decap_8_1412 VPWR VGND sg13cmos5l_decap_8
* cell instance sg13cmos5l_decap_8_1413 r0 *1 0,0
Xsg13cmos5l_decap_8_1413 VPWR VGND sg13cmos5l_decap_8
* cell instance sg13cmos5l_decap_8_1414 r0 *1 0,0
Xsg13cmos5l_decap_8_1414 VPWR VGND sg13cmos5l_decap_8
* cell instance sg13cmos5l_decap_8_1415 r0 *1 0,0
Xsg13cmos5l_decap_8_1415 VPWR VGND sg13cmos5l_decap_8
* cell instance sg13cmos5l_decap_8_1416 r0 *1 0,0
Xsg13cmos5l_decap_8_1416 VPWR VGND sg13cmos5l_decap_8
* cell instance sg13cmos5l_decap_8_1417 r0 *1 0,0
Xsg13cmos5l_decap_8_1417 VPWR VGND sg13cmos5l_decap_8
* cell instance sg13cmos5l_decap_8_1418 r0 *1 0,0
Xsg13cmos5l_decap_8_1418 VPWR VGND sg13cmos5l_decap_8
* cell instance sg13cmos5l_decap_8_1419 r0 *1 0,0
Xsg13cmos5l_decap_8_1419 VPWR VGND sg13cmos5l_decap_8
* cell instance sg13cmos5l_decap_8_1420 r0 *1 0,0
Xsg13cmos5l_decap_8_1420 VPWR VGND sg13cmos5l_decap_8
* cell instance sg13cmos5l_decap_8_1421 r0 *1 0,0
Xsg13cmos5l_decap_8_1421 VPWR VGND sg13cmos5l_decap_8
* cell instance sg13cmos5l_decap_8_1422 r0 *1 0,0
Xsg13cmos5l_decap_8_1422 VPWR VGND sg13cmos5l_decap_8
* cell instance sg13cmos5l_decap_8_1423 r0 *1 0,0
Xsg13cmos5l_decap_8_1423 VPWR VGND sg13cmos5l_decap_8
* cell instance sg13cmos5l_decap_8_1424 r0 *1 0,0
Xsg13cmos5l_decap_8_1424 VPWR VGND sg13cmos5l_decap_8
* cell instance sg13cmos5l_decap_8_1425 r0 *1 0,0
Xsg13cmos5l_decap_8_1425 VPWR VGND sg13cmos5l_decap_8
* cell instance sg13cmos5l_decap_8_1426 r0 *1 0,0
Xsg13cmos5l_decap_8_1426 VPWR VGND sg13cmos5l_decap_8
* cell instance sg13cmos5l_decap_8_1427 r0 *1 0,0
Xsg13cmos5l_decap_8_1427 VPWR VGND sg13cmos5l_decap_8
* cell instance sg13cmos5l_decap_8_1428 r0 *1 0,0
Xsg13cmos5l_decap_8_1428 VPWR VGND sg13cmos5l_decap_8
* cell instance sg13cmos5l_decap_8_1429 r0 *1 0,0
Xsg13cmos5l_decap_8_1429 VPWR VGND sg13cmos5l_decap_8
* cell instance sg13cmos5l_decap_8_1430 r0 *1 0,0
Xsg13cmos5l_decap_8_1430 VPWR VGND sg13cmos5l_decap_8
* cell instance sg13cmos5l_decap_8_1431 r0 *1 0,0
Xsg13cmos5l_decap_8_1431 VPWR VGND sg13cmos5l_decap_8
* cell instance sg13cmos5l_decap_8_1432 r0 *1 0,0
Xsg13cmos5l_decap_8_1432 VPWR VGND sg13cmos5l_decap_8
* cell instance sg13cmos5l_decap_8_1433 r0 *1 0,0
Xsg13cmos5l_decap_8_1433 VPWR VGND sg13cmos5l_decap_8
* cell instance sg13cmos5l_decap_8_1434 r0 *1 0,0
Xsg13cmos5l_decap_8_1434 VPWR VGND sg13cmos5l_decap_8
* cell instance sg13cmos5l_decap_8_1435 r0 *1 0,0
Xsg13cmos5l_decap_8_1435 VPWR VGND sg13cmos5l_decap_8
* cell instance sg13cmos5l_decap_8_1436 r0 *1 0,0
Xsg13cmos5l_decap_8_1436 VPWR VGND sg13cmos5l_decap_8
* cell instance sg13cmos5l_decap_8_1437 r0 *1 0,0
Xsg13cmos5l_decap_8_1437 VPWR VGND sg13cmos5l_decap_8
* cell instance sg13cmos5l_decap_8_1438 r0 *1 0,0
Xsg13cmos5l_decap_8_1438 VPWR VGND sg13cmos5l_decap_8
* cell instance sg13cmos5l_decap_8_1439 r0 *1 0,0
Xsg13cmos5l_decap_8_1439 VPWR VGND sg13cmos5l_decap_8
* cell instance sg13cmos5l_decap_8_1440 r0 *1 0,0
Xsg13cmos5l_decap_8_1440 VPWR VGND sg13cmos5l_decap_8
* cell instance sg13cmos5l_decap_8_1441 r0 *1 0,0
Xsg13cmos5l_decap_8_1441 VPWR VGND sg13cmos5l_decap_8
* cell instance sg13cmos5l_decap_8_1442 r0 *1 0,0
Xsg13cmos5l_decap_8_1442 VPWR VGND sg13cmos5l_decap_8
* cell instance sg13cmos5l_decap_8_1443 r0 *1 0,0
Xsg13cmos5l_decap_8_1443 VPWR VGND sg13cmos5l_decap_8
* cell instance sg13cmos5l_decap_8_1444 r0 *1 0,0
Xsg13cmos5l_decap_8_1444 VPWR VGND sg13cmos5l_decap_8
* cell instance sg13cmos5l_decap_8_1445 r0 *1 0,0
Xsg13cmos5l_decap_8_1445 VPWR VGND sg13cmos5l_decap_8
* cell instance sg13cmos5l_decap_8_1446 r0 *1 0,0
Xsg13cmos5l_decap_8_1446 VPWR VGND sg13cmos5l_decap_8
* cell instance sg13cmos5l_decap_8_1447 r0 *1 0,0
Xsg13cmos5l_decap_8_1447 VPWR VGND sg13cmos5l_decap_8
* cell instance sg13cmos5l_decap_8_1448 r0 *1 0,0
Xsg13cmos5l_decap_8_1448 VPWR VGND sg13cmos5l_decap_8
* cell instance sg13cmos5l_decap_8_1449 r0 *1 0,0
Xsg13cmos5l_decap_8_1449 VPWR VGND sg13cmos5l_decap_8
* cell instance sg13cmos5l_decap_8_1450 r0 *1 0,0
Xsg13cmos5l_decap_8_1450 VPWR VGND sg13cmos5l_decap_8
* cell instance sg13cmos5l_decap_8_1451 r0 *1 0,0
Xsg13cmos5l_decap_8_1451 VPWR VGND sg13cmos5l_decap_8
* cell instance sg13cmos5l_decap_8_1452 r0 *1 0,0
Xsg13cmos5l_decap_8_1452 VPWR VGND sg13cmos5l_decap_8
* cell instance sg13cmos5l_decap_8_1453 r0 *1 0,0
Xsg13cmos5l_decap_8_1453 VPWR VGND sg13cmos5l_decap_8
* cell instance sg13cmos5l_decap_8_1454 r0 *1 0,0
Xsg13cmos5l_decap_8_1454 VPWR VGND sg13cmos5l_decap_8
* cell instance sg13cmos5l_decap_8_1455 r0 *1 0,0
Xsg13cmos5l_decap_8_1455 VPWR VGND sg13cmos5l_decap_8
* cell instance sg13cmos5l_decap_8_1456 r0 *1 0,0
Xsg13cmos5l_decap_8_1456 VPWR VGND sg13cmos5l_decap_8
* cell instance sg13cmos5l_decap_8_1457 r0 *1 0,0
Xsg13cmos5l_decap_8_1457 VPWR VGND sg13cmos5l_decap_8
* cell instance sg13cmos5l_decap_8_1458 r0 *1 0,0
Xsg13cmos5l_decap_8_1458 VPWR VGND sg13cmos5l_decap_8
* cell instance sg13cmos5l_decap_8_1459 r0 *1 0,0
Xsg13cmos5l_decap_8_1459 VPWR VGND sg13cmos5l_decap_8
* cell instance sg13cmos5l_decap_8_1460 r0 *1 0,0
Xsg13cmos5l_decap_8_1460 VPWR VGND sg13cmos5l_decap_8
* cell instance sg13cmos5l_decap_8_1461 r0 *1 0,0
Xsg13cmos5l_decap_8_1461 VPWR VGND sg13cmos5l_decap_8
* cell instance sg13cmos5l_decap_8_1462 r0 *1 0,0
Xsg13cmos5l_decap_8_1462 VPWR VGND sg13cmos5l_decap_8
* cell instance sg13cmos5l_decap_8_1463 r0 *1 0,0
Xsg13cmos5l_decap_8_1463 VPWR VGND sg13cmos5l_decap_8
* cell instance sg13cmos5l_decap_8_1464 r0 *1 0,0
Xsg13cmos5l_decap_8_1464 VPWR VGND sg13cmos5l_decap_8
* cell instance sg13cmos5l_decap_8_1465 r0 *1 0,0
Xsg13cmos5l_decap_8_1465 VPWR VGND sg13cmos5l_decap_8
* cell instance sg13cmos5l_decap_8_1466 r0 *1 0,0
Xsg13cmos5l_decap_8_1466 VPWR VGND sg13cmos5l_decap_8
* cell instance sg13cmos5l_decap_8_1467 r0 *1 0,0
Xsg13cmos5l_decap_8_1467 VPWR VGND sg13cmos5l_decap_8
* cell instance sg13cmos5l_decap_8_1468 r0 *1 0,0
Xsg13cmos5l_decap_8_1468 VPWR VGND sg13cmos5l_decap_8
* cell instance sg13cmos5l_decap_8_1469 r0 *1 0,0
Xsg13cmos5l_decap_8_1469 VPWR VGND sg13cmos5l_decap_8
* cell instance sg13cmos5l_decap_8_1470 r0 *1 0,0
Xsg13cmos5l_decap_8_1470 VPWR VGND sg13cmos5l_decap_8
* cell instance sg13cmos5l_decap_8_1471 r0 *1 0,0
Xsg13cmos5l_decap_8_1471 VPWR VGND sg13cmos5l_decap_8
* cell instance sg13cmos5l_decap_8_1472 r0 *1 0,0
Xsg13cmos5l_decap_8_1472 VPWR VGND sg13cmos5l_decap_8
* cell instance sg13cmos5l_decap_8_1473 r0 *1 0,0
Xsg13cmos5l_decap_8_1473 VPWR VGND sg13cmos5l_decap_8
* cell instance sg13cmos5l_decap_8_1474 r0 *1 0,0
Xsg13cmos5l_decap_8_1474 VPWR VGND sg13cmos5l_decap_8
* cell instance sg13cmos5l_decap_8_1475 r0 *1 0,0
Xsg13cmos5l_decap_8_1475 VPWR VGND sg13cmos5l_decap_8
* cell instance sg13cmos5l_decap_8_1476 r0 *1 0,0
Xsg13cmos5l_decap_8_1476 VPWR VGND sg13cmos5l_decap_8
* cell instance sg13cmos5l_decap_8_1477 r0 *1 0,0
Xsg13cmos5l_decap_8_1477 VPWR VGND sg13cmos5l_decap_8
* cell instance sg13cmos5l_decap_8_1478 r0 *1 0,0
Xsg13cmos5l_decap_8_1478 VPWR VGND sg13cmos5l_decap_8
* cell instance sg13cmos5l_decap_8_1479 r0 *1 0,0
Xsg13cmos5l_decap_8_1479 VPWR VGND sg13cmos5l_decap_8
* cell instance sg13cmos5l_decap_8_1480 r0 *1 0,0
Xsg13cmos5l_decap_8_1480 VPWR VGND sg13cmos5l_decap_8
* cell instance sg13cmos5l_decap_8_1481 r0 *1 0,0
Xsg13cmos5l_decap_8_1481 VPWR VGND sg13cmos5l_decap_8
* cell instance sg13cmos5l_decap_8_1482 r0 *1 0,0
Xsg13cmos5l_decap_8_1482 VPWR VGND sg13cmos5l_decap_8
* cell instance sg13cmos5l_decap_8_1483 r0 *1 0,0
Xsg13cmos5l_decap_8_1483 VPWR VGND sg13cmos5l_decap_8
* cell instance sg13cmos5l_decap_8_1484 r0 *1 0,0
Xsg13cmos5l_decap_8_1484 VPWR VGND sg13cmos5l_decap_8
* cell instance sg13cmos5l_decap_8_1485 r0 *1 0,0
Xsg13cmos5l_decap_8_1485 VPWR VGND sg13cmos5l_decap_8
* cell instance sg13cmos5l_decap_8_1486 r0 *1 0,0
Xsg13cmos5l_decap_8_1486 VPWR VGND sg13cmos5l_decap_8
* cell instance sg13cmos5l_decap_8_1487 r0 *1 0,0
Xsg13cmos5l_decap_8_1487 VPWR VGND sg13cmos5l_decap_8
* cell instance sg13cmos5l_decap_8_1488 r0 *1 0,0
Xsg13cmos5l_decap_8_1488 VPWR VGND sg13cmos5l_decap_8
* cell instance sg13cmos5l_decap_8_1489 r0 *1 0,0
Xsg13cmos5l_decap_8_1489 VPWR VGND sg13cmos5l_decap_8
* cell instance sg13cmos5l_decap_8_1490 r0 *1 0,0
Xsg13cmos5l_decap_8_1490 VPWR VGND sg13cmos5l_decap_8
* cell instance sg13cmos5l_decap_8_1491 r0 *1 0,0
Xsg13cmos5l_decap_8_1491 VPWR VGND sg13cmos5l_decap_8
* cell instance sg13cmos5l_decap_8_1492 r0 *1 0,0
Xsg13cmos5l_decap_8_1492 VPWR VGND sg13cmos5l_decap_8
* cell instance sg13cmos5l_decap_8_1493 r0 *1 0,0
Xsg13cmos5l_decap_8_1493 VPWR VGND sg13cmos5l_decap_8
* cell instance sg13cmos5l_decap_8_1494 r0 *1 0,0
Xsg13cmos5l_decap_8_1494 VPWR VGND sg13cmos5l_decap_8
* cell instance sg13cmos5l_decap_8_1495 r0 *1 0,0
Xsg13cmos5l_decap_8_1495 VPWR VGND sg13cmos5l_decap_8
* cell instance sg13cmos5l_decap_8_1496 r0 *1 0,0
Xsg13cmos5l_decap_8_1496 VPWR VGND sg13cmos5l_decap_8
* cell instance sg13cmos5l_decap_8_1497 r0 *1 0,0
Xsg13cmos5l_decap_8_1497 VPWR VGND sg13cmos5l_decap_8
* cell instance sg13cmos5l_decap_8_1498 r0 *1 0,0
Xsg13cmos5l_decap_8_1498 VPWR VGND sg13cmos5l_decap_8
* cell instance sg13cmos5l_decap_8_1499 r0 *1 0,0
Xsg13cmos5l_decap_8_1499 VPWR VGND sg13cmos5l_decap_8
* cell instance sg13cmos5l_decap_8_1500 r0 *1 0,0
Xsg13cmos5l_decap_8_1500 VPWR VGND sg13cmos5l_decap_8
* cell instance sg13cmos5l_decap_8_1501 r0 *1 0,0
Xsg13cmos5l_decap_8_1501 VPWR VGND sg13cmos5l_decap_8
* cell instance sg13cmos5l_decap_8_1502 r0 *1 0,0
Xsg13cmos5l_decap_8_1502 VPWR VGND sg13cmos5l_decap_8
* cell instance sg13cmos5l_decap_8_1503 r0 *1 0,0
Xsg13cmos5l_decap_8_1503 VPWR VGND sg13cmos5l_decap_8
* cell instance sg13cmos5l_decap_8_1504 r0 *1 0,0
Xsg13cmos5l_decap_8_1504 VPWR VGND sg13cmos5l_decap_8
* cell instance sg13cmos5l_decap_8_1505 r0 *1 0,0
Xsg13cmos5l_decap_8_1505 VPWR VGND sg13cmos5l_decap_8
* cell instance sg13cmos5l_decap_8_1506 r0 *1 0,0
Xsg13cmos5l_decap_8_1506 VPWR VGND sg13cmos5l_decap_8
* cell instance sg13cmos5l_decap_8_1507 r0 *1 0,0
Xsg13cmos5l_decap_8_1507 VPWR VGND sg13cmos5l_decap_8
* cell instance sg13cmos5l_decap_8_1508 r0 *1 0,0
Xsg13cmos5l_decap_8_1508 VPWR VGND sg13cmos5l_decap_8
* cell instance sg13cmos5l_decap_8_1509 r0 *1 0,0
Xsg13cmos5l_decap_8_1509 VPWR VGND sg13cmos5l_decap_8
* cell instance sg13cmos5l_decap_8_1510 r0 *1 0,0
Xsg13cmos5l_decap_8_1510 VPWR VGND sg13cmos5l_decap_8
* cell instance sg13cmos5l_decap_8_1511 r0 *1 0,0
Xsg13cmos5l_decap_8_1511 VPWR VGND sg13cmos5l_decap_8
* cell instance sg13cmos5l_decap_8_1512 r0 *1 0,0
Xsg13cmos5l_decap_8_1512 VPWR VGND sg13cmos5l_decap_8
* cell instance sg13cmos5l_decap_8_1513 r0 *1 0,0
Xsg13cmos5l_decap_8_1513 VPWR VGND sg13cmos5l_decap_8
* cell instance sg13cmos5l_decap_8_1514 r0 *1 0,0
Xsg13cmos5l_decap_8_1514 VPWR VGND sg13cmos5l_decap_8
* cell instance sg13cmos5l_decap_8_1515 r0 *1 0,0
Xsg13cmos5l_decap_8_1515 VPWR VGND sg13cmos5l_decap_8
* cell instance sg13cmos5l_decap_8_1516 r0 *1 0,0
Xsg13cmos5l_decap_8_1516 VPWR VGND sg13cmos5l_decap_8
* cell instance sg13cmos5l_decap_8_1517 r0 *1 0,0
Xsg13cmos5l_decap_8_1517 VPWR VGND sg13cmos5l_decap_8
* cell instance sg13cmos5l_decap_8_1518 r0 *1 0,0
Xsg13cmos5l_decap_8_1518 VPWR VGND sg13cmos5l_decap_8
* cell instance sg13cmos5l_decap_8_1519 r0 *1 0,0
Xsg13cmos5l_decap_8_1519 VPWR VGND sg13cmos5l_decap_8
* cell instance sg13cmos5l_decap_8_1520 r0 *1 0,0
Xsg13cmos5l_decap_8_1520 VPWR VGND sg13cmos5l_decap_8
* cell instance sg13cmos5l_decap_8_1521 r0 *1 0,0
Xsg13cmos5l_decap_8_1521 VPWR VGND sg13cmos5l_decap_8
* cell instance sg13cmos5l_decap_8_1522 r0 *1 0,0
Xsg13cmos5l_decap_8_1522 VPWR VGND sg13cmos5l_decap_8
* cell instance sg13cmos5l_decap_8_1523 r0 *1 0,0
Xsg13cmos5l_decap_8_1523 VPWR VGND sg13cmos5l_decap_8
* cell instance sg13cmos5l_decap_8_1524 r0 *1 0,0
Xsg13cmos5l_decap_8_1524 VPWR VGND sg13cmos5l_decap_8
* cell instance sg13cmos5l_decap_8_1525 r0 *1 0,0
Xsg13cmos5l_decap_8_1525 VPWR VGND sg13cmos5l_decap_8
* cell instance sg13cmos5l_decap_8_1526 r0 *1 0,0
Xsg13cmos5l_decap_8_1526 VPWR VGND sg13cmos5l_decap_8
* cell instance sg13cmos5l_decap_8_1527 r0 *1 0,0
Xsg13cmos5l_decap_8_1527 VPWR VGND sg13cmos5l_decap_8
* cell instance sg13cmos5l_decap_8_1528 r0 *1 0,0
Xsg13cmos5l_decap_8_1528 VPWR VGND sg13cmos5l_decap_8
* cell instance sg13cmos5l_decap_8_1529 r0 *1 0,0
Xsg13cmos5l_decap_8_1529 VPWR VGND sg13cmos5l_decap_8
* cell instance sg13cmos5l_decap_8_1530 r0 *1 0,0
Xsg13cmos5l_decap_8_1530 VPWR VGND sg13cmos5l_decap_8
* cell instance sg13cmos5l_decap_8_1531 r0 *1 0,0
Xsg13cmos5l_decap_8_1531 VPWR VGND sg13cmos5l_decap_8
* cell instance sg13cmos5l_decap_8_1532 r0 *1 0,0
Xsg13cmos5l_decap_8_1532 VPWR VGND sg13cmos5l_decap_8
* cell instance sg13cmos5l_decap_8_1533 r0 *1 0,0
Xsg13cmos5l_decap_8_1533 VPWR VGND sg13cmos5l_decap_8
* cell instance sg13cmos5l_decap_8_1534 r0 *1 0,0
Xsg13cmos5l_decap_8_1534 VPWR VGND sg13cmos5l_decap_8
* cell instance sg13cmos5l_decap_8_1535 r0 *1 0,0
Xsg13cmos5l_decap_8_1535 VPWR VGND sg13cmos5l_decap_8
* cell instance sg13cmos5l_decap_8_1536 r0 *1 0,0
Xsg13cmos5l_decap_8_1536 VPWR VGND sg13cmos5l_decap_8
* cell instance sg13cmos5l_decap_8_1537 r0 *1 0,0
Xsg13cmos5l_decap_8_1537 VPWR VGND sg13cmos5l_decap_8
* cell instance sg13cmos5l_decap_8_1538 r0 *1 0,0
Xsg13cmos5l_decap_8_1538 VPWR VGND sg13cmos5l_decap_8
* cell instance sg13cmos5l_decap_8_1539 r0 *1 0,0
Xsg13cmos5l_decap_8_1539 VPWR VGND sg13cmos5l_decap_8
* cell instance sg13cmos5l_decap_8_1540 r0 *1 0,0
Xsg13cmos5l_decap_8_1540 VPWR VGND sg13cmos5l_decap_8
* cell instance sg13cmos5l_decap_8_1541 r0 *1 0,0
Xsg13cmos5l_decap_8_1541 VPWR VGND sg13cmos5l_decap_8
* cell instance sg13cmos5l_decap_8_1542 r0 *1 0,0
Xsg13cmos5l_decap_8_1542 VPWR VGND sg13cmos5l_decap_8
* cell instance sg13cmos5l_decap_8_1543 r0 *1 0,0
Xsg13cmos5l_decap_8_1543 VPWR VGND sg13cmos5l_decap_8
* cell instance sg13cmos5l_decap_8_1544 r0 *1 0,0
Xsg13cmos5l_decap_8_1544 VPWR VGND sg13cmos5l_decap_8
* cell instance sg13cmos5l_decap_8_1545 r0 *1 0,0
Xsg13cmos5l_decap_8_1545 VPWR VGND sg13cmos5l_decap_8
* cell instance sg13cmos5l_decap_8_1546 r0 *1 0,0
Xsg13cmos5l_decap_8_1546 VPWR VGND sg13cmos5l_decap_8
* cell instance sg13cmos5l_decap_8_1547 r0 *1 0,0
Xsg13cmos5l_decap_8_1547 VPWR VGND sg13cmos5l_decap_8
* cell instance sg13cmos5l_decap_8_1548 r0 *1 0,0
Xsg13cmos5l_decap_8_1548 VPWR VGND sg13cmos5l_decap_8
* cell instance sg13cmos5l_decap_8_1549 r0 *1 0,0
Xsg13cmos5l_decap_8_1549 VPWR VGND sg13cmos5l_decap_8
* cell instance sg13cmos5l_decap_8_1550 r0 *1 0,0
Xsg13cmos5l_decap_8_1550 VPWR VGND sg13cmos5l_decap_8
* cell instance sg13cmos5l_decap_8_1551 r0 *1 0,0
Xsg13cmos5l_decap_8_1551 VPWR VGND sg13cmos5l_decap_8
* cell instance sg13cmos5l_decap_8_1552 r0 *1 0,0
Xsg13cmos5l_decap_8_1552 VPWR VGND sg13cmos5l_decap_8
* cell instance sg13cmos5l_decap_8_1553 r0 *1 0,0
Xsg13cmos5l_decap_8_1553 VPWR VGND sg13cmos5l_decap_8
* cell instance sg13cmos5l_decap_8_1554 r0 *1 0,0
Xsg13cmos5l_decap_8_1554 VPWR VGND sg13cmos5l_decap_8
* cell instance sg13cmos5l_decap_8_1555 r0 *1 0,0
Xsg13cmos5l_decap_8_1555 VPWR VGND sg13cmos5l_decap_8
* cell instance sg13cmos5l_decap_8_1556 r0 *1 0,0
Xsg13cmos5l_decap_8_1556 VPWR VGND sg13cmos5l_decap_8
* cell instance sg13cmos5l_decap_8_1557 r0 *1 0,0
Xsg13cmos5l_decap_8_1557 VPWR VGND sg13cmos5l_decap_8
* cell instance sg13cmos5l_decap_8_1558 r0 *1 0,0
Xsg13cmos5l_decap_8_1558 VPWR VGND sg13cmos5l_decap_8
* cell instance sg13cmos5l_decap_8_1559 r0 *1 0,0
Xsg13cmos5l_decap_8_1559 VPWR VGND sg13cmos5l_decap_8
* cell instance sg13cmos5l_decap_8_1560 r0 *1 0,0
Xsg13cmos5l_decap_8_1560 VPWR VGND sg13cmos5l_decap_8
* cell instance sg13cmos5l_decap_8_1561 r0 *1 0,0
Xsg13cmos5l_decap_8_1561 VPWR VGND sg13cmos5l_decap_8
* cell instance sg13cmos5l_decap_8_1562 r0 *1 0,0
Xsg13cmos5l_decap_8_1562 VPWR VGND sg13cmos5l_decap_8
* cell instance sg13cmos5l_decap_8_1563 r0 *1 0,0
Xsg13cmos5l_decap_8_1563 VPWR VGND sg13cmos5l_decap_8
* cell instance sg13cmos5l_decap_8_1564 r0 *1 0,0
Xsg13cmos5l_decap_8_1564 VPWR VGND sg13cmos5l_decap_8
* cell instance sg13cmos5l_decap_8_1565 r0 *1 0,0
Xsg13cmos5l_decap_8_1565 VPWR VGND sg13cmos5l_decap_8
* cell instance sg13cmos5l_decap_8_1566 r0 *1 0,0
Xsg13cmos5l_decap_8_1566 VPWR VGND sg13cmos5l_decap_8
* cell instance sg13cmos5l_decap_8_1567 r0 *1 0,0
Xsg13cmos5l_decap_8_1567 VPWR VGND sg13cmos5l_decap_8
* cell instance sg13cmos5l_decap_8_1568 r0 *1 0,0
Xsg13cmos5l_decap_8_1568 VPWR VGND sg13cmos5l_decap_8
* cell instance sg13cmos5l_decap_8_1569 r0 *1 0,0
Xsg13cmos5l_decap_8_1569 VPWR VGND sg13cmos5l_decap_8
* cell instance sg13cmos5l_decap_8_1570 r0 *1 0,0
Xsg13cmos5l_decap_8_1570 VPWR VGND sg13cmos5l_decap_8
* cell instance sg13cmos5l_decap_8_1571 r0 *1 0,0
Xsg13cmos5l_decap_8_1571 VPWR VGND sg13cmos5l_decap_8
* cell instance sg13cmos5l_decap_8_1572 r0 *1 0,0
Xsg13cmos5l_decap_8_1572 VPWR VGND sg13cmos5l_decap_8
* cell instance sg13cmos5l_decap_8_1573 r0 *1 0,0
Xsg13cmos5l_decap_8_1573 VPWR VGND sg13cmos5l_decap_8
* cell instance sg13cmos5l_decap_8_1574 r0 *1 0,0
Xsg13cmos5l_decap_8_1574 VPWR VGND sg13cmos5l_decap_8
* cell instance sg13cmos5l_decap_8_1575 r0 *1 0,0
Xsg13cmos5l_decap_8_1575 VPWR VGND sg13cmos5l_decap_8
* cell instance sg13cmos5l_decap_8_1576 r0 *1 0,0
Xsg13cmos5l_decap_8_1576 VPWR VGND sg13cmos5l_decap_8
* cell instance sg13cmos5l_decap_8_1577 r0 *1 0,0
Xsg13cmos5l_decap_8_1577 VPWR VGND sg13cmos5l_decap_8
* cell instance sg13cmos5l_decap_8_1578 r0 *1 0,0
Xsg13cmos5l_decap_8_1578 VPWR VGND sg13cmos5l_decap_8
* cell instance sg13cmos5l_decap_8_1579 r0 *1 0,0
Xsg13cmos5l_decap_8_1579 VPWR VGND sg13cmos5l_decap_8
* cell instance sg13cmos5l_decap_8_1580 r0 *1 0,0
Xsg13cmos5l_decap_8_1580 VPWR VGND sg13cmos5l_decap_8
* cell instance sg13cmos5l_decap_8_1581 r0 *1 0,0
Xsg13cmos5l_decap_8_1581 VPWR VGND sg13cmos5l_decap_8
* cell instance sg13cmos5l_decap_8_1582 r0 *1 0,0
Xsg13cmos5l_decap_8_1582 VPWR VGND sg13cmos5l_decap_8
* cell instance sg13cmos5l_decap_8_1583 r0 *1 0,0
Xsg13cmos5l_decap_8_1583 VPWR VGND sg13cmos5l_decap_8
* cell instance sg13cmos5l_decap_8_1584 r0 *1 0,0
Xsg13cmos5l_decap_8_1584 VPWR VGND sg13cmos5l_decap_8
* cell instance sg13cmos5l_decap_8_1585 r0 *1 0,0
Xsg13cmos5l_decap_8_1585 VPWR VGND sg13cmos5l_decap_8
* cell instance sg13cmos5l_decap_8_1586 r0 *1 0,0
Xsg13cmos5l_decap_8_1586 VPWR VGND sg13cmos5l_decap_8
* cell instance sg13cmos5l_decap_8_1587 r0 *1 0,0
Xsg13cmos5l_decap_8_1587 VPWR VGND sg13cmos5l_decap_8
* cell instance sg13cmos5l_decap_8_1588 r0 *1 0,0
Xsg13cmos5l_decap_8_1588 VPWR VGND sg13cmos5l_decap_8
* cell instance sg13cmos5l_decap_8_1589 r0 *1 0,0
Xsg13cmos5l_decap_8_1589 VPWR VGND sg13cmos5l_decap_8
* cell instance sg13cmos5l_decap_8_1590 r0 *1 0,0
Xsg13cmos5l_decap_8_1590 VPWR VGND sg13cmos5l_decap_8
* cell instance sg13cmos5l_decap_8_1591 r0 *1 0,0
Xsg13cmos5l_decap_8_1591 VPWR VGND sg13cmos5l_decap_8
* cell instance sg13cmos5l_decap_8_1592 r0 *1 0,0
Xsg13cmos5l_decap_8_1592 VPWR VGND sg13cmos5l_decap_8
* cell instance sg13cmos5l_decap_8_1593 r0 *1 0,0
Xsg13cmos5l_decap_8_1593 VPWR VGND sg13cmos5l_decap_8
* cell instance sg13cmos5l_decap_8_1594 r0 *1 0,0
Xsg13cmos5l_decap_8_1594 VPWR VGND sg13cmos5l_decap_8
* cell instance sg13cmos5l_decap_8_1595 r0 *1 0,0
Xsg13cmos5l_decap_8_1595 VPWR VGND sg13cmos5l_decap_8
* cell instance sg13cmos5l_decap_8_1596 r0 *1 0,0
Xsg13cmos5l_decap_8_1596 VPWR VGND sg13cmos5l_decap_8
* cell instance sg13cmos5l_decap_8_1597 r0 *1 0,0
Xsg13cmos5l_decap_8_1597 VPWR VGND sg13cmos5l_decap_8
* cell instance sg13cmos5l_decap_8_1598 r0 *1 0,0
Xsg13cmos5l_decap_8_1598 VPWR VGND sg13cmos5l_decap_8
* cell instance sg13cmos5l_decap_8_1599 r0 *1 0,0
Xsg13cmos5l_decap_8_1599 VPWR VGND sg13cmos5l_decap_8
* cell instance sg13cmos5l_decap_8_1600 r0 *1 0,0
Xsg13cmos5l_decap_8_1600 VPWR VGND sg13cmos5l_decap_8
* cell instance sg13cmos5l_decap_8_1601 r0 *1 0,0
Xsg13cmos5l_decap_8_1601 VPWR VGND sg13cmos5l_decap_8
* cell instance sg13cmos5l_decap_8_1602 r0 *1 0,0
Xsg13cmos5l_decap_8_1602 VPWR VGND sg13cmos5l_decap_8
* cell instance sg13cmos5l_decap_8_1603 r0 *1 0,0
Xsg13cmos5l_decap_8_1603 VPWR VGND sg13cmos5l_decap_8
* cell instance sg13cmos5l_decap_8_1604 r0 *1 0,0
Xsg13cmos5l_decap_8_1604 VPWR VGND sg13cmos5l_decap_8
* cell instance sg13cmos5l_decap_8_1605 r0 *1 0,0
Xsg13cmos5l_decap_8_1605 VPWR VGND sg13cmos5l_decap_8
* cell instance sg13cmos5l_decap_8_1606 r0 *1 0,0
Xsg13cmos5l_decap_8_1606 VPWR VGND sg13cmos5l_decap_8
* cell instance sg13cmos5l_decap_8_1607 r0 *1 0,0
Xsg13cmos5l_decap_8_1607 VPWR VGND sg13cmos5l_decap_8
* cell instance sg13cmos5l_decap_8_1608 r0 *1 0,0
Xsg13cmos5l_decap_8_1608 VPWR VGND sg13cmos5l_decap_8
* cell instance sg13cmos5l_decap_8_1609 r0 *1 0,0
Xsg13cmos5l_decap_8_1609 VPWR VGND sg13cmos5l_decap_8
* cell instance sg13cmos5l_decap_8_1610 r0 *1 0,0
Xsg13cmos5l_decap_8_1610 VPWR VGND sg13cmos5l_decap_8
* cell instance sg13cmos5l_decap_8_1611 r0 *1 0,0
Xsg13cmos5l_decap_8_1611 VPWR VGND sg13cmos5l_decap_8
* cell instance sg13cmos5l_decap_8_1612 r0 *1 0,0
Xsg13cmos5l_decap_8_1612 VPWR VGND sg13cmos5l_decap_8
* cell instance sg13cmos5l_decap_8_1613 r0 *1 0,0
Xsg13cmos5l_decap_8_1613 VPWR VGND sg13cmos5l_decap_8
* cell instance sg13cmos5l_decap_8_1614 r0 *1 0,0
Xsg13cmos5l_decap_8_1614 VPWR VGND sg13cmos5l_decap_8
* cell instance sg13cmos5l_decap_8_1615 r0 *1 0,0
Xsg13cmos5l_decap_8_1615 VPWR VGND sg13cmos5l_decap_8
* cell instance sg13cmos5l_decap_8_1616 r0 *1 0,0
Xsg13cmos5l_decap_8_1616 VPWR VGND sg13cmos5l_decap_8
* cell instance sg13cmos5l_decap_8_1617 r0 *1 0,0
Xsg13cmos5l_decap_8_1617 VPWR VGND sg13cmos5l_decap_8
* cell instance sg13cmos5l_decap_8_1618 r0 *1 0,0
Xsg13cmos5l_decap_8_1618 VPWR VGND sg13cmos5l_decap_8
* cell instance sg13cmos5l_decap_8_1619 r0 *1 0,0
Xsg13cmos5l_decap_8_1619 VPWR VGND sg13cmos5l_decap_8
* cell instance sg13cmos5l_decap_8_1620 r0 *1 0,0
Xsg13cmos5l_decap_8_1620 VPWR VGND sg13cmos5l_decap_8
* cell instance sg13cmos5l_decap_8_1621 r0 *1 0,0
Xsg13cmos5l_decap_8_1621 VPWR VGND sg13cmos5l_decap_8
* cell instance sg13cmos5l_decap_8_1622 r0 *1 0,0
Xsg13cmos5l_decap_8_1622 VPWR VGND sg13cmos5l_decap_8
* cell instance sg13cmos5l_decap_8_1623 r0 *1 0,0
Xsg13cmos5l_decap_8_1623 VPWR VGND sg13cmos5l_decap_8
* cell instance sg13cmos5l_decap_8_1624 r0 *1 0,0
Xsg13cmos5l_decap_8_1624 VPWR VGND sg13cmos5l_decap_8
* cell instance sg13cmos5l_decap_8_1625 r0 *1 0,0
Xsg13cmos5l_decap_8_1625 VPWR VGND sg13cmos5l_decap_8
* cell instance sg13cmos5l_decap_8_1626 r0 *1 0,0
Xsg13cmos5l_decap_8_1626 VPWR VGND sg13cmos5l_decap_8
* cell instance sg13cmos5l_decap_8_1627 r0 *1 0,0
Xsg13cmos5l_decap_8_1627 VPWR VGND sg13cmos5l_decap_8
* cell instance sg13cmos5l_decap_8_1628 r0 *1 0,0
Xsg13cmos5l_decap_8_1628 VPWR VGND sg13cmos5l_decap_8
* cell instance sg13cmos5l_decap_8_1629 r0 *1 0,0
Xsg13cmos5l_decap_8_1629 VPWR VGND sg13cmos5l_decap_8
* cell instance sg13cmos5l_decap_8_1630 r0 *1 0,0
Xsg13cmos5l_decap_8_1630 VPWR VGND sg13cmos5l_decap_8
* cell instance sg13cmos5l_decap_8_1631 r0 *1 0,0
Xsg13cmos5l_decap_8_1631 VPWR VGND sg13cmos5l_decap_8
* cell instance sg13cmos5l_decap_8_1632 r0 *1 0,0
Xsg13cmos5l_decap_8_1632 VPWR VGND sg13cmos5l_decap_8
* cell instance sg13cmos5l_decap_8_1633 r0 *1 0,0
Xsg13cmos5l_decap_8_1633 VPWR VGND sg13cmos5l_decap_8
* cell instance sg13cmos5l_decap_8_1634 r0 *1 0,0
Xsg13cmos5l_decap_8_1634 VPWR VGND sg13cmos5l_decap_8
* cell instance sg13cmos5l_decap_8_1635 r0 *1 0,0
Xsg13cmos5l_decap_8_1635 VPWR VGND sg13cmos5l_decap_8
* cell instance sg13cmos5l_decap_8_1636 r0 *1 0,0
Xsg13cmos5l_decap_8_1636 VPWR VGND sg13cmos5l_decap_8
* cell instance sg13cmos5l_decap_8_1637 r0 *1 0,0
Xsg13cmos5l_decap_8_1637 VPWR VGND sg13cmos5l_decap_8
* cell instance sg13cmos5l_decap_8_1638 r0 *1 0,0
Xsg13cmos5l_decap_8_1638 VPWR VGND sg13cmos5l_decap_8
* cell instance sg13cmos5l_decap_8_1639 r0 *1 0,0
Xsg13cmos5l_decap_8_1639 VPWR VGND sg13cmos5l_decap_8
* cell instance sg13cmos5l_decap_8_1640 r0 *1 0,0
Xsg13cmos5l_decap_8_1640 VPWR VGND sg13cmos5l_decap_8
* cell instance sg13cmos5l_decap_8_1641 r0 *1 0,0
Xsg13cmos5l_decap_8_1641 VPWR VGND sg13cmos5l_decap_8
* cell instance sg13cmos5l_decap_8_1642 r0 *1 0,0
Xsg13cmos5l_decap_8_1642 VPWR VGND sg13cmos5l_decap_8
* cell instance sg13cmos5l_decap_8_1643 r0 *1 0,0
Xsg13cmos5l_decap_8_1643 VPWR VGND sg13cmos5l_decap_8
* cell instance sg13cmos5l_decap_8_1644 r0 *1 0,0
Xsg13cmos5l_decap_8_1644 VPWR VGND sg13cmos5l_decap_8
* cell instance sg13cmos5l_decap_8_1645 r0 *1 0,0
Xsg13cmos5l_decap_8_1645 VPWR VGND sg13cmos5l_decap_8
* cell instance sg13cmos5l_decap_8_1646 r0 *1 0,0
Xsg13cmos5l_decap_8_1646 VPWR VGND sg13cmos5l_decap_8
* cell instance sg13cmos5l_decap_8_1647 r0 *1 0,0
Xsg13cmos5l_decap_8_1647 VPWR VGND sg13cmos5l_decap_8
* cell instance sg13cmos5l_decap_8_1648 r0 *1 0,0
Xsg13cmos5l_decap_8_1648 VPWR VGND sg13cmos5l_decap_8
* cell instance sg13cmos5l_decap_8_1649 r0 *1 0,0
Xsg13cmos5l_decap_8_1649 VPWR VGND sg13cmos5l_decap_8
* cell instance sg13cmos5l_decap_8_1650 r0 *1 0,0
Xsg13cmos5l_decap_8_1650 VPWR VGND sg13cmos5l_decap_8
* cell instance sg13cmos5l_decap_8_1651 r0 *1 0,0
Xsg13cmos5l_decap_8_1651 VPWR VGND sg13cmos5l_decap_8
* cell instance sg13cmos5l_decap_8_1652 r0 *1 0,0
Xsg13cmos5l_decap_8_1652 VPWR VGND sg13cmos5l_decap_8
* cell instance sg13cmos5l_decap_8_1653 r0 *1 0,0
Xsg13cmos5l_decap_8_1653 VPWR VGND sg13cmos5l_decap_8
* cell instance sg13cmos5l_decap_8_1654 r0 *1 0,0
Xsg13cmos5l_decap_8_1654 VPWR VGND sg13cmos5l_decap_8
* cell instance sg13cmos5l_decap_8_1655 r0 *1 0,0
Xsg13cmos5l_decap_8_1655 VPWR VGND sg13cmos5l_decap_8
* cell instance sg13cmos5l_decap_8_1656 r0 *1 0,0
Xsg13cmos5l_decap_8_1656 VPWR VGND sg13cmos5l_decap_8
* cell instance sg13cmos5l_decap_8_1657 r0 *1 0,0
Xsg13cmos5l_decap_8_1657 VPWR VGND sg13cmos5l_decap_8
* cell instance sg13cmos5l_decap_8_1658 r0 *1 0,0
Xsg13cmos5l_decap_8_1658 VPWR VGND sg13cmos5l_decap_8
* cell instance sg13cmos5l_decap_8_1659 r0 *1 0,0
Xsg13cmos5l_decap_8_1659 VPWR VGND sg13cmos5l_decap_8
* cell instance sg13cmos5l_decap_8_1660 r0 *1 0,0
Xsg13cmos5l_decap_8_1660 VPWR VGND sg13cmos5l_decap_8
* cell instance sg13cmos5l_decap_8_1661 r0 *1 0,0
Xsg13cmos5l_decap_8_1661 VPWR VGND sg13cmos5l_decap_8
* cell instance sg13cmos5l_decap_8_1662 r0 *1 0,0
Xsg13cmos5l_decap_8_1662 VPWR VGND sg13cmos5l_decap_8
* cell instance sg13cmos5l_decap_8_1663 r0 *1 0,0
Xsg13cmos5l_decap_8_1663 VPWR VGND sg13cmos5l_decap_8
* cell instance sg13cmos5l_decap_8_1664 r0 *1 0,0
Xsg13cmos5l_decap_8_1664 VPWR VGND sg13cmos5l_decap_8
* cell instance sg13cmos5l_decap_8_1665 r0 *1 0,0
Xsg13cmos5l_decap_8_1665 VPWR VGND sg13cmos5l_decap_8
* cell instance sg13cmos5l_decap_8_1666 r0 *1 0,0
Xsg13cmos5l_decap_8_1666 VPWR VGND sg13cmos5l_decap_8
* cell instance sg13cmos5l_decap_8_1667 r0 *1 0,0
Xsg13cmos5l_decap_8_1667 VPWR VGND sg13cmos5l_decap_8
* cell instance sg13cmos5l_decap_8_1668 r0 *1 0,0
Xsg13cmos5l_decap_8_1668 VPWR VGND sg13cmos5l_decap_8
* cell instance sg13cmos5l_decap_8_1669 r0 *1 0,0
Xsg13cmos5l_decap_8_1669 VPWR VGND sg13cmos5l_decap_8
* cell instance sg13cmos5l_decap_8_1670 r0 *1 0,0
Xsg13cmos5l_decap_8_1670 VPWR VGND sg13cmos5l_decap_8
* cell instance sg13cmos5l_decap_8_1671 r0 *1 0,0
Xsg13cmos5l_decap_8_1671 VPWR VGND sg13cmos5l_decap_8
* cell instance sg13cmos5l_decap_8_1672 r0 *1 0,0
Xsg13cmos5l_decap_8_1672 VPWR VGND sg13cmos5l_decap_8
* cell instance sg13cmos5l_decap_8_1673 r0 *1 0,0
Xsg13cmos5l_decap_8_1673 VPWR VGND sg13cmos5l_decap_8
* cell instance sg13cmos5l_decap_8_1674 r0 *1 0,0
Xsg13cmos5l_decap_8_1674 VPWR VGND sg13cmos5l_decap_8
* cell instance sg13cmos5l_decap_8_1675 r0 *1 0,0
Xsg13cmos5l_decap_8_1675 VPWR VGND sg13cmos5l_decap_8
* cell instance sg13cmos5l_decap_8_1676 r0 *1 0,0
Xsg13cmos5l_decap_8_1676 VPWR VGND sg13cmos5l_decap_8
* cell instance sg13cmos5l_decap_8_1677 r0 *1 0,0
Xsg13cmos5l_decap_8_1677 VPWR VGND sg13cmos5l_decap_8
* cell instance sg13cmos5l_decap_8_1678 r0 *1 0,0
Xsg13cmos5l_decap_8_1678 VPWR VGND sg13cmos5l_decap_8
* cell instance sg13cmos5l_decap_8_1679 r0 *1 0,0
Xsg13cmos5l_decap_8_1679 VPWR VGND sg13cmos5l_decap_8
* cell instance sg13cmos5l_decap_8_1680 r0 *1 0,0
Xsg13cmos5l_decap_8_1680 VPWR VGND sg13cmos5l_decap_8
* cell instance sg13cmos5l_decap_8_1681 r0 *1 0,0
Xsg13cmos5l_decap_8_1681 VPWR VGND sg13cmos5l_decap_8
* cell instance sg13cmos5l_decap_8_1682 r0 *1 0,0
Xsg13cmos5l_decap_8_1682 VPWR VGND sg13cmos5l_decap_8
* cell instance sg13cmos5l_decap_8_1683 r0 *1 0,0
Xsg13cmos5l_decap_8_1683 VPWR VGND sg13cmos5l_decap_8
* cell instance sg13cmos5l_decap_8_1684 r0 *1 0,0
Xsg13cmos5l_decap_8_1684 VPWR VGND sg13cmos5l_decap_8
* cell instance sg13cmos5l_decap_8_1685 r0 *1 0,0
Xsg13cmos5l_decap_8_1685 VPWR VGND sg13cmos5l_decap_8
* cell instance sg13cmos5l_decap_8_1686 r0 *1 0,0
Xsg13cmos5l_decap_8_1686 VPWR VGND sg13cmos5l_decap_8
* cell instance sg13cmos5l_decap_8_1687 r0 *1 0,0
Xsg13cmos5l_decap_8_1687 VPWR VGND sg13cmos5l_decap_8
* cell instance sg13cmos5l_decap_8_1688 r0 *1 0,0
Xsg13cmos5l_decap_8_1688 VPWR VGND sg13cmos5l_decap_8
* cell instance sg13cmos5l_decap_8_1689 r0 *1 0,0
Xsg13cmos5l_decap_8_1689 VPWR VGND sg13cmos5l_decap_8
* cell instance sg13cmos5l_decap_8_1690 r0 *1 0,0
Xsg13cmos5l_decap_8_1690 VPWR VGND sg13cmos5l_decap_8
* cell instance sg13cmos5l_decap_8_1691 r0 *1 0,0
Xsg13cmos5l_decap_8_1691 VPWR VGND sg13cmos5l_decap_8
* cell instance sg13cmos5l_decap_8_1692 r0 *1 0,0
Xsg13cmos5l_decap_8_1692 VPWR VGND sg13cmos5l_decap_8
* cell instance sg13cmos5l_decap_8_1693 r0 *1 0,0
Xsg13cmos5l_decap_8_1693 VPWR VGND sg13cmos5l_decap_8
* cell instance sg13cmos5l_decap_8_1694 r0 *1 0,0
Xsg13cmos5l_decap_8_1694 VPWR VGND sg13cmos5l_decap_8
* cell instance sg13cmos5l_decap_8_1695 r0 *1 0,0
Xsg13cmos5l_decap_8_1695 VPWR VGND sg13cmos5l_decap_8
* cell instance sg13cmos5l_decap_8_1696 r0 *1 0,0
Xsg13cmos5l_decap_8_1696 VPWR VGND sg13cmos5l_decap_8
* cell instance sg13cmos5l_decap_8_1697 r0 *1 0,0
Xsg13cmos5l_decap_8_1697 VPWR VGND sg13cmos5l_decap_8
* cell instance sg13cmos5l_decap_8_1698 r0 *1 0,0
Xsg13cmos5l_decap_8_1698 VPWR VGND sg13cmos5l_decap_8
* cell instance sg13cmos5l_decap_8_1699 r0 *1 0,0
Xsg13cmos5l_decap_8_1699 VPWR VGND sg13cmos5l_decap_8
* cell instance sg13cmos5l_decap_8_1700 r0 *1 0,0
Xsg13cmos5l_decap_8_1700 VPWR VGND sg13cmos5l_decap_8
* cell instance sg13cmos5l_decap_8_1701 r0 *1 0,0
Xsg13cmos5l_decap_8_1701 VPWR VGND sg13cmos5l_decap_8
* cell instance sg13cmos5l_decap_8_1702 r0 *1 0,0
Xsg13cmos5l_decap_8_1702 VPWR VGND sg13cmos5l_decap_8
* cell instance sg13cmos5l_decap_8_1703 r0 *1 0,0
Xsg13cmos5l_decap_8_1703 VPWR VGND sg13cmos5l_decap_8
* cell instance sg13cmos5l_decap_8_1704 r0 *1 0,0
Xsg13cmos5l_decap_8_1704 VPWR VGND sg13cmos5l_decap_8
* cell instance sg13cmos5l_decap_8_1705 r0 *1 0,0
Xsg13cmos5l_decap_8_1705 VPWR VGND sg13cmos5l_decap_8
* cell instance sg13cmos5l_decap_8_1706 r0 *1 0,0
Xsg13cmos5l_decap_8_1706 VPWR VGND sg13cmos5l_decap_8
* cell instance sg13cmos5l_decap_8_1707 r0 *1 0,0
Xsg13cmos5l_decap_8_1707 VPWR VGND sg13cmos5l_decap_8
* cell instance sg13cmos5l_decap_8_1708 r0 *1 0,0
Xsg13cmos5l_decap_8_1708 VPWR VGND sg13cmos5l_decap_8
* cell instance sg13cmos5l_decap_8_1709 r0 *1 0,0
Xsg13cmos5l_decap_8_1709 VPWR VGND sg13cmos5l_decap_8
* cell instance sg13cmos5l_decap_8_1710 r0 *1 0,0
Xsg13cmos5l_decap_8_1710 VPWR VGND sg13cmos5l_decap_8
* cell instance sg13cmos5l_decap_8_1711 r0 *1 0,0
Xsg13cmos5l_decap_8_1711 VPWR VGND sg13cmos5l_decap_8
* cell instance sg13cmos5l_decap_8_1712 r0 *1 0,0
Xsg13cmos5l_decap_8_1712 VPWR VGND sg13cmos5l_decap_8
* cell instance sg13cmos5l_decap_8_1713 r0 *1 0,0
Xsg13cmos5l_decap_8_1713 VPWR VGND sg13cmos5l_decap_8
* cell instance sg13cmos5l_decap_8_1714 r0 *1 0,0
Xsg13cmos5l_decap_8_1714 VPWR VGND sg13cmos5l_decap_8
* cell instance sg13cmos5l_decap_8_1715 r0 *1 0,0
Xsg13cmos5l_decap_8_1715 VPWR VGND sg13cmos5l_decap_8
* cell instance sg13cmos5l_decap_8_1716 r0 *1 0,0
Xsg13cmos5l_decap_8_1716 VPWR VGND sg13cmos5l_decap_8
* cell instance sg13cmos5l_decap_8_1717 r0 *1 0,0
Xsg13cmos5l_decap_8_1717 VPWR VGND sg13cmos5l_decap_8
* cell instance sg13cmos5l_decap_8_1718 r0 *1 0,0
Xsg13cmos5l_decap_8_1718 VPWR VGND sg13cmos5l_decap_8
* cell instance sg13cmos5l_decap_8_1719 r0 *1 0,0
Xsg13cmos5l_decap_8_1719 VPWR VGND sg13cmos5l_decap_8
* cell instance sg13cmos5l_decap_8_1720 r0 *1 0,0
Xsg13cmos5l_decap_8_1720 VPWR VGND sg13cmos5l_decap_8
* cell instance sg13cmos5l_decap_8_1721 r0 *1 0,0
Xsg13cmos5l_decap_8_1721 VPWR VGND sg13cmos5l_decap_8
* cell instance sg13cmos5l_decap_8_1722 r0 *1 0,0
Xsg13cmos5l_decap_8_1722 VPWR VGND sg13cmos5l_decap_8
* cell instance sg13cmos5l_decap_8_1723 r0 *1 0,0
Xsg13cmos5l_decap_8_1723 VPWR VGND sg13cmos5l_decap_8
* cell instance sg13cmos5l_decap_8_1724 r0 *1 0,0
Xsg13cmos5l_decap_8_1724 VPWR VGND sg13cmos5l_decap_8
* cell instance sg13cmos5l_decap_8_1725 r0 *1 0,0
Xsg13cmos5l_decap_8_1725 VPWR VGND sg13cmos5l_decap_8
* cell instance sg13cmos5l_decap_8_1726 r0 *1 0,0
Xsg13cmos5l_decap_8_1726 VPWR VGND sg13cmos5l_decap_8
* cell instance sg13cmos5l_decap_8_1727 r0 *1 0,0
Xsg13cmos5l_decap_8_1727 VPWR VGND sg13cmos5l_decap_8
* cell instance sg13cmos5l_decap_8_1728 r0 *1 0,0
Xsg13cmos5l_decap_8_1728 VPWR VGND sg13cmos5l_decap_8
* cell instance sg13cmos5l_decap_8_1729 r0 *1 0,0
Xsg13cmos5l_decap_8_1729 VPWR VGND sg13cmos5l_decap_8
* cell instance sg13cmos5l_decap_8_1730 r0 *1 0,0
Xsg13cmos5l_decap_8_1730 VPWR VGND sg13cmos5l_decap_8
* cell instance sg13cmos5l_decap_8_1731 r0 *1 0,0
Xsg13cmos5l_decap_8_1731 VPWR VGND sg13cmos5l_decap_8
* cell instance sg13cmos5l_decap_8_1732 r0 *1 0,0
Xsg13cmos5l_decap_8_1732 VPWR VGND sg13cmos5l_decap_8
* cell instance sg13cmos5l_decap_8_1733 r0 *1 0,0
Xsg13cmos5l_decap_8_1733 VPWR VGND sg13cmos5l_decap_8
* cell instance sg13cmos5l_decap_8_1734 r0 *1 0,0
Xsg13cmos5l_decap_8_1734 VPWR VGND sg13cmos5l_decap_8
* cell instance sg13cmos5l_decap_8_1735 r0 *1 0,0
Xsg13cmos5l_decap_8_1735 VPWR VGND sg13cmos5l_decap_8
* cell instance sg13cmos5l_decap_8_1736 r0 *1 0,0
Xsg13cmos5l_decap_8_1736 VPWR VGND sg13cmos5l_decap_8
* cell instance sg13cmos5l_decap_8_1737 r0 *1 0,0
Xsg13cmos5l_decap_8_1737 VPWR VGND sg13cmos5l_decap_8
* cell instance sg13cmos5l_decap_8_1738 r0 *1 0,0
Xsg13cmos5l_decap_8_1738 VPWR VGND sg13cmos5l_decap_8
* cell instance sg13cmos5l_decap_8_1739 r0 *1 0,0
Xsg13cmos5l_decap_8_1739 VPWR VGND sg13cmos5l_decap_8
* cell instance sg13cmos5l_decap_8_1740 r0 *1 0,0
Xsg13cmos5l_decap_8_1740 VPWR VGND sg13cmos5l_decap_8
* cell instance sg13cmos5l_decap_8_1741 r0 *1 0,0
Xsg13cmos5l_decap_8_1741 VPWR VGND sg13cmos5l_decap_8
* cell instance sg13cmos5l_decap_8_1742 r0 *1 0,0
Xsg13cmos5l_decap_8_1742 VPWR VGND sg13cmos5l_decap_8
* cell instance sg13cmos5l_decap_8_1743 r0 *1 0,0
Xsg13cmos5l_decap_8_1743 VPWR VGND sg13cmos5l_decap_8
* cell instance sg13cmos5l_decap_8_1744 r0 *1 0,0
Xsg13cmos5l_decap_8_1744 VPWR VGND sg13cmos5l_decap_8
* cell instance sg13cmos5l_decap_8_1745 r0 *1 0,0
Xsg13cmos5l_decap_8_1745 VPWR VGND sg13cmos5l_decap_8
* cell instance sg13cmos5l_decap_8_1746 r0 *1 0,0
Xsg13cmos5l_decap_8_1746 VPWR VGND sg13cmos5l_decap_8
* cell instance sg13cmos5l_decap_8_1747 r0 *1 0,0
Xsg13cmos5l_decap_8_1747 VPWR VGND sg13cmos5l_decap_8
* cell instance sg13cmos5l_decap_8_1748 r0 *1 0,0
Xsg13cmos5l_decap_8_1748 VPWR VGND sg13cmos5l_decap_8
* cell instance sg13cmos5l_decap_8_1749 r0 *1 0,0
Xsg13cmos5l_decap_8_1749 VPWR VGND sg13cmos5l_decap_8
* cell instance sg13cmos5l_decap_8_1750 r0 *1 0,0
Xsg13cmos5l_decap_8_1750 VPWR VGND sg13cmos5l_decap_8
* cell instance sg13cmos5l_decap_8_1751 r0 *1 0,0
Xsg13cmos5l_decap_8_1751 VPWR VGND sg13cmos5l_decap_8
* cell instance sg13cmos5l_decap_8_1752 r0 *1 0,0
Xsg13cmos5l_decap_8_1752 VPWR VGND sg13cmos5l_decap_8
* cell instance sg13cmos5l_decap_8_1753 r0 *1 0,0
Xsg13cmos5l_decap_8_1753 VPWR VGND sg13cmos5l_decap_8
* cell instance sg13cmos5l_decap_8_1754 r0 *1 0,0
Xsg13cmos5l_decap_8_1754 VPWR VGND sg13cmos5l_decap_8
* cell instance sg13cmos5l_decap_8_1755 r0 *1 0,0
Xsg13cmos5l_decap_8_1755 VPWR VGND sg13cmos5l_decap_8
* cell instance sg13cmos5l_decap_8_1756 r0 *1 0,0
Xsg13cmos5l_decap_8_1756 VPWR VGND sg13cmos5l_decap_8
* cell instance sg13cmos5l_decap_8_1757 r0 *1 0,0
Xsg13cmos5l_decap_8_1757 VPWR VGND sg13cmos5l_decap_8
* cell instance sg13cmos5l_decap_8_1758 r0 *1 0,0
Xsg13cmos5l_decap_8_1758 VPWR VGND sg13cmos5l_decap_8
* cell instance sg13cmos5l_decap_8_1759 r0 *1 0,0
Xsg13cmos5l_decap_8_1759 VPWR VGND sg13cmos5l_decap_8
* cell instance sg13cmos5l_decap_8_1760 r0 *1 0,0
Xsg13cmos5l_decap_8_1760 VPWR VGND sg13cmos5l_decap_8
* cell instance sg13cmos5l_decap_8_1761 r0 *1 0,0
Xsg13cmos5l_decap_8_1761 VPWR VGND sg13cmos5l_decap_8
* cell instance sg13cmos5l_decap_8_1762 r0 *1 0,0
Xsg13cmos5l_decap_8_1762 VPWR VGND sg13cmos5l_decap_8
* cell instance sg13cmos5l_decap_8_1763 r0 *1 0,0
Xsg13cmos5l_decap_8_1763 VPWR VGND sg13cmos5l_decap_8
* cell instance sg13cmos5l_decap_8_1764 r0 *1 0,0
Xsg13cmos5l_decap_8_1764 VPWR VGND sg13cmos5l_decap_8
* cell instance sg13cmos5l_decap_8_1765 r0 *1 0,0
Xsg13cmos5l_decap_8_1765 VPWR VGND sg13cmos5l_decap_8
* cell instance sg13cmos5l_decap_8_1766 r0 *1 0,0
Xsg13cmos5l_decap_8_1766 VPWR VGND sg13cmos5l_decap_8
* cell instance sg13cmos5l_decap_8_1767 r0 *1 0,0
Xsg13cmos5l_decap_8_1767 VPWR VGND sg13cmos5l_decap_8
* cell instance sg13cmos5l_decap_8_1768 r0 *1 0,0
Xsg13cmos5l_decap_8_1768 VPWR VGND sg13cmos5l_decap_8
* cell instance sg13cmos5l_decap_8_1769 r0 *1 0,0
Xsg13cmos5l_decap_8_1769 VPWR VGND sg13cmos5l_decap_8
* cell instance sg13cmos5l_decap_8_1770 r0 *1 0,0
Xsg13cmos5l_decap_8_1770 VPWR VGND sg13cmos5l_decap_8
* cell instance sg13cmos5l_decap_8_1771 r0 *1 0,0
Xsg13cmos5l_decap_8_1771 VPWR VGND sg13cmos5l_decap_8
* cell instance sg13cmos5l_decap_8_1772 r0 *1 0,0
Xsg13cmos5l_decap_8_1772 VPWR VGND sg13cmos5l_decap_8
* cell instance sg13cmos5l_decap_8_1773 r0 *1 0,0
Xsg13cmos5l_decap_8_1773 VPWR VGND sg13cmos5l_decap_8
* cell instance sg13cmos5l_decap_8_1774 r0 *1 0,0
Xsg13cmos5l_decap_8_1774 VPWR VGND sg13cmos5l_decap_8
* cell instance sg13cmos5l_decap_8_1775 r0 *1 0,0
Xsg13cmos5l_decap_8_1775 VPWR VGND sg13cmos5l_decap_8
* cell instance sg13cmos5l_decap_8_1776 r0 *1 0,0
Xsg13cmos5l_decap_8_1776 VPWR VGND sg13cmos5l_decap_8
* cell instance sg13cmos5l_decap_8_1777 r0 *1 0,0
Xsg13cmos5l_decap_8_1777 VPWR VGND sg13cmos5l_decap_8
* cell instance sg13cmos5l_decap_8_1778 r0 *1 0,0
Xsg13cmos5l_decap_8_1778 VPWR VGND sg13cmos5l_decap_8
* cell instance sg13cmos5l_decap_8_1779 r0 *1 0,0
Xsg13cmos5l_decap_8_1779 VPWR VGND sg13cmos5l_decap_8
* cell instance sg13cmos5l_decap_8_1780 r0 *1 0,0
Xsg13cmos5l_decap_8_1780 VPWR VGND sg13cmos5l_decap_8
* cell instance sg13cmos5l_decap_8_1781 r0 *1 0,0
Xsg13cmos5l_decap_8_1781 VPWR VGND sg13cmos5l_decap_8
* cell instance sg13cmos5l_decap_8_1782 r0 *1 0,0
Xsg13cmos5l_decap_8_1782 VPWR VGND sg13cmos5l_decap_8
* cell instance sg13cmos5l_decap_8_1783 r0 *1 0,0
Xsg13cmos5l_decap_8_1783 VPWR VGND sg13cmos5l_decap_8
* cell instance sg13cmos5l_decap_8_1784 r0 *1 0,0
Xsg13cmos5l_decap_8_1784 VPWR VGND sg13cmos5l_decap_8
* cell instance sg13cmos5l_decap_8_1785 r0 *1 0,0
Xsg13cmos5l_decap_8_1785 VPWR VGND sg13cmos5l_decap_8
* cell instance sg13cmos5l_decap_8_1786 r0 *1 0,0
Xsg13cmos5l_decap_8_1786 VPWR VGND sg13cmos5l_decap_8
* cell instance sg13cmos5l_decap_8_1787 r0 *1 0,0
Xsg13cmos5l_decap_8_1787 VPWR VGND sg13cmos5l_decap_8
* cell instance sg13cmos5l_decap_8_1788 r0 *1 0,0
Xsg13cmos5l_decap_8_1788 VPWR VGND sg13cmos5l_decap_8
* cell instance sg13cmos5l_decap_8_1789 r0 *1 0,0
Xsg13cmos5l_decap_8_1789 VPWR VGND sg13cmos5l_decap_8
* cell instance sg13cmos5l_decap_8_1790 r0 *1 0,0
Xsg13cmos5l_decap_8_1790 VPWR VGND sg13cmos5l_decap_8
* cell instance sg13cmos5l_decap_8_1791 r0 *1 0,0
Xsg13cmos5l_decap_8_1791 VPWR VGND sg13cmos5l_decap_8
* cell instance sg13cmos5l_decap_8_1792 r0 *1 0,0
Xsg13cmos5l_decap_8_1792 VPWR VGND sg13cmos5l_decap_8
* cell instance sg13cmos5l_decap_8_1793 r0 *1 0,0
Xsg13cmos5l_decap_8_1793 VPWR VGND sg13cmos5l_decap_8
* cell instance sg13cmos5l_decap_8_1794 r0 *1 0,0
Xsg13cmos5l_decap_8_1794 VPWR VGND sg13cmos5l_decap_8
* cell instance sg13cmos5l_decap_8_1795 r0 *1 0,0
Xsg13cmos5l_decap_8_1795 VPWR VGND sg13cmos5l_decap_8
* cell instance sg13cmos5l_decap_8_1796 r0 *1 0,0
Xsg13cmos5l_decap_8_1796 VPWR VGND sg13cmos5l_decap_8
* cell instance sg13cmos5l_decap_8_1797 r0 *1 0,0
Xsg13cmos5l_decap_8_1797 VPWR VGND sg13cmos5l_decap_8
* cell instance sg13cmos5l_decap_8_1798 r0 *1 0,0
Xsg13cmos5l_decap_8_1798 VPWR VGND sg13cmos5l_decap_8
* cell instance sg13cmos5l_decap_8_1799 r0 *1 0,0
Xsg13cmos5l_decap_8_1799 VPWR VGND sg13cmos5l_decap_8
* cell instance sg13cmos5l_decap_8_1800 r0 *1 0,0
Xsg13cmos5l_decap_8_1800 VPWR VGND sg13cmos5l_decap_8
* cell instance sg13cmos5l_decap_8_1801 r0 *1 0,0
Xsg13cmos5l_decap_8_1801 VPWR VGND sg13cmos5l_decap_8
* cell instance sg13cmos5l_decap_8_1802 r0 *1 0,0
Xsg13cmos5l_decap_8_1802 VPWR VGND sg13cmos5l_decap_8
* cell instance sg13cmos5l_decap_8_1803 r0 *1 0,0
Xsg13cmos5l_decap_8_1803 VPWR VGND sg13cmos5l_decap_8
* cell instance sg13cmos5l_decap_8_1804 r0 *1 0,0
Xsg13cmos5l_decap_8_1804 VPWR VGND sg13cmos5l_decap_8
* cell instance sg13cmos5l_decap_8_1805 r0 *1 0,0
Xsg13cmos5l_decap_8_1805 VPWR VGND sg13cmos5l_decap_8
* cell instance sg13cmos5l_decap_8_1806 r0 *1 0,0
Xsg13cmos5l_decap_8_1806 VPWR VGND sg13cmos5l_decap_8
* cell instance sg13cmos5l_decap_8_1807 r0 *1 0,0
Xsg13cmos5l_decap_8_1807 VPWR VGND sg13cmos5l_decap_8
* cell instance sg13cmos5l_decap_8_1808 r0 *1 0,0
Xsg13cmos5l_decap_8_1808 VPWR VGND sg13cmos5l_decap_8
* cell instance sg13cmos5l_decap_8_1809 r0 *1 0,0
Xsg13cmos5l_decap_8_1809 VPWR VGND sg13cmos5l_decap_8
* cell instance sg13cmos5l_decap_8_1810 r0 *1 0,0
Xsg13cmos5l_decap_8_1810 VPWR VGND sg13cmos5l_decap_8
* cell instance sg13cmos5l_decap_8_1811 r0 *1 0,0
Xsg13cmos5l_decap_8_1811 VPWR VGND sg13cmos5l_decap_8
* cell instance sg13cmos5l_decap_8_1812 r0 *1 0,0
Xsg13cmos5l_decap_8_1812 VPWR VGND sg13cmos5l_decap_8
* cell instance sg13cmos5l_decap_8_1813 r0 *1 0,0
Xsg13cmos5l_decap_8_1813 VPWR VGND sg13cmos5l_decap_8
* cell instance sg13cmos5l_decap_8_1814 r0 *1 0,0
Xsg13cmos5l_decap_8_1814 VPWR VGND sg13cmos5l_decap_8
* cell instance sg13cmos5l_decap_8_1815 r0 *1 0,0
Xsg13cmos5l_decap_8_1815 VPWR VGND sg13cmos5l_decap_8
* cell instance sg13cmos5l_decap_8_1816 r0 *1 0,0
Xsg13cmos5l_decap_8_1816 VPWR VGND sg13cmos5l_decap_8
* cell instance sg13cmos5l_decap_8_1817 r0 *1 0,0
Xsg13cmos5l_decap_8_1817 VPWR VGND sg13cmos5l_decap_8
* cell instance sg13cmos5l_decap_8_1818 r0 *1 0,0
Xsg13cmos5l_decap_8_1818 VPWR VGND sg13cmos5l_decap_8
* cell instance sg13cmos5l_decap_8_1819 r0 *1 0,0
Xsg13cmos5l_decap_8_1819 VPWR VGND sg13cmos5l_decap_8
* cell instance sg13cmos5l_decap_8_1820 r0 *1 0,0
Xsg13cmos5l_decap_8_1820 VPWR VGND sg13cmos5l_decap_8
* cell instance sg13cmos5l_decap_8_1821 r0 *1 0,0
Xsg13cmos5l_decap_8_1821 VPWR VGND sg13cmos5l_decap_8
* cell instance sg13cmos5l_decap_8_1822 r0 *1 0,0
Xsg13cmos5l_decap_8_1822 VPWR VGND sg13cmos5l_decap_8
* cell instance sg13cmos5l_decap_8_1823 r0 *1 0,0
Xsg13cmos5l_decap_8_1823 VPWR VGND sg13cmos5l_decap_8
* cell instance sg13cmos5l_decap_8_1824 r0 *1 0,0
Xsg13cmos5l_decap_8_1824 VPWR VGND sg13cmos5l_decap_8
* cell instance sg13cmos5l_decap_8_1825 r0 *1 0,0
Xsg13cmos5l_decap_8_1825 VPWR VGND sg13cmos5l_decap_8
* cell instance sg13cmos5l_decap_8_1826 r0 *1 0,0
Xsg13cmos5l_decap_8_1826 VPWR VGND sg13cmos5l_decap_8
* cell instance sg13cmos5l_decap_8_1827 r0 *1 0,0
Xsg13cmos5l_decap_8_1827 VPWR VGND sg13cmos5l_decap_8
* cell instance sg13cmos5l_decap_8_1828 r0 *1 0,0
Xsg13cmos5l_decap_8_1828 VPWR VGND sg13cmos5l_decap_8
* cell instance sg13cmos5l_decap_8_1829 r0 *1 0,0
Xsg13cmos5l_decap_8_1829 VPWR VGND sg13cmos5l_decap_8
* cell instance sg13cmos5l_decap_8_1830 r0 *1 0,0
Xsg13cmos5l_decap_8_1830 VPWR VGND sg13cmos5l_decap_8
* cell instance sg13cmos5l_decap_8_1831 r0 *1 0,0
Xsg13cmos5l_decap_8_1831 VPWR VGND sg13cmos5l_decap_8
* cell instance sg13cmos5l_decap_8_1832 r0 *1 0,0
Xsg13cmos5l_decap_8_1832 VPWR VGND sg13cmos5l_decap_8
* cell instance sg13cmos5l_decap_8_1833 r0 *1 0,0
Xsg13cmos5l_decap_8_1833 VPWR VGND sg13cmos5l_decap_8
* cell instance sg13cmos5l_decap_8_1834 r0 *1 0,0
Xsg13cmos5l_decap_8_1834 VPWR VGND sg13cmos5l_decap_8
* cell instance sg13cmos5l_decap_8_1835 r0 *1 0,0
Xsg13cmos5l_decap_8_1835 VPWR VGND sg13cmos5l_decap_8
* cell instance sg13cmos5l_decap_8_1836 r0 *1 0,0
Xsg13cmos5l_decap_8_1836 VPWR VGND sg13cmos5l_decap_8
* cell instance sg13cmos5l_decap_8_1837 r0 *1 0,0
Xsg13cmos5l_decap_8_1837 VPWR VGND sg13cmos5l_decap_8
* cell instance sg13cmos5l_decap_8_1838 r0 *1 0,0
Xsg13cmos5l_decap_8_1838 VPWR VGND sg13cmos5l_decap_8
* cell instance sg13cmos5l_decap_8_1839 r0 *1 0,0
Xsg13cmos5l_decap_8_1839 VPWR VGND sg13cmos5l_decap_8
* cell instance sg13cmos5l_decap_8_1840 r0 *1 0,0
Xsg13cmos5l_decap_8_1840 VPWR VGND sg13cmos5l_decap_8
* cell instance sg13cmos5l_decap_8_1841 r0 *1 0,0
Xsg13cmos5l_decap_8_1841 VPWR VGND sg13cmos5l_decap_8
* cell instance sg13cmos5l_decap_8_1842 r0 *1 0,0
Xsg13cmos5l_decap_8_1842 VPWR VGND sg13cmos5l_decap_8
* cell instance sg13cmos5l_decap_8_1843 r0 *1 0,0
Xsg13cmos5l_decap_8_1843 VPWR VGND sg13cmos5l_decap_8
* cell instance sg13cmos5l_decap_8_1844 r0 *1 0,0
Xsg13cmos5l_decap_8_1844 VPWR VGND sg13cmos5l_decap_8
* cell instance sg13cmos5l_decap_8_1845 r0 *1 0,0
Xsg13cmos5l_decap_8_1845 VPWR VGND sg13cmos5l_decap_8
* cell instance sg13cmos5l_decap_8_1846 r0 *1 0,0
Xsg13cmos5l_decap_8_1846 VPWR VGND sg13cmos5l_decap_8
* cell instance sg13cmos5l_decap_8_1847 r0 *1 0,0
Xsg13cmos5l_decap_8_1847 VPWR VGND sg13cmos5l_decap_8
* cell instance sg13cmos5l_decap_8_1848 r0 *1 0,0
Xsg13cmos5l_decap_8_1848 VPWR VGND sg13cmos5l_decap_8
* cell instance sg13cmos5l_decap_8_1849 r0 *1 0,0
Xsg13cmos5l_decap_8_1849 VPWR VGND sg13cmos5l_decap_8
* cell instance sg13cmos5l_decap_8_1850 r0 *1 0,0
Xsg13cmos5l_decap_8_1850 VPWR VGND sg13cmos5l_decap_8
* cell instance sg13cmos5l_decap_8_1851 r0 *1 0,0
Xsg13cmos5l_decap_8_1851 VPWR VGND sg13cmos5l_decap_8
* cell instance sg13cmos5l_decap_8_1852 r0 *1 0,0
Xsg13cmos5l_decap_8_1852 VPWR VGND sg13cmos5l_decap_8
* cell instance sg13cmos5l_decap_8_1853 r0 *1 0,0
Xsg13cmos5l_decap_8_1853 VPWR VGND sg13cmos5l_decap_8
* cell instance sg13cmos5l_decap_8_1854 r0 *1 0,0
Xsg13cmos5l_decap_8_1854 VPWR VGND sg13cmos5l_decap_8
* cell instance sg13cmos5l_decap_8_1855 r0 *1 0,0
Xsg13cmos5l_decap_8_1855 VPWR VGND sg13cmos5l_decap_8
* cell instance sg13cmos5l_decap_8_1856 r0 *1 0,0
Xsg13cmos5l_decap_8_1856 VPWR VGND sg13cmos5l_decap_8
* cell instance sg13cmos5l_decap_8_1857 r0 *1 0,0
Xsg13cmos5l_decap_8_1857 VPWR VGND sg13cmos5l_decap_8
* cell instance sg13cmos5l_decap_8_1858 r0 *1 0,0
Xsg13cmos5l_decap_8_1858 VPWR VGND sg13cmos5l_decap_8
* cell instance sg13cmos5l_decap_8_1859 r0 *1 0,0
Xsg13cmos5l_decap_8_1859 VPWR VGND sg13cmos5l_decap_8
* cell instance sg13cmos5l_decap_8_1860 r0 *1 0,0
Xsg13cmos5l_decap_8_1860 VPWR VGND sg13cmos5l_decap_8
* cell instance sg13cmos5l_decap_8_1861 r0 *1 0,0
Xsg13cmos5l_decap_8_1861 VPWR VGND sg13cmos5l_decap_8
* cell instance sg13cmos5l_decap_8_1862 r0 *1 0,0
Xsg13cmos5l_decap_8_1862 VPWR VGND sg13cmos5l_decap_8
* cell instance sg13cmos5l_decap_8_1863 r0 *1 0,0
Xsg13cmos5l_decap_8_1863 VPWR VGND sg13cmos5l_decap_8
* cell instance sg13cmos5l_decap_8_1864 r0 *1 0,0
Xsg13cmos5l_decap_8_1864 VPWR VGND sg13cmos5l_decap_8
* cell instance sg13cmos5l_decap_8_1865 r0 *1 0,0
Xsg13cmos5l_decap_8_1865 VPWR VGND sg13cmos5l_decap_8
* cell instance sg13cmos5l_decap_8_1866 r0 *1 0,0
Xsg13cmos5l_decap_8_1866 VPWR VGND sg13cmos5l_decap_8
* cell instance sg13cmos5l_decap_8_1867 r0 *1 0,0
Xsg13cmos5l_decap_8_1867 VPWR VGND sg13cmos5l_decap_8
* cell instance sg13cmos5l_decap_8_1868 r0 *1 0,0
Xsg13cmos5l_decap_8_1868 VPWR VGND sg13cmos5l_decap_8
* cell instance sg13cmos5l_decap_8_1869 r0 *1 0,0
Xsg13cmos5l_decap_8_1869 VPWR VGND sg13cmos5l_decap_8
* cell instance sg13cmos5l_decap_8_1870 r0 *1 0,0
Xsg13cmos5l_decap_8_1870 VPWR VGND sg13cmos5l_decap_8
* cell instance sg13cmos5l_decap_8_1871 r0 *1 0,0
Xsg13cmos5l_decap_8_1871 VPWR VGND sg13cmos5l_decap_8
* cell instance sg13cmos5l_decap_8_1872 r0 *1 0,0
Xsg13cmos5l_decap_8_1872 VPWR VGND sg13cmos5l_decap_8
* cell instance sg13cmos5l_decap_8_1873 r0 *1 0,0
Xsg13cmos5l_decap_8_1873 VPWR VGND sg13cmos5l_decap_8
* cell instance sg13cmos5l_decap_8_1874 r0 *1 0,0
Xsg13cmos5l_decap_8_1874 VPWR VGND sg13cmos5l_decap_8
* cell instance sg13cmos5l_decap_8_1875 r0 *1 0,0
Xsg13cmos5l_decap_8_1875 VPWR VGND sg13cmos5l_decap_8
* cell instance sg13cmos5l_decap_8_1876 r0 *1 0,0
Xsg13cmos5l_decap_8_1876 VPWR VGND sg13cmos5l_decap_8
* cell instance sg13cmos5l_decap_8_1877 r0 *1 0,0
Xsg13cmos5l_decap_8_1877 VPWR VGND sg13cmos5l_decap_8
* cell instance sg13cmos5l_decap_8_1878 r0 *1 0,0
Xsg13cmos5l_decap_8_1878 VPWR VGND sg13cmos5l_decap_8
* cell instance sg13cmos5l_decap_8_1879 r0 *1 0,0
Xsg13cmos5l_decap_8_1879 VPWR VGND sg13cmos5l_decap_8
* cell instance sg13cmos5l_decap_8_1880 r0 *1 0,0
Xsg13cmos5l_decap_8_1880 VPWR VGND sg13cmos5l_decap_8
* cell instance sg13cmos5l_decap_8_1881 r0 *1 0,0
Xsg13cmos5l_decap_8_1881 VPWR VGND sg13cmos5l_decap_8
* cell instance sg13cmos5l_decap_8_1882 r0 *1 0,0
Xsg13cmos5l_decap_8_1882 VPWR VGND sg13cmos5l_decap_8
* cell instance sg13cmos5l_decap_8_1883 r0 *1 0,0
Xsg13cmos5l_decap_8_1883 VPWR VGND sg13cmos5l_decap_8
* cell instance sg13cmos5l_decap_8_1884 r0 *1 0,0
Xsg13cmos5l_decap_8_1884 VPWR VGND sg13cmos5l_decap_8
* cell instance sg13cmos5l_decap_8_1885 r0 *1 0,0
Xsg13cmos5l_decap_8_1885 VPWR VGND sg13cmos5l_decap_8
* cell instance sg13cmos5l_decap_8_1886 r0 *1 0,0
Xsg13cmos5l_decap_8_1886 VPWR VGND sg13cmos5l_decap_8
* cell instance sg13cmos5l_decap_8_1887 r0 *1 0,0
Xsg13cmos5l_decap_8_1887 VPWR VGND sg13cmos5l_decap_8
* cell instance sg13cmos5l_decap_8_1888 r0 *1 0,0
Xsg13cmos5l_decap_8_1888 VPWR VGND sg13cmos5l_decap_8
* cell instance sg13cmos5l_decap_8_1889 r0 *1 0,0
Xsg13cmos5l_decap_8_1889 VPWR VGND sg13cmos5l_decap_8
* cell instance sg13cmos5l_decap_8_1890 r0 *1 0,0
Xsg13cmos5l_decap_8_1890 VPWR VGND sg13cmos5l_decap_8
* cell instance sg13cmos5l_decap_8_1891 r0 *1 0,0
Xsg13cmos5l_decap_8_1891 VPWR VGND sg13cmos5l_decap_8
* cell instance sg13cmos5l_decap_8_1892 r0 *1 0,0
Xsg13cmos5l_decap_8_1892 VPWR VGND sg13cmos5l_decap_8
* cell instance sg13cmos5l_decap_8_1893 r0 *1 0,0
Xsg13cmos5l_decap_8_1893 VPWR VGND sg13cmos5l_decap_8
* cell instance sg13cmos5l_decap_8_1894 r0 *1 0,0
Xsg13cmos5l_decap_8_1894 VPWR VGND sg13cmos5l_decap_8
* cell instance sg13cmos5l_decap_8_1895 r0 *1 0,0
Xsg13cmos5l_decap_8_1895 VPWR VGND sg13cmos5l_decap_8
* cell instance sg13cmos5l_decap_8_1896 r0 *1 0,0
Xsg13cmos5l_decap_8_1896 VPWR VGND sg13cmos5l_decap_8
* cell instance sg13cmos5l_decap_8_1897 r0 *1 0,0
Xsg13cmos5l_decap_8_1897 VPWR VGND sg13cmos5l_decap_8
* cell instance sg13cmos5l_decap_8_1898 r0 *1 0,0
Xsg13cmos5l_decap_8_1898 VPWR VGND sg13cmos5l_decap_8
* cell instance sg13cmos5l_decap_8_1899 r0 *1 0,0
Xsg13cmos5l_decap_8_1899 VPWR VGND sg13cmos5l_decap_8
* cell instance sg13cmos5l_decap_8_1900 r0 *1 0,0
Xsg13cmos5l_decap_8_1900 VPWR VGND sg13cmos5l_decap_8
* cell instance sg13cmos5l_decap_8_1901 r0 *1 0,0
Xsg13cmos5l_decap_8_1901 VPWR VGND sg13cmos5l_decap_8
* cell instance sg13cmos5l_decap_8_1902 r0 *1 0,0
Xsg13cmos5l_decap_8_1902 VPWR VGND sg13cmos5l_decap_8
* cell instance sg13cmos5l_decap_8_1903 r0 *1 0,0
Xsg13cmos5l_decap_8_1903 VPWR VGND sg13cmos5l_decap_8
* cell instance sg13cmos5l_decap_8_1904 r0 *1 0,0
Xsg13cmos5l_decap_8_1904 VPWR VGND sg13cmos5l_decap_8
* cell instance sg13cmos5l_decap_8_1905 r0 *1 0,0
Xsg13cmos5l_decap_8_1905 VPWR VGND sg13cmos5l_decap_8
* cell instance sg13cmos5l_decap_8_1906 r0 *1 0,0
Xsg13cmos5l_decap_8_1906 VPWR VGND sg13cmos5l_decap_8
* cell instance sg13cmos5l_decap_8_1907 r0 *1 0,0
Xsg13cmos5l_decap_8_1907 VPWR VGND sg13cmos5l_decap_8
* cell instance sg13cmos5l_decap_8_1908 r0 *1 0,0
Xsg13cmos5l_decap_8_1908 VPWR VGND sg13cmos5l_decap_8
* cell instance sg13cmos5l_decap_8_1909 r0 *1 0,0
Xsg13cmos5l_decap_8_1909 VPWR VGND sg13cmos5l_decap_8
* cell instance sg13cmos5l_decap_8_1910 r0 *1 0,0
Xsg13cmos5l_decap_8_1910 VPWR VGND sg13cmos5l_decap_8
* cell instance sg13cmos5l_decap_8_1911 r0 *1 0,0
Xsg13cmos5l_decap_8_1911 VPWR VGND sg13cmos5l_decap_8
* cell instance sg13cmos5l_decap_8_1912 r0 *1 0,0
Xsg13cmos5l_decap_8_1912 VPWR VGND sg13cmos5l_decap_8
* cell instance sg13cmos5l_decap_8_1913 r0 *1 0,0
Xsg13cmos5l_decap_8_1913 VPWR VGND sg13cmos5l_decap_8
* cell instance sg13cmos5l_decap_8_1914 r0 *1 0,0
Xsg13cmos5l_decap_8_1914 VPWR VGND sg13cmos5l_decap_8
* cell instance sg13cmos5l_decap_8_1915 r0 *1 0,0
Xsg13cmos5l_decap_8_1915 VPWR VGND sg13cmos5l_decap_8
* cell instance sg13cmos5l_decap_8_1916 r0 *1 0,0
Xsg13cmos5l_decap_8_1916 VPWR VGND sg13cmos5l_decap_8
* cell instance sg13cmos5l_decap_8_1917 r0 *1 0,0
Xsg13cmos5l_decap_8_1917 VPWR VGND sg13cmos5l_decap_8
* cell instance sg13cmos5l_decap_8_1918 r0 *1 0,0
Xsg13cmos5l_decap_8_1918 VPWR VGND sg13cmos5l_decap_8
* cell instance sg13cmos5l_decap_8_1919 r0 *1 0,0
Xsg13cmos5l_decap_8_1919 VPWR VGND sg13cmos5l_decap_8
* cell instance sg13cmos5l_decap_8_1920 r0 *1 0,0
Xsg13cmos5l_decap_8_1920 VPWR VGND sg13cmos5l_decap_8
* cell instance sg13cmos5l_decap_8_1921 r0 *1 0,0
Xsg13cmos5l_decap_8_1921 VPWR VGND sg13cmos5l_decap_8
* cell instance sg13cmos5l_decap_8_1922 r0 *1 0,0
Xsg13cmos5l_decap_8_1922 VPWR VGND sg13cmos5l_decap_8
* cell instance sg13cmos5l_decap_8_1923 r0 *1 0,0
Xsg13cmos5l_decap_8_1923 VPWR VGND sg13cmos5l_decap_8
* cell instance sg13cmos5l_decap_8_1924 r0 *1 0,0
Xsg13cmos5l_decap_8_1924 VPWR VGND sg13cmos5l_decap_8
* cell instance sg13cmos5l_decap_8_1925 r0 *1 0,0
Xsg13cmos5l_decap_8_1925 VPWR VGND sg13cmos5l_decap_8
* cell instance sg13cmos5l_decap_8_1926 r0 *1 0,0
Xsg13cmos5l_decap_8_1926 VPWR VGND sg13cmos5l_decap_8
* cell instance sg13cmos5l_decap_8_1927 r0 *1 0,0
Xsg13cmos5l_decap_8_1927 VPWR VGND sg13cmos5l_decap_8
* cell instance sg13cmos5l_decap_8_1928 r0 *1 0,0
Xsg13cmos5l_decap_8_1928 VPWR VGND sg13cmos5l_decap_8
* cell instance sg13cmos5l_decap_8_1929 r0 *1 0,0
Xsg13cmos5l_decap_8_1929 VPWR VGND sg13cmos5l_decap_8
* cell instance sg13cmos5l_decap_8_1930 r0 *1 0,0
Xsg13cmos5l_decap_8_1930 VPWR VGND sg13cmos5l_decap_8
* cell instance sg13cmos5l_decap_8_1931 r0 *1 0,0
Xsg13cmos5l_decap_8_1931 VPWR VGND sg13cmos5l_decap_8
* cell instance sg13cmos5l_decap_8_1932 r0 *1 0,0
Xsg13cmos5l_decap_8_1932 VPWR VGND sg13cmos5l_decap_8
* cell instance sg13cmos5l_decap_8_1933 r0 *1 0,0
Xsg13cmos5l_decap_8_1933 VPWR VGND sg13cmos5l_decap_8
* cell instance sg13cmos5l_decap_8_1934 r0 *1 0,0
Xsg13cmos5l_decap_8_1934 VPWR VGND sg13cmos5l_decap_8
* cell instance sg13cmos5l_decap_8_1935 r0 *1 0,0
Xsg13cmos5l_decap_8_1935 VPWR VGND sg13cmos5l_decap_8
* cell instance sg13cmos5l_decap_8_1936 r0 *1 0,0
Xsg13cmos5l_decap_8_1936 VPWR VGND sg13cmos5l_decap_8
* cell instance sg13cmos5l_decap_8_1937 r0 *1 0,0
Xsg13cmos5l_decap_8_1937 VPWR VGND sg13cmos5l_decap_8
* cell instance sg13cmos5l_decap_8_1938 r0 *1 0,0
Xsg13cmos5l_decap_8_1938 VPWR VGND sg13cmos5l_decap_8
* cell instance sg13cmos5l_decap_8_1939 r0 *1 0,0
Xsg13cmos5l_decap_8_1939 VPWR VGND sg13cmos5l_decap_8
* cell instance sg13cmos5l_decap_8_1940 r0 *1 0,0
Xsg13cmos5l_decap_8_1940 VPWR VGND sg13cmos5l_decap_8
* cell instance sg13cmos5l_decap_8_1941 r0 *1 0,0
Xsg13cmos5l_decap_8_1941 VPWR VGND sg13cmos5l_decap_8
* cell instance sg13cmos5l_decap_8_1942 r0 *1 0,0
Xsg13cmos5l_decap_8_1942 VPWR VGND sg13cmos5l_decap_8
* cell instance sg13cmos5l_decap_8_1943 r0 *1 0,0
Xsg13cmos5l_decap_8_1943 VPWR VGND sg13cmos5l_decap_8
* cell instance sg13cmos5l_decap_8_1944 r0 *1 0,0
Xsg13cmos5l_decap_8_1944 VPWR VGND sg13cmos5l_decap_8
* cell instance sg13cmos5l_decap_8_1945 r0 *1 0,0
Xsg13cmos5l_decap_8_1945 VPWR VGND sg13cmos5l_decap_8
* cell instance sg13cmos5l_decap_8_1946 r0 *1 0,0
Xsg13cmos5l_decap_8_1946 VPWR VGND sg13cmos5l_decap_8
* cell instance sg13cmos5l_decap_8_1947 r0 *1 0,0
Xsg13cmos5l_decap_8_1947 VPWR VGND sg13cmos5l_decap_8
* cell instance sg13cmos5l_decap_8_1948 r0 *1 0,0
Xsg13cmos5l_decap_8_1948 VPWR VGND sg13cmos5l_decap_8
* cell instance sg13cmos5l_decap_8_1949 r0 *1 0,0
Xsg13cmos5l_decap_8_1949 VPWR VGND sg13cmos5l_decap_8
* cell instance sg13cmos5l_decap_8_1950 r0 *1 0,0
Xsg13cmos5l_decap_8_1950 VPWR VGND sg13cmos5l_decap_8
* cell instance sg13cmos5l_decap_8_1951 r0 *1 0,0
Xsg13cmos5l_decap_8_1951 VPWR VGND sg13cmos5l_decap_8
* cell instance sg13cmos5l_decap_8_1952 r0 *1 0,0
Xsg13cmos5l_decap_8_1952 VPWR VGND sg13cmos5l_decap_8
* cell instance sg13cmos5l_decap_8_1953 r0 *1 0,0
Xsg13cmos5l_decap_8_1953 VPWR VGND sg13cmos5l_decap_8
* cell instance sg13cmos5l_decap_8_1954 r0 *1 0,0
Xsg13cmos5l_decap_8_1954 VPWR VGND sg13cmos5l_decap_8
* cell instance sg13cmos5l_decap_8_1955 r0 *1 0,0
Xsg13cmos5l_decap_8_1955 VPWR VGND sg13cmos5l_decap_8
* cell instance sg13cmos5l_decap_8_1956 r0 *1 0,0
Xsg13cmos5l_decap_8_1956 VPWR VGND sg13cmos5l_decap_8
* cell instance sg13cmos5l_decap_8_1957 r0 *1 0,0
Xsg13cmos5l_decap_8_1957 VPWR VGND sg13cmos5l_decap_8
* cell instance sg13cmos5l_decap_8_1958 r0 *1 0,0
Xsg13cmos5l_decap_8_1958 VPWR VGND sg13cmos5l_decap_8
* cell instance sg13cmos5l_decap_8_1959 r0 *1 0,0
Xsg13cmos5l_decap_8_1959 VPWR VGND sg13cmos5l_decap_8
* cell instance sg13cmos5l_decap_8_1960 r0 *1 0,0
Xsg13cmos5l_decap_8_1960 VPWR VGND sg13cmos5l_decap_8
* cell instance sg13cmos5l_decap_8_1961 r0 *1 0,0
Xsg13cmos5l_decap_8_1961 VPWR VGND sg13cmos5l_decap_8
* cell instance sg13cmos5l_decap_8_1962 r0 *1 0,0
Xsg13cmos5l_decap_8_1962 VPWR VGND sg13cmos5l_decap_8
* cell instance sg13cmos5l_decap_8_1963 r0 *1 0,0
Xsg13cmos5l_decap_8_1963 VPWR VGND sg13cmos5l_decap_8
* cell instance sg13cmos5l_decap_8_1964 r0 *1 0,0
Xsg13cmos5l_decap_8_1964 VPWR VGND sg13cmos5l_decap_8
* cell instance sg13cmos5l_decap_8_1965 r0 *1 0,0
Xsg13cmos5l_decap_8_1965 VPWR VGND sg13cmos5l_decap_8
* cell instance sg13cmos5l_decap_8_1966 r0 *1 0,0
Xsg13cmos5l_decap_8_1966 VPWR VGND sg13cmos5l_decap_8
* cell instance sg13cmos5l_decap_8_1967 r0 *1 0,0
Xsg13cmos5l_decap_8_1967 VPWR VGND sg13cmos5l_decap_8
* cell instance sg13cmos5l_decap_8_1968 r0 *1 0,0
Xsg13cmos5l_decap_8_1968 VPWR VGND sg13cmos5l_decap_8
* cell instance sg13cmos5l_decap_8_1969 r0 *1 0,0
Xsg13cmos5l_decap_8_1969 VPWR VGND sg13cmos5l_decap_8
* cell instance sg13cmos5l_decap_8_1970 r0 *1 0,0
Xsg13cmos5l_decap_8_1970 VPWR VGND sg13cmos5l_decap_8
* cell instance sg13cmos5l_decap_8_1971 r0 *1 0,0
Xsg13cmos5l_decap_8_1971 VPWR VGND sg13cmos5l_decap_8
* cell instance sg13cmos5l_decap_8_1972 r0 *1 0,0
Xsg13cmos5l_decap_8_1972 VPWR VGND sg13cmos5l_decap_8
* cell instance sg13cmos5l_decap_8_1973 r0 *1 0,0
Xsg13cmos5l_decap_8_1973 VPWR VGND sg13cmos5l_decap_8
* cell instance sg13cmos5l_decap_8_1974 r0 *1 0,0
Xsg13cmos5l_decap_8_1974 VPWR VGND sg13cmos5l_decap_8
* cell instance sg13cmos5l_decap_8_1975 r0 *1 0,0
Xsg13cmos5l_decap_8_1975 VPWR VGND sg13cmos5l_decap_8
* cell instance sg13cmos5l_decap_8_1976 r0 *1 0,0
Xsg13cmos5l_decap_8_1976 VPWR VGND sg13cmos5l_decap_8
* cell instance sg13cmos5l_decap_8_1977 r0 *1 0,0
Xsg13cmos5l_decap_8_1977 VPWR VGND sg13cmos5l_decap_8
* cell instance sg13cmos5l_decap_8_1978 r0 *1 0,0
Xsg13cmos5l_decap_8_1978 VPWR VGND sg13cmos5l_decap_8
* cell instance sg13cmos5l_decap_8_1979 r0 *1 0,0
Xsg13cmos5l_decap_8_1979 VPWR VGND sg13cmos5l_decap_8
* cell instance sg13cmos5l_decap_8_1980 r0 *1 0,0
Xsg13cmos5l_decap_8_1980 VPWR VGND sg13cmos5l_decap_8
* cell instance sg13cmos5l_decap_8_1981 r0 *1 0,0
Xsg13cmos5l_decap_8_1981 VPWR VGND sg13cmos5l_decap_8
* cell instance sg13cmos5l_decap_8_1982 r0 *1 0,0
Xsg13cmos5l_decap_8_1982 VPWR VGND sg13cmos5l_decap_8
* cell instance sg13cmos5l_decap_8_1983 r0 *1 0,0
Xsg13cmos5l_decap_8_1983 VPWR VGND sg13cmos5l_decap_8
* cell instance sg13cmos5l_decap_8_1984 r0 *1 0,0
Xsg13cmos5l_decap_8_1984 VPWR VGND sg13cmos5l_decap_8
* cell instance sg13cmos5l_decap_8_1985 r0 *1 0,0
Xsg13cmos5l_decap_8_1985 VPWR VGND sg13cmos5l_decap_8
* cell instance sg13cmos5l_decap_8_1986 r0 *1 0,0
Xsg13cmos5l_decap_8_1986 VPWR VGND sg13cmos5l_decap_8
* cell instance sg13cmos5l_decap_8_1987 r0 *1 0,0
Xsg13cmos5l_decap_8_1987 VPWR VGND sg13cmos5l_decap_8
* cell instance sg13cmos5l_decap_8_1988 r0 *1 0,0
Xsg13cmos5l_decap_8_1988 VPWR VGND sg13cmos5l_decap_8
* cell instance sg13cmos5l_decap_8_1989 r0 *1 0,0
Xsg13cmos5l_decap_8_1989 VPWR VGND sg13cmos5l_decap_8
* cell instance sg13cmos5l_decap_8_1990 r0 *1 0,0
Xsg13cmos5l_decap_8_1990 VPWR VGND sg13cmos5l_decap_8
* cell instance sg13cmos5l_decap_8_1991 r0 *1 0,0
Xsg13cmos5l_decap_8_1991 VPWR VGND sg13cmos5l_decap_8
* cell instance sg13cmos5l_decap_8_1992 r0 *1 0,0
Xsg13cmos5l_decap_8_1992 VPWR VGND sg13cmos5l_decap_8
* cell instance sg13cmos5l_decap_8_1993 r0 *1 0,0
Xsg13cmos5l_decap_8_1993 VPWR VGND sg13cmos5l_decap_8
* cell instance sg13cmos5l_decap_8_1994 r0 *1 0,0
Xsg13cmos5l_decap_8_1994 VPWR VGND sg13cmos5l_decap_8
* cell instance sg13cmos5l_decap_8_1995 r0 *1 0,0
Xsg13cmos5l_decap_8_1995 VPWR VGND sg13cmos5l_decap_8
* cell instance sg13cmos5l_decap_8_1996 r0 *1 0,0
Xsg13cmos5l_decap_8_1996 VPWR VGND sg13cmos5l_decap_8
* cell instance sg13cmos5l_decap_8_1997 r0 *1 0,0
Xsg13cmos5l_decap_8_1997 VPWR VGND sg13cmos5l_decap_8
* cell instance sg13cmos5l_decap_8_1998 r0 *1 0,0
Xsg13cmos5l_decap_8_1998 VPWR VGND sg13cmos5l_decap_8
* cell instance sg13cmos5l_decap_8_1999 r0 *1 0,0
Xsg13cmos5l_decap_8_1999 VPWR VGND sg13cmos5l_decap_8
* cell instance sg13cmos5l_decap_8_2000 r0 *1 0,0
Xsg13cmos5l_decap_8_2000 VPWR VGND sg13cmos5l_decap_8
* cell instance sg13cmos5l_decap_8_2001 r0 *1 0,0
Xsg13cmos5l_decap_8_2001 VPWR VGND sg13cmos5l_decap_8
* cell instance sg13cmos5l_decap_8_2002 r0 *1 0,0
Xsg13cmos5l_decap_8_2002 VPWR VGND sg13cmos5l_decap_8
* cell instance sg13cmos5l_decap_8_2003 r0 *1 0,0
Xsg13cmos5l_decap_8_2003 VPWR VGND sg13cmos5l_decap_8
* cell instance sg13cmos5l_decap_8_2004 r0 *1 0,0
Xsg13cmos5l_decap_8_2004 VPWR VGND sg13cmos5l_decap_8
* cell instance sg13cmos5l_decap_8_2005 r0 *1 0,0
Xsg13cmos5l_decap_8_2005 VPWR VGND sg13cmos5l_decap_8
* cell instance sg13cmos5l_decap_8_2006 r0 *1 0,0
Xsg13cmos5l_decap_8_2006 VPWR VGND sg13cmos5l_decap_8
* cell instance sg13cmos5l_decap_8_2007 r0 *1 0,0
Xsg13cmos5l_decap_8_2007 VPWR VGND sg13cmos5l_decap_8
* cell instance sg13cmos5l_decap_8_2008 r0 *1 0,0
Xsg13cmos5l_decap_8_2008 VPWR VGND sg13cmos5l_decap_8
* cell instance sg13cmos5l_decap_8_2009 r0 *1 0,0
Xsg13cmos5l_decap_8_2009 VPWR VGND sg13cmos5l_decap_8
* cell instance sg13cmos5l_decap_8_2010 r0 *1 0,0
Xsg13cmos5l_decap_8_2010 VPWR VGND sg13cmos5l_decap_8
* cell instance sg13cmos5l_decap_8_2011 r0 *1 0,0
Xsg13cmos5l_decap_8_2011 VPWR VGND sg13cmos5l_decap_8
* cell instance sg13cmos5l_decap_8_2012 r0 *1 0,0
Xsg13cmos5l_decap_8_2012 VPWR VGND sg13cmos5l_decap_8
* cell instance sg13cmos5l_decap_8_2013 r0 *1 0,0
Xsg13cmos5l_decap_8_2013 VPWR VGND sg13cmos5l_decap_8
* cell instance sg13cmos5l_decap_8_2014 r0 *1 0,0
Xsg13cmos5l_decap_8_2014 VPWR VGND sg13cmos5l_decap_8
* cell instance sg13cmos5l_decap_8_2015 r0 *1 0,0
Xsg13cmos5l_decap_8_2015 VPWR VGND sg13cmos5l_decap_8
* cell instance sg13cmos5l_decap_8_2016 r0 *1 0,0
Xsg13cmos5l_decap_8_2016 VPWR VGND sg13cmos5l_decap_8
* cell instance sg13cmos5l_decap_8_2017 r0 *1 0,0
Xsg13cmos5l_decap_8_2017 VPWR VGND sg13cmos5l_decap_8
* cell instance sg13cmos5l_decap_8_2018 r0 *1 0,0
Xsg13cmos5l_decap_8_2018 VPWR VGND sg13cmos5l_decap_8
* cell instance sg13cmos5l_decap_8_2019 r0 *1 0,0
Xsg13cmos5l_decap_8_2019 VPWR VGND sg13cmos5l_decap_8
* cell instance sg13cmos5l_decap_8_2020 r0 *1 0,0
Xsg13cmos5l_decap_8_2020 VPWR VGND sg13cmos5l_decap_8
* cell instance sg13cmos5l_decap_8_2021 r0 *1 0,0
Xsg13cmos5l_decap_8_2021 VPWR VGND sg13cmos5l_decap_8
* cell instance sg13cmos5l_decap_8_2022 r0 *1 0,0
Xsg13cmos5l_decap_8_2022 VPWR VGND sg13cmos5l_decap_8
* cell instance sg13cmos5l_decap_8_2023 r0 *1 0,0
Xsg13cmos5l_decap_8_2023 VPWR VGND sg13cmos5l_decap_8
* cell instance sg13cmos5l_decap_8_2024 r0 *1 0,0
Xsg13cmos5l_decap_8_2024 VPWR VGND sg13cmos5l_decap_8
* cell instance sg13cmos5l_decap_8_2025 r0 *1 0,0
Xsg13cmos5l_decap_8_2025 VPWR VGND sg13cmos5l_decap_8
* cell instance sg13cmos5l_decap_8_2026 r0 *1 0,0
Xsg13cmos5l_decap_8_2026 VPWR VGND sg13cmos5l_decap_8
* cell instance sg13cmos5l_decap_8_2027 r0 *1 0,0
Xsg13cmos5l_decap_8_2027 VPWR VGND sg13cmos5l_decap_8
* cell instance sg13cmos5l_decap_8_2028 r0 *1 0,0
Xsg13cmos5l_decap_8_2028 VPWR VGND sg13cmos5l_decap_8
* cell instance sg13cmos5l_decap_8_2029 r0 *1 0,0
Xsg13cmos5l_decap_8_2029 VPWR VGND sg13cmos5l_decap_8
* cell instance sg13cmos5l_decap_8_2030 r0 *1 0,0
Xsg13cmos5l_decap_8_2030 VPWR VGND sg13cmos5l_decap_8
* cell instance sg13cmos5l_decap_8_2031 r0 *1 0,0
Xsg13cmos5l_decap_8_2031 VPWR VGND sg13cmos5l_decap_8
* cell instance sg13cmos5l_decap_8_2032 r0 *1 0,0
Xsg13cmos5l_decap_8_2032 VPWR VGND sg13cmos5l_decap_8
* cell instance sg13cmos5l_decap_8_2033 r0 *1 0,0
Xsg13cmos5l_decap_8_2033 VPWR VGND sg13cmos5l_decap_8
* cell instance sg13cmos5l_decap_8_2034 r0 *1 0,0
Xsg13cmos5l_decap_8_2034 VPWR VGND sg13cmos5l_decap_8
* cell instance sg13cmos5l_decap_8_2035 r0 *1 0,0
Xsg13cmos5l_decap_8_2035 VPWR VGND sg13cmos5l_decap_8
* cell instance sg13cmos5l_decap_8_2036 r0 *1 0,0
Xsg13cmos5l_decap_8_2036 VPWR VGND sg13cmos5l_decap_8
* cell instance sg13cmos5l_decap_8_2037 r0 *1 0,0
Xsg13cmos5l_decap_8_2037 VPWR VGND sg13cmos5l_decap_8
* cell instance sg13cmos5l_decap_8_2038 r0 *1 0,0
Xsg13cmos5l_decap_8_2038 VPWR VGND sg13cmos5l_decap_8
* cell instance sg13cmos5l_decap_8_2039 r0 *1 0,0
Xsg13cmos5l_decap_8_2039 VPWR VGND sg13cmos5l_decap_8
* cell instance sg13cmos5l_decap_8_2040 r0 *1 0,0
Xsg13cmos5l_decap_8_2040 VPWR VGND sg13cmos5l_decap_8
* cell instance sg13cmos5l_decap_8_2041 r0 *1 0,0
Xsg13cmos5l_decap_8_2041 VPWR VGND sg13cmos5l_decap_8
* cell instance sg13cmos5l_decap_8_2042 r0 *1 0,0
Xsg13cmos5l_decap_8_2042 VPWR VGND sg13cmos5l_decap_8
* cell instance sg13cmos5l_decap_8_2043 r0 *1 0,0
Xsg13cmos5l_decap_8_2043 VPWR VGND sg13cmos5l_decap_8
* cell instance sg13cmos5l_decap_8_2044 r0 *1 0,0
Xsg13cmos5l_decap_8_2044 VPWR VGND sg13cmos5l_decap_8
* cell instance sg13cmos5l_decap_8_2045 r0 *1 0,0
Xsg13cmos5l_decap_8_2045 VPWR VGND sg13cmos5l_decap_8
* cell instance sg13cmos5l_decap_8_2046 r0 *1 0,0
Xsg13cmos5l_decap_8_2046 VPWR VGND sg13cmos5l_decap_8
* cell instance sg13cmos5l_decap_8_2047 r0 *1 0,0
Xsg13cmos5l_decap_8_2047 VPWR VGND sg13cmos5l_decap_8
* cell instance sg13cmos5l_decap_8_2048 r0 *1 0,0
Xsg13cmos5l_decap_8_2048 VPWR VGND sg13cmos5l_decap_8
* cell instance sg13cmos5l_decap_8_2049 r0 *1 0,0
Xsg13cmos5l_decap_8_2049 VPWR VGND sg13cmos5l_decap_8
* cell instance sg13cmos5l_decap_8_2050 r0 *1 0,0
Xsg13cmos5l_decap_8_2050 VPWR VGND sg13cmos5l_decap_8
* cell instance sg13cmos5l_decap_8_2051 r0 *1 0,0
Xsg13cmos5l_decap_8_2051 VPWR VGND sg13cmos5l_decap_8
* cell instance sg13cmos5l_decap_8_2052 r0 *1 0,0
Xsg13cmos5l_decap_8_2052 VPWR VGND sg13cmos5l_decap_8
* cell instance sg13cmos5l_decap_8_2053 r0 *1 0,0
Xsg13cmos5l_decap_8_2053 VPWR VGND sg13cmos5l_decap_8
* cell instance sg13cmos5l_decap_8_2054 r0 *1 0,0
Xsg13cmos5l_decap_8_2054 VPWR VGND sg13cmos5l_decap_8
* cell instance sg13cmos5l_decap_8_2055 r0 *1 0,0
Xsg13cmos5l_decap_8_2055 VPWR VGND sg13cmos5l_decap_8
* cell instance sg13cmos5l_decap_8_2056 r0 *1 0,0
Xsg13cmos5l_decap_8_2056 VPWR VGND sg13cmos5l_decap_8
* cell instance sg13cmos5l_decap_8_2057 r0 *1 0,0
Xsg13cmos5l_decap_8_2057 VPWR VGND sg13cmos5l_decap_8
* cell instance sg13cmos5l_decap_8_2058 r0 *1 0,0
Xsg13cmos5l_decap_8_2058 VPWR VGND sg13cmos5l_decap_8
* cell instance sg13cmos5l_decap_8_2059 r0 *1 0,0
Xsg13cmos5l_decap_8_2059 VPWR VGND sg13cmos5l_decap_8
* cell instance sg13cmos5l_decap_8_2060 r0 *1 0,0
Xsg13cmos5l_decap_8_2060 VPWR VGND sg13cmos5l_decap_8
* cell instance sg13cmos5l_decap_8_2061 r0 *1 0,0
Xsg13cmos5l_decap_8_2061 VPWR VGND sg13cmos5l_decap_8
* cell instance sg13cmos5l_decap_8_2062 r0 *1 0,0
Xsg13cmos5l_decap_8_2062 VPWR VGND sg13cmos5l_decap_8
* cell instance sg13cmos5l_decap_8_2063 r0 *1 0,0
Xsg13cmos5l_decap_8_2063 VPWR VGND sg13cmos5l_decap_8
* cell instance sg13cmos5l_decap_8_2064 r0 *1 0,0
Xsg13cmos5l_decap_8_2064 VPWR VGND sg13cmos5l_decap_8
* cell instance sg13cmos5l_decap_8_2065 r0 *1 0,0
Xsg13cmos5l_decap_8_2065 VPWR VGND sg13cmos5l_decap_8
* cell instance sg13cmos5l_decap_8_2066 r0 *1 0,0
Xsg13cmos5l_decap_8_2066 VPWR VGND sg13cmos5l_decap_8
* cell instance sg13cmos5l_decap_8_2067 r0 *1 0,0
Xsg13cmos5l_decap_8_2067 VPWR VGND sg13cmos5l_decap_8
* cell instance sg13cmos5l_decap_8_2068 r0 *1 0,0
Xsg13cmos5l_decap_8_2068 VPWR VGND sg13cmos5l_decap_8
* cell instance sg13cmos5l_decap_8_2069 r0 *1 0,0
Xsg13cmos5l_decap_8_2069 VPWR VGND sg13cmos5l_decap_8
* cell instance sg13cmos5l_decap_8_2070 r0 *1 0,0
Xsg13cmos5l_decap_8_2070 VPWR VGND sg13cmos5l_decap_8
* cell instance sg13cmos5l_decap_8_2071 r0 *1 0,0
Xsg13cmos5l_decap_8_2071 VPWR VGND sg13cmos5l_decap_8
* cell instance sg13cmos5l_decap_8_2072 r0 *1 0,0
Xsg13cmos5l_decap_8_2072 VPWR VGND sg13cmos5l_decap_8
* cell instance sg13cmos5l_decap_8_2073 r0 *1 0,0
Xsg13cmos5l_decap_8_2073 VPWR VGND sg13cmos5l_decap_8
* cell instance sg13cmos5l_decap_8_2074 r0 *1 0,0
Xsg13cmos5l_decap_8_2074 VPWR VGND sg13cmos5l_decap_8
* cell instance sg13cmos5l_decap_8_2075 r0 *1 0,0
Xsg13cmos5l_decap_8_2075 VPWR VGND sg13cmos5l_decap_8
* cell instance sg13cmos5l_decap_8_2076 r0 *1 0,0
Xsg13cmos5l_decap_8_2076 VPWR VGND sg13cmos5l_decap_8
* cell instance sg13cmos5l_decap_8_2077 r0 *1 0,0
Xsg13cmos5l_decap_8_2077 VPWR VGND sg13cmos5l_decap_8
* cell instance sg13cmos5l_decap_8_2078 r0 *1 0,0
Xsg13cmos5l_decap_8_2078 VPWR VGND sg13cmos5l_decap_8
* cell instance sg13cmos5l_decap_8_2079 r0 *1 0,0
Xsg13cmos5l_decap_8_2079 VPWR VGND sg13cmos5l_decap_8
* cell instance sg13cmos5l_decap_8_2080 r0 *1 0,0
Xsg13cmos5l_decap_8_2080 VPWR VGND sg13cmos5l_decap_8
* cell instance sg13cmos5l_decap_8_2081 r0 *1 0,0
Xsg13cmos5l_decap_8_2081 VPWR VGND sg13cmos5l_decap_8
* cell instance sg13cmos5l_decap_8_2082 r0 *1 0,0
Xsg13cmos5l_decap_8_2082 VPWR VGND sg13cmos5l_decap_8
* cell instance sg13cmos5l_decap_8_2083 r0 *1 0,0
Xsg13cmos5l_decap_8_2083 VPWR VGND sg13cmos5l_decap_8
* cell instance sg13cmos5l_decap_8_2084 r0 *1 0,0
Xsg13cmos5l_decap_8_2084 VPWR VGND sg13cmos5l_decap_8
* cell instance sg13cmos5l_decap_8_2085 r0 *1 0,0
Xsg13cmos5l_decap_8_2085 VPWR VGND sg13cmos5l_decap_8
* cell instance sg13cmos5l_decap_8_2086 r0 *1 0,0
Xsg13cmos5l_decap_8_2086 VPWR VGND sg13cmos5l_decap_8
* cell instance sg13cmos5l_decap_8_2087 r0 *1 0,0
Xsg13cmos5l_decap_8_2087 VPWR VGND sg13cmos5l_decap_8
* cell instance sg13cmos5l_decap_8_2088 r0 *1 0,0
Xsg13cmos5l_decap_8_2088 VPWR VGND sg13cmos5l_decap_8
* cell instance sg13cmos5l_decap_8_2089 r0 *1 0,0
Xsg13cmos5l_decap_8_2089 VPWR VGND sg13cmos5l_decap_8
* cell instance sg13cmos5l_decap_8_2090 r0 *1 0,0
Xsg13cmos5l_decap_8_2090 VPWR VGND sg13cmos5l_decap_8
* cell instance sg13cmos5l_decap_8_2091 r0 *1 0,0
Xsg13cmos5l_decap_8_2091 VPWR VGND sg13cmos5l_decap_8
* cell instance sg13cmos5l_decap_8_2092 r0 *1 0,0
Xsg13cmos5l_decap_8_2092 VPWR VGND sg13cmos5l_decap_8
* cell instance sg13cmos5l_decap_8_2093 r0 *1 0,0
Xsg13cmos5l_decap_8_2093 VPWR VGND sg13cmos5l_decap_8
* cell instance sg13cmos5l_decap_8_2094 r0 *1 0,0
Xsg13cmos5l_decap_8_2094 VPWR VGND sg13cmos5l_decap_8
* cell instance sg13cmos5l_decap_8_2095 r0 *1 0,0
Xsg13cmos5l_decap_8_2095 VPWR VGND sg13cmos5l_decap_8
* cell instance sg13cmos5l_decap_8_2096 r0 *1 0,0
Xsg13cmos5l_decap_8_2096 VPWR VGND sg13cmos5l_decap_8
* cell instance sg13cmos5l_decap_8_2097 r0 *1 0,0
Xsg13cmos5l_decap_8_2097 VPWR VGND sg13cmos5l_decap_8
* cell instance sg13cmos5l_decap_8_2098 r0 *1 0,0
Xsg13cmos5l_decap_8_2098 VPWR VGND sg13cmos5l_decap_8
* cell instance sg13cmos5l_decap_8_2099 r0 *1 0,0
Xsg13cmos5l_decap_8_2099 VPWR VGND sg13cmos5l_decap_8
* cell instance sg13cmos5l_decap_8_2100 r0 *1 0,0
Xsg13cmos5l_decap_8_2100 VPWR VGND sg13cmos5l_decap_8
* cell instance sg13cmos5l_decap_8_2101 r0 *1 0,0
Xsg13cmos5l_decap_8_2101 VPWR VGND sg13cmos5l_decap_8
* cell instance sg13cmos5l_decap_8_2102 r0 *1 0,0
Xsg13cmos5l_decap_8_2102 VPWR VGND sg13cmos5l_decap_8
* cell instance sg13cmos5l_decap_8_2103 r0 *1 0,0
Xsg13cmos5l_decap_8_2103 VPWR VGND sg13cmos5l_decap_8
* cell instance sg13cmos5l_decap_8_2104 r0 *1 0,0
Xsg13cmos5l_decap_8_2104 VPWR VGND sg13cmos5l_decap_8
* cell instance sg13cmos5l_decap_8_2105 r0 *1 0,0
Xsg13cmos5l_decap_8_2105 VPWR VGND sg13cmos5l_decap_8
* cell instance sg13cmos5l_decap_8_2106 r0 *1 0,0
Xsg13cmos5l_decap_8_2106 VPWR VGND sg13cmos5l_decap_8
* cell instance sg13cmos5l_decap_8_2107 r0 *1 0,0
Xsg13cmos5l_decap_8_2107 VPWR VGND sg13cmos5l_decap_8
* cell instance sg13cmos5l_decap_8_2108 r0 *1 0,0
Xsg13cmos5l_decap_8_2108 VPWR VGND sg13cmos5l_decap_8
* cell instance sg13cmos5l_decap_8_2109 r0 *1 0,0
Xsg13cmos5l_decap_8_2109 VPWR VGND sg13cmos5l_decap_8
* cell instance sg13cmos5l_decap_8_2110 r0 *1 0,0
Xsg13cmos5l_decap_8_2110 VPWR VGND sg13cmos5l_decap_8
* cell instance sg13cmos5l_decap_8_2111 r0 *1 0,0
Xsg13cmos5l_decap_8_2111 VPWR VGND sg13cmos5l_decap_8
* cell instance sg13cmos5l_decap_8_2112 r0 *1 0,0
Xsg13cmos5l_decap_8_2112 VPWR VGND sg13cmos5l_decap_8
* cell instance sg13cmos5l_decap_8_2113 r0 *1 0,0
Xsg13cmos5l_decap_8_2113 VPWR VGND sg13cmos5l_decap_8
* cell instance sg13cmos5l_decap_8_2114 r0 *1 0,0
Xsg13cmos5l_decap_8_2114 VPWR VGND sg13cmos5l_decap_8
* cell instance sg13cmos5l_decap_8_2115 r0 *1 0,0
Xsg13cmos5l_decap_8_2115 VPWR VGND sg13cmos5l_decap_8
* cell instance sg13cmos5l_decap_8_2116 r0 *1 0,0
Xsg13cmos5l_decap_8_2116 VPWR VGND sg13cmos5l_decap_8
* cell instance sg13cmos5l_decap_8_2117 r0 *1 0,0
Xsg13cmos5l_decap_8_2117 VPWR VGND sg13cmos5l_decap_8
* cell instance sg13cmos5l_decap_8_2118 r0 *1 0,0
Xsg13cmos5l_decap_8_2118 VPWR VGND sg13cmos5l_decap_8
* cell instance sg13cmos5l_decap_8_2119 r0 *1 0,0
Xsg13cmos5l_decap_8_2119 VPWR VGND sg13cmos5l_decap_8
* cell instance sg13cmos5l_decap_8_2120 r0 *1 0,0
Xsg13cmos5l_decap_8_2120 VPWR VGND sg13cmos5l_decap_8
* cell instance sg13cmos5l_decap_8_2121 r0 *1 0,0
Xsg13cmos5l_decap_8_2121 VPWR VGND sg13cmos5l_decap_8
* cell instance sg13cmos5l_decap_8_2122 r0 *1 0,0
Xsg13cmos5l_decap_8_2122 VPWR VGND sg13cmos5l_decap_8
* cell instance sg13cmos5l_decap_8_2123 r0 *1 0,0
Xsg13cmos5l_decap_8_2123 VPWR VGND sg13cmos5l_decap_8
* cell instance sg13cmos5l_decap_8_2124 r0 *1 0,0
Xsg13cmos5l_decap_8_2124 VPWR VGND sg13cmos5l_decap_8
* cell instance sg13cmos5l_decap_8_2125 r0 *1 0,0
Xsg13cmos5l_decap_8_2125 VPWR VGND sg13cmos5l_decap_8
* cell instance sg13cmos5l_decap_8_2126 r0 *1 0,0
Xsg13cmos5l_decap_8_2126 VPWR VGND sg13cmos5l_decap_8
* cell instance sg13cmos5l_decap_8_2127 r0 *1 0,0
Xsg13cmos5l_decap_8_2127 VPWR VGND sg13cmos5l_decap_8
* cell instance sg13cmos5l_decap_8_2128 r0 *1 0,0
Xsg13cmos5l_decap_8_2128 VPWR VGND sg13cmos5l_decap_8
* cell instance sg13cmos5l_decap_8_2129 r0 *1 0,0
Xsg13cmos5l_decap_8_2129 VPWR VGND sg13cmos5l_decap_8
* cell instance sg13cmos5l_decap_8_2130 r0 *1 0,0
Xsg13cmos5l_decap_8_2130 VPWR VGND sg13cmos5l_decap_8
* cell instance sg13cmos5l_decap_8_2131 r0 *1 0,0
Xsg13cmos5l_decap_8_2131 VPWR VGND sg13cmos5l_decap_8
* cell instance sg13cmos5l_decap_8_2132 r0 *1 0,0
Xsg13cmos5l_decap_8_2132 VPWR VGND sg13cmos5l_decap_8
* cell instance sg13cmos5l_decap_8_2133 r0 *1 0,0
Xsg13cmos5l_decap_8_2133 VPWR VGND sg13cmos5l_decap_8
* cell instance sg13cmos5l_decap_8_2134 r0 *1 0,0
Xsg13cmos5l_decap_8_2134 VPWR VGND sg13cmos5l_decap_8
* cell instance sg13cmos5l_decap_8_2135 r0 *1 0,0
Xsg13cmos5l_decap_8_2135 VPWR VGND sg13cmos5l_decap_8
* cell instance sg13cmos5l_decap_8_2136 r0 *1 0,0
Xsg13cmos5l_decap_8_2136 VPWR VGND sg13cmos5l_decap_8
* cell instance sg13cmos5l_decap_8_2137 r0 *1 0,0
Xsg13cmos5l_decap_8_2137 VPWR VGND sg13cmos5l_decap_8
* cell instance sg13cmos5l_decap_8_2138 r0 *1 0,0
Xsg13cmos5l_decap_8_2138 VPWR VGND sg13cmos5l_decap_8
* cell instance sg13cmos5l_decap_8_2139 r0 *1 0,0
Xsg13cmos5l_decap_8_2139 VPWR VGND sg13cmos5l_decap_8
* cell instance sg13cmos5l_decap_8_2140 r0 *1 0,0
Xsg13cmos5l_decap_8_2140 VPWR VGND sg13cmos5l_decap_8
* cell instance sg13cmos5l_decap_8_2141 r0 *1 0,0
Xsg13cmos5l_decap_8_2141 VPWR VGND sg13cmos5l_decap_8
* cell instance sg13cmos5l_decap_8_2142 r0 *1 0,0
Xsg13cmos5l_decap_8_2142 VPWR VGND sg13cmos5l_decap_8
* cell instance sg13cmos5l_decap_8_2143 r0 *1 0,0
Xsg13cmos5l_decap_8_2143 VPWR VGND sg13cmos5l_decap_8
* cell instance sg13cmos5l_decap_8_2144 r0 *1 0,0
Xsg13cmos5l_decap_8_2144 VPWR VGND sg13cmos5l_decap_8
* cell instance sg13cmos5l_decap_8_2145 r0 *1 0,0
Xsg13cmos5l_decap_8_2145 VPWR VGND sg13cmos5l_decap_8
* cell instance sg13cmos5l_decap_8_2146 r0 *1 0,0
Xsg13cmos5l_decap_8_2146 VPWR VGND sg13cmos5l_decap_8
* cell instance sg13cmos5l_decap_8_2147 r0 *1 0,0
Xsg13cmos5l_decap_8_2147 VPWR VGND sg13cmos5l_decap_8
* cell instance sg13cmos5l_decap_8_2148 r0 *1 0,0
Xsg13cmos5l_decap_8_2148 VPWR VGND sg13cmos5l_decap_8
* cell instance sg13cmos5l_decap_8_2149 r0 *1 0,0
Xsg13cmos5l_decap_8_2149 VPWR VGND sg13cmos5l_decap_8
* cell instance sg13cmos5l_decap_8_2150 r0 *1 0,0
Xsg13cmos5l_decap_8_2150 VPWR VGND sg13cmos5l_decap_8
* cell instance sg13cmos5l_decap_8_2151 r0 *1 0,0
Xsg13cmos5l_decap_8_2151 VPWR VGND sg13cmos5l_decap_8
* cell instance sg13cmos5l_decap_8_2152 r0 *1 0,0
Xsg13cmos5l_decap_8_2152 VPWR VGND sg13cmos5l_decap_8
* cell instance sg13cmos5l_decap_8_2153 r0 *1 0,0
Xsg13cmos5l_decap_8_2153 VPWR VGND sg13cmos5l_decap_8
* cell instance sg13cmos5l_decap_8_2154 r0 *1 0,0
Xsg13cmos5l_decap_8_2154 VPWR VGND sg13cmos5l_decap_8
* cell instance sg13cmos5l_decap_8_2155 r0 *1 0,0
Xsg13cmos5l_decap_8_2155 VPWR VGND sg13cmos5l_decap_8
* cell instance sg13cmos5l_decap_8_2156 r0 *1 0,0
Xsg13cmos5l_decap_8_2156 VPWR VGND sg13cmos5l_decap_8
* cell instance sg13cmos5l_decap_8_2157 r0 *1 0,0
Xsg13cmos5l_decap_8_2157 VPWR VGND sg13cmos5l_decap_8
* cell instance sg13cmos5l_decap_8_2158 r0 *1 0,0
Xsg13cmos5l_decap_8_2158 VPWR VGND sg13cmos5l_decap_8
* cell instance sg13cmos5l_decap_8_2159 r0 *1 0,0
Xsg13cmos5l_decap_8_2159 VPWR VGND sg13cmos5l_decap_8
* cell instance sg13cmos5l_decap_8_2160 r0 *1 0,0
Xsg13cmos5l_decap_8_2160 VPWR VGND sg13cmos5l_decap_8
* cell instance sg13cmos5l_decap_8_2161 r0 *1 0,0
Xsg13cmos5l_decap_8_2161 VPWR VGND sg13cmos5l_decap_8
* cell instance sg13cmos5l_decap_8_2162 r0 *1 0,0
Xsg13cmos5l_decap_8_2162 VPWR VGND sg13cmos5l_decap_8
* cell instance sg13cmos5l_decap_8_2163 r0 *1 0,0
Xsg13cmos5l_decap_8_2163 VPWR VGND sg13cmos5l_decap_8
* cell instance sg13cmos5l_decap_8_2164 r0 *1 0,0
Xsg13cmos5l_decap_8_2164 VPWR VGND sg13cmos5l_decap_8
* cell instance sg13cmos5l_decap_8_2165 r0 *1 0,0
Xsg13cmos5l_decap_8_2165 VPWR VGND sg13cmos5l_decap_8
* cell instance sg13cmos5l_decap_8_2166 r0 *1 0,0
Xsg13cmos5l_decap_8_2166 VPWR VGND sg13cmos5l_decap_8
* cell instance sg13cmos5l_decap_8_2167 r0 *1 0,0
Xsg13cmos5l_decap_8_2167 VPWR VGND sg13cmos5l_decap_8
* cell instance sg13cmos5l_decap_8_2168 r0 *1 0,0
Xsg13cmos5l_decap_8_2168 VPWR VGND sg13cmos5l_decap_8
* cell instance sg13cmos5l_decap_8_2169 r0 *1 0,0
Xsg13cmos5l_decap_8_2169 VPWR VGND sg13cmos5l_decap_8
* cell instance sg13cmos5l_decap_8_2170 r0 *1 0,0
Xsg13cmos5l_decap_8_2170 VPWR VGND sg13cmos5l_decap_8
* cell instance sg13cmos5l_decap_8_2171 r0 *1 0,0
Xsg13cmos5l_decap_8_2171 VPWR VGND sg13cmos5l_decap_8
* cell instance sg13cmos5l_decap_8_2172 r0 *1 0,0
Xsg13cmos5l_decap_8_2172 VPWR VGND sg13cmos5l_decap_8
* cell instance sg13cmos5l_decap_8_2173 r0 *1 0,0
Xsg13cmos5l_decap_8_2173 VPWR VGND sg13cmos5l_decap_8
* cell instance sg13cmos5l_decap_8_2174 r0 *1 0,0
Xsg13cmos5l_decap_8_2174 VPWR VGND sg13cmos5l_decap_8
* cell instance sg13cmos5l_decap_8_2175 r0 *1 0,0
Xsg13cmos5l_decap_8_2175 VPWR VGND sg13cmos5l_decap_8
* cell instance sg13cmos5l_decap_8_2176 r0 *1 0,0
Xsg13cmos5l_decap_8_2176 VPWR VGND sg13cmos5l_decap_8
* cell instance sg13cmos5l_decap_8_2177 r0 *1 0,0
Xsg13cmos5l_decap_8_2177 VPWR VGND sg13cmos5l_decap_8
* cell instance sg13cmos5l_decap_8_2178 r0 *1 0,0
Xsg13cmos5l_decap_8_2178 VPWR VGND sg13cmos5l_decap_8
* cell instance sg13cmos5l_decap_8_2179 r0 *1 0,0
Xsg13cmos5l_decap_8_2179 VPWR VGND sg13cmos5l_decap_8
* cell instance sg13cmos5l_decap_8_2180 r0 *1 0,0
Xsg13cmos5l_decap_8_2180 VPWR VGND sg13cmos5l_decap_8
* cell instance sg13cmos5l_decap_8_2181 r0 *1 0,0
Xsg13cmos5l_decap_8_2181 VPWR VGND sg13cmos5l_decap_8
* cell instance sg13cmos5l_decap_8_2182 r0 *1 0,0
Xsg13cmos5l_decap_8_2182 VPWR VGND sg13cmos5l_decap_8
* cell instance sg13cmos5l_decap_8_2183 r0 *1 0,0
Xsg13cmos5l_decap_8_2183 VPWR VGND sg13cmos5l_decap_8
* cell instance sg13cmos5l_decap_8_2184 r0 *1 0,0
Xsg13cmos5l_decap_8_2184 VPWR VGND sg13cmos5l_decap_8
* cell instance sg13cmos5l_decap_8_2185 r0 *1 0,0
Xsg13cmos5l_decap_8_2185 VPWR VGND sg13cmos5l_decap_8
* cell instance sg13cmos5l_decap_8_2186 r0 *1 0,0
Xsg13cmos5l_decap_8_2186 VPWR VGND sg13cmos5l_decap_8
* cell instance sg13cmos5l_decap_8_2187 r0 *1 0,0
Xsg13cmos5l_decap_8_2187 VPWR VGND sg13cmos5l_decap_8
* cell instance sg13cmos5l_decap_8_2188 r0 *1 0,0
Xsg13cmos5l_decap_8_2188 VPWR VGND sg13cmos5l_decap_8
* cell instance sg13cmos5l_decap_8_2189 r0 *1 0,0
Xsg13cmos5l_decap_8_2189 VPWR VGND sg13cmos5l_decap_8
* cell instance sg13cmos5l_decap_8_2190 r0 *1 0,0
Xsg13cmos5l_decap_8_2190 VPWR VGND sg13cmos5l_decap_8
* cell instance sg13cmos5l_decap_8_2191 r0 *1 0,0
Xsg13cmos5l_decap_8_2191 VPWR VGND sg13cmos5l_decap_8
* cell instance sg13cmos5l_decap_8_2192 r0 *1 0,0
Xsg13cmos5l_decap_8_2192 VPWR VGND sg13cmos5l_decap_8
* cell instance sg13cmos5l_decap_8_2193 r0 *1 0,0
Xsg13cmos5l_decap_8_2193 VPWR VGND sg13cmos5l_decap_8
* cell instance sg13cmos5l_decap_8_2194 r0 *1 0,0
Xsg13cmos5l_decap_8_2194 VPWR VGND sg13cmos5l_decap_8
* cell instance sg13cmos5l_decap_8_2195 r0 *1 0,0
Xsg13cmos5l_decap_8_2195 VPWR VGND sg13cmos5l_decap_8
* cell instance sg13cmos5l_decap_8_2196 r0 *1 0,0
Xsg13cmos5l_decap_8_2196 VPWR VGND sg13cmos5l_decap_8
* cell instance sg13cmos5l_decap_8_2197 r0 *1 0,0
Xsg13cmos5l_decap_8_2197 VPWR VGND sg13cmos5l_decap_8
* cell instance sg13cmos5l_decap_8_2198 r0 *1 0,0
Xsg13cmos5l_decap_8_2198 VPWR VGND sg13cmos5l_decap_8
* cell instance sg13cmos5l_decap_8_2199 r0 *1 0,0
Xsg13cmos5l_decap_8_2199 VPWR VGND sg13cmos5l_decap_8
* cell instance sg13cmos5l_decap_8_2200 r0 *1 0,0
Xsg13cmos5l_decap_8_2200 VPWR VGND sg13cmos5l_decap_8
* cell instance sg13cmos5l_decap_8_2201 r0 *1 0,0
Xsg13cmos5l_decap_8_2201 VPWR VGND sg13cmos5l_decap_8
* cell instance sg13cmos5l_decap_8_2202 r0 *1 0,0
Xsg13cmos5l_decap_8_2202 VPWR VGND sg13cmos5l_decap_8
* cell instance sg13cmos5l_decap_8_2203 r0 *1 0,0
Xsg13cmos5l_decap_8_2203 VPWR VGND sg13cmos5l_decap_8
* cell instance sg13cmos5l_decap_8_2204 r0 *1 0,0
Xsg13cmos5l_decap_8_2204 VPWR VGND sg13cmos5l_decap_8
* cell instance sg13cmos5l_decap_8_2205 r0 *1 0,0
Xsg13cmos5l_decap_8_2205 VPWR VGND sg13cmos5l_decap_8
* cell instance sg13cmos5l_decap_8_2206 r0 *1 0,0
Xsg13cmos5l_decap_8_2206 VPWR VGND sg13cmos5l_decap_8
* cell instance sg13cmos5l_decap_8_2207 r0 *1 0,0
Xsg13cmos5l_decap_8_2207 VPWR VGND sg13cmos5l_decap_8
* cell instance sg13cmos5l_decap_8_2208 r0 *1 0,0
Xsg13cmos5l_decap_8_2208 VPWR VGND sg13cmos5l_decap_8
* cell instance sg13cmos5l_decap_8_2209 r0 *1 0,0
Xsg13cmos5l_decap_8_2209 VPWR VGND sg13cmos5l_decap_8
* cell instance sg13cmos5l_decap_8_2210 r0 *1 0,0
Xsg13cmos5l_decap_8_2210 VPWR VGND sg13cmos5l_decap_8
* cell instance sg13cmos5l_decap_8_2211 r0 *1 0,0
Xsg13cmos5l_decap_8_2211 VPWR VGND sg13cmos5l_decap_8
* cell instance sg13cmos5l_decap_8_2212 r0 *1 0,0
Xsg13cmos5l_decap_8_2212 VPWR VGND sg13cmos5l_decap_8
* cell instance sg13cmos5l_decap_8_2213 r0 *1 0,0
Xsg13cmos5l_decap_8_2213 VPWR VGND sg13cmos5l_decap_8
* cell instance sg13cmos5l_decap_8_2214 r0 *1 0,0
Xsg13cmos5l_decap_8_2214 VPWR VGND sg13cmos5l_decap_8
* cell instance sg13cmos5l_decap_8_2215 r0 *1 0,0
Xsg13cmos5l_decap_8_2215 VPWR VGND sg13cmos5l_decap_8
* cell instance sg13cmos5l_decap_8_2216 r0 *1 0,0
Xsg13cmos5l_decap_8_2216 VPWR VGND sg13cmos5l_decap_8
* cell instance sg13cmos5l_decap_8_2217 r0 *1 0,0
Xsg13cmos5l_decap_8_2217 VPWR VGND sg13cmos5l_decap_8
* cell instance sg13cmos5l_decap_8_2218 r0 *1 0,0
Xsg13cmos5l_decap_8_2218 VPWR VGND sg13cmos5l_decap_8
* cell instance sg13cmos5l_decap_8_2219 r0 *1 0,0
Xsg13cmos5l_decap_8_2219 VPWR VGND sg13cmos5l_decap_8
* cell instance sg13cmos5l_decap_8_2220 r0 *1 0,0
Xsg13cmos5l_decap_8_2220 VPWR VGND sg13cmos5l_decap_8
* cell instance sg13cmos5l_decap_8_2221 r0 *1 0,0
Xsg13cmos5l_decap_8_2221 VPWR VGND sg13cmos5l_decap_8
* cell instance sg13cmos5l_decap_8_2222 r0 *1 0,0
Xsg13cmos5l_decap_8_2222 VPWR VGND sg13cmos5l_decap_8
* cell instance sg13cmos5l_decap_8_2223 r0 *1 0,0
Xsg13cmos5l_decap_8_2223 VPWR VGND sg13cmos5l_decap_8
* cell instance sg13cmos5l_decap_8_2224 r0 *1 0,0
Xsg13cmos5l_decap_8_2224 VPWR VGND sg13cmos5l_decap_8
* cell instance sg13cmos5l_decap_8_2225 r0 *1 0,0
Xsg13cmos5l_decap_8_2225 VPWR VGND sg13cmos5l_decap_8
* cell instance sg13cmos5l_decap_8_2226 r0 *1 0,0
Xsg13cmos5l_decap_8_2226 VPWR VGND sg13cmos5l_decap_8
* cell instance sg13cmos5l_decap_8_2227 r0 *1 0,0
Xsg13cmos5l_decap_8_2227 VPWR VGND sg13cmos5l_decap_8
* cell instance sg13cmos5l_decap_8_2228 r0 *1 0,0
Xsg13cmos5l_decap_8_2228 VPWR VGND sg13cmos5l_decap_8
* cell instance sg13cmos5l_decap_8_2229 r0 *1 0,0
Xsg13cmos5l_decap_8_2229 VPWR VGND sg13cmos5l_decap_8
* cell instance sg13cmos5l_decap_8_2230 r0 *1 0,0
Xsg13cmos5l_decap_8_2230 VPWR VGND sg13cmos5l_decap_8
* cell instance sg13cmos5l_decap_8_2231 r0 *1 0,0
Xsg13cmos5l_decap_8_2231 VPWR VGND sg13cmos5l_decap_8
* cell instance sg13cmos5l_decap_8_2232 r0 *1 0,0
Xsg13cmos5l_decap_8_2232 VPWR VGND sg13cmos5l_decap_8
* cell instance sg13cmos5l_decap_8_2233 r0 *1 0,0
Xsg13cmos5l_decap_8_2233 VPWR VGND sg13cmos5l_decap_8
* cell instance sg13cmos5l_decap_8_2234 r0 *1 0,0
Xsg13cmos5l_decap_8_2234 VPWR VGND sg13cmos5l_decap_8
* cell instance sg13cmos5l_decap_8_2235 r0 *1 0,0
Xsg13cmos5l_decap_8_2235 VPWR VGND sg13cmos5l_decap_8
* cell instance sg13cmos5l_decap_8_2236 r0 *1 0,0
Xsg13cmos5l_decap_8_2236 VPWR VGND sg13cmos5l_decap_8
* cell instance sg13cmos5l_decap_8_2237 r0 *1 0,0
Xsg13cmos5l_decap_8_2237 VPWR VGND sg13cmos5l_decap_8
* cell instance sg13cmos5l_decap_8_2238 r0 *1 0,0
Xsg13cmos5l_decap_8_2238 VPWR VGND sg13cmos5l_decap_8
* cell instance sg13cmos5l_decap_8_2239 r0 *1 0,0
Xsg13cmos5l_decap_8_2239 VPWR VGND sg13cmos5l_decap_8
* cell instance sg13cmos5l_decap_8_2240 r0 *1 0,0
Xsg13cmos5l_decap_8_2240 VPWR VGND sg13cmos5l_decap_8
* cell instance sg13cmos5l_decap_8_2241 r0 *1 0,0
Xsg13cmos5l_decap_8_2241 VPWR VGND sg13cmos5l_decap_8
* cell instance sg13cmos5l_decap_8_2242 r0 *1 0,0
Xsg13cmos5l_decap_8_2242 VPWR VGND sg13cmos5l_decap_8
* cell instance sg13cmos5l_decap_8_2243 r0 *1 0,0
Xsg13cmos5l_decap_8_2243 VPWR VGND sg13cmos5l_decap_8
* cell instance sg13cmos5l_decap_8_2244 r0 *1 0,0
Xsg13cmos5l_decap_8_2244 VPWR VGND sg13cmos5l_decap_8
* cell instance sg13cmos5l_decap_8_2245 r0 *1 0,0
Xsg13cmos5l_decap_8_2245 VPWR VGND sg13cmos5l_decap_8
* cell instance sg13cmos5l_decap_8_2246 r0 *1 0,0
Xsg13cmos5l_decap_8_2246 VPWR VGND sg13cmos5l_decap_8
* cell instance sg13cmos5l_decap_8_2247 r0 *1 0,0
Xsg13cmos5l_decap_8_2247 VPWR VGND sg13cmos5l_decap_8
* cell instance sg13cmos5l_decap_8_2248 r0 *1 0,0
Xsg13cmos5l_decap_8_2248 VPWR VGND sg13cmos5l_decap_8
* cell instance sg13cmos5l_decap_8_2249 r0 *1 0,0
Xsg13cmos5l_decap_8_2249 VPWR VGND sg13cmos5l_decap_8
* cell instance sg13cmos5l_decap_8_2250 r0 *1 0,0
Xsg13cmos5l_decap_8_2250 VPWR VGND sg13cmos5l_decap_8
* cell instance sg13cmos5l_decap_8_2251 r0 *1 0,0
Xsg13cmos5l_decap_8_2251 VPWR VGND sg13cmos5l_decap_8
* cell instance sg13cmos5l_decap_8_2252 r0 *1 0,0
Xsg13cmos5l_decap_8_2252 VPWR VGND sg13cmos5l_decap_8
* cell instance sg13cmos5l_decap_8_2253 r0 *1 0,0
Xsg13cmos5l_decap_8_2253 VPWR VGND sg13cmos5l_decap_8
* cell instance sg13cmos5l_decap_8_2254 r0 *1 0,0
Xsg13cmos5l_decap_8_2254 VPWR VGND sg13cmos5l_decap_8
* cell instance sg13cmos5l_decap_8_2255 r0 *1 0,0
Xsg13cmos5l_decap_8_2255 VPWR VGND sg13cmos5l_decap_8
* cell instance sg13cmos5l_decap_8_2256 r0 *1 0,0
Xsg13cmos5l_decap_8_2256 VPWR VGND sg13cmos5l_decap_8
* cell instance sg13cmos5l_decap_8_2257 r0 *1 0,0
Xsg13cmos5l_decap_8_2257 VPWR VGND sg13cmos5l_decap_8
* cell instance sg13cmos5l_decap_8_2258 r0 *1 0,0
Xsg13cmos5l_decap_8_2258 VPWR VGND sg13cmos5l_decap_8
* cell instance sg13cmos5l_decap_8_2259 r0 *1 0,0
Xsg13cmos5l_decap_8_2259 VPWR VGND sg13cmos5l_decap_8
* cell instance sg13cmos5l_decap_8_2260 r0 *1 0,0
Xsg13cmos5l_decap_8_2260 VPWR VGND sg13cmos5l_decap_8
* cell instance sg13cmos5l_decap_8_2261 r0 *1 0,0
Xsg13cmos5l_decap_8_2261 VPWR VGND sg13cmos5l_decap_8
* cell instance sg13cmos5l_decap_8_2262 r0 *1 0,0
Xsg13cmos5l_decap_8_2262 VPWR VGND sg13cmos5l_decap_8
* cell instance sg13cmos5l_decap_8_2263 r0 *1 0,0
Xsg13cmos5l_decap_8_2263 VPWR VGND sg13cmos5l_decap_8
* cell instance sg13cmos5l_decap_8_2264 r0 *1 0,0
Xsg13cmos5l_decap_8_2264 VPWR VGND sg13cmos5l_decap_8
* cell instance sg13cmos5l_decap_8_2265 r0 *1 0,0
Xsg13cmos5l_decap_8_2265 VPWR VGND sg13cmos5l_decap_8
* cell instance sg13cmos5l_decap_8_2266 r0 *1 0,0
Xsg13cmos5l_decap_8_2266 VPWR VGND sg13cmos5l_decap_8
* cell instance sg13cmos5l_decap_8_2267 r0 *1 0,0
Xsg13cmos5l_decap_8_2267 VPWR VGND sg13cmos5l_decap_8
* cell instance sg13cmos5l_decap_8_2268 r0 *1 0,0
Xsg13cmos5l_decap_8_2268 VPWR VGND sg13cmos5l_decap_8
* cell instance sg13cmos5l_decap_8_2269 r0 *1 0,0
Xsg13cmos5l_decap_8_2269 VPWR VGND sg13cmos5l_decap_8
* cell instance sg13cmos5l_decap_8_2270 r0 *1 0,0
Xsg13cmos5l_decap_8_2270 VPWR VGND sg13cmos5l_decap_8
* cell instance sg13cmos5l_decap_8_2271 r0 *1 0,0
Xsg13cmos5l_decap_8_2271 VPWR VGND sg13cmos5l_decap_8
* cell instance sg13cmos5l_decap_8_2272 r0 *1 0,0
Xsg13cmos5l_decap_8_2272 VPWR VGND sg13cmos5l_decap_8
* cell instance sg13cmos5l_decap_8_2273 r0 *1 0,0
Xsg13cmos5l_decap_8_2273 VPWR VGND sg13cmos5l_decap_8
* cell instance sg13cmos5l_decap_8_2274 r0 *1 0,0
Xsg13cmos5l_decap_8_2274 VPWR VGND sg13cmos5l_decap_8
* cell instance sg13cmos5l_decap_8_2275 r0 *1 0,0
Xsg13cmos5l_decap_8_2275 VPWR VGND sg13cmos5l_decap_8
* cell instance sg13cmos5l_decap_8_2276 r0 *1 0,0
Xsg13cmos5l_decap_8_2276 VPWR VGND sg13cmos5l_decap_8
* cell instance sg13cmos5l_decap_8_2277 r0 *1 0,0
Xsg13cmos5l_decap_8_2277 VPWR VGND sg13cmos5l_decap_8
* cell instance sg13cmos5l_decap_8_2278 r0 *1 0,0
Xsg13cmos5l_decap_8_2278 VPWR VGND sg13cmos5l_decap_8
* cell instance sg13cmos5l_decap_8_2279 r0 *1 0,0
Xsg13cmos5l_decap_8_2279 VPWR VGND sg13cmos5l_decap_8
* cell instance sg13cmos5l_decap_8_2280 r0 *1 0,0
Xsg13cmos5l_decap_8_2280 VPWR VGND sg13cmos5l_decap_8
* cell instance sg13cmos5l_decap_8_2281 r0 *1 0,0
Xsg13cmos5l_decap_8_2281 VPWR VGND sg13cmos5l_decap_8
* cell instance sg13cmos5l_decap_8_2282 r0 *1 0,0
Xsg13cmos5l_decap_8_2282 VPWR VGND sg13cmos5l_decap_8
* cell instance sg13cmos5l_decap_8_2283 r0 *1 0,0
Xsg13cmos5l_decap_8_2283 VPWR VGND sg13cmos5l_decap_8
* cell instance sg13cmos5l_decap_8_2284 r0 *1 0,0
Xsg13cmos5l_decap_8_2284 VPWR VGND sg13cmos5l_decap_8
* cell instance sg13cmos5l_decap_8_2285 r0 *1 0,0
Xsg13cmos5l_decap_8_2285 VPWR VGND sg13cmos5l_decap_8
* cell instance sg13cmos5l_decap_8_2286 r0 *1 0,0
Xsg13cmos5l_decap_8_2286 VPWR VGND sg13cmos5l_decap_8
* cell instance sg13cmos5l_decap_8_2287 r0 *1 0,0
Xsg13cmos5l_decap_8_2287 VPWR VGND sg13cmos5l_decap_8
* cell instance sg13cmos5l_decap_8_2288 r0 *1 0,0
Xsg13cmos5l_decap_8_2288 VPWR VGND sg13cmos5l_decap_8
* cell instance sg13cmos5l_decap_8_2289 r0 *1 0,0
Xsg13cmos5l_decap_8_2289 VPWR VGND sg13cmos5l_decap_8
* cell instance sg13cmos5l_decap_8_2290 r0 *1 0,0
Xsg13cmos5l_decap_8_2290 VPWR VGND sg13cmos5l_decap_8
* cell instance sg13cmos5l_decap_8_2291 r0 *1 0,0
Xsg13cmos5l_decap_8_2291 VPWR VGND sg13cmos5l_decap_8
* cell instance sg13cmos5l_decap_8_2292 r0 *1 0,0
Xsg13cmos5l_decap_8_2292 VPWR VGND sg13cmos5l_decap_8
* cell instance sg13cmos5l_decap_8_2293 r0 *1 0,0
Xsg13cmos5l_decap_8_2293 VPWR VGND sg13cmos5l_decap_8
* cell instance sg13cmos5l_decap_8_2294 r0 *1 0,0
Xsg13cmos5l_decap_8_2294 VPWR VGND sg13cmos5l_decap_8
* cell instance sg13cmos5l_decap_8_2295 r0 *1 0,0
Xsg13cmos5l_decap_8_2295 VPWR VGND sg13cmos5l_decap_8
* cell instance sg13cmos5l_decap_8_2296 r0 *1 0,0
Xsg13cmos5l_decap_8_2296 VPWR VGND sg13cmos5l_decap_8
* cell instance sg13cmos5l_decap_8_2297 r0 *1 0,0
Xsg13cmos5l_decap_8_2297 VPWR VGND sg13cmos5l_decap_8
* cell instance sg13cmos5l_decap_8_2298 r0 *1 0,0
Xsg13cmos5l_decap_8_2298 VPWR VGND sg13cmos5l_decap_8
* cell instance sg13cmos5l_decap_8_2299 r0 *1 0,0
Xsg13cmos5l_decap_8_2299 VPWR VGND sg13cmos5l_decap_8
* cell instance sg13cmos5l_decap_8_2300 r0 *1 0,0
Xsg13cmos5l_decap_8_2300 VPWR VGND sg13cmos5l_decap_8
* cell instance sg13cmos5l_decap_8_2301 r0 *1 0,0
Xsg13cmos5l_decap_8_2301 VPWR VGND sg13cmos5l_decap_8
* cell instance sg13cmos5l_decap_8_2302 r0 *1 0,0
Xsg13cmos5l_decap_8_2302 VPWR VGND sg13cmos5l_decap_8
* cell instance sg13cmos5l_decap_8_2303 r0 *1 0,0
Xsg13cmos5l_decap_8_2303 VPWR VGND sg13cmos5l_decap_8
* cell instance sg13cmos5l_decap_8_2304 r0 *1 0,0
Xsg13cmos5l_decap_8_2304 VPWR VGND sg13cmos5l_decap_8
* cell instance sg13cmos5l_decap_8_2305 r0 *1 0,0
Xsg13cmos5l_decap_8_2305 VPWR VGND sg13cmos5l_decap_8
* cell instance sg13cmos5l_decap_8_2306 r0 *1 0,0
Xsg13cmos5l_decap_8_2306 VPWR VGND sg13cmos5l_decap_8
* cell instance sg13cmos5l_decap_8_2307 r0 *1 0,0
Xsg13cmos5l_decap_8_2307 VPWR VGND sg13cmos5l_decap_8
* cell instance sg13cmos5l_decap_8_2308 r0 *1 0,0
Xsg13cmos5l_decap_8_2308 VPWR VGND sg13cmos5l_decap_8
* cell instance sg13cmos5l_decap_8_2309 r0 *1 0,0
Xsg13cmos5l_decap_8_2309 VPWR VGND sg13cmos5l_decap_8
* cell instance sg13cmos5l_decap_8_2310 r0 *1 0,0
Xsg13cmos5l_decap_8_2310 VPWR VGND sg13cmos5l_decap_8
* cell instance sg13cmos5l_decap_8_2311 r0 *1 0,0
Xsg13cmos5l_decap_8_2311 VPWR VGND sg13cmos5l_decap_8
* cell instance sg13cmos5l_decap_8_2312 r0 *1 0,0
Xsg13cmos5l_decap_8_2312 VPWR VGND sg13cmos5l_decap_8
* cell instance sg13cmos5l_decap_8_2313 r0 *1 0,0
Xsg13cmos5l_decap_8_2313 VPWR VGND sg13cmos5l_decap_8
* cell instance sg13cmos5l_decap_8_2314 r0 *1 0,0
Xsg13cmos5l_decap_8_2314 VPWR VGND sg13cmos5l_decap_8
* cell instance sg13cmos5l_decap_8_2315 r0 *1 0,0
Xsg13cmos5l_decap_8_2315 VPWR VGND sg13cmos5l_decap_8
* cell instance sg13cmos5l_decap_8_2316 r0 *1 0,0
Xsg13cmos5l_decap_8_2316 VPWR VGND sg13cmos5l_decap_8
* cell instance sg13cmos5l_decap_8_2317 r0 *1 0,0
Xsg13cmos5l_decap_8_2317 VPWR VGND sg13cmos5l_decap_8
* cell instance sg13cmos5l_decap_8_2318 r0 *1 0,0
Xsg13cmos5l_decap_8_2318 VPWR VGND sg13cmos5l_decap_8
* cell instance sg13cmos5l_decap_8_2319 r0 *1 0,0
Xsg13cmos5l_decap_8_2319 VPWR VGND sg13cmos5l_decap_8
* cell instance sg13cmos5l_decap_8_2320 r0 *1 0,0
Xsg13cmos5l_decap_8_2320 VPWR VGND sg13cmos5l_decap_8
* cell instance sg13cmos5l_decap_8_2321 r0 *1 0,0
Xsg13cmos5l_decap_8_2321 VPWR VGND sg13cmos5l_decap_8
* cell instance sg13cmos5l_decap_8_2322 r0 *1 0,0
Xsg13cmos5l_decap_8_2322 VPWR VGND sg13cmos5l_decap_8
* cell instance sg13cmos5l_decap_8_2323 r0 *1 0,0
Xsg13cmos5l_decap_8_2323 VPWR VGND sg13cmos5l_decap_8
* cell instance sg13cmos5l_decap_8_2324 r0 *1 0,0
Xsg13cmos5l_decap_8_2324 VPWR VGND sg13cmos5l_decap_8
* cell instance sg13cmos5l_decap_8_2325 r0 *1 0,0
Xsg13cmos5l_decap_8_2325 VPWR VGND sg13cmos5l_decap_8
* cell instance sg13cmos5l_decap_8_2326 r0 *1 0,0
Xsg13cmos5l_decap_8_2326 VPWR VGND sg13cmos5l_decap_8
* cell instance sg13cmos5l_decap_8_2327 r0 *1 0,0
Xsg13cmos5l_decap_8_2327 VPWR VGND sg13cmos5l_decap_8
* cell instance sg13cmos5l_decap_8_2328 r0 *1 0,0
Xsg13cmos5l_decap_8_2328 VPWR VGND sg13cmos5l_decap_8
* cell instance sg13cmos5l_decap_8_2329 r0 *1 0,0
Xsg13cmos5l_decap_8_2329 VPWR VGND sg13cmos5l_decap_8
* cell instance sg13cmos5l_decap_8_2330 r0 *1 0,0
Xsg13cmos5l_decap_8_2330 VPWR VGND sg13cmos5l_decap_8
* cell instance sg13cmos5l_decap_8_2331 r0 *1 0,0
Xsg13cmos5l_decap_8_2331 VPWR VGND sg13cmos5l_decap_8
* cell instance sg13cmos5l_decap_8_2332 r0 *1 0,0
Xsg13cmos5l_decap_8_2332 VPWR VGND sg13cmos5l_decap_8
* cell instance sg13cmos5l_decap_8_2333 r0 *1 0,0
Xsg13cmos5l_decap_8_2333 VPWR VGND sg13cmos5l_decap_8
* cell instance sg13cmos5l_decap_8_2334 r0 *1 0,0
Xsg13cmos5l_decap_8_2334 VPWR VGND sg13cmos5l_decap_8
* cell instance sg13cmos5l_decap_8_2335 r0 *1 0,0
Xsg13cmos5l_decap_8_2335 VPWR VGND sg13cmos5l_decap_8
* cell instance sg13cmos5l_decap_8_2336 r0 *1 0,0
Xsg13cmos5l_decap_8_2336 VPWR VGND sg13cmos5l_decap_8
* cell instance sg13cmos5l_decap_8_2337 r0 *1 0,0
Xsg13cmos5l_decap_8_2337 VPWR VGND sg13cmos5l_decap_8
* cell instance sg13cmos5l_decap_8_2338 r0 *1 0,0
Xsg13cmos5l_decap_8_2338 VPWR VGND sg13cmos5l_decap_8
* cell instance sg13cmos5l_decap_8_2339 r0 *1 0,0
Xsg13cmos5l_decap_8_2339 VPWR VGND sg13cmos5l_decap_8
* cell instance sg13cmos5l_decap_8_2340 r0 *1 0,0
Xsg13cmos5l_decap_8_2340 VPWR VGND sg13cmos5l_decap_8
* cell instance sg13cmos5l_decap_8_2341 r0 *1 0,0
Xsg13cmos5l_decap_8_2341 VPWR VGND sg13cmos5l_decap_8
* cell instance sg13cmos5l_decap_8_2342 r0 *1 0,0
Xsg13cmos5l_decap_8_2342 VPWR VGND sg13cmos5l_decap_8
* cell instance sg13cmos5l_decap_8_2343 r0 *1 0,0
Xsg13cmos5l_decap_8_2343 VPWR VGND sg13cmos5l_decap_8
* cell instance sg13cmos5l_decap_8_2344 r0 *1 0,0
Xsg13cmos5l_decap_8_2344 VPWR VGND sg13cmos5l_decap_8
* cell instance sg13cmos5l_decap_8_2345 r0 *1 0,0
Xsg13cmos5l_decap_8_2345 VPWR VGND sg13cmos5l_decap_8
* cell instance sg13cmos5l_decap_8_2346 r0 *1 0,0
Xsg13cmos5l_decap_8_2346 VPWR VGND sg13cmos5l_decap_8
* cell instance sg13cmos5l_decap_8_2347 r0 *1 0,0
Xsg13cmos5l_decap_8_2347 VPWR VGND sg13cmos5l_decap_8
* cell instance sg13cmos5l_decap_8_2348 r0 *1 0,0
Xsg13cmos5l_decap_8_2348 VPWR VGND sg13cmos5l_decap_8
* cell instance sg13cmos5l_decap_8_2349 r0 *1 0,0
Xsg13cmos5l_decap_8_2349 VPWR VGND sg13cmos5l_decap_8
* cell instance sg13cmos5l_decap_8_2350 r0 *1 0,0
Xsg13cmos5l_decap_8_2350 VPWR VGND sg13cmos5l_decap_8
* cell instance sg13cmos5l_decap_8_2351 r0 *1 0,0
Xsg13cmos5l_decap_8_2351 VPWR VGND sg13cmos5l_decap_8
* cell instance sg13cmos5l_decap_8_2352 r0 *1 0,0
Xsg13cmos5l_decap_8_2352 VPWR VGND sg13cmos5l_decap_8
* cell instance sg13cmos5l_decap_8_2353 r0 *1 0,0
Xsg13cmos5l_decap_8_2353 VPWR VGND sg13cmos5l_decap_8
* cell instance sg13cmos5l_decap_8_2354 r0 *1 0,0
Xsg13cmos5l_decap_8_2354 VPWR VGND sg13cmos5l_decap_8
* cell instance sg13cmos5l_decap_8_2355 r0 *1 0,0
Xsg13cmos5l_decap_8_2355 VPWR VGND sg13cmos5l_decap_8
* cell instance sg13cmos5l_decap_8_2356 r0 *1 0,0
Xsg13cmos5l_decap_8_2356 VPWR VGND sg13cmos5l_decap_8
* cell instance sg13cmos5l_decap_8_2357 r0 *1 0,0
Xsg13cmos5l_decap_8_2357 VPWR VGND sg13cmos5l_decap_8
* cell instance sg13cmos5l_decap_8_2358 r0 *1 0,0
Xsg13cmos5l_decap_8_2358 VPWR VGND sg13cmos5l_decap_8
* cell instance sg13cmos5l_decap_8_2359 r0 *1 0,0
Xsg13cmos5l_decap_8_2359 VPWR VGND sg13cmos5l_decap_8
* cell instance sg13cmos5l_decap_8_2360 r0 *1 0,0
Xsg13cmos5l_decap_8_2360 VPWR VGND sg13cmos5l_decap_8
* cell instance sg13cmos5l_decap_8_2361 r0 *1 0,0
Xsg13cmos5l_decap_8_2361 VPWR VGND sg13cmos5l_decap_8
* cell instance sg13cmos5l_decap_8_2362 r0 *1 0,0
Xsg13cmos5l_decap_8_2362 VPWR VGND sg13cmos5l_decap_8
* cell instance sg13cmos5l_decap_8_2363 r0 *1 0,0
Xsg13cmos5l_decap_8_2363 VPWR VGND sg13cmos5l_decap_8
* cell instance sg13cmos5l_decap_8_2364 r0 *1 0,0
Xsg13cmos5l_decap_8_2364 VPWR VGND sg13cmos5l_decap_8
* cell instance sg13cmos5l_decap_8_2365 r0 *1 0,0
Xsg13cmos5l_decap_8_2365 VPWR VGND sg13cmos5l_decap_8
* cell instance sg13cmos5l_decap_8_2366 r0 *1 0,0
Xsg13cmos5l_decap_8_2366 VPWR VGND sg13cmos5l_decap_8
* cell instance sg13cmos5l_decap_8_2367 r0 *1 0,0
Xsg13cmos5l_decap_8_2367 VPWR VGND sg13cmos5l_decap_8
* cell instance sg13cmos5l_decap_8_2368 r0 *1 0,0
Xsg13cmos5l_decap_8_2368 VPWR VGND sg13cmos5l_decap_8
* cell instance sg13cmos5l_decap_8_2369 r0 *1 0,0
Xsg13cmos5l_decap_8_2369 VPWR VGND sg13cmos5l_decap_8
* cell instance sg13cmos5l_decap_8_2370 r0 *1 0,0
Xsg13cmos5l_decap_8_2370 VPWR VGND sg13cmos5l_decap_8
* cell instance sg13cmos5l_decap_8_2371 r0 *1 0,0
Xsg13cmos5l_decap_8_2371 VPWR VGND sg13cmos5l_decap_8
* cell instance sg13cmos5l_decap_8_2372 r0 *1 0,0
Xsg13cmos5l_decap_8_2372 VPWR VGND sg13cmos5l_decap_8
* cell instance sg13cmos5l_decap_8_2373 r0 *1 0,0
Xsg13cmos5l_decap_8_2373 VPWR VGND sg13cmos5l_decap_8
* cell instance sg13cmos5l_decap_8_2374 r0 *1 0,0
Xsg13cmos5l_decap_8_2374 VPWR VGND sg13cmos5l_decap_8
* cell instance sg13cmos5l_decap_8_2375 r0 *1 0,0
Xsg13cmos5l_decap_8_2375 VPWR VGND sg13cmos5l_decap_8
* cell instance sg13cmos5l_decap_8_2376 r0 *1 0,0
Xsg13cmos5l_decap_8_2376 VPWR VGND sg13cmos5l_decap_8
* cell instance sg13cmos5l_decap_8_2377 r0 *1 0,0
Xsg13cmos5l_decap_8_2377 VPWR VGND sg13cmos5l_decap_8
* cell instance sg13cmos5l_decap_8_2378 r0 *1 0,0
Xsg13cmos5l_decap_8_2378 VPWR VGND sg13cmos5l_decap_8
* cell instance sg13cmos5l_decap_8_2379 r0 *1 0,0
Xsg13cmos5l_decap_8_2379 VPWR VGND sg13cmos5l_decap_8
* cell instance sg13cmos5l_decap_8_2380 r0 *1 0,0
Xsg13cmos5l_decap_8_2380 VPWR VGND sg13cmos5l_decap_8
* cell instance sg13cmos5l_decap_8_2381 r0 *1 0,0
Xsg13cmos5l_decap_8_2381 VPWR VGND sg13cmos5l_decap_8
* cell instance sg13cmos5l_decap_8_2382 r0 *1 0,0
Xsg13cmos5l_decap_8_2382 VPWR VGND sg13cmos5l_decap_8
* cell instance sg13cmos5l_decap_8_2383 r0 *1 0,0
Xsg13cmos5l_decap_8_2383 VPWR VGND sg13cmos5l_decap_8
* cell instance sg13cmos5l_decap_8_2384 r0 *1 0,0
Xsg13cmos5l_decap_8_2384 VPWR VGND sg13cmos5l_decap_8
* cell instance sg13cmos5l_decap_8_2385 r0 *1 0,0
Xsg13cmos5l_decap_8_2385 VPWR VGND sg13cmos5l_decap_8
* cell instance sg13cmos5l_decap_8_2386 r0 *1 0,0
Xsg13cmos5l_decap_8_2386 VPWR VGND sg13cmos5l_decap_8
* cell instance sg13cmos5l_decap_8_2387 r0 *1 0,0
Xsg13cmos5l_decap_8_2387 VPWR VGND sg13cmos5l_decap_8
* cell instance sg13cmos5l_decap_8_2388 r0 *1 0,0
Xsg13cmos5l_decap_8_2388 VPWR VGND sg13cmos5l_decap_8
* cell instance sg13cmos5l_decap_8_2389 r0 *1 0,0
Xsg13cmos5l_decap_8_2389 VPWR VGND sg13cmos5l_decap_8
* cell instance sg13cmos5l_decap_8_2390 r0 *1 0,0
Xsg13cmos5l_decap_8_2390 VPWR VGND sg13cmos5l_decap_8
* cell instance sg13cmos5l_decap_8_2391 r0 *1 0,0
Xsg13cmos5l_decap_8_2391 VPWR VGND sg13cmos5l_decap_8
* cell instance sg13cmos5l_decap_8_2392 r0 *1 0,0
Xsg13cmos5l_decap_8_2392 VPWR VGND sg13cmos5l_decap_8
* cell instance sg13cmos5l_decap_8_2393 r0 *1 0,0
Xsg13cmos5l_decap_8_2393 VPWR VGND sg13cmos5l_decap_8
* cell instance sg13cmos5l_decap_8_2394 r0 *1 0,0
Xsg13cmos5l_decap_8_2394 VPWR VGND sg13cmos5l_decap_8
* cell instance sg13cmos5l_decap_8_2395 r0 *1 0,0
Xsg13cmos5l_decap_8_2395 VPWR VGND sg13cmos5l_decap_8
* cell instance sg13cmos5l_decap_8_2396 r0 *1 0,0
Xsg13cmos5l_decap_8_2396 VPWR VGND sg13cmos5l_decap_8
* cell instance sg13cmos5l_decap_8_2397 r0 *1 0,0
Xsg13cmos5l_decap_8_2397 VPWR VGND sg13cmos5l_decap_8
* cell instance sg13cmos5l_decap_8_2398 r0 *1 0,0
Xsg13cmos5l_decap_8_2398 VPWR VGND sg13cmos5l_decap_8
* cell instance sg13cmos5l_decap_8_2399 r0 *1 0,0
Xsg13cmos5l_decap_8_2399 VPWR VGND sg13cmos5l_decap_8
* cell instance sg13cmos5l_decap_8_2400 r0 *1 0,0
Xsg13cmos5l_decap_8_2400 VPWR VGND sg13cmos5l_decap_8
* cell instance sg13cmos5l_decap_8_2401 r0 *1 0,0
Xsg13cmos5l_decap_8_2401 VPWR VGND sg13cmos5l_decap_8
* cell instance sg13cmos5l_decap_8_2402 r0 *1 0,0
Xsg13cmos5l_decap_8_2402 VPWR VGND sg13cmos5l_decap_8
* cell instance sg13cmos5l_decap_8_2403 r0 *1 0,0
Xsg13cmos5l_decap_8_2403 VPWR VGND sg13cmos5l_decap_8
* cell instance sg13cmos5l_decap_8_2404 r0 *1 0,0
Xsg13cmos5l_decap_8_2404 VPWR VGND sg13cmos5l_decap_8
* cell instance sg13cmos5l_decap_8_2405 r0 *1 0,0
Xsg13cmos5l_decap_8_2405 VPWR VGND sg13cmos5l_decap_8
* cell instance sg13cmos5l_decap_8_2406 r0 *1 0,0
Xsg13cmos5l_decap_8_2406 VPWR VGND sg13cmos5l_decap_8
* cell instance sg13cmos5l_decap_8_2407 r0 *1 0,0
Xsg13cmos5l_decap_8_2407 VPWR VGND sg13cmos5l_decap_8
* cell instance sg13cmos5l_decap_8_2408 r0 *1 0,0
Xsg13cmos5l_decap_8_2408 VPWR VGND sg13cmos5l_decap_8
* cell instance sg13cmos5l_decap_8_2409 r0 *1 0,0
Xsg13cmos5l_decap_8_2409 VPWR VGND sg13cmos5l_decap_8
* cell instance sg13cmos5l_decap_8_2410 r0 *1 0,0
Xsg13cmos5l_decap_8_2410 VPWR VGND sg13cmos5l_decap_8
* cell instance sg13cmos5l_decap_8_2411 r0 *1 0,0
Xsg13cmos5l_decap_8_2411 VPWR VGND sg13cmos5l_decap_8
* cell instance sg13cmos5l_decap_8_2412 r0 *1 0,0
Xsg13cmos5l_decap_8_2412 VPWR VGND sg13cmos5l_decap_8
* cell instance sg13cmos5l_decap_8_2413 r0 *1 0,0
Xsg13cmos5l_decap_8_2413 VPWR VGND sg13cmos5l_decap_8
* cell instance sg13cmos5l_decap_8_2414 r0 *1 0,0
Xsg13cmos5l_decap_8_2414 VPWR VGND sg13cmos5l_decap_8
* cell instance sg13cmos5l_decap_8_2415 r0 *1 0,0
Xsg13cmos5l_decap_8_2415 VPWR VGND sg13cmos5l_decap_8
* cell instance sg13cmos5l_decap_8_2416 r0 *1 0,0
Xsg13cmos5l_decap_8_2416 VPWR VGND sg13cmos5l_decap_8
* cell instance sg13cmos5l_decap_8_2417 r0 *1 0,0
Xsg13cmos5l_decap_8_2417 VPWR VGND sg13cmos5l_decap_8
* cell instance sg13cmos5l_decap_8_2418 r0 *1 0,0
Xsg13cmos5l_decap_8_2418 VPWR VGND sg13cmos5l_decap_8
* cell instance sg13cmos5l_decap_8_2419 r0 *1 0,0
Xsg13cmos5l_decap_8_2419 VPWR VGND sg13cmos5l_decap_8
* cell instance sg13cmos5l_decap_8_2420 r0 *1 0,0
Xsg13cmos5l_decap_8_2420 VPWR VGND sg13cmos5l_decap_8
* cell instance sg13cmos5l_decap_8_2421 r0 *1 0,0
Xsg13cmos5l_decap_8_2421 VPWR VGND sg13cmos5l_decap_8
* cell instance sg13cmos5l_decap_8_2422 r0 *1 0,0
Xsg13cmos5l_decap_8_2422 VPWR VGND sg13cmos5l_decap_8
* cell instance sg13cmos5l_decap_8_2423 r0 *1 0,0
Xsg13cmos5l_decap_8_2423 VPWR VGND sg13cmos5l_decap_8
* cell instance sg13cmos5l_decap_8_2424 r0 *1 0,0
Xsg13cmos5l_decap_8_2424 VPWR VGND sg13cmos5l_decap_8
* cell instance sg13cmos5l_decap_8_2425 r0 *1 0,0
Xsg13cmos5l_decap_8_2425 VPWR VGND sg13cmos5l_decap_8
* cell instance sg13cmos5l_decap_8_2426 r0 *1 0,0
Xsg13cmos5l_decap_8_2426 VPWR VGND sg13cmos5l_decap_8
* cell instance sg13cmos5l_decap_8_2427 r0 *1 0,0
Xsg13cmos5l_decap_8_2427 VPWR VGND sg13cmos5l_decap_8
* cell instance sg13cmos5l_decap_8_2428 r0 *1 0,0
Xsg13cmos5l_decap_8_2428 VPWR VGND sg13cmos5l_decap_8
* cell instance sg13cmos5l_decap_8_2429 r0 *1 0,0
Xsg13cmos5l_decap_8_2429 VPWR VGND sg13cmos5l_decap_8
* cell instance sg13cmos5l_decap_8_2430 r0 *1 0,0
Xsg13cmos5l_decap_8_2430 VPWR VGND sg13cmos5l_decap_8
* cell instance sg13cmos5l_decap_8_2431 r0 *1 0,0
Xsg13cmos5l_decap_8_2431 VPWR VGND sg13cmos5l_decap_8
* cell instance sg13cmos5l_decap_8_2432 r0 *1 0,0
Xsg13cmos5l_decap_8_2432 VPWR VGND sg13cmos5l_decap_8
* cell instance sg13cmos5l_decap_8_2433 r0 *1 0,0
Xsg13cmos5l_decap_8_2433 VPWR VGND sg13cmos5l_decap_8
* cell instance sg13cmos5l_decap_8_2434 r0 *1 0,0
Xsg13cmos5l_decap_8_2434 VPWR VGND sg13cmos5l_decap_8
* cell instance sg13cmos5l_decap_8_2435 r0 *1 0,0
Xsg13cmos5l_decap_8_2435 VPWR VGND sg13cmos5l_decap_8
* cell instance sg13cmos5l_decap_8_2436 r0 *1 0,0
Xsg13cmos5l_decap_8_2436 VPWR VGND sg13cmos5l_decap_8
* cell instance sg13cmos5l_decap_8_2437 r0 *1 0,0
Xsg13cmos5l_decap_8_2437 VPWR VGND sg13cmos5l_decap_8
* cell instance sg13cmos5l_decap_8_2438 r0 *1 0,0
Xsg13cmos5l_decap_8_2438 VPWR VGND sg13cmos5l_decap_8
* cell instance sg13cmos5l_decap_8_2439 r0 *1 0,0
Xsg13cmos5l_decap_8_2439 VPWR VGND sg13cmos5l_decap_8
* cell instance sg13cmos5l_decap_8_2440 r0 *1 0,0
Xsg13cmos5l_decap_8_2440 VPWR VGND sg13cmos5l_decap_8
* cell instance sg13cmos5l_decap_8_2441 r0 *1 0,0
Xsg13cmos5l_decap_8_2441 VPWR VGND sg13cmos5l_decap_8
* cell instance sg13cmos5l_decap_8_2442 r0 *1 0,0
Xsg13cmos5l_decap_8_2442 VPWR VGND sg13cmos5l_decap_8
* cell instance sg13cmos5l_decap_8_2443 r0 *1 0,0
Xsg13cmos5l_decap_8_2443 VPWR VGND sg13cmos5l_decap_8
* cell instance sg13cmos5l_decap_8_2444 r0 *1 0,0
Xsg13cmos5l_decap_8_2444 VPWR VGND sg13cmos5l_decap_8
* cell instance sg13cmos5l_decap_8_2445 r0 *1 0,0
Xsg13cmos5l_decap_8_2445 VPWR VGND sg13cmos5l_decap_8
* cell instance sg13cmos5l_decap_8_2446 r0 *1 0,0
Xsg13cmos5l_decap_8_2446 VPWR VGND sg13cmos5l_decap_8
* cell instance sg13cmos5l_decap_8_2447 r0 *1 0,0
Xsg13cmos5l_decap_8_2447 VPWR VGND sg13cmos5l_decap_8
* cell instance sg13cmos5l_decap_8_2448 r0 *1 0,0
Xsg13cmos5l_decap_8_2448 VPWR VGND sg13cmos5l_decap_8
* cell instance sg13cmos5l_decap_8_2449 r0 *1 0,0
Xsg13cmos5l_decap_8_2449 VPWR VGND sg13cmos5l_decap_8
* cell instance sg13cmos5l_decap_8_2450 r0 *1 0,0
Xsg13cmos5l_decap_8_2450 VPWR VGND sg13cmos5l_decap_8
* cell instance sg13cmos5l_decap_8_2451 r0 *1 0,0
Xsg13cmos5l_decap_8_2451 VPWR VGND sg13cmos5l_decap_8
* cell instance sg13cmos5l_decap_8_2452 r0 *1 0,0
Xsg13cmos5l_decap_8_2452 VPWR VGND sg13cmos5l_decap_8
* cell instance sg13cmos5l_decap_8_2453 r0 *1 0,0
Xsg13cmos5l_decap_8_2453 VPWR VGND sg13cmos5l_decap_8
* cell instance sg13cmos5l_decap_8_2454 r0 *1 0,0
Xsg13cmos5l_decap_8_2454 VPWR VGND sg13cmos5l_decap_8
* cell instance sg13cmos5l_decap_8_2455 r0 *1 0,0
Xsg13cmos5l_decap_8_2455 VPWR VGND sg13cmos5l_decap_8
* cell instance sg13cmos5l_decap_8_2456 r0 *1 0,0
Xsg13cmos5l_decap_8_2456 VPWR VGND sg13cmos5l_decap_8
* cell instance sg13cmos5l_decap_8_2457 r0 *1 0,0
Xsg13cmos5l_decap_8_2457 VPWR VGND sg13cmos5l_decap_8
* cell instance sg13cmos5l_decap_8_2458 r0 *1 0,0
Xsg13cmos5l_decap_8_2458 VPWR VGND sg13cmos5l_decap_8
* cell instance sg13cmos5l_decap_8_2459 r0 *1 0,0
Xsg13cmos5l_decap_8_2459 VPWR VGND sg13cmos5l_decap_8
* cell instance sg13cmos5l_decap_8_2460 r0 *1 0,0
Xsg13cmos5l_decap_8_2460 VPWR VGND sg13cmos5l_decap_8
* cell instance sg13cmos5l_decap_8_2461 r0 *1 0,0
Xsg13cmos5l_decap_8_2461 VPWR VGND sg13cmos5l_decap_8
* cell instance sg13cmos5l_decap_8_2462 r0 *1 0,0
Xsg13cmos5l_decap_8_2462 VPWR VGND sg13cmos5l_decap_8
* cell instance sg13cmos5l_decap_8_2463 r0 *1 0,0
Xsg13cmos5l_decap_8_2463 VPWR VGND sg13cmos5l_decap_8
* cell instance sg13cmos5l_decap_8_2464 r0 *1 0,0
Xsg13cmos5l_decap_8_2464 VPWR VGND sg13cmos5l_decap_8
* cell instance sg13cmos5l_decap_8_2465 r0 *1 0,0
Xsg13cmos5l_decap_8_2465 VPWR VGND sg13cmos5l_decap_8
* cell instance sg13cmos5l_decap_8_2466 r0 *1 0,0
Xsg13cmos5l_decap_8_2466 VPWR VGND sg13cmos5l_decap_8
* cell instance sg13cmos5l_decap_8_2467 r0 *1 0,0
Xsg13cmos5l_decap_8_2467 VPWR VGND sg13cmos5l_decap_8
* cell instance sg13cmos5l_decap_8_2468 r0 *1 0,0
Xsg13cmos5l_decap_8_2468 VPWR VGND sg13cmos5l_decap_8
* cell instance sg13cmos5l_decap_8_2469 r0 *1 0,0
Xsg13cmos5l_decap_8_2469 VPWR VGND sg13cmos5l_decap_8
* cell instance sg13cmos5l_decap_8_2470 r0 *1 0,0
Xsg13cmos5l_decap_8_2470 VPWR VGND sg13cmos5l_decap_8
* cell instance sg13cmos5l_decap_8_2471 r0 *1 0,0
Xsg13cmos5l_decap_8_2471 VPWR VGND sg13cmos5l_decap_8
* cell instance sg13cmos5l_decap_8_2472 r0 *1 0,0
Xsg13cmos5l_decap_8_2472 VPWR VGND sg13cmos5l_decap_8
* cell instance sg13cmos5l_decap_8_2473 r0 *1 0,0
Xsg13cmos5l_decap_8_2473 VPWR VGND sg13cmos5l_decap_8
* cell instance sg13cmos5l_decap_8_2474 r0 *1 0,0
Xsg13cmos5l_decap_8_2474 VPWR VGND sg13cmos5l_decap_8
* cell instance sg13cmos5l_decap_8_2475 r0 *1 0,0
Xsg13cmos5l_decap_8_2475 VPWR VGND sg13cmos5l_decap_8
* cell instance sg13cmos5l_decap_8_2476 r0 *1 0,0
Xsg13cmos5l_decap_8_2476 VPWR VGND sg13cmos5l_decap_8
* cell instance sg13cmos5l_decap_8_2477 r0 *1 0,0
Xsg13cmos5l_decap_8_2477 VPWR VGND sg13cmos5l_decap_8
* cell instance sg13cmos5l_decap_8_2478 r0 *1 0,0
Xsg13cmos5l_decap_8_2478 VPWR VGND sg13cmos5l_decap_8
* cell instance sg13cmos5l_decap_8_2479 r0 *1 0,0
Xsg13cmos5l_decap_8_2479 VPWR VGND sg13cmos5l_decap_8
* cell instance sg13cmos5l_decap_8_2480 r0 *1 0,0
Xsg13cmos5l_decap_8_2480 VPWR VGND sg13cmos5l_decap_8
* cell instance sg13cmos5l_decap_8_2481 r0 *1 0,0
Xsg13cmos5l_decap_8_2481 VPWR VGND sg13cmos5l_decap_8
* cell instance sg13cmos5l_decap_8_2482 r0 *1 0,0
Xsg13cmos5l_decap_8_2482 VPWR VGND sg13cmos5l_decap_8
* cell instance sg13cmos5l_decap_8_2483 r0 *1 0,0
Xsg13cmos5l_decap_8_2483 VPWR VGND sg13cmos5l_decap_8
* cell instance sg13cmos5l_decap_8_2484 r0 *1 0,0
Xsg13cmos5l_decap_8_2484 VPWR VGND sg13cmos5l_decap_8
* cell instance sg13cmos5l_decap_8_2485 r0 *1 0,0
Xsg13cmos5l_decap_8_2485 VPWR VGND sg13cmos5l_decap_8
* cell instance sg13cmos5l_decap_8_2486 r0 *1 0,0
Xsg13cmos5l_decap_8_2486 VPWR VGND sg13cmos5l_decap_8
* cell instance sg13cmos5l_decap_8_2487 r0 *1 0,0
Xsg13cmos5l_decap_8_2487 VPWR VGND sg13cmos5l_decap_8
* cell instance sg13cmos5l_decap_8_2488 r0 *1 0,0
Xsg13cmos5l_decap_8_2488 VPWR VGND sg13cmos5l_decap_8
* cell instance sg13cmos5l_decap_8_2489 r0 *1 0,0
Xsg13cmos5l_decap_8_2489 VPWR VGND sg13cmos5l_decap_8
* cell instance sg13cmos5l_decap_8_2490 r0 *1 0,0
Xsg13cmos5l_decap_8_2490 VPWR VGND sg13cmos5l_decap_8
* cell instance sg13cmos5l_decap_8_2491 r0 *1 0,0
Xsg13cmos5l_decap_8_2491 VPWR VGND sg13cmos5l_decap_8
* cell instance sg13cmos5l_decap_8_2492 r0 *1 0,0
Xsg13cmos5l_decap_8_2492 VPWR VGND sg13cmos5l_decap_8
* cell instance sg13cmos5l_decap_8_2493 r0 *1 0,0
Xsg13cmos5l_decap_8_2493 VPWR VGND sg13cmos5l_decap_8
* cell instance sg13cmos5l_decap_8_2494 r0 *1 0,0
Xsg13cmos5l_decap_8_2494 VPWR VGND sg13cmos5l_decap_8
* cell instance sg13cmos5l_decap_8_2495 r0 *1 0,0
Xsg13cmos5l_decap_8_2495 VPWR VGND sg13cmos5l_decap_8
* cell instance sg13cmos5l_decap_8_2496 r0 *1 0,0
Xsg13cmos5l_decap_8_2496 VPWR VGND sg13cmos5l_decap_8
* cell instance sg13cmos5l_decap_8_2497 r0 *1 0,0
Xsg13cmos5l_decap_8_2497 VPWR VGND sg13cmos5l_decap_8
* cell instance sg13cmos5l_decap_8_2498 r0 *1 0,0
Xsg13cmos5l_decap_8_2498 VPWR VGND sg13cmos5l_decap_8
* cell instance sg13cmos5l_decap_8_2499 r0 *1 0,0
Xsg13cmos5l_decap_8_2499 VPWR VGND sg13cmos5l_decap_8
* cell instance sg13cmos5l_decap_8_2500 r0 *1 0,0
Xsg13cmos5l_decap_8_2500 VPWR VGND sg13cmos5l_decap_8
* cell instance sg13cmos5l_decap_8_2501 r0 *1 0,0
Xsg13cmos5l_decap_8_2501 VPWR VGND sg13cmos5l_decap_8
* cell instance sg13cmos5l_decap_8_2502 r0 *1 0,0
Xsg13cmos5l_decap_8_2502 VPWR VGND sg13cmos5l_decap_8
* cell instance sg13cmos5l_decap_8_2503 r0 *1 0,0
Xsg13cmos5l_decap_8_2503 VPWR VGND sg13cmos5l_decap_8
* cell instance sg13cmos5l_decap_8_2504 r0 *1 0,0
Xsg13cmos5l_decap_8_2504 VPWR VGND sg13cmos5l_decap_8
* cell instance sg13cmos5l_decap_8_2505 r0 *1 0,0
Xsg13cmos5l_decap_8_2505 VPWR VGND sg13cmos5l_decap_8
* cell instance sg13cmos5l_decap_8_2506 r0 *1 0,0
Xsg13cmos5l_decap_8_2506 VPWR VGND sg13cmos5l_decap_8
* cell instance sg13cmos5l_decap_8_2507 r0 *1 0,0
Xsg13cmos5l_decap_8_2507 VPWR VGND sg13cmos5l_decap_8
* cell instance sg13cmos5l_decap_8_2508 r0 *1 0,0
Xsg13cmos5l_decap_8_2508 VPWR VGND sg13cmos5l_decap_8
* cell instance sg13cmos5l_decap_8_2509 r0 *1 0,0
Xsg13cmos5l_decap_8_2509 VPWR VGND sg13cmos5l_decap_8
* cell instance sg13cmos5l_decap_8_2510 r0 *1 0,0
Xsg13cmos5l_decap_8_2510 VPWR VGND sg13cmos5l_decap_8
* cell instance sg13cmos5l_decap_8_2511 r0 *1 0,0
Xsg13cmos5l_decap_8_2511 VPWR VGND sg13cmos5l_decap_8
* cell instance sg13cmos5l_decap_8_2512 r0 *1 0,0
Xsg13cmos5l_decap_8_2512 VPWR VGND sg13cmos5l_decap_8
* cell instance sg13cmos5l_decap_8_2513 r0 *1 0,0
Xsg13cmos5l_decap_8_2513 VPWR VGND sg13cmos5l_decap_8
* cell instance sg13cmos5l_decap_8_2514 r0 *1 0,0
Xsg13cmos5l_decap_8_2514 VPWR VGND sg13cmos5l_decap_8
* cell instance sg13cmos5l_decap_8_2515 r0 *1 0,0
Xsg13cmos5l_decap_8_2515 VPWR VGND sg13cmos5l_decap_8
* cell instance sg13cmos5l_decap_8_2516 r0 *1 0,0
Xsg13cmos5l_decap_8_2516 VPWR VGND sg13cmos5l_decap_8
* cell instance sg13cmos5l_decap_8_2517 r0 *1 0,0
Xsg13cmos5l_decap_8_2517 VPWR VGND sg13cmos5l_decap_8
* cell instance sg13cmos5l_decap_8_2518 r0 *1 0,0
Xsg13cmos5l_decap_8_2518 VPWR VGND sg13cmos5l_decap_8
* cell instance sg13cmos5l_decap_8_2519 r0 *1 0,0
Xsg13cmos5l_decap_8_2519 VPWR VGND sg13cmos5l_decap_8
* cell instance sg13cmos5l_decap_8_2520 r0 *1 0,0
Xsg13cmos5l_decap_8_2520 VPWR VGND sg13cmos5l_decap_8
* cell instance sg13cmos5l_decap_8_2521 r0 *1 0,0
Xsg13cmos5l_decap_8_2521 VPWR VGND sg13cmos5l_decap_8
* cell instance sg13cmos5l_decap_8_2522 r0 *1 0,0
Xsg13cmos5l_decap_8_2522 VPWR VGND sg13cmos5l_decap_8
* cell instance sg13cmos5l_decap_8_2523 r0 *1 0,0
Xsg13cmos5l_decap_8_2523 VPWR VGND sg13cmos5l_decap_8
* cell instance sg13cmos5l_decap_8_2524 r0 *1 0,0
Xsg13cmos5l_decap_8_2524 VPWR VGND sg13cmos5l_decap_8
* cell instance sg13cmos5l_decap_8_2525 r0 *1 0,0
Xsg13cmos5l_decap_8_2525 VPWR VGND sg13cmos5l_decap_8
* cell instance sg13cmos5l_decap_8_2526 r0 *1 0,0
Xsg13cmos5l_decap_8_2526 VPWR VGND sg13cmos5l_decap_8
* cell instance sg13cmos5l_decap_8_2527 r0 *1 0,0
Xsg13cmos5l_decap_8_2527 VPWR VGND sg13cmos5l_decap_8
* cell instance sg13cmos5l_decap_8_2528 r0 *1 0,0
Xsg13cmos5l_decap_8_2528 VPWR VGND sg13cmos5l_decap_8
* cell instance sg13cmos5l_decap_8_2529 r0 *1 0,0
Xsg13cmos5l_decap_8_2529 VPWR VGND sg13cmos5l_decap_8
* cell instance sg13cmos5l_decap_8_2530 r0 *1 0,0
Xsg13cmos5l_decap_8_2530 VPWR VGND sg13cmos5l_decap_8
* cell instance sg13cmos5l_decap_8_2531 r0 *1 0,0
Xsg13cmos5l_decap_8_2531 VPWR VGND sg13cmos5l_decap_8
* cell instance sg13cmos5l_decap_8_2532 r0 *1 0,0
Xsg13cmos5l_decap_8_2532 VPWR VGND sg13cmos5l_decap_8
* cell instance sg13cmos5l_decap_8_2533 r0 *1 0,0
Xsg13cmos5l_decap_8_2533 VPWR VGND sg13cmos5l_decap_8
* cell instance sg13cmos5l_decap_8_2534 r0 *1 0,0
Xsg13cmos5l_decap_8_2534 VPWR VGND sg13cmos5l_decap_8
* cell instance sg13cmos5l_decap_8_2535 r0 *1 0,0
Xsg13cmos5l_decap_8_2535 VPWR VGND sg13cmos5l_decap_8
* cell instance sg13cmos5l_decap_8_2536 r0 *1 0,0
Xsg13cmos5l_decap_8_2536 VPWR VGND sg13cmos5l_decap_8
* cell instance sg13cmos5l_decap_8_2537 r0 *1 0,0
Xsg13cmos5l_decap_8_2537 VPWR VGND sg13cmos5l_decap_8
* cell instance sg13cmos5l_decap_8_2538 r0 *1 0,0
Xsg13cmos5l_decap_8_2538 VPWR VGND sg13cmos5l_decap_8
* cell instance sg13cmos5l_decap_8_2539 r0 *1 0,0
Xsg13cmos5l_decap_8_2539 VPWR VGND sg13cmos5l_decap_8
* cell instance sg13cmos5l_decap_8_2540 r0 *1 0,0
Xsg13cmos5l_decap_8_2540 VPWR VGND sg13cmos5l_decap_8
* cell instance sg13cmos5l_decap_8_2541 r0 *1 0,0
Xsg13cmos5l_decap_8_2541 VPWR VGND sg13cmos5l_decap_8
* cell instance sg13cmos5l_decap_8_2542 r0 *1 0,0
Xsg13cmos5l_decap_8_2542 VPWR VGND sg13cmos5l_decap_8
* cell instance sg13cmos5l_decap_8_2543 r0 *1 0,0
Xsg13cmos5l_decap_8_2543 VPWR VGND sg13cmos5l_decap_8
* cell instance sg13cmos5l_decap_8_2544 r0 *1 0,0
Xsg13cmos5l_decap_8_2544 VPWR VGND sg13cmos5l_decap_8
* cell instance sg13cmos5l_decap_8_2545 r0 *1 0,0
Xsg13cmos5l_decap_8_2545 VPWR VGND sg13cmos5l_decap_8
* cell instance sg13cmos5l_decap_8_2546 r0 *1 0,0
Xsg13cmos5l_decap_8_2546 VPWR VGND sg13cmos5l_decap_8
* cell instance sg13cmos5l_decap_8_2547 r0 *1 0,0
Xsg13cmos5l_decap_8_2547 VPWR VGND sg13cmos5l_decap_8
* cell instance sg13cmos5l_decap_8_2548 r0 *1 0,0
Xsg13cmos5l_decap_8_2548 VPWR VGND sg13cmos5l_decap_8
* cell instance sg13cmos5l_decap_8_2549 r0 *1 0,0
Xsg13cmos5l_decap_8_2549 VPWR VGND sg13cmos5l_decap_8
* cell instance sg13cmos5l_decap_8_2550 r0 *1 0,0
Xsg13cmos5l_decap_8_2550 VPWR VGND sg13cmos5l_decap_8
* cell instance sg13cmos5l_decap_8_2551 r0 *1 0,0
Xsg13cmos5l_decap_8_2551 VPWR VGND sg13cmos5l_decap_8
* cell instance sg13cmos5l_decap_8_2552 r0 *1 0,0
Xsg13cmos5l_decap_8_2552 VPWR VGND sg13cmos5l_decap_8
* cell instance sg13cmos5l_decap_8_2553 r0 *1 0,0
Xsg13cmos5l_decap_8_2553 VPWR VGND sg13cmos5l_decap_8
* cell instance sg13cmos5l_decap_8_2554 r0 *1 0,0
Xsg13cmos5l_decap_8_2554 VPWR VGND sg13cmos5l_decap_8
* cell instance sg13cmos5l_decap_8_2555 r0 *1 0,0
Xsg13cmos5l_decap_8_2555 VPWR VGND sg13cmos5l_decap_8
* cell instance sg13cmos5l_decap_8_2556 r0 *1 0,0
Xsg13cmos5l_decap_8_2556 VPWR VGND sg13cmos5l_decap_8
* cell instance sg13cmos5l_decap_8_2557 r0 *1 0,0
Xsg13cmos5l_decap_8_2557 VPWR VGND sg13cmos5l_decap_8
* cell instance sg13cmos5l_decap_8_2558 r0 *1 0,0
Xsg13cmos5l_decap_8_2558 VPWR VGND sg13cmos5l_decap_8
* cell instance sg13cmos5l_decap_8_2559 r0 *1 0,0
Xsg13cmos5l_decap_8_2559 VPWR VGND sg13cmos5l_decap_8
* cell instance sg13cmos5l_decap_8_2560 r0 *1 0,0
Xsg13cmos5l_decap_8_2560 VPWR VGND sg13cmos5l_decap_8
* cell instance sg13cmos5l_decap_8_2561 r0 *1 0,0
Xsg13cmos5l_decap_8_2561 VPWR VGND sg13cmos5l_decap_8
* cell instance sg13cmos5l_decap_8_2562 r0 *1 0,0
Xsg13cmos5l_decap_8_2562 VPWR VGND sg13cmos5l_decap_8
* cell instance sg13cmos5l_decap_8_2563 r0 *1 0,0
Xsg13cmos5l_decap_8_2563 VPWR VGND sg13cmos5l_decap_8
* cell instance sg13cmos5l_decap_8_2564 r0 *1 0,0
Xsg13cmos5l_decap_8_2564 VPWR VGND sg13cmos5l_decap_8
* cell instance sg13cmos5l_decap_8_2565 r0 *1 0,0
Xsg13cmos5l_decap_8_2565 VPWR VGND sg13cmos5l_decap_8
* cell instance sg13cmos5l_decap_8_2566 r0 *1 0,0
Xsg13cmos5l_decap_8_2566 VPWR VGND sg13cmos5l_decap_8
* cell instance sg13cmos5l_decap_8_2567 r0 *1 0,0
Xsg13cmos5l_decap_8_2567 VPWR VGND sg13cmos5l_decap_8
* cell instance sg13cmos5l_decap_8_2568 r0 *1 0,0
Xsg13cmos5l_decap_8_2568 VPWR VGND sg13cmos5l_decap_8
* cell instance sg13cmos5l_decap_8_2569 r0 *1 0,0
Xsg13cmos5l_decap_8_2569 VPWR VGND sg13cmos5l_decap_8
* cell instance sg13cmos5l_decap_8_2570 r0 *1 0,0
Xsg13cmos5l_decap_8_2570 VPWR VGND sg13cmos5l_decap_8
* cell instance sg13cmos5l_decap_8_2571 r0 *1 0,0
Xsg13cmos5l_decap_8_2571 VPWR VGND sg13cmos5l_decap_8
* cell instance sg13cmos5l_decap_8_2572 r0 *1 0,0
Xsg13cmos5l_decap_8_2572 VPWR VGND sg13cmos5l_decap_8
* cell instance sg13cmos5l_decap_8_2573 r0 *1 0,0
Xsg13cmos5l_decap_8_2573 VPWR VGND sg13cmos5l_decap_8
* cell instance sg13cmos5l_decap_8_2574 r0 *1 0,0
Xsg13cmos5l_decap_8_2574 VPWR VGND sg13cmos5l_decap_8
* cell instance sg13cmos5l_decap_8_2575 r0 *1 0,0
Xsg13cmos5l_decap_8_2575 VPWR VGND sg13cmos5l_decap_8
* cell instance sg13cmos5l_decap_8_2576 r0 *1 0,0
Xsg13cmos5l_decap_8_2576 VPWR VGND sg13cmos5l_decap_8
* cell instance sg13cmos5l_decap_8_2577 r0 *1 0,0
Xsg13cmos5l_decap_8_2577 VPWR VGND sg13cmos5l_decap_8
* cell instance sg13cmos5l_decap_8_2578 r0 *1 0,0
Xsg13cmos5l_decap_8_2578 VPWR VGND sg13cmos5l_decap_8
* cell instance sg13cmos5l_decap_8_2579 r0 *1 0,0
Xsg13cmos5l_decap_8_2579 VPWR VGND sg13cmos5l_decap_8
* cell instance sg13cmos5l_decap_8_2580 r0 *1 0,0
Xsg13cmos5l_decap_8_2580 VPWR VGND sg13cmos5l_decap_8
* cell instance sg13cmos5l_decap_8_2581 r0 *1 0,0
Xsg13cmos5l_decap_8_2581 VPWR VGND sg13cmos5l_decap_8
* cell instance sg13cmos5l_decap_8_2582 r0 *1 0,0
Xsg13cmos5l_decap_8_2582 VPWR VGND sg13cmos5l_decap_8
* cell instance sg13cmos5l_decap_8_2583 r0 *1 0,0
Xsg13cmos5l_decap_8_2583 VPWR VGND sg13cmos5l_decap_8
* cell instance sg13cmos5l_decap_8_2584 r0 *1 0,0
Xsg13cmos5l_decap_8_2584 VPWR VGND sg13cmos5l_decap_8
* cell instance sg13cmos5l_decap_8_2585 r0 *1 0,0
Xsg13cmos5l_decap_8_2585 VPWR VGND sg13cmos5l_decap_8
* cell instance sg13cmos5l_decap_8_2586 r0 *1 0,0
Xsg13cmos5l_decap_8_2586 VPWR VGND sg13cmos5l_decap_8
* cell instance sg13cmos5l_decap_8_2587 r0 *1 0,0
Xsg13cmos5l_decap_8_2587 VPWR VGND sg13cmos5l_decap_8
* cell instance sg13cmos5l_decap_8_2588 r0 *1 0,0
Xsg13cmos5l_decap_8_2588 VPWR VGND sg13cmos5l_decap_8
* cell instance sg13cmos5l_decap_8_2589 r0 *1 0,0
Xsg13cmos5l_decap_8_2589 VPWR VGND sg13cmos5l_decap_8
* cell instance sg13cmos5l_decap_8_2590 r0 *1 0,0
Xsg13cmos5l_decap_8_2590 VPWR VGND sg13cmos5l_decap_8
* cell instance sg13cmos5l_decap_8_2591 r0 *1 0,0
Xsg13cmos5l_decap_8_2591 VPWR VGND sg13cmos5l_decap_8
* cell instance sg13cmos5l_decap_8_2592 r0 *1 0,0
Xsg13cmos5l_decap_8_2592 VPWR VGND sg13cmos5l_decap_8
* cell instance sg13cmos5l_decap_8_2593 r0 *1 0,0
Xsg13cmos5l_decap_8_2593 VPWR VGND sg13cmos5l_decap_8
* cell instance sg13cmos5l_decap_8_2594 r0 *1 0,0
Xsg13cmos5l_decap_8_2594 VPWR VGND sg13cmos5l_decap_8
* cell instance sg13cmos5l_decap_8_2595 r0 *1 0,0
Xsg13cmos5l_decap_8_2595 VPWR VGND sg13cmos5l_decap_8
* cell instance sg13cmos5l_decap_8_2596 r0 *1 0,0
Xsg13cmos5l_decap_8_2596 VPWR VGND sg13cmos5l_decap_8
* cell instance sg13cmos5l_decap_8_2597 r0 *1 0,0
Xsg13cmos5l_decap_8_2597 VPWR VGND sg13cmos5l_decap_8
* cell instance sg13cmos5l_decap_8_2598 r0 *1 0,0
Xsg13cmos5l_decap_8_2598 VPWR VGND sg13cmos5l_decap_8
* cell instance sg13cmos5l_decap_8_2599 r0 *1 0,0
Xsg13cmos5l_decap_8_2599 VPWR VGND sg13cmos5l_decap_8
* cell instance sg13cmos5l_decap_8_2600 r0 *1 0,0
Xsg13cmos5l_decap_8_2600 VPWR VGND sg13cmos5l_decap_8
* cell instance sg13cmos5l_decap_8_2601 r0 *1 0,0
Xsg13cmos5l_decap_8_2601 VPWR VGND sg13cmos5l_decap_8
* cell instance sg13cmos5l_decap_8_2602 r0 *1 0,0
Xsg13cmos5l_decap_8_2602 VPWR VGND sg13cmos5l_decap_8
* cell instance sg13cmos5l_decap_8_2603 r0 *1 0,0
Xsg13cmos5l_decap_8_2603 VPWR VGND sg13cmos5l_decap_8
* cell instance sg13cmos5l_decap_8_2604 r0 *1 0,0
Xsg13cmos5l_decap_8_2604 VPWR VGND sg13cmos5l_decap_8
* cell instance sg13cmos5l_decap_8_2605 r0 *1 0,0
Xsg13cmos5l_decap_8_2605 VPWR VGND sg13cmos5l_decap_8
* cell instance sg13cmos5l_decap_8_2606 r0 *1 0,0
Xsg13cmos5l_decap_8_2606 VPWR VGND sg13cmos5l_decap_8
* cell instance sg13cmos5l_decap_8_2607 r0 *1 0,0
Xsg13cmos5l_decap_8_2607 VPWR VGND sg13cmos5l_decap_8
* cell instance sg13cmos5l_decap_8_2608 r0 *1 0,0
Xsg13cmos5l_decap_8_2608 VPWR VGND sg13cmos5l_decap_8
* cell instance sg13cmos5l_decap_8_2609 r0 *1 0,0
Xsg13cmos5l_decap_8_2609 VPWR VGND sg13cmos5l_decap_8
* cell instance sg13cmos5l_decap_8_2610 r0 *1 0,0
Xsg13cmos5l_decap_8_2610 VPWR VGND sg13cmos5l_decap_8
* cell instance sg13cmos5l_decap_8_2611 r0 *1 0,0
Xsg13cmos5l_decap_8_2611 VPWR VGND sg13cmos5l_decap_8
* cell instance sg13cmos5l_decap_8_2612 r0 *1 0,0
Xsg13cmos5l_decap_8_2612 VPWR VGND sg13cmos5l_decap_8
* cell instance sg13cmos5l_decap_8_2613 r0 *1 0,0
Xsg13cmos5l_decap_8_2613 VPWR VGND sg13cmos5l_decap_8
* cell instance sg13cmos5l_decap_8_2614 r0 *1 0,0
Xsg13cmos5l_decap_8_2614 VPWR VGND sg13cmos5l_decap_8
* cell instance sg13cmos5l_decap_8_2615 r0 *1 0,0
Xsg13cmos5l_decap_8_2615 VPWR VGND sg13cmos5l_decap_8
* cell instance sg13cmos5l_decap_8_2616 r0 *1 0,0
Xsg13cmos5l_decap_8_2616 VPWR VGND sg13cmos5l_decap_8
* cell instance sg13cmos5l_decap_8_2617 r0 *1 0,0
Xsg13cmos5l_decap_8_2617 VPWR VGND sg13cmos5l_decap_8
* cell instance sg13cmos5l_decap_8_2618 r0 *1 0,0
Xsg13cmos5l_decap_8_2618 VPWR VGND sg13cmos5l_decap_8
* cell instance sg13cmos5l_decap_8_2619 r0 *1 0,0
Xsg13cmos5l_decap_8_2619 VPWR VGND sg13cmos5l_decap_8
* cell instance sg13cmos5l_decap_8_2620 r0 *1 0,0
Xsg13cmos5l_decap_8_2620 VPWR VGND sg13cmos5l_decap_8
* cell instance sg13cmos5l_decap_8_2621 r0 *1 0,0
Xsg13cmos5l_decap_8_2621 VPWR VGND sg13cmos5l_decap_8
* cell instance sg13cmos5l_decap_8_2622 r0 *1 0,0
Xsg13cmos5l_decap_8_2622 VPWR VGND sg13cmos5l_decap_8
* cell instance sg13cmos5l_decap_8_2623 r0 *1 0,0
Xsg13cmos5l_decap_8_2623 VPWR VGND sg13cmos5l_decap_8
* cell instance sg13cmos5l_decap_8_2624 r0 *1 0,0
Xsg13cmos5l_decap_8_2624 VPWR VGND sg13cmos5l_decap_8
* cell instance sg13cmos5l_decap_8_2625 r0 *1 0,0
Xsg13cmos5l_decap_8_2625 VPWR VGND sg13cmos5l_decap_8
* cell instance sg13cmos5l_decap_8_2626 r0 *1 0,0
Xsg13cmos5l_decap_8_2626 VPWR VGND sg13cmos5l_decap_8
* cell instance sg13cmos5l_decap_8_2627 r0 *1 0,0
Xsg13cmos5l_decap_8_2627 VPWR VGND sg13cmos5l_decap_8
* cell instance sg13cmos5l_decap_8_2628 r0 *1 0,0
Xsg13cmos5l_decap_8_2628 VPWR VGND sg13cmos5l_decap_8
* cell instance sg13cmos5l_decap_8_2629 r0 *1 0,0
Xsg13cmos5l_decap_8_2629 VPWR VGND sg13cmos5l_decap_8
* cell instance sg13cmos5l_decap_8_2630 r0 *1 0,0
Xsg13cmos5l_decap_8_2630 VPWR VGND sg13cmos5l_decap_8
* cell instance sg13cmos5l_decap_8_2631 r0 *1 0,0
Xsg13cmos5l_decap_8_2631 VPWR VGND sg13cmos5l_decap_8
* cell instance sg13cmos5l_decap_8_2632 r0 *1 0,0
Xsg13cmos5l_decap_8_2632 VPWR VGND sg13cmos5l_decap_8
* cell instance sg13cmos5l_decap_8_2633 r0 *1 0,0
Xsg13cmos5l_decap_8_2633 VPWR VGND sg13cmos5l_decap_8
* cell instance sg13cmos5l_decap_8_2634 r0 *1 0,0
Xsg13cmos5l_decap_8_2634 VPWR VGND sg13cmos5l_decap_8
* cell instance sg13cmos5l_decap_8_2635 r0 *1 0,0
Xsg13cmos5l_decap_8_2635 VPWR VGND sg13cmos5l_decap_8
* cell instance sg13cmos5l_decap_8_2636 r0 *1 0,0
Xsg13cmos5l_decap_8_2636 VPWR VGND sg13cmos5l_decap_8
* cell instance sg13cmos5l_decap_8_2637 r0 *1 0,0
Xsg13cmos5l_decap_8_2637 VPWR VGND sg13cmos5l_decap_8
* cell instance sg13cmos5l_decap_8_2638 r0 *1 0,0
Xsg13cmos5l_decap_8_2638 VPWR VGND sg13cmos5l_decap_8
* cell instance sg13cmos5l_decap_8_2639 r0 *1 0,0
Xsg13cmos5l_decap_8_2639 VPWR VGND sg13cmos5l_decap_8
* cell instance sg13cmos5l_decap_8_2640 r0 *1 0,0
Xsg13cmos5l_decap_8_2640 VPWR VGND sg13cmos5l_decap_8
* cell instance sg13cmos5l_decap_8_2641 r0 *1 0,0
Xsg13cmos5l_decap_8_2641 VPWR VGND sg13cmos5l_decap_8
* cell instance sg13cmos5l_decap_8_2642 r0 *1 0,0
Xsg13cmos5l_decap_8_2642 VPWR VGND sg13cmos5l_decap_8
* cell instance sg13cmos5l_decap_8_2643 r0 *1 0,0
Xsg13cmos5l_decap_8_2643 VPWR VGND sg13cmos5l_decap_8
* cell instance sg13cmos5l_decap_8_2644 r0 *1 0,0
Xsg13cmos5l_decap_8_2644 VPWR VGND sg13cmos5l_decap_8
* cell instance sg13cmos5l_decap_8_2645 r0 *1 0,0
Xsg13cmos5l_decap_8_2645 VPWR VGND sg13cmos5l_decap_8
* cell instance sg13cmos5l_decap_8_2646 r0 *1 0,0
Xsg13cmos5l_decap_8_2646 VPWR VGND sg13cmos5l_decap_8
* cell instance sg13cmos5l_decap_8_2647 r0 *1 0,0
Xsg13cmos5l_decap_8_2647 VPWR VGND sg13cmos5l_decap_8
* cell instance sg13cmos5l_decap_8_2648 r0 *1 0,0
Xsg13cmos5l_decap_8_2648 VPWR VGND sg13cmos5l_decap_8
* cell instance sg13cmos5l_decap_8_2649 r0 *1 0,0
Xsg13cmos5l_decap_8_2649 VPWR VGND sg13cmos5l_decap_8
* cell instance sg13cmos5l_decap_8_2650 r0 *1 0,0
Xsg13cmos5l_decap_8_2650 VPWR VGND sg13cmos5l_decap_8
* cell instance sg13cmos5l_decap_8_2651 r0 *1 0,0
Xsg13cmos5l_decap_8_2651 VPWR VGND sg13cmos5l_decap_8
* cell instance sg13cmos5l_decap_8_2652 r0 *1 0,0
Xsg13cmos5l_decap_8_2652 VPWR VGND sg13cmos5l_decap_8
* cell instance sg13cmos5l_decap_8_2653 r0 *1 0,0
Xsg13cmos5l_decap_8_2653 VPWR VGND sg13cmos5l_decap_8
* cell instance sg13cmos5l_decap_8_2654 r0 *1 0,0
Xsg13cmos5l_decap_8_2654 VPWR VGND sg13cmos5l_decap_8
* cell instance sg13cmos5l_decap_8_2655 r0 *1 0,0
Xsg13cmos5l_decap_8_2655 VPWR VGND sg13cmos5l_decap_8
* cell instance sg13cmos5l_decap_8_2656 r0 *1 0,0
Xsg13cmos5l_decap_8_2656 VPWR VGND sg13cmos5l_decap_8
* cell instance sg13cmos5l_decap_8_2657 r0 *1 0,0
Xsg13cmos5l_decap_8_2657 VPWR VGND sg13cmos5l_decap_8
* cell instance sg13cmos5l_decap_8_2658 r0 *1 0,0
Xsg13cmos5l_decap_8_2658 VPWR VGND sg13cmos5l_decap_8
* cell instance sg13cmos5l_decap_8_2659 r0 *1 0,0
Xsg13cmos5l_decap_8_2659 VPWR VGND sg13cmos5l_decap_8
* cell instance sg13cmos5l_decap_8_2660 r0 *1 0,0
Xsg13cmos5l_decap_8_2660 VPWR VGND sg13cmos5l_decap_8
* cell instance sg13cmos5l_decap_8_2661 r0 *1 0,0
Xsg13cmos5l_decap_8_2661 VPWR VGND sg13cmos5l_decap_8
* cell instance sg13cmos5l_decap_8_2662 r0 *1 0,0
Xsg13cmos5l_decap_8_2662 VPWR VGND sg13cmos5l_decap_8
* cell instance sg13cmos5l_decap_8_2663 r0 *1 0,0
Xsg13cmos5l_decap_8_2663 VPWR VGND sg13cmos5l_decap_8
* cell instance sg13cmos5l_decap_8_2664 r0 *1 0,0
Xsg13cmos5l_decap_8_2664 VPWR VGND sg13cmos5l_decap_8
* cell instance sg13cmos5l_decap_8_2665 r0 *1 0,0
Xsg13cmos5l_decap_8_2665 VPWR VGND sg13cmos5l_decap_8
* cell instance sg13cmos5l_decap_8_2666 r0 *1 0,0
Xsg13cmos5l_decap_8_2666 VPWR VGND sg13cmos5l_decap_8
* cell instance sg13cmos5l_decap_8_2667 r0 *1 0,0
Xsg13cmos5l_decap_8_2667 VPWR VGND sg13cmos5l_decap_8
* cell instance sg13cmos5l_decap_8_2668 r0 *1 0,0
Xsg13cmos5l_decap_8_2668 VPWR VGND sg13cmos5l_decap_8
* cell instance sg13cmos5l_decap_8_2669 r0 *1 0,0
Xsg13cmos5l_decap_8_2669 VPWR VGND sg13cmos5l_decap_8
* cell instance sg13cmos5l_decap_8_2670 r0 *1 0,0
Xsg13cmos5l_decap_8_2670 VPWR VGND sg13cmos5l_decap_8
* cell instance sg13cmos5l_decap_8_2671 r0 *1 0,0
Xsg13cmos5l_decap_8_2671 VPWR VGND sg13cmos5l_decap_8
* cell instance sg13cmos5l_decap_8_2672 r0 *1 0,0
Xsg13cmos5l_decap_8_2672 VPWR VGND sg13cmos5l_decap_8
* cell instance sg13cmos5l_decap_8_2673 r0 *1 0,0
Xsg13cmos5l_decap_8_2673 VPWR VGND sg13cmos5l_decap_8
* cell instance sg13cmos5l_decap_8_2674 r0 *1 0,0
Xsg13cmos5l_decap_8_2674 VPWR VGND sg13cmos5l_decap_8
* cell instance sg13cmos5l_decap_8_2675 r0 *1 0,0
Xsg13cmos5l_decap_8_2675 VPWR VGND sg13cmos5l_decap_8
* cell instance sg13cmos5l_decap_8_2676 r0 *1 0,0
Xsg13cmos5l_decap_8_2676 VPWR VGND sg13cmos5l_decap_8
* cell instance sg13cmos5l_decap_8_2677 r0 *1 0,0
Xsg13cmos5l_decap_8_2677 VPWR VGND sg13cmos5l_decap_8
* cell instance sg13cmos5l_decap_8_2678 r0 *1 0,0
Xsg13cmos5l_decap_8_2678 VPWR VGND sg13cmos5l_decap_8
* cell instance sg13cmos5l_decap_8_2679 r0 *1 0,0
Xsg13cmos5l_decap_8_2679 VPWR VGND sg13cmos5l_decap_8
* cell instance sg13cmos5l_decap_8_2680 r0 *1 0,0
Xsg13cmos5l_decap_8_2680 VPWR VGND sg13cmos5l_decap_8
* cell instance sg13cmos5l_decap_8_2681 r0 *1 0,0
Xsg13cmos5l_decap_8_2681 VPWR VGND sg13cmos5l_decap_8
* cell instance sg13cmos5l_decap_8_2682 r0 *1 0,0
Xsg13cmos5l_decap_8_2682 VPWR VGND sg13cmos5l_decap_8
* cell instance sg13cmos5l_decap_8_2683 r0 *1 0,0
Xsg13cmos5l_decap_8_2683 VPWR VGND sg13cmos5l_decap_8
* cell instance sg13cmos5l_decap_8_2684 r0 *1 0,0
Xsg13cmos5l_decap_8_2684 VPWR VGND sg13cmos5l_decap_8
* cell instance sg13cmos5l_decap_8_2685 r0 *1 0,0
Xsg13cmos5l_decap_8_2685 VPWR VGND sg13cmos5l_decap_8
* cell instance sg13cmos5l_decap_8_2686 r0 *1 0,0
Xsg13cmos5l_decap_8_2686 VPWR VGND sg13cmos5l_decap_8
* cell instance sg13cmos5l_decap_8_2687 r0 *1 0,0
Xsg13cmos5l_decap_8_2687 VPWR VGND sg13cmos5l_decap_8
* cell instance sg13cmos5l_decap_8_2688 r0 *1 0,0
Xsg13cmos5l_decap_8_2688 VPWR VGND sg13cmos5l_decap_8
* cell instance sg13cmos5l_decap_8_2689 r0 *1 0,0
Xsg13cmos5l_decap_8_2689 VPWR VGND sg13cmos5l_decap_8
* cell instance sg13cmos5l_decap_8_2690 r0 *1 0,0
Xsg13cmos5l_decap_8_2690 VPWR VGND sg13cmos5l_decap_8
* cell instance sg13cmos5l_decap_8_2691 r0 *1 0,0
Xsg13cmos5l_decap_8_2691 VPWR VGND sg13cmos5l_decap_8
* cell instance sg13cmos5l_decap_8_2692 r0 *1 0,0
Xsg13cmos5l_decap_8_2692 VPWR VGND sg13cmos5l_decap_8
* cell instance sg13cmos5l_decap_8_2693 r0 *1 0,0
Xsg13cmos5l_decap_8_2693 VPWR VGND sg13cmos5l_decap_8
* cell instance sg13cmos5l_decap_8_2694 r0 *1 0,0
Xsg13cmos5l_decap_8_2694 VPWR VGND sg13cmos5l_decap_8
* cell instance sg13cmos5l_decap_8_2695 r0 *1 0,0
Xsg13cmos5l_decap_8_2695 VPWR VGND sg13cmos5l_decap_8
* cell instance sg13cmos5l_decap_8_2696 r0 *1 0,0
Xsg13cmos5l_decap_8_2696 VPWR VGND sg13cmos5l_decap_8
* cell instance sg13cmos5l_decap_8_2697 r0 *1 0,0
Xsg13cmos5l_decap_8_2697 VPWR VGND sg13cmos5l_decap_8
* cell instance sg13cmos5l_decap_8_2698 r0 *1 0,0
Xsg13cmos5l_decap_8_2698 VPWR VGND sg13cmos5l_decap_8
* cell instance sg13cmos5l_decap_8_2699 r0 *1 0,0
Xsg13cmos5l_decap_8_2699 VPWR VGND sg13cmos5l_decap_8
* cell instance sg13cmos5l_decap_8_2700 r0 *1 0,0
Xsg13cmos5l_decap_8_2700 VPWR VGND sg13cmos5l_decap_8
* cell instance sg13cmos5l_decap_8_2701 r0 *1 0,0
Xsg13cmos5l_decap_8_2701 VPWR VGND sg13cmos5l_decap_8
* cell instance sg13cmos5l_decap_8_2702 r0 *1 0,0
Xsg13cmos5l_decap_8_2702 VPWR VGND sg13cmos5l_decap_8
* cell instance sg13cmos5l_decap_8_2703 r0 *1 0,0
Xsg13cmos5l_decap_8_2703 VPWR VGND sg13cmos5l_decap_8
* cell instance sg13cmos5l_decap_8_2704 r0 *1 0,0
Xsg13cmos5l_decap_8_2704 VPWR VGND sg13cmos5l_decap_8
* cell instance sg13cmos5l_decap_8_2705 r0 *1 0,0
Xsg13cmos5l_decap_8_2705 VPWR VGND sg13cmos5l_decap_8
* cell instance sg13cmos5l_decap_8_2706 r0 *1 0,0
Xsg13cmos5l_decap_8_2706 VPWR VGND sg13cmos5l_decap_8
* cell instance sg13cmos5l_decap_8_2707 r0 *1 0,0
Xsg13cmos5l_decap_8_2707 VPWR VGND sg13cmos5l_decap_8
* cell instance sg13cmos5l_decap_8_2708 r0 *1 0,0
Xsg13cmos5l_decap_8_2708 VPWR VGND sg13cmos5l_decap_8
* cell instance sg13cmos5l_decap_8_2709 r0 *1 0,0
Xsg13cmos5l_decap_8_2709 VPWR VGND sg13cmos5l_decap_8
* cell instance sg13cmos5l_decap_8_2710 r0 *1 0,0
Xsg13cmos5l_decap_8_2710 VPWR VGND sg13cmos5l_decap_8
* cell instance sg13cmos5l_decap_8_2711 r0 *1 0,0
Xsg13cmos5l_decap_8_2711 VPWR VGND sg13cmos5l_decap_8
* cell instance sg13cmos5l_decap_8_2712 r0 *1 0,0
Xsg13cmos5l_decap_8_2712 VPWR VGND sg13cmos5l_decap_8
* cell instance sg13cmos5l_decap_8_2713 r0 *1 0,0
Xsg13cmos5l_decap_8_2713 VPWR VGND sg13cmos5l_decap_8
* cell instance sg13cmos5l_decap_8_2714 r0 *1 0,0
Xsg13cmos5l_decap_8_2714 VPWR VGND sg13cmos5l_decap_8
* cell instance sg13cmos5l_decap_8_2715 r0 *1 0,0
Xsg13cmos5l_decap_8_2715 VPWR VGND sg13cmos5l_decap_8
* cell instance sg13cmos5l_decap_8_2716 r0 *1 0,0
Xsg13cmos5l_decap_8_2716 VPWR VGND sg13cmos5l_decap_8
* cell instance sg13cmos5l_decap_8_2717 r0 *1 0,0
Xsg13cmos5l_decap_8_2717 VPWR VGND sg13cmos5l_decap_8
* cell instance sg13cmos5l_decap_8_2718 r0 *1 0,0
Xsg13cmos5l_decap_8_2718 VPWR VGND sg13cmos5l_decap_8
* cell instance sg13cmos5l_decap_8_2719 r0 *1 0,0
Xsg13cmos5l_decap_8_2719 VPWR VGND sg13cmos5l_decap_8
* cell instance sg13cmos5l_decap_8_2720 r0 *1 0,0
Xsg13cmos5l_decap_8_2720 VPWR VGND sg13cmos5l_decap_8
* cell instance sg13cmos5l_decap_8_2721 r0 *1 0,0
Xsg13cmos5l_decap_8_2721 VPWR VGND sg13cmos5l_decap_8
* cell instance sg13cmos5l_decap_8_2722 r0 *1 0,0
Xsg13cmos5l_decap_8_2722 VPWR VGND sg13cmos5l_decap_8
* cell instance sg13cmos5l_decap_8_2723 r0 *1 0,0
Xsg13cmos5l_decap_8_2723 VPWR VGND sg13cmos5l_decap_8
* cell instance sg13cmos5l_decap_8_2724 r0 *1 0,0
Xsg13cmos5l_decap_8_2724 VPWR VGND sg13cmos5l_decap_8
* cell instance sg13cmos5l_decap_8_2725 r0 *1 0,0
Xsg13cmos5l_decap_8_2725 VPWR VGND sg13cmos5l_decap_8
* cell instance sg13cmos5l_decap_8_2726 r0 *1 0,0
Xsg13cmos5l_decap_8_2726 VPWR VGND sg13cmos5l_decap_8
* cell instance sg13cmos5l_decap_8_2727 r0 *1 0,0
Xsg13cmos5l_decap_8_2727 VPWR VGND sg13cmos5l_decap_8
* cell instance sg13cmos5l_decap_8_2728 r0 *1 0,0
Xsg13cmos5l_decap_8_2728 VPWR VGND sg13cmos5l_decap_8
* cell instance sg13cmos5l_decap_8_2729 r0 *1 0,0
Xsg13cmos5l_decap_8_2729 VPWR VGND sg13cmos5l_decap_8
* cell instance sg13cmos5l_decap_8_2730 r0 *1 0,0
Xsg13cmos5l_decap_8_2730 VPWR VGND sg13cmos5l_decap_8
* cell instance sg13cmos5l_decap_8_2731 r0 *1 0,0
Xsg13cmos5l_decap_8_2731 VPWR VGND sg13cmos5l_decap_8
* cell instance sg13cmos5l_decap_8_2732 r0 *1 0,0
Xsg13cmos5l_decap_8_2732 VPWR VGND sg13cmos5l_decap_8
* cell instance sg13cmos5l_decap_8_2733 r0 *1 0,0
Xsg13cmos5l_decap_8_2733 VPWR VGND sg13cmos5l_decap_8
* cell instance sg13cmos5l_decap_8_2734 r0 *1 0,0
Xsg13cmos5l_decap_8_2734 VPWR VGND sg13cmos5l_decap_8
* cell instance sg13cmos5l_decap_8_2735 r0 *1 0,0
Xsg13cmos5l_decap_8_2735 VPWR VGND sg13cmos5l_decap_8
* cell instance sg13cmos5l_decap_8_2736 r0 *1 0,0
Xsg13cmos5l_decap_8_2736 VPWR VGND sg13cmos5l_decap_8
* cell instance sg13cmos5l_decap_8_2737 r0 *1 0,0
Xsg13cmos5l_decap_8_2737 VPWR VGND sg13cmos5l_decap_8
* cell instance sg13cmos5l_decap_8_2738 r0 *1 0,0
Xsg13cmos5l_decap_8_2738 VPWR VGND sg13cmos5l_decap_8
* cell instance sg13cmos5l_decap_8_2739 r0 *1 0,0
Xsg13cmos5l_decap_8_2739 VPWR VGND sg13cmos5l_decap_8
* cell instance sg13cmos5l_decap_8_2740 r0 *1 0,0
Xsg13cmos5l_decap_8_2740 VPWR VGND sg13cmos5l_decap_8
* cell instance sg13cmos5l_decap_8_2741 r0 *1 0,0
Xsg13cmos5l_decap_8_2741 VPWR VGND sg13cmos5l_decap_8
* cell instance sg13cmos5l_decap_8_2742 r0 *1 0,0
Xsg13cmos5l_decap_8_2742 VPWR VGND sg13cmos5l_decap_8
* cell instance sg13cmos5l_decap_8_2743 r0 *1 0,0
Xsg13cmos5l_decap_8_2743 VPWR VGND sg13cmos5l_decap_8
* cell instance sg13cmos5l_decap_8_2744 r0 *1 0,0
Xsg13cmos5l_decap_8_2744 VPWR VGND sg13cmos5l_decap_8
* cell instance sg13cmos5l_decap_8_2745 r0 *1 0,0
Xsg13cmos5l_decap_8_2745 VPWR VGND sg13cmos5l_decap_8
* cell instance sg13cmos5l_decap_8_2746 r0 *1 0,0
Xsg13cmos5l_decap_8_2746 VPWR VGND sg13cmos5l_decap_8
* cell instance sg13cmos5l_decap_8_2747 r0 *1 0,0
Xsg13cmos5l_decap_8_2747 VPWR VGND sg13cmos5l_decap_8
* cell instance sg13cmos5l_decap_8_2748 r0 *1 0,0
Xsg13cmos5l_decap_8_2748 VPWR VGND sg13cmos5l_decap_8
* cell instance sg13cmos5l_decap_8_2749 r0 *1 0,0
Xsg13cmos5l_decap_8_2749 VPWR VGND sg13cmos5l_decap_8
* cell instance sg13cmos5l_decap_8_2750 r0 *1 0,0
Xsg13cmos5l_decap_8_2750 VPWR VGND sg13cmos5l_decap_8
* cell instance sg13cmos5l_decap_8_2751 r0 *1 0,0
Xsg13cmos5l_decap_8_2751 VPWR VGND sg13cmos5l_decap_8
* cell instance sg13cmos5l_decap_8_2752 r0 *1 0,0
Xsg13cmos5l_decap_8_2752 VPWR VGND sg13cmos5l_decap_8
* cell instance sg13cmos5l_decap_8_2753 r0 *1 0,0
Xsg13cmos5l_decap_8_2753 VPWR VGND sg13cmos5l_decap_8
* cell instance sg13cmos5l_decap_8_2754 r0 *1 0,0
Xsg13cmos5l_decap_8_2754 VPWR VGND sg13cmos5l_decap_8
* cell instance sg13cmos5l_decap_8_2755 r0 *1 0,0
Xsg13cmos5l_decap_8_2755 VPWR VGND sg13cmos5l_decap_8
* cell instance sg13cmos5l_decap_8_2756 r0 *1 0,0
Xsg13cmos5l_decap_8_2756 VPWR VGND sg13cmos5l_decap_8
* cell instance sg13cmos5l_decap_8_2757 r0 *1 0,0
Xsg13cmos5l_decap_8_2757 VPWR VGND sg13cmos5l_decap_8
* cell instance sg13cmos5l_decap_8_2758 r0 *1 0,0
Xsg13cmos5l_decap_8_2758 VPWR VGND sg13cmos5l_decap_8
* cell instance sg13cmos5l_decap_8_2759 r0 *1 0,0
Xsg13cmos5l_decap_8_2759 VPWR VGND sg13cmos5l_decap_8
* cell instance sg13cmos5l_decap_8_2760 r0 *1 0,0
Xsg13cmos5l_decap_8_2760 VPWR VGND sg13cmos5l_decap_8
* cell instance sg13cmos5l_decap_8_2761 r0 *1 0,0
Xsg13cmos5l_decap_8_2761 VPWR VGND sg13cmos5l_decap_8
* cell instance sg13cmos5l_decap_8_2762 r0 *1 0,0
Xsg13cmos5l_decap_8_2762 VPWR VGND sg13cmos5l_decap_8
* cell instance sg13cmos5l_decap_8_2763 r0 *1 0,0
Xsg13cmos5l_decap_8_2763 VPWR VGND sg13cmos5l_decap_8
* cell instance sg13cmos5l_decap_8_2764 r0 *1 0,0
Xsg13cmos5l_decap_8_2764 VPWR VGND sg13cmos5l_decap_8
* cell instance sg13cmos5l_decap_8_2765 r0 *1 0,0
Xsg13cmos5l_decap_8_2765 VPWR VGND sg13cmos5l_decap_8
* cell instance sg13cmos5l_decap_8_2766 r0 *1 0,0
Xsg13cmos5l_decap_8_2766 VPWR VGND sg13cmos5l_decap_8
* cell instance sg13cmos5l_decap_8_2767 r0 *1 0,0
Xsg13cmos5l_decap_8_2767 VPWR VGND sg13cmos5l_decap_8
* cell instance sg13cmos5l_decap_8_2768 r0 *1 0,0
Xsg13cmos5l_decap_8_2768 VPWR VGND sg13cmos5l_decap_8
* cell instance sg13cmos5l_decap_8_2769 r0 *1 0,0
Xsg13cmos5l_decap_8_2769 VPWR VGND sg13cmos5l_decap_8
* cell instance sg13cmos5l_decap_8_2770 r0 *1 0,0
Xsg13cmos5l_decap_8_2770 VPWR VGND sg13cmos5l_decap_8
* cell instance sg13cmos5l_decap_8_2771 r0 *1 0,0
Xsg13cmos5l_decap_8_2771 VPWR VGND sg13cmos5l_decap_8
* cell instance sg13cmos5l_decap_8_2772 r0 *1 0,0
Xsg13cmos5l_decap_8_2772 VPWR VGND sg13cmos5l_decap_8
* cell instance sg13cmos5l_decap_8_2773 r0 *1 0,0
Xsg13cmos5l_decap_8_2773 VPWR VGND sg13cmos5l_decap_8
* cell instance sg13cmos5l_decap_8_2774 r0 *1 0,0
Xsg13cmos5l_decap_8_2774 VPWR VGND sg13cmos5l_decap_8
* cell instance sg13cmos5l_decap_8_2775 r0 *1 0,0
Xsg13cmos5l_decap_8_2775 VPWR VGND sg13cmos5l_decap_8
* cell instance sg13cmos5l_decap_8_2776 r0 *1 0,0
Xsg13cmos5l_decap_8_2776 VPWR VGND sg13cmos5l_decap_8
* cell instance sg13cmos5l_decap_8_2777 r0 *1 0,0
Xsg13cmos5l_decap_8_2777 VPWR VGND sg13cmos5l_decap_8
* cell instance sg13cmos5l_decap_8_2778 r0 *1 0,0
Xsg13cmos5l_decap_8_2778 VPWR VGND sg13cmos5l_decap_8
* cell instance sg13cmos5l_decap_8_2779 r0 *1 0,0
Xsg13cmos5l_decap_8_2779 VPWR VGND sg13cmos5l_decap_8
* cell instance sg13cmos5l_decap_8_2780 r0 *1 0,0
Xsg13cmos5l_decap_8_2780 VPWR VGND sg13cmos5l_decap_8
* cell instance sg13cmos5l_decap_8_2781 r0 *1 0,0
Xsg13cmos5l_decap_8_2781 VPWR VGND sg13cmos5l_decap_8
* cell instance sg13cmos5l_decap_8_2782 r0 *1 0,0
Xsg13cmos5l_decap_8_2782 VPWR VGND sg13cmos5l_decap_8
* cell instance sg13cmos5l_decap_8_2783 r0 *1 0,0
Xsg13cmos5l_decap_8_2783 VPWR VGND sg13cmos5l_decap_8
* cell instance sg13cmos5l_decap_8_2784 r0 *1 0,0
Xsg13cmos5l_decap_8_2784 VPWR VGND sg13cmos5l_decap_8
* cell instance sg13cmos5l_decap_8_2785 r0 *1 0,0
Xsg13cmos5l_decap_8_2785 VPWR VGND sg13cmos5l_decap_8
* cell instance sg13cmos5l_decap_8_2786 r0 *1 0,0
Xsg13cmos5l_decap_8_2786 VPWR VGND sg13cmos5l_decap_8
* cell instance sg13cmos5l_decap_8_2787 r0 *1 0,0
Xsg13cmos5l_decap_8_2787 VPWR VGND sg13cmos5l_decap_8
* cell instance sg13cmos5l_decap_8_2788 r0 *1 0,0
Xsg13cmos5l_decap_8_2788 VPWR VGND sg13cmos5l_decap_8
* cell instance sg13cmos5l_decap_8_2789 r0 *1 0,0
Xsg13cmos5l_decap_8_2789 VPWR VGND sg13cmos5l_decap_8
* cell instance sg13cmos5l_decap_8_2790 r0 *1 0,0
Xsg13cmos5l_decap_8_2790 VPWR VGND sg13cmos5l_decap_8
* cell instance sg13cmos5l_decap_8_2791 r0 *1 0,0
Xsg13cmos5l_decap_8_2791 VPWR VGND sg13cmos5l_decap_8
* cell instance sg13cmos5l_decap_8_2792 r0 *1 0,0
Xsg13cmos5l_decap_8_2792 VPWR VGND sg13cmos5l_decap_8
* cell instance sg13cmos5l_decap_8_2793 r0 *1 0,0
Xsg13cmos5l_decap_8_2793 VPWR VGND sg13cmos5l_decap_8
* cell instance sg13cmos5l_decap_8_2794 r0 *1 0,0
Xsg13cmos5l_decap_8_2794 VPWR VGND sg13cmos5l_decap_8
* cell instance sg13cmos5l_decap_8_2795 r0 *1 0,0
Xsg13cmos5l_decap_8_2795 VPWR VGND sg13cmos5l_decap_8
* cell instance sg13cmos5l_decap_8_2796 r0 *1 0,0
Xsg13cmos5l_decap_8_2796 VPWR VGND sg13cmos5l_decap_8
* cell instance sg13cmos5l_decap_8_2797 r0 *1 0,0
Xsg13cmos5l_decap_8_2797 VPWR VGND sg13cmos5l_decap_8
* cell instance sg13cmos5l_decap_8_2798 r0 *1 0,0
Xsg13cmos5l_decap_8_2798 VPWR VGND sg13cmos5l_decap_8
* cell instance sg13cmos5l_decap_8_2799 r0 *1 0,0
Xsg13cmos5l_decap_8_2799 VPWR VGND sg13cmos5l_decap_8
* cell instance sg13cmos5l_decap_8_2800 r0 *1 0,0
Xsg13cmos5l_decap_8_2800 VPWR VGND sg13cmos5l_decap_8
* cell instance sg13cmos5l_decap_8_2801 r0 *1 0,0
Xsg13cmos5l_decap_8_2801 VPWR VGND sg13cmos5l_decap_8
* cell instance sg13cmos5l_decap_8_2802 r0 *1 0,0
Xsg13cmos5l_decap_8_2802 VPWR VGND sg13cmos5l_decap_8
* cell instance sg13cmos5l_decap_8_2803 r0 *1 0,0
Xsg13cmos5l_decap_8_2803 VPWR VGND sg13cmos5l_decap_8
* cell instance sg13cmos5l_decap_8_2804 r0 *1 0,0
Xsg13cmos5l_decap_8_2804 VPWR VGND sg13cmos5l_decap_8
* cell instance sg13cmos5l_decap_8_2805 r0 *1 0,0
Xsg13cmos5l_decap_8_2805 VPWR VGND sg13cmos5l_decap_8
* cell instance sg13cmos5l_decap_8_2806 r0 *1 0,0
Xsg13cmos5l_decap_8_2806 VPWR VGND sg13cmos5l_decap_8
* cell instance sg13cmos5l_decap_8_2807 r0 *1 0,0
Xsg13cmos5l_decap_8_2807 VPWR VGND sg13cmos5l_decap_8
* cell instance sg13cmos5l_decap_8_2808 r0 *1 0,0
Xsg13cmos5l_decap_8_2808 VPWR VGND sg13cmos5l_decap_8
* cell instance sg13cmos5l_decap_8_2809 r0 *1 0,0
Xsg13cmos5l_decap_8_2809 VPWR VGND sg13cmos5l_decap_8
* cell instance sg13cmos5l_decap_8_2810 r0 *1 0,0
Xsg13cmos5l_decap_8_2810 VPWR VGND sg13cmos5l_decap_8
* cell instance sg13cmos5l_decap_8_2811 r0 *1 0,0
Xsg13cmos5l_decap_8_2811 VPWR VGND sg13cmos5l_decap_8
* cell instance sg13cmos5l_decap_8_2812 r0 *1 0,0
Xsg13cmos5l_decap_8_2812 VPWR VGND sg13cmos5l_decap_8
* cell instance sg13cmos5l_decap_8_2813 r0 *1 0,0
Xsg13cmos5l_decap_8_2813 VPWR VGND sg13cmos5l_decap_8
* cell instance sg13cmos5l_decap_8_2814 r0 *1 0,0
Xsg13cmos5l_decap_8_2814 VPWR VGND sg13cmos5l_decap_8
* cell instance sg13cmos5l_decap_8_2815 r0 *1 0,0
Xsg13cmos5l_decap_8_2815 VPWR VGND sg13cmos5l_decap_8
* cell instance sg13cmos5l_decap_8_2816 r0 *1 0,0
Xsg13cmos5l_decap_8_2816 VPWR VGND sg13cmos5l_decap_8
* cell instance sg13cmos5l_decap_8_2817 r0 *1 0,0
Xsg13cmos5l_decap_8_2817 VPWR VGND sg13cmos5l_decap_8
* cell instance sg13cmos5l_decap_8_2818 r0 *1 0,0
Xsg13cmos5l_decap_8_2818 VPWR VGND sg13cmos5l_decap_8
* cell instance sg13cmos5l_decap_8_2819 r0 *1 0,0
Xsg13cmos5l_decap_8_2819 VPWR VGND sg13cmos5l_decap_8
* cell instance sg13cmos5l_decap_8_2820 r0 *1 0,0
Xsg13cmos5l_decap_8_2820 VPWR VGND sg13cmos5l_decap_8
* cell instance sg13cmos5l_decap_8_2821 r0 *1 0,0
Xsg13cmos5l_decap_8_2821 VPWR VGND sg13cmos5l_decap_8
* cell instance sg13cmos5l_decap_8_2822 r0 *1 0,0
Xsg13cmos5l_decap_8_2822 VPWR VGND sg13cmos5l_decap_8
* cell instance sg13cmos5l_decap_8_2823 r0 *1 0,0
Xsg13cmos5l_decap_8_2823 VPWR VGND sg13cmos5l_decap_8
* cell instance sg13cmos5l_decap_8_2824 r0 *1 0,0
Xsg13cmos5l_decap_8_2824 VPWR VGND sg13cmos5l_decap_8
* cell instance sg13cmos5l_decap_8_2825 r0 *1 0,0
Xsg13cmos5l_decap_8_2825 VPWR VGND sg13cmos5l_decap_8
* cell instance sg13cmos5l_decap_8_2826 r0 *1 0,0
Xsg13cmos5l_decap_8_2826 VPWR VGND sg13cmos5l_decap_8
* cell instance sg13cmos5l_decap_8_2827 r0 *1 0,0
Xsg13cmos5l_decap_8_2827 VPWR VGND sg13cmos5l_decap_8
* cell instance sg13cmos5l_decap_8_2828 r0 *1 0,0
Xsg13cmos5l_decap_8_2828 VPWR VGND sg13cmos5l_decap_8
* cell instance sg13cmos5l_decap_8_2829 r0 *1 0,0
Xsg13cmos5l_decap_8_2829 VPWR VGND sg13cmos5l_decap_8
* cell instance sg13cmos5l_decap_8_2830 r0 *1 0,0
Xsg13cmos5l_decap_8_2830 VPWR VGND sg13cmos5l_decap_8
* cell instance sg13cmos5l_decap_8_2831 r0 *1 0,0
Xsg13cmos5l_decap_8_2831 VPWR VGND sg13cmos5l_decap_8
* cell instance sg13cmos5l_decap_8_2832 r0 *1 0,0
Xsg13cmos5l_decap_8_2832 VPWR VGND sg13cmos5l_decap_8
* cell instance sg13cmos5l_decap_8_2833 r0 *1 0,0
Xsg13cmos5l_decap_8_2833 VPWR VGND sg13cmos5l_decap_8
* cell instance sg13cmos5l_decap_8_2834 r0 *1 0,0
Xsg13cmos5l_decap_8_2834 VPWR VGND sg13cmos5l_decap_8
* cell instance sg13cmos5l_decap_8_2835 r0 *1 0,0
Xsg13cmos5l_decap_8_2835 VPWR VGND sg13cmos5l_decap_8
* cell instance sg13cmos5l_decap_8_2836 r0 *1 0,0
Xsg13cmos5l_decap_8_2836 VPWR VGND sg13cmos5l_decap_8
* cell instance sg13cmos5l_decap_8_2837 r0 *1 0,0
Xsg13cmos5l_decap_8_2837 VPWR VGND sg13cmos5l_decap_8
* cell instance sg13cmos5l_decap_8_2838 r0 *1 0,0
Xsg13cmos5l_decap_8_2838 VPWR VGND sg13cmos5l_decap_8
* cell instance sg13cmos5l_decap_8_2839 r0 *1 0,0
Xsg13cmos5l_decap_8_2839 VPWR VGND sg13cmos5l_decap_8
* cell instance sg13cmos5l_decap_8_2840 r0 *1 0,0
Xsg13cmos5l_decap_8_2840 VPWR VGND sg13cmos5l_decap_8
* cell instance sg13cmos5l_decap_8_2841 r0 *1 0,0
Xsg13cmos5l_decap_8_2841 VPWR VGND sg13cmos5l_decap_8
* cell instance sg13cmos5l_decap_8_2842 r0 *1 0,0
Xsg13cmos5l_decap_8_2842 VPWR VGND sg13cmos5l_decap_8
* cell instance sg13cmos5l_decap_8_2843 r0 *1 0,0
Xsg13cmos5l_decap_8_2843 VPWR VGND sg13cmos5l_decap_8
* cell instance sg13cmos5l_decap_8_2844 r0 *1 0,0
Xsg13cmos5l_decap_8_2844 VPWR VGND sg13cmos5l_decap_8
* cell instance sg13cmos5l_decap_8_2845 r0 *1 0,0
Xsg13cmos5l_decap_8_2845 VPWR VGND sg13cmos5l_decap_8
* cell instance sg13cmos5l_decap_8_2846 r0 *1 0,0
Xsg13cmos5l_decap_8_2846 VPWR VGND sg13cmos5l_decap_8
* cell instance sg13cmos5l_decap_8_2847 r0 *1 0,0
Xsg13cmos5l_decap_8_2847 VPWR VGND sg13cmos5l_decap_8
* cell instance sg13cmos5l_decap_8_2848 r0 *1 0,0
Xsg13cmos5l_decap_8_2848 VPWR VGND sg13cmos5l_decap_8
* cell instance sg13cmos5l_decap_8_2849 r0 *1 0,0
Xsg13cmos5l_decap_8_2849 VPWR VGND sg13cmos5l_decap_8
* cell instance sg13cmos5l_decap_8_2850 r0 *1 0,0
Xsg13cmos5l_decap_8_2850 VPWR VGND sg13cmos5l_decap_8
* cell instance sg13cmos5l_decap_8_2851 r0 *1 0,0
Xsg13cmos5l_decap_8_2851 VPWR VGND sg13cmos5l_decap_8
* cell instance sg13cmos5l_decap_8_2852 r0 *1 0,0
Xsg13cmos5l_decap_8_2852 VPWR VGND sg13cmos5l_decap_8
* cell instance sg13cmos5l_decap_8_2853 r0 *1 0,0
Xsg13cmos5l_decap_8_2853 VPWR VGND sg13cmos5l_decap_8
* cell instance sg13cmos5l_decap_8_2854 r0 *1 0,0
Xsg13cmos5l_decap_8_2854 VPWR VGND sg13cmos5l_decap_8
* cell instance sg13cmos5l_decap_8_2855 r0 *1 0,0
Xsg13cmos5l_decap_8_2855 VPWR VGND sg13cmos5l_decap_8
* cell instance sg13cmos5l_decap_8_2856 r0 *1 0,0
Xsg13cmos5l_decap_8_2856 VPWR VGND sg13cmos5l_decap_8
* cell instance sg13cmos5l_decap_8_2857 r0 *1 0,0
Xsg13cmos5l_decap_8_2857 VPWR VGND sg13cmos5l_decap_8
* cell instance sg13cmos5l_decap_8_2858 r0 *1 0,0
Xsg13cmos5l_decap_8_2858 VPWR VGND sg13cmos5l_decap_8
* cell instance sg13cmos5l_decap_8_2859 r0 *1 0,0
Xsg13cmos5l_decap_8_2859 VPWR VGND sg13cmos5l_decap_8
* cell instance sg13cmos5l_decap_8_2860 r0 *1 0,0
Xsg13cmos5l_decap_8_2860 VPWR VGND sg13cmos5l_decap_8
* cell instance sg13cmos5l_decap_8_2861 r0 *1 0,0
Xsg13cmos5l_decap_8_2861 VPWR VGND sg13cmos5l_decap_8
* cell instance sg13cmos5l_decap_8_2862 r0 *1 0,0
Xsg13cmos5l_decap_8_2862 VPWR VGND sg13cmos5l_decap_8
* cell instance sg13cmos5l_decap_8_2863 r0 *1 0,0
Xsg13cmos5l_decap_8_2863 VPWR VGND sg13cmos5l_decap_8
* cell instance sg13cmos5l_decap_8_2864 r0 *1 0,0
Xsg13cmos5l_decap_8_2864 VPWR VGND sg13cmos5l_decap_8
* cell instance sg13cmos5l_decap_8_2865 r0 *1 0,0
Xsg13cmos5l_decap_8_2865 VPWR VGND sg13cmos5l_decap_8
* cell instance sg13cmos5l_decap_8_2866 r0 *1 0,0
Xsg13cmos5l_decap_8_2866 VPWR VGND sg13cmos5l_decap_8
* cell instance sg13cmos5l_decap_8_2867 r0 *1 0,0
Xsg13cmos5l_decap_8_2867 VPWR VGND sg13cmos5l_decap_8
* cell instance sg13cmos5l_decap_8_2868 r0 *1 0,0
Xsg13cmos5l_decap_8_2868 VPWR VGND sg13cmos5l_decap_8
* cell instance sg13cmos5l_decap_8_2869 r0 *1 0,0
Xsg13cmos5l_decap_8_2869 VPWR VGND sg13cmos5l_decap_8
* cell instance sg13cmos5l_decap_8_2870 r0 *1 0,0
Xsg13cmos5l_decap_8_2870 VPWR VGND sg13cmos5l_decap_8
* cell instance sg13cmos5l_decap_8_2871 r0 *1 0,0
Xsg13cmos5l_decap_8_2871 VPWR VGND sg13cmos5l_decap_8
* cell instance sg13cmos5l_decap_8_2872 r0 *1 0,0
Xsg13cmos5l_decap_8_2872 VPWR VGND sg13cmos5l_decap_8
* cell instance sg13cmos5l_decap_8_2873 r0 *1 0,0
Xsg13cmos5l_decap_8_2873 VPWR VGND sg13cmos5l_decap_8
* cell instance sg13cmos5l_decap_8_2874 r0 *1 0,0
Xsg13cmos5l_decap_8_2874 VPWR VGND sg13cmos5l_decap_8
* cell instance sg13cmos5l_decap_8_2875 r0 *1 0,0
Xsg13cmos5l_decap_8_2875 VPWR VGND sg13cmos5l_decap_8
* cell instance sg13cmos5l_decap_8_2876 r0 *1 0,0
Xsg13cmos5l_decap_8_2876 VPWR VGND sg13cmos5l_decap_8
* cell instance sg13cmos5l_decap_8_2877 r0 *1 0,0
Xsg13cmos5l_decap_8_2877 VPWR VGND sg13cmos5l_decap_8
* cell instance sg13cmos5l_decap_8_2878 r0 *1 0,0
Xsg13cmos5l_decap_8_2878 VPWR VGND sg13cmos5l_decap_8
* cell instance sg13cmos5l_decap_8_2879 r0 *1 0,0
Xsg13cmos5l_decap_8_2879 VPWR VGND sg13cmos5l_decap_8
* cell instance sg13cmos5l_decap_8_2880 r0 *1 0,0
Xsg13cmos5l_decap_8_2880 VPWR VGND sg13cmos5l_decap_8
* cell instance sg13cmos5l_decap_8_2881 r0 *1 0,0
Xsg13cmos5l_decap_8_2881 VPWR VGND sg13cmos5l_decap_8
* cell instance sg13cmos5l_decap_8_2882 r0 *1 0,0
Xsg13cmos5l_decap_8_2882 VPWR VGND sg13cmos5l_decap_8
* cell instance sg13cmos5l_decap_8_2883 r0 *1 0,0
Xsg13cmos5l_decap_8_2883 VPWR VGND sg13cmos5l_decap_8
* cell instance sg13cmos5l_decap_8_2884 r0 *1 0,0
Xsg13cmos5l_decap_8_2884 VPWR VGND sg13cmos5l_decap_8
* cell instance sg13cmos5l_decap_8_2885 r0 *1 0,0
Xsg13cmos5l_decap_8_2885 VPWR VGND sg13cmos5l_decap_8
* cell instance sg13cmos5l_decap_8_2886 r0 *1 0,0
Xsg13cmos5l_decap_8_2886 VPWR VGND sg13cmos5l_decap_8
* cell instance sg13cmos5l_decap_8_2887 r0 *1 0,0
Xsg13cmos5l_decap_8_2887 VPWR VGND sg13cmos5l_decap_8
* cell instance sg13cmos5l_decap_8_2888 r0 *1 0,0
Xsg13cmos5l_decap_8_2888 VPWR VGND sg13cmos5l_decap_8
* cell instance sg13cmos5l_decap_8_2889 r0 *1 0,0
Xsg13cmos5l_decap_8_2889 VPWR VGND sg13cmos5l_decap_8
* cell instance sg13cmos5l_decap_8_2890 r0 *1 0,0
Xsg13cmos5l_decap_8_2890 VPWR VGND sg13cmos5l_decap_8
* cell instance sg13cmos5l_decap_8_2891 r0 *1 0,0
Xsg13cmos5l_decap_8_2891 VPWR VGND sg13cmos5l_decap_8
* cell instance sg13cmos5l_decap_8_2892 r0 *1 0,0
Xsg13cmos5l_decap_8_2892 VPWR VGND sg13cmos5l_decap_8
* cell instance sg13cmos5l_decap_8_2893 r0 *1 0,0
Xsg13cmos5l_decap_8_2893 VPWR VGND sg13cmos5l_decap_8
* cell instance sg13cmos5l_decap_8_2894 r0 *1 0,0
Xsg13cmos5l_decap_8_2894 VPWR VGND sg13cmos5l_decap_8
* cell instance sg13cmos5l_decap_8_2895 r0 *1 0,0
Xsg13cmos5l_decap_8_2895 VPWR VGND sg13cmos5l_decap_8
* cell instance sg13cmos5l_decap_8_2896 r0 *1 0,0
Xsg13cmos5l_decap_8_2896 VPWR VGND sg13cmos5l_decap_8
* cell instance sg13cmos5l_decap_8_2897 r0 *1 0,0
Xsg13cmos5l_decap_8_2897 VPWR VGND sg13cmos5l_decap_8
* cell instance sg13cmos5l_decap_8_2898 r0 *1 0,0
Xsg13cmos5l_decap_8_2898 VPWR VGND sg13cmos5l_decap_8
* cell instance sg13cmos5l_decap_8_2899 r0 *1 0,0
Xsg13cmos5l_decap_8_2899 VPWR VGND sg13cmos5l_decap_8
* cell instance sg13cmos5l_decap_8_2900 r0 *1 0,0
Xsg13cmos5l_decap_8_2900 VPWR VGND sg13cmos5l_decap_8
* cell instance sg13cmos5l_decap_8_2901 r0 *1 0,0
Xsg13cmos5l_decap_8_2901 VPWR VGND sg13cmos5l_decap_8
* cell instance sg13cmos5l_decap_8_2902 r0 *1 0,0
Xsg13cmos5l_decap_8_2902 VPWR VGND sg13cmos5l_decap_8
* cell instance sg13cmos5l_decap_8_2903 r0 *1 0,0
Xsg13cmos5l_decap_8_2903 VPWR VGND sg13cmos5l_decap_8
* cell instance sg13cmos5l_decap_8_2904 r0 *1 0,0
Xsg13cmos5l_decap_8_2904 VPWR VGND sg13cmos5l_decap_8
* cell instance sg13cmos5l_decap_8_2905 r0 *1 0,0
Xsg13cmos5l_decap_8_2905 VPWR VGND sg13cmos5l_decap_8
* cell instance sg13cmos5l_decap_8_2906 r0 *1 0,0
Xsg13cmos5l_decap_8_2906 VPWR VGND sg13cmos5l_decap_8
* cell instance sg13cmos5l_decap_8_2907 r0 *1 0,0
Xsg13cmos5l_decap_8_2907 VPWR VGND sg13cmos5l_decap_8
* cell instance sg13cmos5l_decap_8_2908 r0 *1 0,0
Xsg13cmos5l_decap_8_2908 VPWR VGND sg13cmos5l_decap_8
* cell instance sg13cmos5l_decap_8_2909 r0 *1 0,0
Xsg13cmos5l_decap_8_2909 VPWR VGND sg13cmos5l_decap_8
* cell instance sg13cmos5l_decap_8_2910 r0 *1 0,0
Xsg13cmos5l_decap_8_2910 VPWR VGND sg13cmos5l_decap_8
* cell instance sg13cmos5l_decap_8_2911 r0 *1 0,0
Xsg13cmos5l_decap_8_2911 VPWR VGND sg13cmos5l_decap_8
* cell instance sg13cmos5l_decap_8_2912 r0 *1 0,0
Xsg13cmos5l_decap_8_2912 VPWR VGND sg13cmos5l_decap_8
* cell instance sg13cmos5l_decap_8_2913 r0 *1 0,0
Xsg13cmos5l_decap_8_2913 VPWR VGND sg13cmos5l_decap_8
* cell instance sg13cmos5l_decap_8_2914 r0 *1 0,0
Xsg13cmos5l_decap_8_2914 VPWR VGND sg13cmos5l_decap_8
* cell instance sg13cmos5l_decap_8_2915 r0 *1 0,0
Xsg13cmos5l_decap_8_2915 VPWR VGND sg13cmos5l_decap_8
* cell instance sg13cmos5l_decap_8_2916 r0 *1 0,0
Xsg13cmos5l_decap_8_2916 VPWR VGND sg13cmos5l_decap_8
* cell instance sg13cmos5l_decap_8_2917 r0 *1 0,0
Xsg13cmos5l_decap_8_2917 VPWR VGND sg13cmos5l_decap_8
* cell instance sg13cmos5l_decap_8_2918 r0 *1 0,0
Xsg13cmos5l_decap_8_2918 VPWR VGND sg13cmos5l_decap_8
* cell instance sg13cmos5l_decap_8_2919 r0 *1 0,0
Xsg13cmos5l_decap_8_2919 VPWR VGND sg13cmos5l_decap_8
* cell instance sg13cmos5l_decap_8_2920 r0 *1 0,0
Xsg13cmos5l_decap_8_2920 VPWR VGND sg13cmos5l_decap_8
* cell instance sg13cmos5l_decap_8_2921 r0 *1 0,0
Xsg13cmos5l_decap_8_2921 VPWR VGND sg13cmos5l_decap_8
* cell instance sg13cmos5l_decap_8_2922 r0 *1 0,0
Xsg13cmos5l_decap_8_2922 VPWR VGND sg13cmos5l_decap_8
* cell instance sg13cmos5l_decap_8_2923 r0 *1 0,0
Xsg13cmos5l_decap_8_2923 VPWR VGND sg13cmos5l_decap_8
* cell instance sg13cmos5l_decap_8_2924 r0 *1 0,0
Xsg13cmos5l_decap_8_2924 VPWR VGND sg13cmos5l_decap_8
* cell instance sg13cmos5l_decap_8_2925 r0 *1 0,0
Xsg13cmos5l_decap_8_2925 VPWR VGND sg13cmos5l_decap_8
* cell instance sg13cmos5l_decap_8_2926 r0 *1 0,0
Xsg13cmos5l_decap_8_2926 VPWR VGND sg13cmos5l_decap_8
* cell instance sg13cmos5l_decap_8_2927 r0 *1 0,0
Xsg13cmos5l_decap_8_2927 VPWR VGND sg13cmos5l_decap_8
* cell instance sg13cmos5l_decap_8_2928 r0 *1 0,0
Xsg13cmos5l_decap_8_2928 VPWR VGND sg13cmos5l_decap_8
* cell instance sg13cmos5l_decap_8_2929 r0 *1 0,0
Xsg13cmos5l_decap_8_2929 VPWR VGND sg13cmos5l_decap_8
* cell instance sg13cmos5l_decap_8_2930 r0 *1 0,0
Xsg13cmos5l_decap_8_2930 VPWR VGND sg13cmos5l_decap_8
* cell instance sg13cmos5l_decap_8_2931 r0 *1 0,0
Xsg13cmos5l_decap_8_2931 VPWR VGND sg13cmos5l_decap_8
* cell instance sg13cmos5l_decap_8_2932 r0 *1 0,0
Xsg13cmos5l_decap_8_2932 VPWR VGND sg13cmos5l_decap_8
* cell instance sg13cmos5l_decap_8_2933 r0 *1 0,0
Xsg13cmos5l_decap_8_2933 VPWR VGND sg13cmos5l_decap_8
* cell instance sg13cmos5l_decap_8_2934 r0 *1 0,0
Xsg13cmos5l_decap_8_2934 VPWR VGND sg13cmos5l_decap_8
* cell instance sg13cmos5l_decap_8_2935 r0 *1 0,0
Xsg13cmos5l_decap_8_2935 VPWR VGND sg13cmos5l_decap_8
* cell instance sg13cmos5l_decap_8_2936 r0 *1 0,0
Xsg13cmos5l_decap_8_2936 VPWR VGND sg13cmos5l_decap_8
* cell instance sg13cmos5l_decap_8_2937 r0 *1 0,0
Xsg13cmos5l_decap_8_2937 VPWR VGND sg13cmos5l_decap_8
* cell instance sg13cmos5l_decap_8_2938 r0 *1 0,0
Xsg13cmos5l_decap_8_2938 VPWR VGND sg13cmos5l_decap_8
* cell instance sg13cmos5l_decap_8_2939 r0 *1 0,0
Xsg13cmos5l_decap_8_2939 VPWR VGND sg13cmos5l_decap_8
* cell instance sg13cmos5l_decap_8_2940 r0 *1 0,0
Xsg13cmos5l_decap_8_2940 VPWR VGND sg13cmos5l_decap_8
* cell instance sg13cmos5l_decap_8_2941 r0 *1 0,0
Xsg13cmos5l_decap_8_2941 VPWR VGND sg13cmos5l_decap_8
* cell instance sg13cmos5l_decap_8_2942 r0 *1 0,0
Xsg13cmos5l_decap_8_2942 VPWR VGND sg13cmos5l_decap_8
* cell instance sg13cmos5l_decap_8_2943 r0 *1 0,0
Xsg13cmos5l_decap_8_2943 VPWR VGND sg13cmos5l_decap_8
* cell instance sg13cmos5l_decap_8_2944 r0 *1 0,0
Xsg13cmos5l_decap_8_2944 VPWR VGND sg13cmos5l_decap_8
* cell instance sg13cmos5l_decap_8_2945 r0 *1 0,0
Xsg13cmos5l_decap_8_2945 VPWR VGND sg13cmos5l_decap_8
* cell instance sg13cmos5l_decap_8_2946 r0 *1 0,0
Xsg13cmos5l_decap_8_2946 VPWR VGND sg13cmos5l_decap_8
* cell instance sg13cmos5l_decap_8_2947 r0 *1 0,0
Xsg13cmos5l_decap_8_2947 VPWR VGND sg13cmos5l_decap_8
* cell instance sg13cmos5l_decap_8_2948 r0 *1 0,0
Xsg13cmos5l_decap_8_2948 VPWR VGND sg13cmos5l_decap_8
* cell instance sg13cmos5l_decap_8_2949 r0 *1 0,0
Xsg13cmos5l_decap_8_2949 VPWR VGND sg13cmos5l_decap_8
* cell instance sg13cmos5l_decap_8_2950 r0 *1 0,0
Xsg13cmos5l_decap_8_2950 VPWR VGND sg13cmos5l_decap_8
* cell instance sg13cmos5l_decap_8_2951 r0 *1 0,0
Xsg13cmos5l_decap_8_2951 VPWR VGND sg13cmos5l_decap_8
* cell instance sg13cmos5l_decap_8_2952 r0 *1 0,0
Xsg13cmos5l_decap_8_2952 VPWR VGND sg13cmos5l_decap_8
* cell instance sg13cmos5l_decap_8_2953 r0 *1 0,0
Xsg13cmos5l_decap_8_2953 VPWR VGND sg13cmos5l_decap_8
* cell instance sg13cmos5l_decap_8_2954 r0 *1 0,0
Xsg13cmos5l_decap_8_2954 VPWR VGND sg13cmos5l_decap_8
* cell instance sg13cmos5l_decap_8_2955 r0 *1 0,0
Xsg13cmos5l_decap_8_2955 VPWR VGND sg13cmos5l_decap_8
* cell instance sg13cmos5l_decap_8_2956 r0 *1 0,0
Xsg13cmos5l_decap_8_2956 VPWR VGND sg13cmos5l_decap_8
* cell instance sg13cmos5l_decap_8_2957 r0 *1 0,0
Xsg13cmos5l_decap_8_2957 VPWR VGND sg13cmos5l_decap_8
* cell instance sg13cmos5l_decap_8_2958 r0 *1 0,0
Xsg13cmos5l_decap_8_2958 VPWR VGND sg13cmos5l_decap_8
* cell instance sg13cmos5l_decap_8_2959 r0 *1 0,0
Xsg13cmos5l_decap_8_2959 VPWR VGND sg13cmos5l_decap_8
* cell instance sg13cmos5l_decap_8_2960 r0 *1 0,0
Xsg13cmos5l_decap_8_2960 VPWR VGND sg13cmos5l_decap_8
* cell instance sg13cmos5l_decap_8_2961 r0 *1 0,0
Xsg13cmos5l_decap_8_2961 VPWR VGND sg13cmos5l_decap_8
* cell instance sg13cmos5l_decap_8_2962 r0 *1 0,0
Xsg13cmos5l_decap_8_2962 VPWR VGND sg13cmos5l_decap_8
* cell instance sg13cmos5l_decap_8_2963 r0 *1 0,0
Xsg13cmos5l_decap_8_2963 VPWR VGND sg13cmos5l_decap_8
* cell instance sg13cmos5l_decap_8_2964 r0 *1 0,0
Xsg13cmos5l_decap_8_2964 VPWR VGND sg13cmos5l_decap_8
* cell instance sg13cmos5l_decap_8_2965 r0 *1 0,0
Xsg13cmos5l_decap_8_2965 VPWR VGND sg13cmos5l_decap_8
* cell instance sg13cmos5l_decap_8_2966 r0 *1 0,0
Xsg13cmos5l_decap_8_2966 VPWR VGND sg13cmos5l_decap_8
* cell instance sg13cmos5l_decap_8_2967 r0 *1 0,0
Xsg13cmos5l_decap_8_2967 VPWR VGND sg13cmos5l_decap_8
* cell instance sg13cmos5l_decap_8_2968 r0 *1 0,0
Xsg13cmos5l_decap_8_2968 VPWR VGND sg13cmos5l_decap_8
* cell instance sg13cmos5l_decap_8_2969 r0 *1 0,0
Xsg13cmos5l_decap_8_2969 VPWR VGND sg13cmos5l_decap_8
* cell instance sg13cmos5l_decap_8_2970 r0 *1 0,0
Xsg13cmos5l_decap_8_2970 VPWR VGND sg13cmos5l_decap_8
* cell instance sg13cmos5l_decap_8_2971 r0 *1 0,0
Xsg13cmos5l_decap_8_2971 VPWR VGND sg13cmos5l_decap_8
* cell instance sg13cmos5l_decap_8_2972 r0 *1 0,0
Xsg13cmos5l_decap_8_2972 VPWR VGND sg13cmos5l_decap_8
* cell instance sg13cmos5l_decap_8_2973 r0 *1 0,0
Xsg13cmos5l_decap_8_2973 VPWR VGND sg13cmos5l_decap_8
* cell instance sg13cmos5l_decap_8_2974 r0 *1 0,0
Xsg13cmos5l_decap_8_2974 VPWR VGND sg13cmos5l_decap_8
* cell instance sg13cmos5l_decap_8_2975 r0 *1 0,0
Xsg13cmos5l_decap_8_2975 VPWR VGND sg13cmos5l_decap_8
* cell instance sg13cmos5l_decap_8_2976 r0 *1 0,0
Xsg13cmos5l_decap_8_2976 VPWR VGND sg13cmos5l_decap_8
* cell instance sg13cmos5l_decap_8_2977 r0 *1 0,0
Xsg13cmos5l_decap_8_2977 VPWR VGND sg13cmos5l_decap_8
* cell instance sg13cmos5l_decap_8_2978 r0 *1 0,0
Xsg13cmos5l_decap_8_2978 VPWR VGND sg13cmos5l_decap_8
* cell instance sg13cmos5l_decap_8_2979 r0 *1 0,0
Xsg13cmos5l_decap_8_2979 VPWR VGND sg13cmos5l_decap_8
* cell instance sg13cmos5l_decap_8_2980 r0 *1 0,0
Xsg13cmos5l_decap_8_2980 VPWR VGND sg13cmos5l_decap_8
* cell instance sg13cmos5l_decap_8_2981 r0 *1 0,0
Xsg13cmos5l_decap_8_2981 VPWR VGND sg13cmos5l_decap_8
* cell instance sg13cmos5l_decap_8_2982 r0 *1 0,0
Xsg13cmos5l_decap_8_2982 VPWR VGND sg13cmos5l_decap_8
* cell instance sg13cmos5l_decap_8_2983 r0 *1 0,0
Xsg13cmos5l_decap_8_2983 VPWR VGND sg13cmos5l_decap_8
* cell instance sg13cmos5l_decap_8_2984 r0 *1 0,0
Xsg13cmos5l_decap_8_2984 VPWR VGND sg13cmos5l_decap_8
* cell instance sg13cmos5l_decap_8_2985 r0 *1 0,0
Xsg13cmos5l_decap_8_2985 VPWR VGND sg13cmos5l_decap_8
* cell instance sg13cmos5l_decap_8_2986 r0 *1 0,0
Xsg13cmos5l_decap_8_2986 VPWR VGND sg13cmos5l_decap_8
* cell instance sg13cmos5l_decap_8_2987 r0 *1 0,0
Xsg13cmos5l_decap_8_2987 VPWR VGND sg13cmos5l_decap_8
* cell instance sg13cmos5l_decap_8_2988 r0 *1 0,0
Xsg13cmos5l_decap_8_2988 VPWR VGND sg13cmos5l_decap_8
* cell instance sg13cmos5l_decap_8_2989 r0 *1 0,0
Xsg13cmos5l_decap_8_2989 VPWR VGND sg13cmos5l_decap_8
* cell instance sg13cmos5l_decap_8_2990 r0 *1 0,0
Xsg13cmos5l_decap_8_2990 VPWR VGND sg13cmos5l_decap_8
* cell instance sg13cmos5l_decap_8_2991 r0 *1 0,0
Xsg13cmos5l_decap_8_2991 VPWR VGND sg13cmos5l_decap_8
* cell instance sg13cmos5l_decap_8_2992 r0 *1 0,0
Xsg13cmos5l_decap_8_2992 VPWR VGND sg13cmos5l_decap_8
* cell instance sg13cmos5l_decap_8_2993 r0 *1 0,0
Xsg13cmos5l_decap_8_2993 VPWR VGND sg13cmos5l_decap_8
* cell instance sg13cmos5l_decap_8_2994 r0 *1 0,0
Xsg13cmos5l_decap_8_2994 VPWR VGND sg13cmos5l_decap_8
* cell instance sg13cmos5l_decap_8_2995 r0 *1 0,0
Xsg13cmos5l_decap_8_2995 VPWR VGND sg13cmos5l_decap_8
* cell instance sg13cmos5l_decap_8_2996 r0 *1 0,0
Xsg13cmos5l_decap_8_2996 VPWR VGND sg13cmos5l_decap_8
* cell instance sg13cmos5l_decap_8_2997 r0 *1 0,0
Xsg13cmos5l_decap_8_2997 VPWR VGND sg13cmos5l_decap_8
* cell instance sg13cmos5l_decap_8_2998 r0 *1 0,0
Xsg13cmos5l_decap_8_2998 VPWR VGND sg13cmos5l_decap_8
* cell instance sg13cmos5l_decap_8_2999 r0 *1 0,0
Xsg13cmos5l_decap_8_2999 VPWR VGND sg13cmos5l_decap_8
* cell instance sg13cmos5l_decap_8_3000 r0 *1 0,0
Xsg13cmos5l_decap_8_3000 VPWR VGND sg13cmos5l_decap_8
* cell instance sg13cmos5l_decap_8_3001 r0 *1 0,0
Xsg13cmos5l_decap_8_3001 VPWR VGND sg13cmos5l_decap_8
* cell instance sg13cmos5l_decap_8_3002 r0 *1 0,0
Xsg13cmos5l_decap_8_3002 VPWR VGND sg13cmos5l_decap_8
* cell instance sg13cmos5l_decap_8_3003 r0 *1 0,0
Xsg13cmos5l_decap_8_3003 VPWR VGND sg13cmos5l_decap_8
* cell instance sg13cmos5l_decap_8_3004 r0 *1 0,0
Xsg13cmos5l_decap_8_3004 VPWR VGND sg13cmos5l_decap_8
* cell instance sg13cmos5l_decap_8_3005 r0 *1 0,0
Xsg13cmos5l_decap_8_3005 VPWR VGND sg13cmos5l_decap_8
* cell instance sg13cmos5l_decap_8_3006 r0 *1 0,0
Xsg13cmos5l_decap_8_3006 VPWR VGND sg13cmos5l_decap_8
* cell instance sg13cmos5l_decap_8_3007 r0 *1 0,0
Xsg13cmos5l_decap_8_3007 VPWR VGND sg13cmos5l_decap_8
* cell instance sg13cmos5l_decap_8_3008 r0 *1 0,0
Xsg13cmos5l_decap_8_3008 VPWR VGND sg13cmos5l_decap_8
* cell instance sg13cmos5l_decap_8_3009 r0 *1 0,0
Xsg13cmos5l_decap_8_3009 VPWR VGND sg13cmos5l_decap_8
* cell instance sg13cmos5l_decap_8_3010 r0 *1 0,0
Xsg13cmos5l_decap_8_3010 VPWR VGND sg13cmos5l_decap_8
* cell instance sg13cmos5l_decap_8_3011 r0 *1 0,0
Xsg13cmos5l_decap_8_3011 VPWR VGND sg13cmos5l_decap_8
* cell instance sg13cmos5l_decap_8_3012 r0 *1 0,0
Xsg13cmos5l_decap_8_3012 VPWR VGND sg13cmos5l_decap_8
* cell instance sg13cmos5l_decap_8_3013 r0 *1 0,0
Xsg13cmos5l_decap_8_3013 VPWR VGND sg13cmos5l_decap_8
* cell instance sg13cmos5l_decap_8_3014 r0 *1 0,0
Xsg13cmos5l_decap_8_3014 VPWR VGND sg13cmos5l_decap_8
* cell instance sg13cmos5l_decap_8_3015 r0 *1 0,0
Xsg13cmos5l_decap_8_3015 VPWR VGND sg13cmos5l_decap_8
* cell instance sg13cmos5l_decap_8_3016 r0 *1 0,0
Xsg13cmos5l_decap_8_3016 VPWR VGND sg13cmos5l_decap_8
* cell instance sg13cmos5l_decap_8_3017 r0 *1 0,0
Xsg13cmos5l_decap_8_3017 VPWR VGND sg13cmos5l_decap_8
* cell instance sg13cmos5l_decap_8_3018 r0 *1 0,0
Xsg13cmos5l_decap_8_3018 VPWR VGND sg13cmos5l_decap_8
* cell instance sg13cmos5l_decap_8_3019 r0 *1 0,0
Xsg13cmos5l_decap_8_3019 VPWR VGND sg13cmos5l_decap_8
* cell instance sg13cmos5l_decap_8_3020 r0 *1 0,0
Xsg13cmos5l_decap_8_3020 VPWR VGND sg13cmos5l_decap_8
* cell instance sg13cmos5l_decap_8_3021 r0 *1 0,0
Xsg13cmos5l_decap_8_3021 VPWR VGND sg13cmos5l_decap_8
* cell instance sg13cmos5l_decap_8_3022 r0 *1 0,0
Xsg13cmos5l_decap_8_3022 VPWR VGND sg13cmos5l_decap_8
* cell instance sg13cmos5l_decap_8_3023 r0 *1 0,0
Xsg13cmos5l_decap_8_3023 VPWR VGND sg13cmos5l_decap_8
* cell instance sg13cmos5l_decap_8_3024 r0 *1 0,0
Xsg13cmos5l_decap_8_3024 VPWR VGND sg13cmos5l_decap_8
* cell instance sg13cmos5l_decap_8_3025 r0 *1 0,0
Xsg13cmos5l_decap_8_3025 VPWR VGND sg13cmos5l_decap_8
* cell instance sg13cmos5l_decap_8_3026 r0 *1 0,0
Xsg13cmos5l_decap_8_3026 VPWR VGND sg13cmos5l_decap_8
* cell instance sg13cmos5l_decap_8_3027 r0 *1 0,0
Xsg13cmos5l_decap_8_3027 VPWR VGND sg13cmos5l_decap_8
* cell instance sg13cmos5l_decap_8_3028 r0 *1 0,0
Xsg13cmos5l_decap_8_3028 VPWR VGND sg13cmos5l_decap_8
* cell instance sg13cmos5l_decap_8_3029 r0 *1 0,0
Xsg13cmos5l_decap_8_3029 VPWR VGND sg13cmos5l_decap_8
* cell instance sg13cmos5l_decap_8_3030 r0 *1 0,0
Xsg13cmos5l_decap_8_3030 VPWR VGND sg13cmos5l_decap_8
* cell instance sg13cmos5l_decap_8_3031 r0 *1 0,0
Xsg13cmos5l_decap_8_3031 VPWR VGND sg13cmos5l_decap_8
* cell instance sg13cmos5l_decap_8_3032 r0 *1 0,0
Xsg13cmos5l_decap_8_3032 VPWR VGND sg13cmos5l_decap_8
* cell instance sg13cmos5l_decap_8_3033 r0 *1 0,0
Xsg13cmos5l_decap_8_3033 VPWR VGND sg13cmos5l_decap_8
* cell instance sg13cmos5l_decap_8_3034 r0 *1 0,0
Xsg13cmos5l_decap_8_3034 VPWR VGND sg13cmos5l_decap_8
* cell instance sg13cmos5l_decap_8_3035 r0 *1 0,0
Xsg13cmos5l_decap_8_3035 VPWR VGND sg13cmos5l_decap_8
* cell instance sg13cmos5l_decap_8_3036 r0 *1 0,0
Xsg13cmos5l_decap_8_3036 VPWR VGND sg13cmos5l_decap_8
* cell instance sg13cmos5l_decap_8_3037 r0 *1 0,0
Xsg13cmos5l_decap_8_3037 VPWR VGND sg13cmos5l_decap_8
* cell instance sg13cmos5l_decap_8_3038 r0 *1 0,0
Xsg13cmos5l_decap_8_3038 VPWR VGND sg13cmos5l_decap_8
* cell instance sg13cmos5l_decap_8_3039 r0 *1 0,0
Xsg13cmos5l_decap_8_3039 VPWR VGND sg13cmos5l_decap_8
* cell instance sg13cmos5l_decap_8_3040 r0 *1 0,0
Xsg13cmos5l_decap_8_3040 VPWR VGND sg13cmos5l_decap_8
* cell instance sg13cmos5l_decap_8_3041 r0 *1 0,0
Xsg13cmos5l_decap_8_3041 VPWR VGND sg13cmos5l_decap_8
* cell instance sg13cmos5l_decap_8_3042 r0 *1 0,0
Xsg13cmos5l_decap_8_3042 VPWR VGND sg13cmos5l_decap_8
* cell instance sg13cmos5l_decap_8_3043 r0 *1 0,0
Xsg13cmos5l_decap_8_3043 VPWR VGND sg13cmos5l_decap_8
* cell instance sg13cmos5l_decap_8_3044 r0 *1 0,0
Xsg13cmos5l_decap_8_3044 VPWR VGND sg13cmos5l_decap_8
* cell instance sg13cmos5l_decap_8_3045 r0 *1 0,0
Xsg13cmos5l_decap_8_3045 VPWR VGND sg13cmos5l_decap_8
* cell instance sg13cmos5l_decap_8_3046 r0 *1 0,0
Xsg13cmos5l_decap_8_3046 VPWR VGND sg13cmos5l_decap_8
* cell instance sg13cmos5l_decap_8_3047 r0 *1 0,0
Xsg13cmos5l_decap_8_3047 VPWR VGND sg13cmos5l_decap_8
* cell instance sg13cmos5l_decap_8_3048 r0 *1 0,0
Xsg13cmos5l_decap_8_3048 VPWR VGND sg13cmos5l_decap_8
* cell instance sg13cmos5l_decap_8_3049 r0 *1 0,0
Xsg13cmos5l_decap_8_3049 VPWR VGND sg13cmos5l_decap_8
* cell instance sg13cmos5l_decap_8_3050 r0 *1 0,0
Xsg13cmos5l_decap_8_3050 VPWR VGND sg13cmos5l_decap_8
* cell instance sg13cmos5l_decap_8_3051 r0 *1 0,0
Xsg13cmos5l_decap_8_3051 VPWR VGND sg13cmos5l_decap_8
* cell instance sg13cmos5l_decap_8_3052 r0 *1 0,0
Xsg13cmos5l_decap_8_3052 VPWR VGND sg13cmos5l_decap_8
* cell instance sg13cmos5l_decap_8_3053 r0 *1 0,0
Xsg13cmos5l_decap_8_3053 VPWR VGND sg13cmos5l_decap_8
* cell instance sg13cmos5l_decap_8_3054 r0 *1 0,0
Xsg13cmos5l_decap_8_3054 VPWR VGND sg13cmos5l_decap_8
* cell instance sg13cmos5l_decap_8_3055 r0 *1 0,0
Xsg13cmos5l_decap_8_3055 VPWR VGND sg13cmos5l_decap_8
* cell instance sg13cmos5l_decap_8_3056 r0 *1 0,0
Xsg13cmos5l_decap_8_3056 VPWR VGND sg13cmos5l_decap_8
* cell instance sg13cmos5l_decap_8_3057 r0 *1 0,0
Xsg13cmos5l_decap_8_3057 VPWR VGND sg13cmos5l_decap_8
* cell instance sg13cmos5l_decap_8_3058 r0 *1 0,0
Xsg13cmos5l_decap_8_3058 VPWR VGND sg13cmos5l_decap_8
* cell instance sg13cmos5l_decap_8_3059 r0 *1 0,0
Xsg13cmos5l_decap_8_3059 VPWR VGND sg13cmos5l_decap_8
* cell instance sg13cmos5l_decap_8_3060 r0 *1 0,0
Xsg13cmos5l_decap_8_3060 VPWR VGND sg13cmos5l_decap_8
* cell instance sg13cmos5l_decap_8_3061 r0 *1 0,0
Xsg13cmos5l_decap_8_3061 VPWR VGND sg13cmos5l_decap_8
* cell instance sg13cmos5l_decap_8_3062 r0 *1 0,0
Xsg13cmos5l_decap_8_3062 VPWR VGND sg13cmos5l_decap_8
* cell instance sg13cmos5l_decap_8_3063 r0 *1 0,0
Xsg13cmos5l_decap_8_3063 VPWR VGND sg13cmos5l_decap_8
* cell instance sg13cmos5l_decap_8_3064 r0 *1 0,0
Xsg13cmos5l_decap_8_3064 VPWR VGND sg13cmos5l_decap_8
* cell instance sg13cmos5l_decap_8_3065 r0 *1 0,0
Xsg13cmos5l_decap_8_3065 VPWR VGND sg13cmos5l_decap_8
* cell instance sg13cmos5l_decap_8_3066 r0 *1 0,0
Xsg13cmos5l_decap_8_3066 VPWR VGND sg13cmos5l_decap_8
* cell instance sg13cmos5l_decap_8_3067 r0 *1 0,0
Xsg13cmos5l_decap_8_3067 VPWR VGND sg13cmos5l_decap_8
* cell instance sg13cmos5l_decap_8_3068 r0 *1 0,0
Xsg13cmos5l_decap_8_3068 VPWR VGND sg13cmos5l_decap_8
* cell instance sg13cmos5l_decap_8_3069 r0 *1 0,0
Xsg13cmos5l_decap_8_3069 VPWR VGND sg13cmos5l_decap_8
* cell instance sg13cmos5l_decap_8_3070 r0 *1 0,0
Xsg13cmos5l_decap_8_3070 VPWR VGND sg13cmos5l_decap_8
* cell instance sg13cmos5l_decap_8_3071 r0 *1 0,0
Xsg13cmos5l_decap_8_3071 VPWR VGND sg13cmos5l_decap_8
* cell instance sg13cmos5l_decap_8_3072 r0 *1 0,0
Xsg13cmos5l_decap_8_3072 VPWR VGND sg13cmos5l_decap_8
* cell instance sg13cmos5l_decap_8_3073 r0 *1 0,0
Xsg13cmos5l_decap_8_3073 VPWR VGND sg13cmos5l_decap_8
* cell instance sg13cmos5l_decap_8_3074 r0 *1 0,0
Xsg13cmos5l_decap_8_3074 VPWR VGND sg13cmos5l_decap_8
* cell instance sg13cmos5l_decap_8_3075 r0 *1 0,0
Xsg13cmos5l_decap_8_3075 VPWR VGND sg13cmos5l_decap_8
* cell instance sg13cmos5l_decap_8_3076 r0 *1 0,0
Xsg13cmos5l_decap_8_3076 VPWR VGND sg13cmos5l_decap_8
* cell instance sg13cmos5l_decap_8_3077 r0 *1 0,0
Xsg13cmos5l_decap_8_3077 VPWR VGND sg13cmos5l_decap_8
* cell instance sg13cmos5l_decap_8_3078 r0 *1 0,0
Xsg13cmos5l_decap_8_3078 VPWR VGND sg13cmos5l_decap_8
* cell instance sg13cmos5l_decap_8_3079 r0 *1 0,0
Xsg13cmos5l_decap_8_3079 VPWR VGND sg13cmos5l_decap_8
* cell instance sg13cmos5l_decap_8_3080 r0 *1 0,0
Xsg13cmos5l_decap_8_3080 VPWR VGND sg13cmos5l_decap_8
* cell instance sg13cmos5l_decap_8_3081 r0 *1 0,0
Xsg13cmos5l_decap_8_3081 VPWR VGND sg13cmos5l_decap_8
* cell instance sg13cmos5l_decap_8_3082 r0 *1 0,0
Xsg13cmos5l_decap_8_3082 VPWR VGND sg13cmos5l_decap_8
* cell instance sg13cmos5l_decap_8_3083 r0 *1 0,0
Xsg13cmos5l_decap_8_3083 VPWR VGND sg13cmos5l_decap_8
* cell instance sg13cmos5l_decap_8_3084 r0 *1 0,0
Xsg13cmos5l_decap_8_3084 VPWR VGND sg13cmos5l_decap_8
* cell instance sg13cmos5l_decap_8_3085 r0 *1 0,0
Xsg13cmos5l_decap_8_3085 VPWR VGND sg13cmos5l_decap_8
* cell instance sg13cmos5l_decap_8_3086 r0 *1 0,0
Xsg13cmos5l_decap_8_3086 VPWR VGND sg13cmos5l_decap_8
* cell instance sg13cmos5l_decap_8_3087 r0 *1 0,0
Xsg13cmos5l_decap_8_3087 VPWR VGND sg13cmos5l_decap_8
* cell instance sg13cmos5l_decap_8_3088 r0 *1 0,0
Xsg13cmos5l_decap_8_3088 VPWR VGND sg13cmos5l_decap_8
* cell instance sg13cmos5l_decap_8_3089 r0 *1 0,0
Xsg13cmos5l_decap_8_3089 VPWR VGND sg13cmos5l_decap_8
* cell instance sg13cmos5l_decap_8_3090 r0 *1 0,0
Xsg13cmos5l_decap_8_3090 VPWR VGND sg13cmos5l_decap_8
* cell instance sg13cmos5l_decap_8_3091 r0 *1 0,0
Xsg13cmos5l_decap_8_3091 VPWR VGND sg13cmos5l_decap_8
* cell instance sg13cmos5l_decap_8_3092 r0 *1 0,0
Xsg13cmos5l_decap_8_3092 VPWR VGND sg13cmos5l_decap_8
* cell instance sg13cmos5l_decap_8_3093 r0 *1 0,0
Xsg13cmos5l_decap_8_3093 VPWR VGND sg13cmos5l_decap_8
* cell instance sg13cmos5l_decap_8_3094 r0 *1 0,0
Xsg13cmos5l_decap_8_3094 VPWR VGND sg13cmos5l_decap_8
* cell instance sg13cmos5l_decap_8_3095 r0 *1 0,0
Xsg13cmos5l_decap_8_3095 VPWR VGND sg13cmos5l_decap_8
* cell instance sg13cmos5l_decap_8_3096 r0 *1 0,0
Xsg13cmos5l_decap_8_3096 VPWR VGND sg13cmos5l_decap_8
* cell instance sg13cmos5l_decap_8_3097 r0 *1 0,0
Xsg13cmos5l_decap_8_3097 VPWR VGND sg13cmos5l_decap_8
* cell instance sg13cmos5l_decap_8_3098 r0 *1 0,0
Xsg13cmos5l_decap_8_3098 VPWR VGND sg13cmos5l_decap_8
* cell instance sg13cmos5l_decap_8_3099 r0 *1 0,0
Xsg13cmos5l_decap_8_3099 VPWR VGND sg13cmos5l_decap_8
* cell instance sg13cmos5l_decap_8_3100 r0 *1 0,0
Xsg13cmos5l_decap_8_3100 VPWR VGND sg13cmos5l_decap_8
* cell instance sg13cmos5l_decap_8_3101 r0 *1 0,0
Xsg13cmos5l_decap_8_3101 VPWR VGND sg13cmos5l_decap_8
* cell instance sg13cmos5l_decap_8_3102 r0 *1 0,0
Xsg13cmos5l_decap_8_3102 VPWR VGND sg13cmos5l_decap_8
* cell instance sg13cmos5l_decap_8_3103 r0 *1 0,0
Xsg13cmos5l_decap_8_3103 VPWR VGND sg13cmos5l_decap_8
* cell instance sg13cmos5l_decap_8_3104 r0 *1 0,0
Xsg13cmos5l_decap_8_3104 VPWR VGND sg13cmos5l_decap_8
* cell instance sg13cmos5l_decap_8_3105 r0 *1 0,0
Xsg13cmos5l_decap_8_3105 VPWR VGND sg13cmos5l_decap_8
* cell instance sg13cmos5l_decap_8_3106 r0 *1 0,0
Xsg13cmos5l_decap_8_3106 VPWR VGND sg13cmos5l_decap_8
* cell instance sg13cmos5l_decap_8_3107 r0 *1 0,0
Xsg13cmos5l_decap_8_3107 VPWR VGND sg13cmos5l_decap_8
* cell instance sg13cmos5l_decap_8_3108 r0 *1 0,0
Xsg13cmos5l_decap_8_3108 VPWR VGND sg13cmos5l_decap_8
* cell instance sg13cmos5l_decap_8_3109 r0 *1 0,0
Xsg13cmos5l_decap_8_3109 VPWR VGND sg13cmos5l_decap_8
* cell instance sg13cmos5l_decap_8_3110 r0 *1 0,0
Xsg13cmos5l_decap_8_3110 VPWR VGND sg13cmos5l_decap_8
* cell instance sg13cmos5l_decap_8_3111 r0 *1 0,0
Xsg13cmos5l_decap_8_3111 VPWR VGND sg13cmos5l_decap_8
* cell instance sg13cmos5l_decap_8_3112 r0 *1 0,0
Xsg13cmos5l_decap_8_3112 VPWR VGND sg13cmos5l_decap_8
* cell instance sg13cmos5l_decap_8_3113 r0 *1 0,0
Xsg13cmos5l_decap_8_3113 VPWR VGND sg13cmos5l_decap_8
* cell instance sg13cmos5l_decap_8_3114 r0 *1 0,0
Xsg13cmos5l_decap_8_3114 VPWR VGND sg13cmos5l_decap_8
* cell instance sg13cmos5l_decap_8_3115 r0 *1 0,0
Xsg13cmos5l_decap_8_3115 VPWR VGND sg13cmos5l_decap_8
* cell instance sg13cmos5l_decap_8_3116 r0 *1 0,0
Xsg13cmos5l_decap_8_3116 VPWR VGND sg13cmos5l_decap_8
* cell instance sg13cmos5l_decap_8_3117 r0 *1 0,0
Xsg13cmos5l_decap_8_3117 VPWR VGND sg13cmos5l_decap_8
* cell instance sg13cmos5l_decap_8_3118 r0 *1 0,0
Xsg13cmos5l_decap_8_3118 VPWR VGND sg13cmos5l_decap_8
* cell instance sg13cmos5l_decap_8_3119 r0 *1 0,0
Xsg13cmos5l_decap_8_3119 VPWR VGND sg13cmos5l_decap_8
* cell instance sg13cmos5l_decap_8_3120 r0 *1 0,0
Xsg13cmos5l_decap_8_3120 VPWR VGND sg13cmos5l_decap_8
* cell instance sg13cmos5l_decap_8_3121 r0 *1 0,0
Xsg13cmos5l_decap_8_3121 VPWR VGND sg13cmos5l_decap_8
* cell instance sg13cmos5l_decap_8_3122 r0 *1 0,0
Xsg13cmos5l_decap_8_3122 VPWR VGND sg13cmos5l_decap_8
* cell instance sg13cmos5l_decap_8_3123 r0 *1 0,0
Xsg13cmos5l_decap_8_3123 VPWR VGND sg13cmos5l_decap_8
* cell instance sg13cmos5l_decap_8_3124 r0 *1 0,0
Xsg13cmos5l_decap_8_3124 VPWR VGND sg13cmos5l_decap_8
* cell instance sg13cmos5l_decap_8_3125 r0 *1 0,0
Xsg13cmos5l_decap_8_3125 VPWR VGND sg13cmos5l_decap_8
* cell instance sg13cmos5l_decap_8_3126 r0 *1 0,0
Xsg13cmos5l_decap_8_3126 VPWR VGND sg13cmos5l_decap_8
* cell instance sg13cmos5l_decap_8_3127 r0 *1 0,0
Xsg13cmos5l_decap_8_3127 VPWR VGND sg13cmos5l_decap_8
* cell instance sg13cmos5l_decap_8_3128 r0 *1 0,0
Xsg13cmos5l_decap_8_3128 VPWR VGND sg13cmos5l_decap_8
* cell instance sg13cmos5l_decap_8_3129 r0 *1 0,0
Xsg13cmos5l_decap_8_3129 VPWR VGND sg13cmos5l_decap_8
* cell instance sg13cmos5l_decap_8_3130 r0 *1 0,0
Xsg13cmos5l_decap_8_3130 VPWR VGND sg13cmos5l_decap_8
* cell instance sg13cmos5l_decap_8_3131 r0 *1 0,0
Xsg13cmos5l_decap_8_3131 VPWR VGND sg13cmos5l_decap_8
* cell instance sg13cmos5l_decap_8_3132 r0 *1 0,0
Xsg13cmos5l_decap_8_3132 VPWR VGND sg13cmos5l_decap_8
* cell instance sg13cmos5l_decap_8_3133 r0 *1 0,0
Xsg13cmos5l_decap_8_3133 VPWR VGND sg13cmos5l_decap_8
* cell instance sg13cmos5l_decap_8_3134 r0 *1 0,0
Xsg13cmos5l_decap_8_3134 VPWR VGND sg13cmos5l_decap_8
* cell instance sg13cmos5l_decap_8_3135 r0 *1 0,0
Xsg13cmos5l_decap_8_3135 VPWR VGND sg13cmos5l_decap_8
* cell instance sg13cmos5l_decap_8_3136 r0 *1 0,0
Xsg13cmos5l_decap_8_3136 VPWR VGND sg13cmos5l_decap_8
* cell instance sg13cmos5l_decap_8_3137 r0 *1 0,0
Xsg13cmos5l_decap_8_3137 VPWR VGND sg13cmos5l_decap_8
* cell instance sg13cmos5l_decap_8_3138 r0 *1 0,0
Xsg13cmos5l_decap_8_3138 VPWR VGND sg13cmos5l_decap_8
* cell instance sg13cmos5l_decap_8_3139 r0 *1 0,0
Xsg13cmos5l_decap_8_3139 VPWR VGND sg13cmos5l_decap_8
* cell instance sg13cmos5l_decap_8_3140 r0 *1 0,0
Xsg13cmos5l_decap_8_3140 VPWR VGND sg13cmos5l_decap_8
* cell instance sg13cmos5l_decap_8_3141 r0 *1 0,0
Xsg13cmos5l_decap_8_3141 VPWR VGND sg13cmos5l_decap_8
* cell instance sg13cmos5l_decap_8_3142 r0 *1 0,0
Xsg13cmos5l_decap_8_3142 VPWR VGND sg13cmos5l_decap_8
* cell instance sg13cmos5l_decap_8_3143 r0 *1 0,0
Xsg13cmos5l_decap_8_3143 VPWR VGND sg13cmos5l_decap_8
* cell instance sg13cmos5l_decap_8_3144 r0 *1 0,0
Xsg13cmos5l_decap_8_3144 VPWR VGND sg13cmos5l_decap_8
* cell instance sg13cmos5l_decap_8_3145 r0 *1 0,0
Xsg13cmos5l_decap_8_3145 VPWR VGND sg13cmos5l_decap_8
* cell instance sg13cmos5l_decap_8_3146 r0 *1 0,0
Xsg13cmos5l_decap_8_3146 VPWR VGND sg13cmos5l_decap_8
* cell instance sg13cmos5l_decap_8_3147 r0 *1 0,0
Xsg13cmos5l_decap_8_3147 VPWR VGND sg13cmos5l_decap_8
* cell instance sg13cmos5l_decap_8_3148 r0 *1 0,0
Xsg13cmos5l_decap_8_3148 VPWR VGND sg13cmos5l_decap_8
* cell instance sg13cmos5l_decap_8_3149 r0 *1 0,0
Xsg13cmos5l_decap_8_3149 VPWR VGND sg13cmos5l_decap_8
* cell instance sg13cmos5l_decap_8_3150 r0 *1 0,0
Xsg13cmos5l_decap_8_3150 VPWR VGND sg13cmos5l_decap_8
* cell instance sg13cmos5l_decap_8_3151 r0 *1 0,0
Xsg13cmos5l_decap_8_3151 VPWR VGND sg13cmos5l_decap_8
* cell instance sg13cmos5l_decap_8_3152 r0 *1 0,0
Xsg13cmos5l_decap_8_3152 VPWR VGND sg13cmos5l_decap_8
* cell instance sg13cmos5l_decap_8_3153 r0 *1 0,0
Xsg13cmos5l_decap_8_3153 VPWR VGND sg13cmos5l_decap_8
* cell instance sg13cmos5l_decap_8_3154 r0 *1 0,0
Xsg13cmos5l_decap_8_3154 VPWR VGND sg13cmos5l_decap_8
* cell instance sg13cmos5l_decap_8_3155 r0 *1 0,0
Xsg13cmos5l_decap_8_3155 VPWR VGND sg13cmos5l_decap_8
* cell instance sg13cmos5l_decap_8_3156 r0 *1 0,0
Xsg13cmos5l_decap_8_3156 VPWR VGND sg13cmos5l_decap_8
* cell instance sg13cmos5l_decap_8_3157 r0 *1 0,0
Xsg13cmos5l_decap_8_3157 VPWR VGND sg13cmos5l_decap_8
* cell instance sg13cmos5l_decap_8_3158 r0 *1 0,0
Xsg13cmos5l_decap_8_3158 VPWR VGND sg13cmos5l_decap_8
* cell instance sg13cmos5l_decap_8_3159 r0 *1 0,0
Xsg13cmos5l_decap_8_3159 VPWR VGND sg13cmos5l_decap_8
* cell instance sg13cmos5l_decap_8_3160 r0 *1 0,0
Xsg13cmos5l_decap_8_3160 VPWR VGND sg13cmos5l_decap_8
* cell instance sg13cmos5l_decap_8_3161 r0 *1 0,0
Xsg13cmos5l_decap_8_3161 VPWR VGND sg13cmos5l_decap_8
* cell instance sg13cmos5l_decap_8_3162 r0 *1 0,0
Xsg13cmos5l_decap_8_3162 VPWR VGND sg13cmos5l_decap_8
* cell instance sg13cmos5l_decap_8_3163 r0 *1 0,0
Xsg13cmos5l_decap_8_3163 VPWR VGND sg13cmos5l_decap_8
* cell instance sg13cmos5l_decap_8_3164 r0 *1 0,0
Xsg13cmos5l_decap_8_3164 VPWR VGND sg13cmos5l_decap_8
* cell instance sg13cmos5l_decap_8_3165 r0 *1 0,0
Xsg13cmos5l_decap_8_3165 VPWR VGND sg13cmos5l_decap_8
* cell instance sg13cmos5l_decap_8_3166 r0 *1 0,0
Xsg13cmos5l_decap_8_3166 VPWR VGND sg13cmos5l_decap_8
* cell instance sg13cmos5l_decap_8_3167 r0 *1 0,0
Xsg13cmos5l_decap_8_3167 VPWR VGND sg13cmos5l_decap_8
* cell instance sg13cmos5l_decap_8_3168 r0 *1 0,0
Xsg13cmos5l_decap_8_3168 VPWR VGND sg13cmos5l_decap_8
* cell instance sg13cmos5l_decap_8_3169 r0 *1 0,0
Xsg13cmos5l_decap_8_3169 VPWR VGND sg13cmos5l_decap_8
* cell instance sg13cmos5l_decap_8_3170 r0 *1 0,0
Xsg13cmos5l_decap_8_3170 VPWR VGND sg13cmos5l_decap_8
* cell instance sg13cmos5l_decap_8_3171 r0 *1 0,0
Xsg13cmos5l_decap_8_3171 VPWR VGND sg13cmos5l_decap_8
* cell instance sg13cmos5l_decap_8_3172 r0 *1 0,0
Xsg13cmos5l_decap_8_3172 VPWR VGND sg13cmos5l_decap_8
* cell instance sg13cmos5l_decap_8_3173 r0 *1 0,0
Xsg13cmos5l_decap_8_3173 VPWR VGND sg13cmos5l_decap_8
* cell instance sg13cmos5l_decap_8_3174 r0 *1 0,0
Xsg13cmos5l_decap_8_3174 VPWR VGND sg13cmos5l_decap_8
* cell instance sg13cmos5l_decap_8_3175 r0 *1 0,0
Xsg13cmos5l_decap_8_3175 VPWR VGND sg13cmos5l_decap_8
* cell instance sg13cmos5l_decap_8_3176 r0 *1 0,0
Xsg13cmos5l_decap_8_3176 VPWR VGND sg13cmos5l_decap_8
* cell instance sg13cmos5l_decap_8_3177 r0 *1 0,0
Xsg13cmos5l_decap_8_3177 VPWR VGND sg13cmos5l_decap_8
* cell instance sg13cmos5l_decap_8_3178 r0 *1 0,0
Xsg13cmos5l_decap_8_3178 VPWR VGND sg13cmos5l_decap_8
* cell instance sg13cmos5l_decap_8_3179 r0 *1 0,0
Xsg13cmos5l_decap_8_3179 VPWR VGND sg13cmos5l_decap_8
* cell instance sg13cmos5l_decap_8_3180 r0 *1 0,0
Xsg13cmos5l_decap_8_3180 VPWR VGND sg13cmos5l_decap_8
* cell instance sg13cmos5l_decap_8_3181 r0 *1 0,0
Xsg13cmos5l_decap_8_3181 VPWR VGND sg13cmos5l_decap_8
* cell instance sg13cmos5l_decap_8_3182 r0 *1 0,0
Xsg13cmos5l_decap_8_3182 VPWR VGND sg13cmos5l_decap_8
* cell instance sg13cmos5l_decap_8_3183 r0 *1 0,0
Xsg13cmos5l_decap_8_3183 VPWR VGND sg13cmos5l_decap_8
* cell instance sg13cmos5l_decap_8_3184 r0 *1 0,0
Xsg13cmos5l_decap_8_3184 VPWR VGND sg13cmos5l_decap_8
* cell instance sg13cmos5l_decap_8_3185 r0 *1 0,0
Xsg13cmos5l_decap_8_3185 VPWR VGND sg13cmos5l_decap_8
* cell instance sg13cmos5l_decap_8_3186 r0 *1 0,0
Xsg13cmos5l_decap_8_3186 VPWR VGND sg13cmos5l_decap_8
* cell instance sg13cmos5l_decap_8_3187 r0 *1 0,0
Xsg13cmos5l_decap_8_3187 VPWR VGND sg13cmos5l_decap_8
* cell instance sg13cmos5l_decap_8_3188 r0 *1 0,0
Xsg13cmos5l_decap_8_3188 VPWR VGND sg13cmos5l_decap_8
* cell instance sg13cmos5l_decap_8_3189 r0 *1 0,0
Xsg13cmos5l_decap_8_3189 VPWR VGND sg13cmos5l_decap_8
* cell instance sg13cmos5l_decap_8_3190 r0 *1 0,0
Xsg13cmos5l_decap_8_3190 VPWR VGND sg13cmos5l_decap_8
* cell instance sg13cmos5l_decap_8_3191 r0 *1 0,0
Xsg13cmos5l_decap_8_3191 VPWR VGND sg13cmos5l_decap_8
* cell instance sg13cmos5l_decap_8_3192 r0 *1 0,0
Xsg13cmos5l_decap_8_3192 VPWR VGND sg13cmos5l_decap_8
* cell instance sg13cmos5l_decap_8_3193 r0 *1 0,0
Xsg13cmos5l_decap_8_3193 VPWR VGND sg13cmos5l_decap_8
* cell instance sg13cmos5l_decap_8_3194 r0 *1 0,0
Xsg13cmos5l_decap_8_3194 VPWR VGND sg13cmos5l_decap_8
* cell instance sg13cmos5l_decap_8_3195 r0 *1 0,0
Xsg13cmos5l_decap_8_3195 VPWR VGND sg13cmos5l_decap_8
* cell instance sg13cmos5l_decap_8_3196 r0 *1 0,0
Xsg13cmos5l_decap_8_3196 VPWR VGND sg13cmos5l_decap_8
* cell instance sg13cmos5l_decap_8_3197 r0 *1 0,0
Xsg13cmos5l_decap_8_3197 VPWR VGND sg13cmos5l_decap_8
* cell instance sg13cmos5l_decap_8_3198 r0 *1 0,0
Xsg13cmos5l_decap_8_3198 VPWR VGND sg13cmos5l_decap_8
* cell instance sg13cmos5l_decap_8_3199 r0 *1 0,0
Xsg13cmos5l_decap_8_3199 VPWR VGND sg13cmos5l_decap_8
* cell instance sg13cmos5l_decap_8_3200 r0 *1 0,0
Xsg13cmos5l_decap_8_3200 VPWR VGND sg13cmos5l_decap_8
* cell instance sg13cmos5l_decap_8_3201 r0 *1 0,0
Xsg13cmos5l_decap_8_3201 VPWR VGND sg13cmos5l_decap_8
* cell instance sg13cmos5l_decap_8_3202 r0 *1 0,0
Xsg13cmos5l_decap_8_3202 VPWR VGND sg13cmos5l_decap_8
* cell instance sg13cmos5l_decap_8_3203 r0 *1 0,0
Xsg13cmos5l_decap_8_3203 VPWR VGND sg13cmos5l_decap_8
* cell instance sg13cmos5l_decap_8_3204 r0 *1 0,0
Xsg13cmos5l_decap_8_3204 VPWR VGND sg13cmos5l_decap_8
* cell instance sg13cmos5l_decap_8_3205 r0 *1 0,0
Xsg13cmos5l_decap_8_3205 VPWR VGND sg13cmos5l_decap_8
* cell instance sg13cmos5l_decap_8_3206 r0 *1 0,0
Xsg13cmos5l_decap_8_3206 VPWR VGND sg13cmos5l_decap_8
* cell instance sg13cmos5l_decap_8_3207 r0 *1 0,0
Xsg13cmos5l_decap_8_3207 VPWR VGND sg13cmos5l_decap_8
* cell instance sg13cmos5l_decap_8_3208 r0 *1 0,0
Xsg13cmos5l_decap_8_3208 VPWR VGND sg13cmos5l_decap_8
* cell instance sg13cmos5l_decap_8_3209 r0 *1 0,0
Xsg13cmos5l_decap_8_3209 VPWR VGND sg13cmos5l_decap_8
* cell instance sg13cmos5l_decap_8_3210 r0 *1 0,0
Xsg13cmos5l_decap_8_3210 VPWR VGND sg13cmos5l_decap_8
* cell instance sg13cmos5l_decap_8_3211 r0 *1 0,0
Xsg13cmos5l_decap_8_3211 VPWR VGND sg13cmos5l_decap_8
* cell instance sg13cmos5l_decap_8_3212 r0 *1 0,0
Xsg13cmos5l_decap_8_3212 VPWR VGND sg13cmos5l_decap_8
* cell instance sg13cmos5l_decap_8_3213 r0 *1 0,0
Xsg13cmos5l_decap_8_3213 VPWR VGND sg13cmos5l_decap_8
* cell instance sg13cmos5l_decap_8_3214 r0 *1 0,0
Xsg13cmos5l_decap_8_3214 VPWR VGND sg13cmos5l_decap_8
* cell instance sg13cmos5l_decap_8_3215 r0 *1 0,0
Xsg13cmos5l_decap_8_3215 VPWR VGND sg13cmos5l_decap_8
* cell instance sg13cmos5l_decap_8_3216 r0 *1 0,0
Xsg13cmos5l_decap_8_3216 VPWR VGND sg13cmos5l_decap_8
* cell instance sg13cmos5l_decap_8_3217 r0 *1 0,0
Xsg13cmos5l_decap_8_3217 VPWR VGND sg13cmos5l_decap_8
* cell instance sg13cmos5l_decap_8_3218 r0 *1 0,0
Xsg13cmos5l_decap_8_3218 VPWR VGND sg13cmos5l_decap_8
* cell instance sg13cmos5l_decap_8_3219 r0 *1 0,0
Xsg13cmos5l_decap_8_3219 VPWR VGND sg13cmos5l_decap_8
* cell instance sg13cmos5l_decap_8_3220 r0 *1 0,0
Xsg13cmos5l_decap_8_3220 VPWR VGND sg13cmos5l_decap_8
* cell instance sg13cmos5l_decap_8_3221 r0 *1 0,0
Xsg13cmos5l_decap_8_3221 VPWR VGND sg13cmos5l_decap_8
* cell instance sg13cmos5l_decap_8_3222 r0 *1 0,0
Xsg13cmos5l_decap_8_3222 VPWR VGND sg13cmos5l_decap_8
* cell instance sg13cmos5l_decap_8_3223 r0 *1 0,0
Xsg13cmos5l_decap_8_3223 VPWR VGND sg13cmos5l_decap_8
* cell instance sg13cmos5l_decap_8_3224 r0 *1 0,0
Xsg13cmos5l_decap_8_3224 VPWR VGND sg13cmos5l_decap_8
* cell instance sg13cmos5l_decap_8_3225 r0 *1 0,0
Xsg13cmos5l_decap_8_3225 VPWR VGND sg13cmos5l_decap_8
* cell instance sg13cmos5l_decap_8_3226 r0 *1 0,0
Xsg13cmos5l_decap_8_3226 VPWR VGND sg13cmos5l_decap_8
* cell instance sg13cmos5l_decap_8_3227 r0 *1 0,0
Xsg13cmos5l_decap_8_3227 VPWR VGND sg13cmos5l_decap_8
* cell instance sg13cmos5l_decap_8_3228 r0 *1 0,0
Xsg13cmos5l_decap_8_3228 VPWR VGND sg13cmos5l_decap_8
* cell instance sg13cmos5l_decap_8_3229 r0 *1 0,0
Xsg13cmos5l_decap_8_3229 VPWR VGND sg13cmos5l_decap_8
* cell instance sg13cmos5l_decap_8_3230 r0 *1 0,0
Xsg13cmos5l_decap_8_3230 VPWR VGND sg13cmos5l_decap_8
* cell instance sg13cmos5l_decap_8_3231 r0 *1 0,0
Xsg13cmos5l_decap_8_3231 VPWR VGND sg13cmos5l_decap_8
* cell instance sg13cmos5l_decap_8_3232 r0 *1 0,0
Xsg13cmos5l_decap_8_3232 VPWR VGND sg13cmos5l_decap_8
* cell instance sg13cmos5l_decap_8_3233 r0 *1 0,0
Xsg13cmos5l_decap_8_3233 VPWR VGND sg13cmos5l_decap_8
* cell instance sg13cmos5l_decap_8_3234 r0 *1 0,0
Xsg13cmos5l_decap_8_3234 VPWR VGND sg13cmos5l_decap_8
* cell instance sg13cmos5l_decap_8_3235 r0 *1 0,0
Xsg13cmos5l_decap_8_3235 VPWR VGND sg13cmos5l_decap_8
* cell instance sg13cmos5l_decap_8_3236 r0 *1 0,0
Xsg13cmos5l_decap_8_3236 VPWR VGND sg13cmos5l_decap_8
* cell instance sg13cmos5l_decap_8_3237 r0 *1 0,0
Xsg13cmos5l_decap_8_3237 VPWR VGND sg13cmos5l_decap_8
* cell instance sg13cmos5l_decap_8_3238 r0 *1 0,0
Xsg13cmos5l_decap_8_3238 VPWR VGND sg13cmos5l_decap_8
* cell instance sg13cmos5l_decap_8_3239 r0 *1 0,0
Xsg13cmos5l_decap_8_3239 VPWR VGND sg13cmos5l_decap_8
* cell instance sg13cmos5l_decap_8_3240 r0 *1 0,0
Xsg13cmos5l_decap_8_3240 VPWR VGND sg13cmos5l_decap_8
* cell instance sg13cmos5l_decap_8_3241 r0 *1 0,0
Xsg13cmos5l_decap_8_3241 VPWR VGND sg13cmos5l_decap_8
* cell instance sg13cmos5l_decap_8_3242 r0 *1 0,0
Xsg13cmos5l_decap_8_3242 VPWR VGND sg13cmos5l_decap_8
* cell instance sg13cmos5l_decap_8_3243 r0 *1 0,0
Xsg13cmos5l_decap_8_3243 VPWR VGND sg13cmos5l_decap_8
* cell instance sg13cmos5l_decap_8_3244 r0 *1 0,0
Xsg13cmos5l_decap_8_3244 VPWR VGND sg13cmos5l_decap_8
* cell instance sg13cmos5l_decap_8_3245 r0 *1 0,0
Xsg13cmos5l_decap_8_3245 VPWR VGND sg13cmos5l_decap_8
* cell instance sg13cmos5l_decap_8_3246 r0 *1 0,0
Xsg13cmos5l_decap_8_3246 VPWR VGND sg13cmos5l_decap_8
* cell instance sg13cmos5l_decap_8_3247 r0 *1 0,0
Xsg13cmos5l_decap_8_3247 VPWR VGND sg13cmos5l_decap_8
* cell instance sg13cmos5l_decap_8_3248 r0 *1 0,0
Xsg13cmos5l_decap_8_3248 VPWR VGND sg13cmos5l_decap_8
* cell instance sg13cmos5l_decap_8_3249 r0 *1 0,0
Xsg13cmos5l_decap_8_3249 VPWR VGND sg13cmos5l_decap_8
* cell instance sg13cmos5l_decap_8_3250 r0 *1 0,0
Xsg13cmos5l_decap_8_3250 VPWR VGND sg13cmos5l_decap_8
* cell instance sg13cmos5l_decap_8_3251 r0 *1 0,0
Xsg13cmos5l_decap_8_3251 VPWR VGND sg13cmos5l_decap_8
* cell instance sg13cmos5l_decap_8_3252 r0 *1 0,0
Xsg13cmos5l_decap_8_3252 VPWR VGND sg13cmos5l_decap_8
* cell instance sg13cmos5l_decap_8_3253 r0 *1 0,0
Xsg13cmos5l_decap_8_3253 VPWR VGND sg13cmos5l_decap_8
* cell instance sg13cmos5l_decap_8_3254 r0 *1 0,0
Xsg13cmos5l_decap_8_3254 VPWR VGND sg13cmos5l_decap_8
* cell instance sg13cmos5l_decap_8_3255 r0 *1 0,0
Xsg13cmos5l_decap_8_3255 VPWR VGND sg13cmos5l_decap_8
* cell instance sg13cmos5l_decap_8_3256 r0 *1 0,0
Xsg13cmos5l_decap_8_3256 VPWR VGND sg13cmos5l_decap_8
* cell instance sg13cmos5l_decap_8_3257 r0 *1 0,0
Xsg13cmos5l_decap_8_3257 VPWR VGND sg13cmos5l_decap_8
* cell instance sg13cmos5l_decap_8_3258 r0 *1 0,0
Xsg13cmos5l_decap_8_3258 VPWR VGND sg13cmos5l_decap_8
* cell instance sg13cmos5l_decap_8_3259 r0 *1 0,0
Xsg13cmos5l_decap_8_3259 VPWR VGND sg13cmos5l_decap_8
* cell instance sg13cmos5l_decap_8_3260 r0 *1 0,0
Xsg13cmos5l_decap_8_3260 VPWR VGND sg13cmos5l_decap_8
* cell instance sg13cmos5l_decap_8_3261 r0 *1 0,0
Xsg13cmos5l_decap_8_3261 VPWR VGND sg13cmos5l_decap_8
* cell instance sg13cmos5l_decap_8_3262 r0 *1 0,0
Xsg13cmos5l_decap_8_3262 VPWR VGND sg13cmos5l_decap_8
* cell instance sg13cmos5l_decap_8_3263 r0 *1 0,0
Xsg13cmos5l_decap_8_3263 VPWR VGND sg13cmos5l_decap_8
* cell instance sg13cmos5l_decap_8_3264 r0 *1 0,0
Xsg13cmos5l_decap_8_3264 VPWR VGND sg13cmos5l_decap_8
* cell instance sg13cmos5l_decap_8_3265 r0 *1 0,0
Xsg13cmos5l_decap_8_3265 VPWR VGND sg13cmos5l_decap_8
* cell instance sg13cmos5l_decap_8_3266 r0 *1 0,0
Xsg13cmos5l_decap_8_3266 VPWR VGND sg13cmos5l_decap_8
* cell instance sg13cmos5l_decap_8_3267 r0 *1 0,0
Xsg13cmos5l_decap_8_3267 VPWR VGND sg13cmos5l_decap_8
* cell instance sg13cmos5l_decap_8_3268 r0 *1 0,0
Xsg13cmos5l_decap_8_3268 VPWR VGND sg13cmos5l_decap_8
* cell instance sg13cmos5l_decap_8_3269 r0 *1 0,0
Xsg13cmos5l_decap_8_3269 VPWR VGND sg13cmos5l_decap_8
* cell instance sg13cmos5l_decap_8_3270 r0 *1 0,0
Xsg13cmos5l_decap_8_3270 VPWR VGND sg13cmos5l_decap_8
* cell instance sg13cmos5l_decap_8_3271 r0 *1 0,0
Xsg13cmos5l_decap_8_3271 VPWR VGND sg13cmos5l_decap_8
* cell instance sg13cmos5l_decap_8_3272 r0 *1 0,0
Xsg13cmos5l_decap_8_3272 VPWR VGND sg13cmos5l_decap_8
* cell instance sg13cmos5l_decap_8_3273 r0 *1 0,0
Xsg13cmos5l_decap_8_3273 VPWR VGND sg13cmos5l_decap_8
* cell instance sg13cmos5l_decap_8_3274 r0 *1 0,0
Xsg13cmos5l_decap_8_3274 VPWR VGND sg13cmos5l_decap_8
* cell instance sg13cmos5l_decap_8_3275 r0 *1 0,0
Xsg13cmos5l_decap_8_3275 VPWR VGND sg13cmos5l_decap_8
* cell instance sg13cmos5l_decap_8_3276 r0 *1 0,0
Xsg13cmos5l_decap_8_3276 VPWR VGND sg13cmos5l_decap_8
* cell instance sg13cmos5l_decap_8_3277 r0 *1 0,0
Xsg13cmos5l_decap_8_3277 VPWR VGND sg13cmos5l_decap_8
* cell instance sg13cmos5l_decap_8_3278 r0 *1 0,0
Xsg13cmos5l_decap_8_3278 VPWR VGND sg13cmos5l_decap_8
* cell instance sg13cmos5l_decap_8_3279 r0 *1 0,0
Xsg13cmos5l_decap_8_3279 VPWR VGND sg13cmos5l_decap_8
* cell instance sg13cmos5l_decap_8_3280 r0 *1 0,0
Xsg13cmos5l_decap_8_3280 VPWR VGND sg13cmos5l_decap_8
* cell instance sg13cmos5l_decap_8_3281 r0 *1 0,0
Xsg13cmos5l_decap_8_3281 VPWR VGND sg13cmos5l_decap_8
* cell instance sg13cmos5l_decap_8_3282 r0 *1 0,0
Xsg13cmos5l_decap_8_3282 VPWR VGND sg13cmos5l_decap_8
* cell instance sg13cmos5l_decap_8_3283 r0 *1 0,0
Xsg13cmos5l_decap_8_3283 VPWR VGND sg13cmos5l_decap_8
* cell instance sg13cmos5l_decap_8_3284 r0 *1 0,0
Xsg13cmos5l_decap_8_3284 VPWR VGND sg13cmos5l_decap_8
* cell instance sg13cmos5l_decap_8_3285 r0 *1 0,0
Xsg13cmos5l_decap_8_3285 VPWR VGND sg13cmos5l_decap_8
* cell instance sg13cmos5l_decap_8_3286 r0 *1 0,0
Xsg13cmos5l_decap_8_3286 VPWR VGND sg13cmos5l_decap_8
* cell instance sg13cmos5l_decap_8_3287 r0 *1 0,0
Xsg13cmos5l_decap_8_3287 VPWR VGND sg13cmos5l_decap_8
* cell instance sg13cmos5l_decap_8_3288 r0 *1 0,0
Xsg13cmos5l_decap_8_3288 VPWR VGND sg13cmos5l_decap_8
* cell instance sg13cmos5l_decap_8_3289 r0 *1 0,0
Xsg13cmos5l_decap_8_3289 VPWR VGND sg13cmos5l_decap_8
* cell instance sg13cmos5l_decap_8_3290 r0 *1 0,0
Xsg13cmos5l_decap_8_3290 VPWR VGND sg13cmos5l_decap_8
* cell instance sg13cmos5l_decap_8_3291 r0 *1 0,0
Xsg13cmos5l_decap_8_3291 VPWR VGND sg13cmos5l_decap_8
* cell instance sg13cmos5l_decap_8_3292 r0 *1 0,0
Xsg13cmos5l_decap_8_3292 VPWR VGND sg13cmos5l_decap_8
* cell instance sg13cmos5l_decap_8_3293 r0 *1 0,0
Xsg13cmos5l_decap_8_3293 VPWR VGND sg13cmos5l_decap_8
* cell instance sg13cmos5l_decap_8_3294 r0 *1 0,0
Xsg13cmos5l_decap_8_3294 VPWR VGND sg13cmos5l_decap_8
* cell instance sg13cmos5l_decap_8_3295 r0 *1 0,0
Xsg13cmos5l_decap_8_3295 VPWR VGND sg13cmos5l_decap_8
* cell instance sg13cmos5l_decap_8_3296 r0 *1 0,0
Xsg13cmos5l_decap_8_3296 VPWR VGND sg13cmos5l_decap_8
* cell instance sg13cmos5l_decap_8_3297 r0 *1 0,0
Xsg13cmos5l_decap_8_3297 VPWR VGND sg13cmos5l_decap_8
* cell instance sg13cmos5l_decap_8_3298 r0 *1 0,0
Xsg13cmos5l_decap_8_3298 VPWR VGND sg13cmos5l_decap_8
* cell instance sg13cmos5l_decap_8_3299 r0 *1 0,0
Xsg13cmos5l_decap_8_3299 VPWR VGND sg13cmos5l_decap_8
* cell instance sg13cmos5l_decap_8_3300 r0 *1 0,0
Xsg13cmos5l_decap_8_3300 VPWR VGND sg13cmos5l_decap_8
* cell instance sg13cmos5l_decap_8_3301 r0 *1 0,0
Xsg13cmos5l_decap_8_3301 VPWR VGND sg13cmos5l_decap_8
* cell instance sg13cmos5l_decap_8_3302 r0 *1 0,0
Xsg13cmos5l_decap_8_3302 VPWR VGND sg13cmos5l_decap_8
* cell instance sg13cmos5l_decap_8_3303 r0 *1 0,0
Xsg13cmos5l_decap_8_3303 VPWR VGND sg13cmos5l_decap_8
* cell instance sg13cmos5l_decap_8_3304 r0 *1 0,0
Xsg13cmos5l_decap_8_3304 VPWR VGND sg13cmos5l_decap_8
* cell instance sg13cmos5l_decap_8_3305 r0 *1 0,0
Xsg13cmos5l_decap_8_3305 VPWR VGND sg13cmos5l_decap_8
* cell instance sg13cmos5l_decap_8_3306 r0 *1 0,0
Xsg13cmos5l_decap_8_3306 VPWR VGND sg13cmos5l_decap_8
* cell instance sg13cmos5l_decap_8_3307 r0 *1 0,0
Xsg13cmos5l_decap_8_3307 VPWR VGND sg13cmos5l_decap_8
* cell instance sg13cmos5l_decap_8_3308 r0 *1 0,0
Xsg13cmos5l_decap_8_3308 VPWR VGND sg13cmos5l_decap_8
* cell instance sg13cmos5l_decap_8_3309 r0 *1 0,0
Xsg13cmos5l_decap_8_3309 VPWR VGND sg13cmos5l_decap_8
* cell instance sg13cmos5l_decap_8_3310 r0 *1 0,0
Xsg13cmos5l_decap_8_3310 VPWR VGND sg13cmos5l_decap_8
* cell instance sg13cmos5l_decap_8_3311 r0 *1 0,0
Xsg13cmos5l_decap_8_3311 VPWR VGND sg13cmos5l_decap_8
* cell instance sg13cmos5l_decap_8_3312 r0 *1 0,0
Xsg13cmos5l_decap_8_3312 VPWR VGND sg13cmos5l_decap_8
* cell instance sg13cmos5l_decap_8_3313 r0 *1 0,0
Xsg13cmos5l_decap_8_3313 VPWR VGND sg13cmos5l_decap_8
* cell instance sg13cmos5l_decap_8_3314 r0 *1 0,0
Xsg13cmos5l_decap_8_3314 VPWR VGND sg13cmos5l_decap_8
* cell instance sg13cmos5l_decap_8_3315 r0 *1 0,0
Xsg13cmos5l_decap_8_3315 VPWR VGND sg13cmos5l_decap_8
* cell instance sg13cmos5l_decap_8_3316 r0 *1 0,0
Xsg13cmos5l_decap_8_3316 VPWR VGND sg13cmos5l_decap_8
* cell instance sg13cmos5l_decap_8_3317 r0 *1 0,0
Xsg13cmos5l_decap_8_3317 VPWR VGND sg13cmos5l_decap_8
* cell instance sg13cmos5l_decap_8_3318 r0 *1 0,0
Xsg13cmos5l_decap_8_3318 VPWR VGND sg13cmos5l_decap_8
* cell instance sg13cmos5l_decap_8_3319 r0 *1 0,0
Xsg13cmos5l_decap_8_3319 VPWR VGND sg13cmos5l_decap_8
* cell instance sg13cmos5l_decap_8_3320 r0 *1 0,0
Xsg13cmos5l_decap_8_3320 VPWR VGND sg13cmos5l_decap_8
* cell instance sg13cmos5l_decap_8_3321 r0 *1 0,0
Xsg13cmos5l_decap_8_3321 VPWR VGND sg13cmos5l_decap_8
* cell instance sg13cmos5l_decap_8_3322 r0 *1 0,0
Xsg13cmos5l_decap_8_3322 VPWR VGND sg13cmos5l_decap_8
* cell instance sg13cmos5l_decap_8_3323 r0 *1 0,0
Xsg13cmos5l_decap_8_3323 VPWR VGND sg13cmos5l_decap_8
* cell instance sg13cmos5l_decap_8_3324 r0 *1 0,0
Xsg13cmos5l_decap_8_3324 VPWR VGND sg13cmos5l_decap_8
* cell instance sg13cmos5l_decap_8_3325 r0 *1 0,0
Xsg13cmos5l_decap_8_3325 VPWR VGND sg13cmos5l_decap_8
* cell instance sg13cmos5l_decap_8_3326 r0 *1 0,0
Xsg13cmos5l_decap_8_3326 VPWR VGND sg13cmos5l_decap_8
* cell instance sg13cmos5l_decap_8_3327 r0 *1 0,0
Xsg13cmos5l_decap_8_3327 VPWR VGND sg13cmos5l_decap_8
* cell instance sg13cmos5l_decap_8_3328 r0 *1 0,0
Xsg13cmos5l_decap_8_3328 VPWR VGND sg13cmos5l_decap_8
* cell instance sg13cmos5l_decap_8_3329 r0 *1 0,0
Xsg13cmos5l_decap_8_3329 VPWR VGND sg13cmos5l_decap_8
* cell instance sg13cmos5l_decap_8_3330 r0 *1 0,0
Xsg13cmos5l_decap_8_3330 VPWR VGND sg13cmos5l_decap_8
* cell instance sg13cmos5l_decap_8_3331 r0 *1 0,0
Xsg13cmos5l_decap_8_3331 VPWR VGND sg13cmos5l_decap_8
* cell instance sg13cmos5l_decap_8_3332 r0 *1 0,0
Xsg13cmos5l_decap_8_3332 VPWR VGND sg13cmos5l_decap_8
* cell instance sg13cmos5l_decap_8_3333 r0 *1 0,0
Xsg13cmos5l_decap_8_3333 VPWR VGND sg13cmos5l_decap_8
* cell instance sg13cmos5l_decap_8_3334 r0 *1 0,0
Xsg13cmos5l_decap_8_3334 VPWR VGND sg13cmos5l_decap_8
* cell instance sg13cmos5l_decap_8_3335 r0 *1 0,0
Xsg13cmos5l_decap_8_3335 VPWR VGND sg13cmos5l_decap_8
* cell instance sg13cmos5l_decap_8_3336 r0 *1 0,0
Xsg13cmos5l_decap_8_3336 VPWR VGND sg13cmos5l_decap_8
* cell instance sg13cmos5l_decap_8_3337 r0 *1 0,0
Xsg13cmos5l_decap_8_3337 VPWR VGND sg13cmos5l_decap_8
* cell instance sg13cmos5l_decap_8_3338 r0 *1 0,0
Xsg13cmos5l_decap_8_3338 VPWR VGND sg13cmos5l_decap_8
* cell instance sg13cmos5l_decap_8_3339 r0 *1 0,0
Xsg13cmos5l_decap_8_3339 VPWR VGND sg13cmos5l_decap_8
* cell instance sg13cmos5l_decap_8_3340 r0 *1 0,0
Xsg13cmos5l_decap_8_3340 VPWR VGND sg13cmos5l_decap_8
* cell instance sg13cmos5l_decap_8_3341 r0 *1 0,0
Xsg13cmos5l_decap_8_3341 VPWR VGND sg13cmos5l_decap_8
* cell instance sg13cmos5l_decap_8_3342 r0 *1 0,0
Xsg13cmos5l_decap_8_3342 VPWR VGND sg13cmos5l_decap_8
* cell instance sg13cmos5l_decap_8_3343 r0 *1 0,0
Xsg13cmos5l_decap_8_3343 VPWR VGND sg13cmos5l_decap_8
* cell instance sg13cmos5l_decap_8_3344 r0 *1 0,0
Xsg13cmos5l_decap_8_3344 VPWR VGND sg13cmos5l_decap_8
* cell instance sg13cmos5l_decap_8_3345 r0 *1 0,0
Xsg13cmos5l_decap_8_3345 VPWR VGND sg13cmos5l_decap_8
* cell instance sg13cmos5l_decap_8_3346 r0 *1 0,0
Xsg13cmos5l_decap_8_3346 VPWR VGND sg13cmos5l_decap_8
* cell instance sg13cmos5l_decap_8_3347 r0 *1 0,0
Xsg13cmos5l_decap_8_3347 VPWR VGND sg13cmos5l_decap_8
* cell instance sg13cmos5l_decap_8_3348 r0 *1 0,0
Xsg13cmos5l_decap_8_3348 VPWR VGND sg13cmos5l_decap_8
* cell instance sg13cmos5l_decap_8_3349 r0 *1 0,0
Xsg13cmos5l_decap_8_3349 VPWR VGND sg13cmos5l_decap_8
* cell instance sg13cmos5l_decap_8_3350 r0 *1 0,0
Xsg13cmos5l_decap_8_3350 VPWR VGND sg13cmos5l_decap_8
* cell instance sg13cmos5l_decap_8_3351 r0 *1 0,0
Xsg13cmos5l_decap_8_3351 VPWR VGND sg13cmos5l_decap_8
* cell instance sg13cmos5l_decap_8_3352 r0 *1 0,0
Xsg13cmos5l_decap_8_3352 VPWR VGND sg13cmos5l_decap_8
* cell instance sg13cmos5l_decap_8_3353 r0 *1 0,0
Xsg13cmos5l_decap_8_3353 VPWR VGND sg13cmos5l_decap_8
* cell instance sg13cmos5l_decap_8_3354 r0 *1 0,0
Xsg13cmos5l_decap_8_3354 VPWR VGND sg13cmos5l_decap_8
* cell instance sg13cmos5l_decap_8_3355 r0 *1 0,0
Xsg13cmos5l_decap_8_3355 VPWR VGND sg13cmos5l_decap_8
* cell instance sg13cmos5l_decap_8_3356 r0 *1 0,0
Xsg13cmos5l_decap_8_3356 VPWR VGND sg13cmos5l_decap_8
* cell instance sg13cmos5l_decap_8_3357 r0 *1 0,0
Xsg13cmos5l_decap_8_3357 VPWR VGND sg13cmos5l_decap_8
* cell instance sg13cmos5l_decap_8_3358 r0 *1 0,0
Xsg13cmos5l_decap_8_3358 VPWR VGND sg13cmos5l_decap_8
* cell instance sg13cmos5l_decap_8_3359 r0 *1 0,0
Xsg13cmos5l_decap_8_3359 VPWR VGND sg13cmos5l_decap_8
* cell instance sg13cmos5l_decap_8_3360 r0 *1 0,0
Xsg13cmos5l_decap_8_3360 VPWR VGND sg13cmos5l_decap_8
* cell instance sg13cmos5l_decap_8_3361 r0 *1 0,0
Xsg13cmos5l_decap_8_3361 VPWR VGND sg13cmos5l_decap_8
* cell instance sg13cmos5l_decap_8_3362 r0 *1 0,0
Xsg13cmos5l_decap_8_3362 VPWR VGND sg13cmos5l_decap_8
* cell instance sg13cmos5l_decap_8_3363 r0 *1 0,0
Xsg13cmos5l_decap_8_3363 VPWR VGND sg13cmos5l_decap_8
* cell instance sg13cmos5l_decap_8_3364 r0 *1 0,0
Xsg13cmos5l_decap_8_3364 VPWR VGND sg13cmos5l_decap_8
* cell instance sg13cmos5l_decap_8_3365 r0 *1 0,0
Xsg13cmos5l_decap_8_3365 VPWR VGND sg13cmos5l_decap_8
* cell instance sg13cmos5l_decap_8_3366 r0 *1 0,0
Xsg13cmos5l_decap_8_3366 VPWR VGND sg13cmos5l_decap_8
* cell instance sg13cmos5l_decap_8_3367 r0 *1 0,0
Xsg13cmos5l_decap_8_3367 VPWR VGND sg13cmos5l_decap_8
* cell instance sg13cmos5l_decap_8_3368 r0 *1 0,0
Xsg13cmos5l_decap_8_3368 VPWR VGND sg13cmos5l_decap_8
* cell instance sg13cmos5l_decap_8_3369 r0 *1 0,0
Xsg13cmos5l_decap_8_3369 VPWR VGND sg13cmos5l_decap_8
* cell instance sg13cmos5l_decap_8_3370 r0 *1 0,0
Xsg13cmos5l_decap_8_3370 VPWR VGND sg13cmos5l_decap_8
* cell instance sg13cmos5l_decap_8_3371 r0 *1 0,0
Xsg13cmos5l_decap_8_3371 VPWR VGND sg13cmos5l_decap_8
* cell instance sg13cmos5l_decap_8_3372 r0 *1 0,0
Xsg13cmos5l_decap_8_3372 VPWR VGND sg13cmos5l_decap_8
* cell instance sg13cmos5l_decap_8_3373 r0 *1 0,0
Xsg13cmos5l_decap_8_3373 VPWR VGND sg13cmos5l_decap_8
* cell instance sg13cmos5l_decap_8_3374 r0 *1 0,0
Xsg13cmos5l_decap_8_3374 VPWR VGND sg13cmos5l_decap_8
* cell instance sg13cmos5l_decap_8_3375 r0 *1 0,0
Xsg13cmos5l_decap_8_3375 VPWR VGND sg13cmos5l_decap_8
* cell instance sg13cmos5l_decap_8_3376 r0 *1 0,0
Xsg13cmos5l_decap_8_3376 VPWR VGND sg13cmos5l_decap_8
* cell instance sg13cmos5l_decap_8_3377 r0 *1 0,0
Xsg13cmos5l_decap_8_3377 VPWR VGND sg13cmos5l_decap_8
* cell instance sg13cmos5l_decap_8_3378 r0 *1 0,0
Xsg13cmos5l_decap_8_3378 VPWR VGND sg13cmos5l_decap_8
* cell instance sg13cmos5l_decap_8_3379 r0 *1 0,0
Xsg13cmos5l_decap_8_3379 VPWR VGND sg13cmos5l_decap_8
* cell instance sg13cmos5l_decap_8_3380 r0 *1 0,0
Xsg13cmos5l_decap_8_3380 VPWR VGND sg13cmos5l_decap_8
* cell instance sg13cmos5l_decap_8_3381 r0 *1 0,0
Xsg13cmos5l_decap_8_3381 VPWR VGND sg13cmos5l_decap_8
* cell instance sg13cmos5l_decap_8_3382 r0 *1 0,0
Xsg13cmos5l_decap_8_3382 VPWR VGND sg13cmos5l_decap_8
* cell instance sg13cmos5l_decap_8_3383 r0 *1 0,0
Xsg13cmos5l_decap_8_3383 VPWR VGND sg13cmos5l_decap_8
* cell instance sg13cmos5l_decap_8_3384 r0 *1 0,0
Xsg13cmos5l_decap_8_3384 VPWR VGND sg13cmos5l_decap_8
* cell instance sg13cmos5l_decap_8_3385 r0 *1 0,0
Xsg13cmos5l_decap_8_3385 VPWR VGND sg13cmos5l_decap_8
* cell instance sg13cmos5l_decap_8_3386 r0 *1 0,0
Xsg13cmos5l_decap_8_3386 VPWR VGND sg13cmos5l_decap_8
* cell instance sg13cmos5l_decap_8_3387 r0 *1 0,0
Xsg13cmos5l_decap_8_3387 VPWR VGND sg13cmos5l_decap_8
* cell instance sg13cmos5l_decap_8_3388 r0 *1 0,0
Xsg13cmos5l_decap_8_3388 VPWR VGND sg13cmos5l_decap_8
* cell instance sg13cmos5l_decap_8_3389 r0 *1 0,0
Xsg13cmos5l_decap_8_3389 VPWR VGND sg13cmos5l_decap_8
* cell instance sg13cmos5l_decap_8_3390 r0 *1 0,0
Xsg13cmos5l_decap_8_3390 VPWR VGND sg13cmos5l_decap_8
* cell instance sg13cmos5l_decap_8_3391 r0 *1 0,0
Xsg13cmos5l_decap_8_3391 VPWR VGND sg13cmos5l_decap_8
* cell instance sg13cmos5l_decap_8_3392 r0 *1 0,0
Xsg13cmos5l_decap_8_3392 VPWR VGND sg13cmos5l_decap_8
* cell instance sg13cmos5l_decap_8_3393 r0 *1 0,0
Xsg13cmos5l_decap_8_3393 VPWR VGND sg13cmos5l_decap_8
* cell instance sg13cmos5l_decap_8_3394 r0 *1 0,0
Xsg13cmos5l_decap_8_3394 VPWR VGND sg13cmos5l_decap_8
* cell instance sg13cmos5l_decap_8_3395 r0 *1 0,0
Xsg13cmos5l_decap_8_3395 VPWR VGND sg13cmos5l_decap_8
* cell instance sg13cmos5l_decap_8_3396 r0 *1 0,0
Xsg13cmos5l_decap_8_3396 VPWR VGND sg13cmos5l_decap_8
* cell instance sg13cmos5l_decap_8_3397 r0 *1 0,0
Xsg13cmos5l_decap_8_3397 VPWR VGND sg13cmos5l_decap_8
* cell instance sg13cmos5l_decap_8_3398 r0 *1 0,0
Xsg13cmos5l_decap_8_3398 VPWR VGND sg13cmos5l_decap_8
* cell instance sg13cmos5l_decap_8_3399 r0 *1 0,0
Xsg13cmos5l_decap_8_3399 VPWR VGND sg13cmos5l_decap_8
* cell instance sg13cmos5l_decap_8_3400 r0 *1 0,0
Xsg13cmos5l_decap_8_3400 VPWR VGND sg13cmos5l_decap_8
* cell instance sg13cmos5l_decap_8_3401 r0 *1 0,0
Xsg13cmos5l_decap_8_3401 VPWR VGND sg13cmos5l_decap_8
* cell instance sg13cmos5l_decap_8_3402 r0 *1 0,0
Xsg13cmos5l_decap_8_3402 VPWR VGND sg13cmos5l_decap_8
* cell instance sg13cmos5l_decap_8_3403 r0 *1 0,0
Xsg13cmos5l_decap_8_3403 VPWR VGND sg13cmos5l_decap_8
* cell instance sg13cmos5l_decap_8_3404 r0 *1 0,0
Xsg13cmos5l_decap_8_3404 VPWR VGND sg13cmos5l_decap_8
* cell instance sg13cmos5l_decap_8_3405 r0 *1 0,0
Xsg13cmos5l_decap_8_3405 VPWR VGND sg13cmos5l_decap_8
* cell instance sg13cmos5l_decap_8_3406 r0 *1 0,0
Xsg13cmos5l_decap_8_3406 VPWR VGND sg13cmos5l_decap_8
* cell instance sg13cmos5l_decap_8_3407 r0 *1 0,0
Xsg13cmos5l_decap_8_3407 VPWR VGND sg13cmos5l_decap_8
* cell instance sg13cmos5l_decap_8_3408 r0 *1 0,0
Xsg13cmos5l_decap_8_3408 VPWR VGND sg13cmos5l_decap_8
* cell instance sg13cmos5l_decap_8_3409 r0 *1 0,0
Xsg13cmos5l_decap_8_3409 VPWR VGND sg13cmos5l_decap_8
* cell instance sg13cmos5l_decap_8_3410 r0 *1 0,0
Xsg13cmos5l_decap_8_3410 VPWR VGND sg13cmos5l_decap_8
* cell instance sg13cmos5l_decap_8_3411 r0 *1 0,0
Xsg13cmos5l_decap_8_3411 VPWR VGND sg13cmos5l_decap_8
* cell instance sg13cmos5l_decap_8_3412 r0 *1 0,0
Xsg13cmos5l_decap_8_3412 VPWR VGND sg13cmos5l_decap_8
* cell instance sg13cmos5l_decap_8_3413 r0 *1 0,0
Xsg13cmos5l_decap_8_3413 VPWR VGND sg13cmos5l_decap_8
* cell instance sg13cmos5l_decap_8_3414 r0 *1 0,0
Xsg13cmos5l_decap_8_3414 VPWR VGND sg13cmos5l_decap_8
* cell instance sg13cmos5l_decap_8_3415 r0 *1 0,0
Xsg13cmos5l_decap_8_3415 VPWR VGND sg13cmos5l_decap_8
* cell instance sg13cmos5l_decap_8_3416 r0 *1 0,0
Xsg13cmos5l_decap_8_3416 VPWR VGND sg13cmos5l_decap_8
* cell instance sg13cmos5l_decap_8_3417 r0 *1 0,0
Xsg13cmos5l_decap_8_3417 VPWR VGND sg13cmos5l_decap_8
* cell instance sg13cmos5l_decap_8_3418 r0 *1 0,0
Xsg13cmos5l_decap_8_3418 VPWR VGND sg13cmos5l_decap_8
* cell instance sg13cmos5l_decap_8_3419 r0 *1 0,0
Xsg13cmos5l_decap_8_3419 VPWR VGND sg13cmos5l_decap_8
* cell instance sg13cmos5l_decap_8_3420 r0 *1 0,0
Xsg13cmos5l_decap_8_3420 VPWR VGND sg13cmos5l_decap_8
* cell instance sg13cmos5l_decap_8_3421 r0 *1 0,0
Xsg13cmos5l_decap_8_3421 VPWR VGND sg13cmos5l_decap_8
* cell instance sg13cmos5l_decap_8_3422 r0 *1 0,0
Xsg13cmos5l_decap_8_3422 VPWR VGND sg13cmos5l_decap_8
* cell instance sg13cmos5l_decap_8_3423 r0 *1 0,0
Xsg13cmos5l_decap_8_3423 VPWR VGND sg13cmos5l_decap_8
* cell instance sg13cmos5l_decap_8_3424 r0 *1 0,0
Xsg13cmos5l_decap_8_3424 VPWR VGND sg13cmos5l_decap_8
* cell instance sg13cmos5l_decap_8_3425 r0 *1 0,0
Xsg13cmos5l_decap_8_3425 VPWR VGND sg13cmos5l_decap_8
* cell instance sg13cmos5l_decap_8_3426 r0 *1 0,0
Xsg13cmos5l_decap_8_3426 VPWR VGND sg13cmos5l_decap_8
* cell instance sg13cmos5l_decap_8_3427 r0 *1 0,0
Xsg13cmos5l_decap_8_3427 VPWR VGND sg13cmos5l_decap_8
* cell instance sg13cmos5l_decap_8_3428 r0 *1 0,0
Xsg13cmos5l_decap_8_3428 VPWR VGND sg13cmos5l_decap_8
* cell instance sg13cmos5l_decap_8_3429 r0 *1 0,0
Xsg13cmos5l_decap_8_3429 VPWR VGND sg13cmos5l_decap_8
* cell instance sg13cmos5l_decap_8_3430 r0 *1 0,0
Xsg13cmos5l_decap_8_3430 VPWR VGND sg13cmos5l_decap_8
* cell instance sg13cmos5l_decap_8_3431 r0 *1 0,0
Xsg13cmos5l_decap_8_3431 VPWR VGND sg13cmos5l_decap_8
* cell instance sg13cmos5l_decap_8_3432 r0 *1 0,0
Xsg13cmos5l_decap_8_3432 VPWR VGND sg13cmos5l_decap_8
* cell instance sg13cmos5l_decap_8_3433 r0 *1 0,0
Xsg13cmos5l_decap_8_3433 VPWR VGND sg13cmos5l_decap_8
* cell instance sg13cmos5l_decap_8_3434 r0 *1 0,0
Xsg13cmos5l_decap_8_3434 VPWR VGND sg13cmos5l_decap_8
* cell instance sg13cmos5l_decap_8_3435 r0 *1 0,0
Xsg13cmos5l_decap_8_3435 VPWR VGND sg13cmos5l_decap_8
* cell instance sg13cmos5l_decap_8_3436 r0 *1 0,0
Xsg13cmos5l_decap_8_3436 VPWR VGND sg13cmos5l_decap_8
* cell instance sg13cmos5l_decap_8_3437 r0 *1 0,0
Xsg13cmos5l_decap_8_3437 VPWR VGND sg13cmos5l_decap_8
* cell instance sg13cmos5l_decap_8_3438 r0 *1 0,0
Xsg13cmos5l_decap_8_3438 VPWR VGND sg13cmos5l_decap_8
* cell instance sg13cmos5l_decap_8_3439 r0 *1 0,0
Xsg13cmos5l_decap_8_3439 VPWR VGND sg13cmos5l_decap_8
* cell instance sg13cmos5l_decap_8_3440 r0 *1 0,0
Xsg13cmos5l_decap_8_3440 VPWR VGND sg13cmos5l_decap_8
* cell instance sg13cmos5l_decap_8_3441 r0 *1 0,0
Xsg13cmos5l_decap_8_3441 VPWR VGND sg13cmos5l_decap_8
* cell instance sg13cmos5l_decap_8_3442 r0 *1 0,0
Xsg13cmos5l_decap_8_3442 VPWR VGND sg13cmos5l_decap_8
* cell instance sg13cmos5l_decap_8_3443 r0 *1 0,0
Xsg13cmos5l_decap_8_3443 VPWR VGND sg13cmos5l_decap_8
* cell instance sg13cmos5l_decap_8_3444 r0 *1 0,0
Xsg13cmos5l_decap_8_3444 VPWR VGND sg13cmos5l_decap_8
* cell instance sg13cmos5l_decap_8_3445 r0 *1 0,0
Xsg13cmos5l_decap_8_3445 VPWR VGND sg13cmos5l_decap_8
* cell instance sg13cmos5l_decap_8_3446 r0 *1 0,0
Xsg13cmos5l_decap_8_3446 VPWR VGND sg13cmos5l_decap_8
* cell instance sg13cmos5l_decap_8_3447 r0 *1 0,0
Xsg13cmos5l_decap_8_3447 VPWR VGND sg13cmos5l_decap_8
* cell instance sg13cmos5l_decap_8_3448 r0 *1 0,0
Xsg13cmos5l_decap_8_3448 VPWR VGND sg13cmos5l_decap_8
* cell instance sg13cmos5l_decap_8_3449 r0 *1 0,0
Xsg13cmos5l_decap_8_3449 VPWR VGND sg13cmos5l_decap_8
* cell instance sg13cmos5l_decap_8_3450 r0 *1 0,0
Xsg13cmos5l_decap_8_3450 VPWR VGND sg13cmos5l_decap_8
* cell instance sg13cmos5l_decap_8_3451 r0 *1 0,0
Xsg13cmos5l_decap_8_3451 VPWR VGND sg13cmos5l_decap_8
* cell instance sg13cmos5l_decap_8_3452 r0 *1 0,0
Xsg13cmos5l_decap_8_3452 VPWR VGND sg13cmos5l_decap_8
* cell instance sg13cmos5l_decap_8_3453 r0 *1 0,0
Xsg13cmos5l_decap_8_3453 VPWR VGND sg13cmos5l_decap_8
* cell instance sg13cmos5l_decap_8_3454 r0 *1 0,0
Xsg13cmos5l_decap_8_3454 VPWR VGND sg13cmos5l_decap_8
* cell instance sg13cmos5l_decap_8_3455 r0 *1 0,0
Xsg13cmos5l_decap_8_3455 VPWR VGND sg13cmos5l_decap_8
* cell instance sg13cmos5l_decap_8_3456 r0 *1 0,0
Xsg13cmos5l_decap_8_3456 VPWR VGND sg13cmos5l_decap_8
* cell instance sg13cmos5l_decap_8_3457 r0 *1 0,0
Xsg13cmos5l_decap_8_3457 VPWR VGND sg13cmos5l_decap_8
* cell instance sg13cmos5l_decap_8_3458 r0 *1 0,0
Xsg13cmos5l_decap_8_3458 VPWR VGND sg13cmos5l_decap_8
* cell instance sg13cmos5l_decap_8_3459 r0 *1 0,0
Xsg13cmos5l_decap_8_3459 VPWR VGND sg13cmos5l_decap_8
* cell instance sg13cmos5l_decap_8_3460 r0 *1 0,0
Xsg13cmos5l_decap_8_3460 VPWR VGND sg13cmos5l_decap_8
* cell instance sg13cmos5l_decap_8_3461 r0 *1 0,0
Xsg13cmos5l_decap_8_3461 VPWR VGND sg13cmos5l_decap_8
* cell instance sg13cmos5l_decap_8_3462 r0 *1 0,0
Xsg13cmos5l_decap_8_3462 VPWR VGND sg13cmos5l_decap_8
* cell instance sg13cmos5l_decap_8_3463 r0 *1 0,0
Xsg13cmos5l_decap_8_3463 VPWR VGND sg13cmos5l_decap_8
* cell instance sg13cmos5l_decap_8_3464 r0 *1 0,0
Xsg13cmos5l_decap_8_3464 VPWR VGND sg13cmos5l_decap_8
* cell instance sg13cmos5l_decap_8_3465 r0 *1 0,0
Xsg13cmos5l_decap_8_3465 VPWR VGND sg13cmos5l_decap_8
* cell instance sg13cmos5l_decap_8_3466 r0 *1 0,0
Xsg13cmos5l_decap_8_3466 VPWR VGND sg13cmos5l_decap_8
* cell instance sg13cmos5l_decap_8_3467 r0 *1 0,0
Xsg13cmos5l_decap_8_3467 VPWR VGND sg13cmos5l_decap_8
* cell instance sg13cmos5l_decap_8_3468 r0 *1 0,0
Xsg13cmos5l_decap_8_3468 VPWR VGND sg13cmos5l_decap_8
* cell instance sg13cmos5l_decap_8_3469 r0 *1 0,0
Xsg13cmos5l_decap_8_3469 VPWR VGND sg13cmos5l_decap_8
* cell instance sg13cmos5l_decap_8_3470 r0 *1 0,0
Xsg13cmos5l_decap_8_3470 VPWR VGND sg13cmos5l_decap_8
* cell instance sg13cmos5l_decap_8_3471 r0 *1 0,0
Xsg13cmos5l_decap_8_3471 VPWR VGND sg13cmos5l_decap_8
* cell instance sg13cmos5l_decap_8_3472 r0 *1 0,0
Xsg13cmos5l_decap_8_3472 VPWR VGND sg13cmos5l_decap_8
* cell instance sg13cmos5l_decap_8_3473 r0 *1 0,0
Xsg13cmos5l_decap_8_3473 VPWR VGND sg13cmos5l_decap_8
* cell instance sg13cmos5l_decap_8_3474 r0 *1 0,0
Xsg13cmos5l_decap_8_3474 VPWR VGND sg13cmos5l_decap_8
* cell instance sg13cmos5l_decap_8_3475 r0 *1 0,0
Xsg13cmos5l_decap_8_3475 VPWR VGND sg13cmos5l_decap_8
* cell instance sg13cmos5l_decap_8_3476 r0 *1 0,0
Xsg13cmos5l_decap_8_3476 VPWR VGND sg13cmos5l_decap_8
* cell instance sg13cmos5l_decap_8_3477 r0 *1 0,0
Xsg13cmos5l_decap_8_3477 VPWR VGND sg13cmos5l_decap_8
* cell instance sg13cmos5l_decap_8_3478 r0 *1 0,0
Xsg13cmos5l_decap_8_3478 VPWR VGND sg13cmos5l_decap_8
* cell instance sg13cmos5l_decap_8_3479 r0 *1 0,0
Xsg13cmos5l_decap_8_3479 VPWR VGND sg13cmos5l_decap_8
* cell instance sg13cmos5l_decap_8_3480 r0 *1 0,0
Xsg13cmos5l_decap_8_3480 VPWR VGND sg13cmos5l_decap_8
* cell instance sg13cmos5l_decap_8_3481 r0 *1 0,0
Xsg13cmos5l_decap_8_3481 VPWR VGND sg13cmos5l_decap_8
* cell instance sg13cmos5l_decap_8_3482 r0 *1 0,0
Xsg13cmos5l_decap_8_3482 VPWR VGND sg13cmos5l_decap_8
* cell instance sg13cmos5l_decap_8_3483 r0 *1 0,0
Xsg13cmos5l_decap_8_3483 VPWR VGND sg13cmos5l_decap_8
* cell instance sg13cmos5l_decap_8_3484 r0 *1 0,0
Xsg13cmos5l_decap_8_3484 VPWR VGND sg13cmos5l_decap_8
* cell instance sg13cmos5l_decap_8_3485 r0 *1 0,0
Xsg13cmos5l_decap_8_3485 VPWR VGND sg13cmos5l_decap_8
* cell instance sg13cmos5l_decap_8_3486 r0 *1 0,0
Xsg13cmos5l_decap_8_3486 VPWR VGND sg13cmos5l_decap_8
* cell instance sg13cmos5l_decap_8_3487 r0 *1 0,0
Xsg13cmos5l_decap_8_3487 VPWR VGND sg13cmos5l_decap_8
* cell instance sg13cmos5l_decap_8_3488 r0 *1 0,0
Xsg13cmos5l_decap_8_3488 VPWR VGND sg13cmos5l_decap_8
* cell instance sg13cmos5l_decap_8_3489 r0 *1 0,0
Xsg13cmos5l_decap_8_3489 VPWR VGND sg13cmos5l_decap_8
* cell instance sg13cmos5l_decap_8_3490 r0 *1 0,0
Xsg13cmos5l_decap_8_3490 VPWR VGND sg13cmos5l_decap_8
* cell instance sg13cmos5l_decap_8_3491 r0 *1 0,0
Xsg13cmos5l_decap_8_3491 VPWR VGND sg13cmos5l_decap_8
* cell instance sg13cmos5l_decap_8_3492 r0 *1 0,0
Xsg13cmos5l_decap_8_3492 VPWR VGND sg13cmos5l_decap_8
* cell instance sg13cmos5l_decap_8_3493 r0 *1 0,0
Xsg13cmos5l_decap_8_3493 VPWR VGND sg13cmos5l_decap_8
* cell instance sg13cmos5l_decap_8_3494 r0 *1 0,0
Xsg13cmos5l_decap_8_3494 VPWR VGND sg13cmos5l_decap_8
* cell instance sg13cmos5l_decap_8_3495 r0 *1 0,0
Xsg13cmos5l_decap_8_3495 VPWR VGND sg13cmos5l_decap_8
* cell instance sg13cmos5l_decap_8_3496 r0 *1 0,0
Xsg13cmos5l_decap_8_3496 VPWR VGND sg13cmos5l_decap_8
* cell instance sg13cmos5l_decap_8_3497 r0 *1 0,0
Xsg13cmos5l_decap_8_3497 VPWR VGND sg13cmos5l_decap_8
* cell instance sg13cmos5l_decap_8_3498 r0 *1 0,0
Xsg13cmos5l_decap_8_3498 VPWR VGND sg13cmos5l_decap_8
* cell instance sg13cmos5l_decap_8_3499 r0 *1 0,0
Xsg13cmos5l_decap_8_3499 VPWR VGND sg13cmos5l_decap_8
* cell instance sg13cmos5l_decap_8_3500 r0 *1 0,0
Xsg13cmos5l_decap_8_3500 VPWR VGND sg13cmos5l_decap_8
* cell instance sg13cmos5l_decap_8_3501 r0 *1 0,0
Xsg13cmos5l_decap_8_3501 VPWR VGND sg13cmos5l_decap_8
* cell instance sg13cmos5l_decap_8_3502 r0 *1 0,0
Xsg13cmos5l_decap_8_3502 VPWR VGND sg13cmos5l_decap_8
* cell instance sg13cmos5l_decap_8_3503 r0 *1 0,0
Xsg13cmos5l_decap_8_3503 VPWR VGND sg13cmos5l_decap_8
* cell instance sg13cmos5l_decap_8_3504 r0 *1 0,0
Xsg13cmos5l_decap_8_3504 VPWR VGND sg13cmos5l_decap_8
* cell instance sg13cmos5l_decap_8_3505 r0 *1 0,0
Xsg13cmos5l_decap_8_3505 VPWR VGND sg13cmos5l_decap_8
* cell instance sg13cmos5l_decap_8_3506 r0 *1 0,0
Xsg13cmos5l_decap_8_3506 VPWR VGND sg13cmos5l_decap_8
* cell instance sg13cmos5l_decap_8_3507 r0 *1 0,0
Xsg13cmos5l_decap_8_3507 VPWR VGND sg13cmos5l_decap_8
* cell instance sg13cmos5l_decap_8_3508 r0 *1 0,0
Xsg13cmos5l_decap_8_3508 VPWR VGND sg13cmos5l_decap_8
* cell instance sg13cmos5l_decap_8_3509 r0 *1 0,0
Xsg13cmos5l_decap_8_3509 VPWR VGND sg13cmos5l_decap_8
* cell instance sg13cmos5l_decap_8_3510 r0 *1 0,0
Xsg13cmos5l_decap_8_3510 VPWR VGND sg13cmos5l_decap_8
* cell instance sg13cmos5l_decap_8_3511 r0 *1 0,0
Xsg13cmos5l_decap_8_3511 VPWR VGND sg13cmos5l_decap_8
* cell instance sg13cmos5l_decap_8_3512 r0 *1 0,0
Xsg13cmos5l_decap_8_3512 VPWR VGND sg13cmos5l_decap_8
* cell instance sg13cmos5l_decap_8_3513 r0 *1 0,0
Xsg13cmos5l_decap_8_3513 VPWR VGND sg13cmos5l_decap_8
* cell instance sg13cmos5l_decap_8_3514 r0 *1 0,0
Xsg13cmos5l_decap_8_3514 VPWR VGND sg13cmos5l_decap_8
* cell instance sg13cmos5l_decap_8_3515 r0 *1 0,0
Xsg13cmos5l_decap_8_3515 VPWR VGND sg13cmos5l_decap_8
* cell instance sg13cmos5l_decap_8_3516 r0 *1 0,0
Xsg13cmos5l_decap_8_3516 VPWR VGND sg13cmos5l_decap_8
* cell instance sg13cmos5l_decap_8_3517 r0 *1 0,0
Xsg13cmos5l_decap_8_3517 VPWR VGND sg13cmos5l_decap_8
* cell instance sg13cmos5l_decap_8_3518 r0 *1 0,0
Xsg13cmos5l_decap_8_3518 VPWR VGND sg13cmos5l_decap_8
* cell instance sg13cmos5l_decap_8_3519 r0 *1 0,0
Xsg13cmos5l_decap_8_3519 VPWR VGND sg13cmos5l_decap_8
* cell instance sg13cmos5l_decap_8_3520 r0 *1 0,0
Xsg13cmos5l_decap_8_3520 VPWR VGND sg13cmos5l_decap_8
* cell instance sg13cmos5l_decap_8_3521 r0 *1 0,0
Xsg13cmos5l_decap_8_3521 VPWR VGND sg13cmos5l_decap_8
* cell instance sg13cmos5l_decap_8_3522 r0 *1 0,0
Xsg13cmos5l_decap_8_3522 VPWR VGND sg13cmos5l_decap_8
* cell instance sg13cmos5l_decap_8_3523 r0 *1 0,0
Xsg13cmos5l_decap_8_3523 VPWR VGND sg13cmos5l_decap_8
* cell instance sg13cmos5l_decap_8_3524 r0 *1 0,0
Xsg13cmos5l_decap_8_3524 VPWR VGND sg13cmos5l_decap_8
* cell instance sg13cmos5l_decap_8_3525 r0 *1 0,0
Xsg13cmos5l_decap_8_3525 VPWR VGND sg13cmos5l_decap_8
* cell instance sg13cmos5l_decap_8_3526 r0 *1 0,0
Xsg13cmos5l_decap_8_3526 VPWR VGND sg13cmos5l_decap_8
* cell instance sg13cmos5l_decap_8_3527 r0 *1 0,0
Xsg13cmos5l_decap_8_3527 VPWR VGND sg13cmos5l_decap_8
* cell instance sg13cmos5l_decap_8_3528 r0 *1 0,0
Xsg13cmos5l_decap_8_3528 VPWR VGND sg13cmos5l_decap_8
* cell instance sg13cmos5l_decap_8_3529 r0 *1 0,0
Xsg13cmos5l_decap_8_3529 VPWR VGND sg13cmos5l_decap_8
* cell instance sg13cmos5l_decap_8_3530 r0 *1 0,0
Xsg13cmos5l_decap_8_3530 VPWR VGND sg13cmos5l_decap_8
* cell instance sg13cmos5l_decap_8_3531 r0 *1 0,0
Xsg13cmos5l_decap_8_3531 VPWR VGND sg13cmos5l_decap_8
* cell instance sg13cmos5l_decap_8_3532 r0 *1 0,0
Xsg13cmos5l_decap_8_3532 VPWR VGND sg13cmos5l_decap_8
* cell instance sg13cmos5l_decap_8_3533 r0 *1 0,0
Xsg13cmos5l_decap_8_3533 VPWR VGND sg13cmos5l_decap_8
* cell instance sg13cmos5l_decap_8_3534 r0 *1 0,0
Xsg13cmos5l_decap_8_3534 VPWR VGND sg13cmos5l_decap_8
* cell instance sg13cmos5l_decap_8_3535 r0 *1 0,0
Xsg13cmos5l_decap_8_3535 VPWR VGND sg13cmos5l_decap_8
* cell instance sg13cmos5l_decap_8_3536 r0 *1 0,0
Xsg13cmos5l_decap_8_3536 VPWR VGND sg13cmos5l_decap_8
* cell instance sg13cmos5l_decap_8_3537 r0 *1 0,0
Xsg13cmos5l_decap_8_3537 VPWR VGND sg13cmos5l_decap_8
* cell instance sg13cmos5l_decap_8_3538 r0 *1 0,0
Xsg13cmos5l_decap_8_3538 VPWR VGND sg13cmos5l_decap_8
* cell instance sg13cmos5l_decap_8_3539 r0 *1 0,0
Xsg13cmos5l_decap_8_3539 VPWR VGND sg13cmos5l_decap_8
* cell instance sg13cmos5l_decap_8_3540 r0 *1 0,0
Xsg13cmos5l_decap_8_3540 VPWR VGND sg13cmos5l_decap_8
* cell instance sg13cmos5l_decap_8_3541 r0 *1 0,0
Xsg13cmos5l_decap_8_3541 VPWR VGND sg13cmos5l_decap_8
* cell instance sg13cmos5l_decap_8_3542 r0 *1 0,0
Xsg13cmos5l_decap_8_3542 VPWR VGND sg13cmos5l_decap_8
* cell instance sg13cmos5l_decap_8_3543 r0 *1 0,0
Xsg13cmos5l_decap_8_3543 VPWR VGND sg13cmos5l_decap_8
* cell instance sg13cmos5l_decap_8_3544 r0 *1 0,0
Xsg13cmos5l_decap_8_3544 VPWR VGND sg13cmos5l_decap_8
* cell instance sg13cmos5l_decap_8_3545 r0 *1 0,0
Xsg13cmos5l_decap_8_3545 VPWR VGND sg13cmos5l_decap_8
* cell instance sg13cmos5l_decap_8_3546 r0 *1 0,0
Xsg13cmos5l_decap_8_3546 VPWR VGND sg13cmos5l_decap_8
* cell instance sg13cmos5l_decap_8_3547 r0 *1 0,0
Xsg13cmos5l_decap_8_3547 VPWR VGND sg13cmos5l_decap_8
* cell instance sg13cmos5l_decap_8_3548 r0 *1 0,0
Xsg13cmos5l_decap_8_3548 VPWR VGND sg13cmos5l_decap_8
* cell instance sg13cmos5l_decap_8_3549 r0 *1 0,0
Xsg13cmos5l_decap_8_3549 VPWR VGND sg13cmos5l_decap_8
* cell instance sg13cmos5l_decap_8_3550 r0 *1 0,0
Xsg13cmos5l_decap_8_3550 VPWR VGND sg13cmos5l_decap_8
* cell instance sg13cmos5l_decap_8_3551 r0 *1 0,0
Xsg13cmos5l_decap_8_3551 VPWR VGND sg13cmos5l_decap_8
* cell instance sg13cmos5l_decap_8_3552 r0 *1 0,0
Xsg13cmos5l_decap_8_3552 VPWR VGND sg13cmos5l_decap_8
* cell instance sg13cmos5l_decap_8_3553 r0 *1 0,0
Xsg13cmos5l_decap_8_3553 VPWR VGND sg13cmos5l_decap_8
* cell instance sg13cmos5l_decap_8_3554 r0 *1 0,0
Xsg13cmos5l_decap_8_3554 VPWR VGND sg13cmos5l_decap_8
* cell instance sg13cmos5l_decap_8_3555 r0 *1 0,0
Xsg13cmos5l_decap_8_3555 VPWR VGND sg13cmos5l_decap_8
* cell instance sg13cmos5l_decap_8_3556 r0 *1 0,0
Xsg13cmos5l_decap_8_3556 VPWR VGND sg13cmos5l_decap_8
* cell instance sg13cmos5l_decap_8_3557 r0 *1 0,0
Xsg13cmos5l_decap_8_3557 VPWR VGND sg13cmos5l_decap_8
* cell instance sg13cmos5l_decap_8_3558 r0 *1 0,0
Xsg13cmos5l_decap_8_3558 VPWR VGND sg13cmos5l_decap_8
* cell instance sg13cmos5l_decap_8_3559 r0 *1 0,0
Xsg13cmos5l_decap_8_3559 VPWR VGND sg13cmos5l_decap_8
* cell instance sg13cmos5l_decap_8_3560 r0 *1 0,0
Xsg13cmos5l_decap_8_3560 VPWR VGND sg13cmos5l_decap_8
* cell instance sg13cmos5l_decap_8_3561 r0 *1 0,0
Xsg13cmos5l_decap_8_3561 VPWR VGND sg13cmos5l_decap_8
* cell instance sg13cmos5l_decap_8_3562 r0 *1 0,0
Xsg13cmos5l_decap_8_3562 VPWR VGND sg13cmos5l_decap_8
* cell instance sg13cmos5l_decap_8_3563 r0 *1 0,0
Xsg13cmos5l_decap_8_3563 VPWR VGND sg13cmos5l_decap_8
* cell instance sg13cmos5l_decap_8_3564 r0 *1 0,0
Xsg13cmos5l_decap_8_3564 VPWR VGND sg13cmos5l_decap_8
* cell instance sg13cmos5l_decap_8_3565 r0 *1 0,0
Xsg13cmos5l_decap_8_3565 VPWR VGND sg13cmos5l_decap_8
* cell instance sg13cmos5l_decap_8_3566 r0 *1 0,0
Xsg13cmos5l_decap_8_3566 VPWR VGND sg13cmos5l_decap_8
* cell instance sg13cmos5l_decap_8_3567 r0 *1 0,0
Xsg13cmos5l_decap_8_3567 VPWR VGND sg13cmos5l_decap_8
* cell instance sg13cmos5l_decap_8_3568 r0 *1 0,0
Xsg13cmos5l_decap_8_3568 VPWR VGND sg13cmos5l_decap_8
* cell instance sg13cmos5l_decap_8_3569 r0 *1 0,0
Xsg13cmos5l_decap_8_3569 VPWR VGND sg13cmos5l_decap_8
* cell instance sg13cmos5l_decap_8_3570 r0 *1 0,0
Xsg13cmos5l_decap_8_3570 VPWR VGND sg13cmos5l_decap_8
* cell instance sg13cmos5l_decap_8_3571 r0 *1 0,0
Xsg13cmos5l_decap_8_3571 VPWR VGND sg13cmos5l_decap_8
* cell instance sg13cmos5l_decap_8_3572 r0 *1 0,0
Xsg13cmos5l_decap_8_3572 VPWR VGND sg13cmos5l_decap_8
* cell instance sg13cmos5l_decap_8_3573 r0 *1 0,0
Xsg13cmos5l_decap_8_3573 VPWR VGND sg13cmos5l_decap_8
* cell instance sg13cmos5l_decap_8_3574 r0 *1 0,0
Xsg13cmos5l_decap_8_3574 VPWR VGND sg13cmos5l_decap_8
* cell instance sg13cmos5l_decap_8_3575 r0 *1 0,0
Xsg13cmos5l_decap_8_3575 VPWR VGND sg13cmos5l_decap_8
* cell instance sg13cmos5l_decap_8_3576 r0 *1 0,0
Xsg13cmos5l_decap_8_3576 VPWR VGND sg13cmos5l_decap_8
* cell instance sg13cmos5l_decap_8_3577 r0 *1 0,0
Xsg13cmos5l_decap_8_3577 VPWR VGND sg13cmos5l_decap_8
* cell instance sg13cmos5l_decap_8_3578 r0 *1 0,0
Xsg13cmos5l_decap_8_3578 VPWR VGND sg13cmos5l_decap_8
* cell instance sg13cmos5l_decap_8_3579 r0 *1 0,0
Xsg13cmos5l_decap_8_3579 VPWR VGND sg13cmos5l_decap_8
* cell instance sg13cmos5l_decap_8_3580 r0 *1 0,0
Xsg13cmos5l_decap_8_3580 VPWR VGND sg13cmos5l_decap_8
* cell instance sg13cmos5l_decap_8_3581 r0 *1 0,0
Xsg13cmos5l_decap_8_3581 VPWR VGND sg13cmos5l_decap_8
* cell instance sg13cmos5l_decap_8_3582 r0 *1 0,0
Xsg13cmos5l_decap_8_3582 VPWR VGND sg13cmos5l_decap_8
* cell instance sg13cmos5l_decap_8_3583 r0 *1 0,0
Xsg13cmos5l_decap_8_3583 VPWR VGND sg13cmos5l_decap_8
* cell instance sg13cmos5l_decap_8_3584 r0 *1 0,0
Xsg13cmos5l_decap_8_3584 VPWR VGND sg13cmos5l_decap_8
* cell instance sg13cmos5l_decap_8_3585 r0 *1 0,0
Xsg13cmos5l_decap_8_3585 VPWR VGND sg13cmos5l_decap_8
* cell instance sg13cmos5l_decap_8_3586 r0 *1 0,0
Xsg13cmos5l_decap_8_3586 VPWR VGND sg13cmos5l_decap_8
* cell instance sg13cmos5l_decap_8_3587 r0 *1 0,0
Xsg13cmos5l_decap_8_3587 VPWR VGND sg13cmos5l_decap_8
* cell instance sg13cmos5l_decap_8_3588 r0 *1 0,0
Xsg13cmos5l_decap_8_3588 VPWR VGND sg13cmos5l_decap_8
* cell instance sg13cmos5l_decap_8_3589 r0 *1 0,0
Xsg13cmos5l_decap_8_3589 VPWR VGND sg13cmos5l_decap_8
* cell instance sg13cmos5l_decap_8_3590 r0 *1 0,0
Xsg13cmos5l_decap_8_3590 VPWR VGND sg13cmos5l_decap_8
* cell instance sg13cmos5l_decap_8_3591 r0 *1 0,0
Xsg13cmos5l_decap_8_3591 VPWR VGND sg13cmos5l_decap_8
* cell instance sg13cmos5l_decap_8_3592 r0 *1 0,0
Xsg13cmos5l_decap_8_3592 VPWR VGND sg13cmos5l_decap_8
* cell instance sg13cmos5l_decap_8_3593 r0 *1 0,0
Xsg13cmos5l_decap_8_3593 VPWR VGND sg13cmos5l_decap_8
* cell instance sg13cmos5l_decap_8_3594 r0 *1 0,0
Xsg13cmos5l_decap_8_3594 VPWR VGND sg13cmos5l_decap_8
* cell instance sg13cmos5l_decap_8_3595 r0 *1 0,0
Xsg13cmos5l_decap_8_3595 VPWR VGND sg13cmos5l_decap_8
* cell instance sg13cmos5l_decap_8_3596 r0 *1 0,0
Xsg13cmos5l_decap_8_3596 VPWR VGND sg13cmos5l_decap_8
* cell instance sg13cmos5l_decap_8_3597 r0 *1 0,0
Xsg13cmos5l_decap_8_3597 VPWR VGND sg13cmos5l_decap_8
* cell instance sg13cmos5l_decap_8_3598 r0 *1 0,0
Xsg13cmos5l_decap_8_3598 VPWR VGND sg13cmos5l_decap_8
* cell instance sg13cmos5l_decap_8_3599 r0 *1 0,0
Xsg13cmos5l_decap_8_3599 VPWR VGND sg13cmos5l_decap_8
* cell instance sg13cmos5l_decap_8_3600 r0 *1 0,0
Xsg13cmos5l_decap_8_3600 VPWR VGND sg13cmos5l_decap_8
* cell instance sg13cmos5l_decap_8_3601 r0 *1 0,0
Xsg13cmos5l_decap_8_3601 VPWR VGND sg13cmos5l_decap_8
* cell instance sg13cmos5l_decap_8_3602 r0 *1 0,0
Xsg13cmos5l_decap_8_3602 VPWR VGND sg13cmos5l_decap_8
* cell instance sg13cmos5l_decap_8_3603 r0 *1 0,0
Xsg13cmos5l_decap_8_3603 VPWR VGND sg13cmos5l_decap_8
* cell instance sg13cmos5l_decap_8_3604 r0 *1 0,0
Xsg13cmos5l_decap_8_3604 VPWR VGND sg13cmos5l_decap_8
* cell instance sg13cmos5l_decap_8_3605 r0 *1 0,0
Xsg13cmos5l_decap_8_3605 VPWR VGND sg13cmos5l_decap_8
* cell instance sg13cmos5l_decap_8_3606 r0 *1 0,0
Xsg13cmos5l_decap_8_3606 VPWR VGND sg13cmos5l_decap_8
* cell instance sg13cmos5l_decap_8_3607 r0 *1 0,0
Xsg13cmos5l_decap_8_3607 VPWR VGND sg13cmos5l_decap_8
* cell instance sg13cmos5l_decap_8_3608 r0 *1 0,0
Xsg13cmos5l_decap_8_3608 VPWR VGND sg13cmos5l_decap_8
* cell instance sg13cmos5l_decap_8_3609 r0 *1 0,0
Xsg13cmos5l_decap_8_3609 VPWR VGND sg13cmos5l_decap_8
* cell instance sg13cmos5l_decap_8_3610 r0 *1 0,0
Xsg13cmos5l_decap_8_3610 VPWR VGND sg13cmos5l_decap_8
* cell instance sg13cmos5l_decap_8_3611 r0 *1 0,0
Xsg13cmos5l_decap_8_3611 VPWR VGND sg13cmos5l_decap_8
* cell instance sg13cmos5l_decap_8_3612 r0 *1 0,0
Xsg13cmos5l_decap_8_3612 VPWR VGND sg13cmos5l_decap_8
* cell instance sg13cmos5l_decap_8_3613 r0 *1 0,0
Xsg13cmos5l_decap_8_3613 VPWR VGND sg13cmos5l_decap_8
* cell instance sg13cmos5l_decap_8_3614 r0 *1 0,0
Xsg13cmos5l_decap_8_3614 VPWR VGND sg13cmos5l_decap_8
* cell instance sg13cmos5l_decap_8_3615 r0 *1 0,0
Xsg13cmos5l_decap_8_3615 VPWR VGND sg13cmos5l_decap_8
* cell instance sg13cmos5l_decap_8_3616 r0 *1 0,0
Xsg13cmos5l_decap_8_3616 VPWR VGND sg13cmos5l_decap_8
* cell instance sg13cmos5l_decap_8_3617 r0 *1 0,0
Xsg13cmos5l_decap_8_3617 VPWR VGND sg13cmos5l_decap_8
* cell instance sg13cmos5l_decap_8_3618 r0 *1 0,0
Xsg13cmos5l_decap_8_3618 VPWR VGND sg13cmos5l_decap_8
* cell instance sg13cmos5l_decap_8_3619 r0 *1 0,0
Xsg13cmos5l_decap_8_3619 VPWR VGND sg13cmos5l_decap_8
* cell instance sg13cmos5l_decap_8_3620 r0 *1 0,0
Xsg13cmos5l_decap_8_3620 VPWR VGND sg13cmos5l_decap_8
* cell instance sg13cmos5l_decap_8_3621 r0 *1 0,0
Xsg13cmos5l_decap_8_3621 VPWR VGND sg13cmos5l_decap_8
* cell instance sg13cmos5l_decap_8_3622 r0 *1 0,0
Xsg13cmos5l_decap_8_3622 VPWR VGND sg13cmos5l_decap_8
* cell instance sg13cmos5l_decap_8_3623 r0 *1 0,0
Xsg13cmos5l_decap_8_3623 VPWR VGND sg13cmos5l_decap_8
* cell instance sg13cmos5l_decap_8_3624 r0 *1 0,0
Xsg13cmos5l_decap_8_3624 VPWR VGND sg13cmos5l_decap_8
* cell instance sg13cmos5l_decap_8_3625 r0 *1 0,0
Xsg13cmos5l_decap_8_3625 VPWR VGND sg13cmos5l_decap_8
* cell instance sg13cmos5l_decap_8_3626 r0 *1 0,0
Xsg13cmos5l_decap_8_3626 VPWR VGND sg13cmos5l_decap_8
* cell instance sg13cmos5l_decap_8_3627 r0 *1 0,0
Xsg13cmos5l_decap_8_3627 VPWR VGND sg13cmos5l_decap_8
* cell instance sg13cmos5l_decap_8_3628 r0 *1 0,0
Xsg13cmos5l_decap_8_3628 VPWR VGND sg13cmos5l_decap_8
* cell instance sg13cmos5l_decap_8_3629 r0 *1 0,0
Xsg13cmos5l_decap_8_3629 VPWR VGND sg13cmos5l_decap_8
* cell instance sg13cmos5l_decap_8_3630 r0 *1 0,0
Xsg13cmos5l_decap_8_3630 VPWR VGND sg13cmos5l_decap_8
* cell instance sg13cmos5l_decap_8_3631 r0 *1 0,0
Xsg13cmos5l_decap_8_3631 VPWR VGND sg13cmos5l_decap_8
* cell instance sg13cmos5l_decap_8_3632 r0 *1 0,0
Xsg13cmos5l_decap_8_3632 VPWR VGND sg13cmos5l_decap_8
* cell instance sg13cmos5l_decap_8_3633 r0 *1 0,0
Xsg13cmos5l_decap_8_3633 VPWR VGND sg13cmos5l_decap_8
* cell instance sg13cmos5l_decap_8_3634 r0 *1 0,0
Xsg13cmos5l_decap_8_3634 VPWR VGND sg13cmos5l_decap_8
* cell instance sg13cmos5l_decap_8_3635 r0 *1 0,0
Xsg13cmos5l_decap_8_3635 VPWR VGND sg13cmos5l_decap_8
* cell instance sg13cmos5l_decap_8_3636 r0 *1 0,0
Xsg13cmos5l_decap_8_3636 VPWR VGND sg13cmos5l_decap_8
* cell instance sg13cmos5l_decap_8_3637 r0 *1 0,0
Xsg13cmos5l_decap_8_3637 VPWR VGND sg13cmos5l_decap_8
* cell instance sg13cmos5l_decap_8_3638 r0 *1 0,0
Xsg13cmos5l_decap_8_3638 VPWR VGND sg13cmos5l_decap_8
* cell instance sg13cmos5l_decap_8_3639 r0 *1 0,0
Xsg13cmos5l_decap_8_3639 VPWR VGND sg13cmos5l_decap_8
* cell instance sg13cmos5l_decap_8_3640 r0 *1 0,0
Xsg13cmos5l_decap_8_3640 VPWR VGND sg13cmos5l_decap_8
* cell instance sg13cmos5l_decap_8_3641 r0 *1 0,0
Xsg13cmos5l_decap_8_3641 VPWR VGND sg13cmos5l_decap_8
* cell instance sg13cmos5l_decap_8_3642 r0 *1 0,0
Xsg13cmos5l_decap_8_3642 VPWR VGND sg13cmos5l_decap_8
* cell instance sg13cmos5l_decap_8_3643 r0 *1 0,0
Xsg13cmos5l_decap_8_3643 VPWR VGND sg13cmos5l_decap_8
* cell instance sg13cmos5l_decap_8_3644 r0 *1 0,0
Xsg13cmos5l_decap_8_3644 VPWR VGND sg13cmos5l_decap_8
* cell instance sg13cmos5l_decap_8_3645 r0 *1 0,0
Xsg13cmos5l_decap_8_3645 VPWR VGND sg13cmos5l_decap_8
* cell instance sg13cmos5l_decap_8_3646 r0 *1 0,0
Xsg13cmos5l_decap_8_3646 VPWR VGND sg13cmos5l_decap_8
* cell instance sg13cmos5l_decap_8_3647 r0 *1 0,0
Xsg13cmos5l_decap_8_3647 VPWR VGND sg13cmos5l_decap_8
* cell instance sg13cmos5l_decap_8_3648 r0 *1 0,0
Xsg13cmos5l_decap_8_3648 VPWR VGND sg13cmos5l_decap_8
* cell instance sg13cmos5l_decap_8_3649 r0 *1 0,0
Xsg13cmos5l_decap_8_3649 VPWR VGND sg13cmos5l_decap_8
* cell instance sg13cmos5l_decap_8_3650 r0 *1 0,0
Xsg13cmos5l_decap_8_3650 VPWR VGND sg13cmos5l_decap_8
* cell instance sg13cmos5l_decap_8_3651 r0 *1 0,0
Xsg13cmos5l_decap_8_3651 VPWR VGND sg13cmos5l_decap_8
* cell instance sg13cmos5l_decap_8_3652 r0 *1 0,0
Xsg13cmos5l_decap_8_3652 VPWR VGND sg13cmos5l_decap_8
* cell instance sg13cmos5l_decap_8_3653 r0 *1 0,0
Xsg13cmos5l_decap_8_3653 VPWR VGND sg13cmos5l_decap_8
* cell instance sg13cmos5l_decap_8_3654 r0 *1 0,0
Xsg13cmos5l_decap_8_3654 VPWR VGND sg13cmos5l_decap_8
* cell instance sg13cmos5l_decap_8_3655 r0 *1 0,0
Xsg13cmos5l_decap_8_3655 VPWR VGND sg13cmos5l_decap_8
* cell instance sg13cmos5l_decap_8_3656 r0 *1 0,0
Xsg13cmos5l_decap_8_3656 VPWR VGND sg13cmos5l_decap_8
* cell instance sg13cmos5l_decap_8_3657 r0 *1 0,0
Xsg13cmos5l_decap_8_3657 VPWR VGND sg13cmos5l_decap_8
* cell instance sg13cmos5l_decap_8_3658 r0 *1 0,0
Xsg13cmos5l_decap_8_3658 VPWR VGND sg13cmos5l_decap_8
* cell instance sg13cmos5l_decap_8_3659 r0 *1 0,0
Xsg13cmos5l_decap_8_3659 VPWR VGND sg13cmos5l_decap_8
* cell instance sg13cmos5l_decap_8_3660 r0 *1 0,0
Xsg13cmos5l_decap_8_3660 VPWR VGND sg13cmos5l_decap_8
* cell instance sg13cmos5l_decap_8_3661 r0 *1 0,0
Xsg13cmos5l_decap_8_3661 VPWR VGND sg13cmos5l_decap_8
* cell instance sg13cmos5l_decap_8_3662 r0 *1 0,0
Xsg13cmos5l_decap_8_3662 VPWR VGND sg13cmos5l_decap_8
* cell instance sg13cmos5l_decap_8_3663 r0 *1 0,0
Xsg13cmos5l_decap_8_3663 VPWR VGND sg13cmos5l_decap_8
* cell instance sg13cmos5l_decap_8_3664 r0 *1 0,0
Xsg13cmos5l_decap_8_3664 VPWR VGND sg13cmos5l_decap_8
* cell instance sg13cmos5l_decap_8_3665 r0 *1 0,0
Xsg13cmos5l_decap_8_3665 VPWR VGND sg13cmos5l_decap_8
* cell instance sg13cmos5l_decap_8_3666 r0 *1 0,0
Xsg13cmos5l_decap_8_3666 VPWR VGND sg13cmos5l_decap_8
* cell instance sg13cmos5l_decap_8_3667 r0 *1 0,0
Xsg13cmos5l_decap_8_3667 VPWR VGND sg13cmos5l_decap_8
* cell instance sg13cmos5l_decap_8_3668 r0 *1 0,0
Xsg13cmos5l_decap_8_3668 VPWR VGND sg13cmos5l_decap_8
* cell instance sg13cmos5l_decap_8_3669 r0 *1 0,0
Xsg13cmos5l_decap_8_3669 VPWR VGND sg13cmos5l_decap_8
* cell instance sg13cmos5l_decap_8_3670 r0 *1 0,0
Xsg13cmos5l_decap_8_3670 VPWR VGND sg13cmos5l_decap_8
* cell instance sg13cmos5l_decap_8_3671 r0 *1 0,0
Xsg13cmos5l_decap_8_3671 VPWR VGND sg13cmos5l_decap_8
* cell instance sg13cmos5l_decap_8_3672 r0 *1 0,0
Xsg13cmos5l_decap_8_3672 VPWR VGND sg13cmos5l_decap_8
* cell instance sg13cmos5l_decap_8_3673 r0 *1 0,0
Xsg13cmos5l_decap_8_3673 VPWR VGND sg13cmos5l_decap_8
* cell instance sg13cmos5l_decap_8_3674 r0 *1 0,0
Xsg13cmos5l_decap_8_3674 VPWR VGND sg13cmos5l_decap_8
* cell instance sg13cmos5l_decap_8_3675 r0 *1 0,0
Xsg13cmos5l_decap_8_3675 VPWR VGND sg13cmos5l_decap_8
* cell instance sg13cmos5l_decap_8_3676 r0 *1 0,0
Xsg13cmos5l_decap_8_3676 VPWR VGND sg13cmos5l_decap_8
* cell instance sg13cmos5l_decap_8_3677 r0 *1 0,0
Xsg13cmos5l_decap_8_3677 VPWR VGND sg13cmos5l_decap_8
* cell instance sg13cmos5l_decap_8_3678 r0 *1 0,0
Xsg13cmos5l_decap_8_3678 VPWR VGND sg13cmos5l_decap_8
* cell instance sg13cmos5l_decap_8_3679 r0 *1 0,0
Xsg13cmos5l_decap_8_3679 VPWR VGND sg13cmos5l_decap_8
* cell instance sg13cmos5l_decap_8_3680 r0 *1 0,0
Xsg13cmos5l_decap_8_3680 VPWR VGND sg13cmos5l_decap_8
* cell instance sg13cmos5l_decap_8_3681 r0 *1 0,0
Xsg13cmos5l_decap_8_3681 VPWR VGND sg13cmos5l_decap_8
* cell instance sg13cmos5l_decap_8_3682 r0 *1 0,0
Xsg13cmos5l_decap_8_3682 VPWR VGND sg13cmos5l_decap_8
* cell instance sg13cmos5l_decap_8_3683 r0 *1 0,0
Xsg13cmos5l_decap_8_3683 VPWR VGND sg13cmos5l_decap_8
* cell instance sg13cmos5l_decap_8_3684 r0 *1 0,0
Xsg13cmos5l_decap_8_3684 VPWR VGND sg13cmos5l_decap_8
* cell instance sg13cmos5l_decap_8_3685 r0 *1 0,0
Xsg13cmos5l_decap_8_3685 VPWR VGND sg13cmos5l_decap_8
* cell instance sg13cmos5l_decap_8_3686 r0 *1 0,0
Xsg13cmos5l_decap_8_3686 VPWR VGND sg13cmos5l_decap_8
* cell instance sg13cmos5l_decap_8_3687 r0 *1 0,0
Xsg13cmos5l_decap_8_3687 VPWR VGND sg13cmos5l_decap_8
* cell instance sg13cmos5l_decap_8_3688 r0 *1 0,0
Xsg13cmos5l_decap_8_3688 VPWR VGND sg13cmos5l_decap_8
* cell instance sg13cmos5l_decap_8_3689 r0 *1 0,0
Xsg13cmos5l_decap_8_3689 VPWR VGND sg13cmos5l_decap_8
* cell instance sg13cmos5l_decap_8_3690 r0 *1 0,0
Xsg13cmos5l_decap_8_3690 VPWR VGND sg13cmos5l_decap_8
* cell instance sg13cmos5l_decap_8_3691 r0 *1 0,0
Xsg13cmos5l_decap_8_3691 VPWR VGND sg13cmos5l_decap_8
* cell instance sg13cmos5l_decap_8_3692 r0 *1 0,0
Xsg13cmos5l_decap_8_3692 VPWR VGND sg13cmos5l_decap_8
* cell instance sg13cmos5l_decap_8_3693 r0 *1 0,0
Xsg13cmos5l_decap_8_3693 VPWR VGND sg13cmos5l_decap_8
* cell instance sg13cmos5l_decap_8_3694 r0 *1 0,0
Xsg13cmos5l_decap_8_3694 VPWR VGND sg13cmos5l_decap_8
* cell instance sg13cmos5l_decap_8_3695 r0 *1 0,0
Xsg13cmos5l_decap_8_3695 VPWR VGND sg13cmos5l_decap_8
* cell instance sg13cmos5l_decap_8_3696 r0 *1 0,0
Xsg13cmos5l_decap_8_3696 VPWR VGND sg13cmos5l_decap_8
* cell instance sg13cmos5l_decap_8_3697 r0 *1 0,0
Xsg13cmos5l_decap_8_3697 VPWR VGND sg13cmos5l_decap_8
* cell instance sg13cmos5l_decap_8_3698 r0 *1 0,0
Xsg13cmos5l_decap_8_3698 VPWR VGND sg13cmos5l_decap_8
* cell instance sg13cmos5l_decap_8_3699 r0 *1 0,0
Xsg13cmos5l_decap_8_3699 VPWR VGND sg13cmos5l_decap_8
* cell instance sg13cmos5l_decap_8_3700 r0 *1 0,0
Xsg13cmos5l_decap_8_3700 VPWR VGND sg13cmos5l_decap_8
* cell instance sg13cmos5l_decap_8_3701 r0 *1 0,0
Xsg13cmos5l_decap_8_3701 VPWR VGND sg13cmos5l_decap_8
* cell instance sg13cmos5l_decap_8_3702 r0 *1 0,0
Xsg13cmos5l_decap_8_3702 VPWR VGND sg13cmos5l_decap_8
* cell instance sg13cmos5l_decap_8_3703 r0 *1 0,0
Xsg13cmos5l_decap_8_3703 VPWR VGND sg13cmos5l_decap_8
* cell instance sg13cmos5l_decap_8_3704 r0 *1 0,0
Xsg13cmos5l_decap_8_3704 VPWR VGND sg13cmos5l_decap_8
* cell instance sg13cmos5l_decap_8_3705 r0 *1 0,0
Xsg13cmos5l_decap_8_3705 VPWR VGND sg13cmos5l_decap_8
* cell instance sg13cmos5l_decap_8_3706 r0 *1 0,0
Xsg13cmos5l_decap_8_3706 VPWR VGND sg13cmos5l_decap_8
* cell instance sg13cmos5l_decap_8_3707 r0 *1 0,0
Xsg13cmos5l_decap_8_3707 VPWR VGND sg13cmos5l_decap_8
* cell instance sg13cmos5l_decap_8_3708 r0 *1 0,0
Xsg13cmos5l_decap_8_3708 VPWR VGND sg13cmos5l_decap_8
* cell instance sg13cmos5l_decap_8_3709 r0 *1 0,0
Xsg13cmos5l_decap_8_3709 VPWR VGND sg13cmos5l_decap_8
* cell instance sg13cmos5l_decap_8_3710 r0 *1 0,0
Xsg13cmos5l_decap_8_3710 VPWR VGND sg13cmos5l_decap_8
* cell instance sg13cmos5l_decap_8_3711 r0 *1 0,0
Xsg13cmos5l_decap_8_3711 VPWR VGND sg13cmos5l_decap_8
* cell instance sg13cmos5l_decap_8_3712 r0 *1 0,0
Xsg13cmos5l_decap_8_3712 VPWR VGND sg13cmos5l_decap_8
* cell instance sg13cmos5l_decap_8_3713 r0 *1 0,0
Xsg13cmos5l_decap_8_3713 VPWR VGND sg13cmos5l_decap_8
* cell instance sg13cmos5l_decap_8_3714 r0 *1 0,0
Xsg13cmos5l_decap_8_3714 VPWR VGND sg13cmos5l_decap_8
* cell instance sg13cmos5l_decap_8_3715 r0 *1 0,0
Xsg13cmos5l_decap_8_3715 VPWR VGND sg13cmos5l_decap_8
* cell instance sg13cmos5l_decap_8_3716 r0 *1 0,0
Xsg13cmos5l_decap_8_3716 VPWR VGND sg13cmos5l_decap_8
* cell instance sg13cmos5l_decap_8_3717 r0 *1 0,0
Xsg13cmos5l_decap_8_3717 VPWR VGND sg13cmos5l_decap_8
* cell instance sg13cmos5l_decap_8_3718 r0 *1 0,0
Xsg13cmos5l_decap_8_3718 VPWR VGND sg13cmos5l_decap_8
* cell instance sg13cmos5l_decap_8_3719 r0 *1 0,0
Xsg13cmos5l_decap_8_3719 VPWR VGND sg13cmos5l_decap_8
* cell instance sg13cmos5l_decap_8_3720 r0 *1 0,0
Xsg13cmos5l_decap_8_3720 VPWR VGND sg13cmos5l_decap_8
* cell instance sg13cmos5l_decap_8_3721 r0 *1 0,0
Xsg13cmos5l_decap_8_3721 VPWR VGND sg13cmos5l_decap_8
* cell instance sg13cmos5l_decap_8_3722 r0 *1 0,0
Xsg13cmos5l_decap_8_3722 VPWR VGND sg13cmos5l_decap_8
* cell instance sg13cmos5l_decap_8_3723 r0 *1 0,0
Xsg13cmos5l_decap_8_3723 VPWR VGND sg13cmos5l_decap_8
* cell instance sg13cmos5l_decap_8_3724 r0 *1 0,0
Xsg13cmos5l_decap_8_3724 VPWR VGND sg13cmos5l_decap_8
* cell instance sg13cmos5l_decap_8_3725 r0 *1 0,0
Xsg13cmos5l_decap_8_3725 VPWR VGND sg13cmos5l_decap_8
* cell instance sg13cmos5l_decap_8_3726 r0 *1 0,0
Xsg13cmos5l_decap_8_3726 VPWR VGND sg13cmos5l_decap_8
* cell instance sg13cmos5l_decap_8_3727 r0 *1 0,0
Xsg13cmos5l_decap_8_3727 VPWR VGND sg13cmos5l_decap_8
* cell instance sg13cmos5l_decap_8_3728 r0 *1 0,0
Xsg13cmos5l_decap_8_3728 VPWR VGND sg13cmos5l_decap_8
* cell instance sg13cmos5l_decap_8_3729 r0 *1 0,0
Xsg13cmos5l_decap_8_3729 VPWR VGND sg13cmos5l_decap_8
* cell instance sg13cmos5l_decap_8_3730 r0 *1 0,0
Xsg13cmos5l_decap_8_3730 VPWR VGND sg13cmos5l_decap_8
* cell instance sg13cmos5l_decap_8_3731 r0 *1 0,0
Xsg13cmos5l_decap_8_3731 VPWR VGND sg13cmos5l_decap_8
* cell instance sg13cmos5l_decap_8_3732 r0 *1 0,0
Xsg13cmos5l_decap_8_3732 VPWR VGND sg13cmos5l_decap_8
* cell instance sg13cmos5l_decap_8_3733 r0 *1 0,0
Xsg13cmos5l_decap_8_3733 VPWR VGND sg13cmos5l_decap_8
* cell instance sg13cmos5l_decap_8_3734 r0 *1 0,0
Xsg13cmos5l_decap_8_3734 VPWR VGND sg13cmos5l_decap_8
* cell instance sg13cmos5l_decap_8_3735 r0 *1 0,0
Xsg13cmos5l_decap_8_3735 VPWR VGND sg13cmos5l_decap_8
* cell instance sg13cmos5l_decap_8_3736 r0 *1 0,0
Xsg13cmos5l_decap_8_3736 VPWR VGND sg13cmos5l_decap_8
* cell instance sg13cmos5l_decap_8_3737 r0 *1 0,0
Xsg13cmos5l_decap_8_3737 VPWR VGND sg13cmos5l_decap_8
* cell instance sg13cmos5l_decap_8_3738 r0 *1 0,0
Xsg13cmos5l_decap_8_3738 VPWR VGND sg13cmos5l_decap_8
* cell instance sg13cmos5l_decap_8_3739 r0 *1 0,0
Xsg13cmos5l_decap_8_3739 VPWR VGND sg13cmos5l_decap_8
* cell instance sg13cmos5l_decap_8_3740 r0 *1 0,0
Xsg13cmos5l_decap_8_3740 VPWR VGND sg13cmos5l_decap_8
* cell instance sg13cmos5l_decap_8_3741 r0 *1 0,0
Xsg13cmos5l_decap_8_3741 VPWR VGND sg13cmos5l_decap_8
* cell instance sg13cmos5l_decap_8_3742 r0 *1 0,0
Xsg13cmos5l_decap_8_3742 VPWR VGND sg13cmos5l_decap_8
* cell instance sg13cmos5l_decap_8_3743 r0 *1 0,0
Xsg13cmos5l_decap_8_3743 VPWR VGND sg13cmos5l_decap_8
* cell instance sg13cmos5l_decap_8_3744 r0 *1 0,0
Xsg13cmos5l_decap_8_3744 VPWR VGND sg13cmos5l_decap_8
* cell instance sg13cmos5l_decap_8_3745 r0 *1 0,0
Xsg13cmos5l_decap_8_3745 VPWR VGND sg13cmos5l_decap_8
* cell instance sg13cmos5l_decap_8_3746 r0 *1 0,0
Xsg13cmos5l_decap_8_3746 VPWR VGND sg13cmos5l_decap_8
* cell instance sg13cmos5l_decap_8_3747 r0 *1 0,0
Xsg13cmos5l_decap_8_3747 VPWR VGND sg13cmos5l_decap_8
* cell instance sg13cmos5l_decap_8_3748 r0 *1 0,0
Xsg13cmos5l_decap_8_3748 VPWR VGND sg13cmos5l_decap_8
* cell instance sg13cmos5l_decap_8_3749 r0 *1 0,0
Xsg13cmos5l_decap_8_3749 VPWR VGND sg13cmos5l_decap_8
* cell instance sg13cmos5l_decap_8_3750 r0 *1 0,0
Xsg13cmos5l_decap_8_3750 VPWR VGND sg13cmos5l_decap_8
* cell instance sg13cmos5l_decap_8_3751 r0 *1 0,0
Xsg13cmos5l_decap_8_3751 VPWR VGND sg13cmos5l_decap_8
* cell instance sg13cmos5l_decap_8_3752 r0 *1 0,0
Xsg13cmos5l_decap_8_3752 VPWR VGND sg13cmos5l_decap_8
* cell instance sg13cmos5l_decap_8_3753 r0 *1 0,0
Xsg13cmos5l_decap_8_3753 VPWR VGND sg13cmos5l_decap_8
* cell instance sg13cmos5l_decap_8_3754 r0 *1 0,0
Xsg13cmos5l_decap_8_3754 VPWR VGND sg13cmos5l_decap_8
* cell instance sg13cmos5l_decap_8_3755 r0 *1 0,0
Xsg13cmos5l_decap_8_3755 VPWR VGND sg13cmos5l_decap_8
* cell instance sg13cmos5l_decap_8_3756 r0 *1 0,0
Xsg13cmos5l_decap_8_3756 VPWR VGND sg13cmos5l_decap_8
* cell instance sg13cmos5l_decap_8_3757 r0 *1 0,0
Xsg13cmos5l_decap_8_3757 VPWR VGND sg13cmos5l_decap_8
* cell instance sg13cmos5l_decap_8_3758 r0 *1 0,0
Xsg13cmos5l_decap_8_3758 VPWR VGND sg13cmos5l_decap_8
* cell instance sg13cmos5l_decap_8_3759 r0 *1 0,0
Xsg13cmos5l_decap_8_3759 VPWR VGND sg13cmos5l_decap_8
* cell instance sg13cmos5l_decap_8_3760 r0 *1 0,0
Xsg13cmos5l_decap_8_3760 VPWR VGND sg13cmos5l_decap_8
* cell instance sg13cmos5l_decap_8_3761 r0 *1 0,0
Xsg13cmos5l_decap_8_3761 VPWR VGND sg13cmos5l_decap_8
* cell instance sg13cmos5l_decap_8_3762 r0 *1 0,0
Xsg13cmos5l_decap_8_3762 VPWR VGND sg13cmos5l_decap_8
* cell instance sg13cmos5l_decap_8_3763 r0 *1 0,0
Xsg13cmos5l_decap_8_3763 VPWR VGND sg13cmos5l_decap_8
* cell instance sg13cmos5l_decap_8_3764 r0 *1 0,0
Xsg13cmos5l_decap_8_3764 VPWR VGND sg13cmos5l_decap_8
* cell instance sg13cmos5l_decap_8_3765 r0 *1 0,0
Xsg13cmos5l_decap_8_3765 VPWR VGND sg13cmos5l_decap_8
* cell instance sg13cmos5l_decap_8_3766 r0 *1 0,0
Xsg13cmos5l_decap_8_3766 VPWR VGND sg13cmos5l_decap_8
* cell instance sg13cmos5l_decap_8_3767 r0 *1 0,0
Xsg13cmos5l_decap_8_3767 VPWR VGND sg13cmos5l_decap_8
* cell instance sg13cmos5l_decap_8_3768 r0 *1 0,0
Xsg13cmos5l_decap_8_3768 VPWR VGND sg13cmos5l_decap_8
* cell instance sg13cmos5l_decap_8_3769 r0 *1 0,0
Xsg13cmos5l_decap_8_3769 VPWR VGND sg13cmos5l_decap_8
* cell instance sg13cmos5l_decap_8_3770 r0 *1 0,0
Xsg13cmos5l_decap_8_3770 VPWR VGND sg13cmos5l_decap_8
* cell instance sg13cmos5l_decap_8_3771 r0 *1 0,0
Xsg13cmos5l_decap_8_3771 VPWR VGND sg13cmos5l_decap_8
* cell instance sg13cmos5l_decap_8_3772 r0 *1 0,0
Xsg13cmos5l_decap_8_3772 VPWR VGND sg13cmos5l_decap_8
* cell instance sg13cmos5l_decap_8_3773 r0 *1 0,0
Xsg13cmos5l_decap_8_3773 VPWR VGND sg13cmos5l_decap_8
* cell instance sg13cmos5l_decap_8_3774 r0 *1 0,0
Xsg13cmos5l_decap_8_3774 VPWR VGND sg13cmos5l_decap_8
* cell instance sg13cmos5l_decap_8_3775 r0 *1 0,0
Xsg13cmos5l_decap_8_3775 VPWR VGND sg13cmos5l_decap_8
* cell instance sg13cmos5l_decap_8_3776 r0 *1 0,0
Xsg13cmos5l_decap_8_3776 VPWR VGND sg13cmos5l_decap_8
* cell instance sg13cmos5l_decap_8_3777 r0 *1 0,0
Xsg13cmos5l_decap_8_3777 VPWR VGND sg13cmos5l_decap_8
* cell instance sg13cmos5l_decap_8_3778 r0 *1 0,0
Xsg13cmos5l_decap_8_3778 VPWR VGND sg13cmos5l_decap_8
* cell instance sg13cmos5l_decap_8_3779 r0 *1 0,0
Xsg13cmos5l_decap_8_3779 VPWR VGND sg13cmos5l_decap_8
* cell instance sg13cmos5l_decap_8_3780 r0 *1 0,0
Xsg13cmos5l_decap_8_3780 VPWR VGND sg13cmos5l_decap_8
* cell instance sg13cmos5l_decap_8_3781 r0 *1 0,0
Xsg13cmos5l_decap_8_3781 VPWR VGND sg13cmos5l_decap_8
* cell instance sg13cmos5l_decap_8_3782 r0 *1 0,0
Xsg13cmos5l_decap_8_3782 VPWR VGND sg13cmos5l_decap_8
* cell instance sg13cmos5l_decap_8_3783 r0 *1 0,0
Xsg13cmos5l_decap_8_3783 VPWR VGND sg13cmos5l_decap_8
* cell instance sg13cmos5l_decap_8_3784 r0 *1 0,0
Xsg13cmos5l_decap_8_3784 VPWR VGND sg13cmos5l_decap_8
* cell instance sg13cmos5l_decap_8_3785 r0 *1 0,0
Xsg13cmos5l_decap_8_3785 VPWR VGND sg13cmos5l_decap_8
* cell instance sg13cmos5l_decap_8_3786 r0 *1 0,0
Xsg13cmos5l_decap_8_3786 VPWR VGND sg13cmos5l_decap_8
* cell instance sg13cmos5l_decap_8_3787 r0 *1 0,0
Xsg13cmos5l_decap_8_3787 VPWR VGND sg13cmos5l_decap_8
* cell instance sg13cmos5l_decap_8_3788 r0 *1 0,0
Xsg13cmos5l_decap_8_3788 VPWR VGND sg13cmos5l_decap_8
* cell instance sg13cmos5l_decap_8_3789 r0 *1 0,0
Xsg13cmos5l_decap_8_3789 VPWR VGND sg13cmos5l_decap_8
* cell instance sg13cmos5l_decap_8_3790 r0 *1 0,0
Xsg13cmos5l_decap_8_3790 VPWR VGND sg13cmos5l_decap_8
* cell instance sg13cmos5l_decap_8_3791 r0 *1 0,0
Xsg13cmos5l_decap_8_3791 VPWR VGND sg13cmos5l_decap_8
* cell instance sg13cmos5l_decap_8_3792 r0 *1 0,0
Xsg13cmos5l_decap_8_3792 VPWR VGND sg13cmos5l_decap_8
* cell instance sg13cmos5l_decap_8_3793 r0 *1 0,0
Xsg13cmos5l_decap_8_3793 VPWR VGND sg13cmos5l_decap_8
* cell instance sg13cmos5l_decap_8_3794 r0 *1 0,0
Xsg13cmos5l_decap_8_3794 VPWR VGND sg13cmos5l_decap_8
* cell instance sg13cmos5l_decap_8_3795 r0 *1 0,0
Xsg13cmos5l_decap_8_3795 VPWR VGND sg13cmos5l_decap_8
* cell instance sg13cmos5l_decap_8_3796 r0 *1 0,0
Xsg13cmos5l_decap_8_3796 VPWR VGND sg13cmos5l_decap_8
* cell instance sg13cmos5l_decap_8_3797 r0 *1 0,0
Xsg13cmos5l_decap_8_3797 VPWR VGND sg13cmos5l_decap_8
* cell instance sg13cmos5l_decap_8_3798 r0 *1 0,0
Xsg13cmos5l_decap_8_3798 VPWR VGND sg13cmos5l_decap_8
* cell instance sg13cmos5l_decap_8_3799 r0 *1 0,0
Xsg13cmos5l_decap_8_3799 VPWR VGND sg13cmos5l_decap_8
* cell instance sg13cmos5l_decap_8_3800 r0 *1 0,0
Xsg13cmos5l_decap_8_3800 VPWR VGND sg13cmos5l_decap_8
* cell instance sg13cmos5l_decap_8_3801 r0 *1 0,0
Xsg13cmos5l_decap_8_3801 VPWR VGND sg13cmos5l_decap_8
* cell instance sg13cmos5l_decap_8_3802 r0 *1 0,0
Xsg13cmos5l_decap_8_3802 VPWR VGND sg13cmos5l_decap_8
* cell instance sg13cmos5l_decap_8_3803 r0 *1 0,0
Xsg13cmos5l_decap_8_3803 VPWR VGND sg13cmos5l_decap_8
* cell instance sg13cmos5l_decap_8_3804 r0 *1 0,0
Xsg13cmos5l_decap_8_3804 VPWR VGND sg13cmos5l_decap_8
* cell instance sg13cmos5l_decap_8_3805 r0 *1 0,0
Xsg13cmos5l_decap_8_3805 VPWR VGND sg13cmos5l_decap_8
* cell instance sg13cmos5l_decap_8_3806 r0 *1 0,0
Xsg13cmos5l_decap_8_3806 VPWR VGND sg13cmos5l_decap_8
* cell instance sg13cmos5l_decap_8_3807 r0 *1 0,0
Xsg13cmos5l_decap_8_3807 VPWR VGND sg13cmos5l_decap_8
* cell instance sg13cmos5l_decap_8_3808 r0 *1 0,0
Xsg13cmos5l_decap_8_3808 VPWR VGND sg13cmos5l_decap_8
* cell instance sg13cmos5l_decap_8_3809 r0 *1 0,0
Xsg13cmos5l_decap_8_3809 VPWR VGND sg13cmos5l_decap_8
* cell instance sg13cmos5l_decap_8_3810 r0 *1 0,0
Xsg13cmos5l_decap_8_3810 VPWR VGND sg13cmos5l_decap_8
* cell instance sg13cmos5l_decap_8_3811 r0 *1 0,0
Xsg13cmos5l_decap_8_3811 VPWR VGND sg13cmos5l_decap_8
* cell instance sg13cmos5l_decap_8_3812 r0 *1 0,0
Xsg13cmos5l_decap_8_3812 VPWR VGND sg13cmos5l_decap_8
* cell instance sg13cmos5l_decap_8_3813 r0 *1 0,0
Xsg13cmos5l_decap_8_3813 VPWR VGND sg13cmos5l_decap_8
* cell instance sg13cmos5l_decap_8_3814 r0 *1 0,0
Xsg13cmos5l_decap_8_3814 VPWR VGND sg13cmos5l_decap_8
* cell instance sg13cmos5l_decap_8_3815 r0 *1 0,0
Xsg13cmos5l_decap_8_3815 VPWR VGND sg13cmos5l_decap_8
* cell instance sg13cmos5l_decap_8_3816 r0 *1 0,0
Xsg13cmos5l_decap_8_3816 VPWR VGND sg13cmos5l_decap_8
* cell instance sg13cmos5l_decap_8_3817 r0 *1 0,0
Xsg13cmos5l_decap_8_3817 VPWR VGND sg13cmos5l_decap_8
* cell instance sg13cmos5l_decap_8_3818 r0 *1 0,0
Xsg13cmos5l_decap_8_3818 VPWR VGND sg13cmos5l_decap_8
* cell instance sg13cmos5l_decap_8_3819 r0 *1 0,0
Xsg13cmos5l_decap_8_3819 VPWR VGND sg13cmos5l_decap_8
* cell instance sg13cmos5l_decap_8_3820 r0 *1 0,0
Xsg13cmos5l_decap_8_3820 VPWR VGND sg13cmos5l_decap_8
* cell instance sg13cmos5l_decap_8_3821 r0 *1 0,0
Xsg13cmos5l_decap_8_3821 VPWR VGND sg13cmos5l_decap_8
* cell instance sg13cmos5l_decap_8_3822 r0 *1 0,0
Xsg13cmos5l_decap_8_3822 VPWR VGND sg13cmos5l_decap_8
* cell instance sg13cmos5l_decap_8_3823 r0 *1 0,0
Xsg13cmos5l_decap_8_3823 VPWR VGND sg13cmos5l_decap_8
* cell instance sg13cmos5l_decap_8_3824 r0 *1 0,0
Xsg13cmos5l_decap_8_3824 VPWR VGND sg13cmos5l_decap_8
* cell instance sg13cmos5l_decap_8_3825 r0 *1 0,0
Xsg13cmos5l_decap_8_3825 VPWR VGND sg13cmos5l_decap_8
* cell instance sg13cmos5l_decap_8_3826 r0 *1 0,0
Xsg13cmos5l_decap_8_3826 VPWR VGND sg13cmos5l_decap_8
* cell instance sg13cmos5l_decap_8_3827 r0 *1 0,0
Xsg13cmos5l_decap_8_3827 VPWR VGND sg13cmos5l_decap_8
* cell instance sg13cmos5l_decap_8_3828 r0 *1 0,0
Xsg13cmos5l_decap_8_3828 VPWR VGND sg13cmos5l_decap_8
* cell instance sg13cmos5l_decap_8_3829 r0 *1 0,0
Xsg13cmos5l_decap_8_3829 VPWR VGND sg13cmos5l_decap_8
* cell instance sg13cmos5l_decap_8_3830 r0 *1 0,0
Xsg13cmos5l_decap_8_3830 VPWR VGND sg13cmos5l_decap_8
* cell instance sg13cmos5l_decap_8_3831 r0 *1 0,0
Xsg13cmos5l_decap_8_3831 VPWR VGND sg13cmos5l_decap_8
* cell instance sg13cmos5l_decap_8_3832 r0 *1 0,0
Xsg13cmos5l_decap_8_3832 VPWR VGND sg13cmos5l_decap_8
* cell instance sg13cmos5l_decap_8_3833 r0 *1 0,0
Xsg13cmos5l_decap_8_3833 VPWR VGND sg13cmos5l_decap_8
* cell instance sg13cmos5l_decap_8_3834 r0 *1 0,0
Xsg13cmos5l_decap_8_3834 VPWR VGND sg13cmos5l_decap_8
* cell instance sg13cmos5l_decap_8_3835 r0 *1 0,0
Xsg13cmos5l_decap_8_3835 VPWR VGND sg13cmos5l_decap_8
* cell instance sg13cmos5l_decap_8_3836 r0 *1 0,0
Xsg13cmos5l_decap_8_3836 VPWR VGND sg13cmos5l_decap_8
* cell instance sg13cmos5l_decap_8_3837 r0 *1 0,0
Xsg13cmos5l_decap_8_3837 VPWR VGND sg13cmos5l_decap_8
* cell instance sg13cmos5l_decap_8_3838 r0 *1 0,0
Xsg13cmos5l_decap_8_3838 VPWR VGND sg13cmos5l_decap_8
* cell instance sg13cmos5l_decap_8_3839 r0 *1 0,0
Xsg13cmos5l_decap_8_3839 VPWR VGND sg13cmos5l_decap_8
* cell instance sg13cmos5l_decap_8_3840 r0 *1 0,0
Xsg13cmos5l_decap_8_3840 VPWR VGND sg13cmos5l_decap_8
* cell instance sg13cmos5l_decap_8_3841 r0 *1 0,0
Xsg13cmos5l_decap_8_3841 VPWR VGND sg13cmos5l_decap_8
* cell instance sg13cmos5l_decap_8_3842 r0 *1 0,0
Xsg13cmos5l_decap_8_3842 VPWR VGND sg13cmos5l_decap_8
* cell instance sg13cmos5l_decap_8_3843 r0 *1 0,0
Xsg13cmos5l_decap_8_3843 VPWR VGND sg13cmos5l_decap_8
* cell instance sg13cmos5l_decap_8_3844 r0 *1 0,0
Xsg13cmos5l_decap_8_3844 VPWR VGND sg13cmos5l_decap_8
* cell instance sg13cmos5l_decap_8_3845 r0 *1 0,0
Xsg13cmos5l_decap_8_3845 VPWR VGND sg13cmos5l_decap_8
* cell instance sg13cmos5l_decap_8_3846 r0 *1 0,0
Xsg13cmos5l_decap_8_3846 VPWR VGND sg13cmos5l_decap_8
* cell instance sg13cmos5l_decap_8_3847 r0 *1 0,0
Xsg13cmos5l_decap_8_3847 VPWR VGND sg13cmos5l_decap_8
* cell instance sg13cmos5l_decap_8_3848 r0 *1 0,0
Xsg13cmos5l_decap_8_3848 VPWR VGND sg13cmos5l_decap_8
* cell instance sg13cmos5l_decap_8_3849 r0 *1 0,0
Xsg13cmos5l_decap_8_3849 VPWR VGND sg13cmos5l_decap_8
* cell instance sg13cmos5l_decap_8_3850 r0 *1 0,0
Xsg13cmos5l_decap_8_3850 VPWR VGND sg13cmos5l_decap_8
* cell instance sg13cmos5l_decap_8_3851 r0 *1 0,0
Xsg13cmos5l_decap_8_3851 VPWR VGND sg13cmos5l_decap_8
* cell instance sg13cmos5l_decap_8_3852 r0 *1 0,0
Xsg13cmos5l_decap_8_3852 VPWR VGND sg13cmos5l_decap_8
* cell instance sg13cmos5l_decap_8_3853 r0 *1 0,0
Xsg13cmos5l_decap_8_3853 VPWR VGND sg13cmos5l_decap_8
* cell instance sg13cmos5l_decap_8_3854 r0 *1 0,0
Xsg13cmos5l_decap_8_3854 VPWR VGND sg13cmos5l_decap_8
* cell instance sg13cmos5l_decap_8_3855 r0 *1 0,0
Xsg13cmos5l_decap_8_3855 VPWR VGND sg13cmos5l_decap_8
* cell instance sg13cmos5l_decap_8_3856 r0 *1 0,0
Xsg13cmos5l_decap_8_3856 VPWR VGND sg13cmos5l_decap_8
* cell instance sg13cmos5l_decap_8_3857 r0 *1 0,0
Xsg13cmos5l_decap_8_3857 VPWR VGND sg13cmos5l_decap_8
* cell instance sg13cmos5l_decap_8_3858 r0 *1 0,0
Xsg13cmos5l_decap_8_3858 VPWR VGND sg13cmos5l_decap_8
* cell instance sg13cmos5l_decap_8_3859 r0 *1 0,0
Xsg13cmos5l_decap_8_3859 VPWR VGND sg13cmos5l_decap_8
* cell instance sg13cmos5l_decap_8_3860 r0 *1 0,0
Xsg13cmos5l_decap_8_3860 VPWR VGND sg13cmos5l_decap_8
* cell instance sg13cmos5l_decap_8_3861 r0 *1 0,0
Xsg13cmos5l_decap_8_3861 VPWR VGND sg13cmos5l_decap_8
* cell instance sg13cmos5l_decap_8_3862 r0 *1 0,0
Xsg13cmos5l_decap_8_3862 VPWR VGND sg13cmos5l_decap_8
* cell instance sg13cmos5l_decap_8_3863 r0 *1 0,0
Xsg13cmos5l_decap_8_3863 VPWR VGND sg13cmos5l_decap_8
* cell instance sg13cmos5l_decap_8_3864 r0 *1 0,0
Xsg13cmos5l_decap_8_3864 VPWR VGND sg13cmos5l_decap_8
* cell instance sg13cmos5l_decap_8_3865 r0 *1 0,0
Xsg13cmos5l_decap_8_3865 VPWR VGND sg13cmos5l_decap_8
* cell instance sg13cmos5l_decap_8_3866 r0 *1 0,0
Xsg13cmos5l_decap_8_3866 VPWR VGND sg13cmos5l_decap_8
* cell instance sg13cmos5l_decap_8_3867 r0 *1 0,0
Xsg13cmos5l_decap_8_3867 VPWR VGND sg13cmos5l_decap_8
* cell instance sg13cmos5l_decap_8_3868 r0 *1 0,0
Xsg13cmos5l_decap_8_3868 VPWR VGND sg13cmos5l_decap_8
* cell instance sg13cmos5l_decap_8_3869 r0 *1 0,0
Xsg13cmos5l_decap_8_3869 VPWR VGND sg13cmos5l_decap_8
* cell instance sg13cmos5l_decap_8_3870 r0 *1 0,0
Xsg13cmos5l_decap_8_3870 VPWR VGND sg13cmos5l_decap_8
* cell instance sg13cmos5l_decap_8_3871 r0 *1 0,0
Xsg13cmos5l_decap_8_3871 VPWR VGND sg13cmos5l_decap_8
* cell instance sg13cmos5l_decap_8_3872 r0 *1 0,0
Xsg13cmos5l_decap_8_3872 VPWR VGND sg13cmos5l_decap_8
* cell instance sg13cmos5l_decap_8_3873 r0 *1 0,0
Xsg13cmos5l_decap_8_3873 VPWR VGND sg13cmos5l_decap_8
* cell instance sg13cmos5l_decap_8_3874 r0 *1 0,0
Xsg13cmos5l_decap_8_3874 VPWR VGND sg13cmos5l_decap_8
* cell instance sg13cmos5l_decap_8_3875 r0 *1 0,0
Xsg13cmos5l_decap_8_3875 VPWR VGND sg13cmos5l_decap_8
* cell instance sg13cmos5l_decap_8_3876 r0 *1 0,0
Xsg13cmos5l_decap_8_3876 VPWR VGND sg13cmos5l_decap_8
* cell instance sg13cmos5l_decap_8_3877 r0 *1 0,0
Xsg13cmos5l_decap_8_3877 VPWR VGND sg13cmos5l_decap_8
* cell instance sg13cmos5l_decap_8_3878 r0 *1 0,0
Xsg13cmos5l_decap_8_3878 VPWR VGND sg13cmos5l_decap_8
* cell instance sg13cmos5l_decap_8_3879 r0 *1 0,0
Xsg13cmos5l_decap_8_3879 VPWR VGND sg13cmos5l_decap_8
* cell instance sg13cmos5l_decap_8_3880 r0 *1 0,0
Xsg13cmos5l_decap_8_3880 VPWR VGND sg13cmos5l_decap_8
* cell instance sg13cmos5l_decap_8_3881 r0 *1 0,0
Xsg13cmos5l_decap_8_3881 VPWR VGND sg13cmos5l_decap_8
* cell instance sg13cmos5l_decap_8_3882 r0 *1 0,0
Xsg13cmos5l_decap_8_3882 VPWR VGND sg13cmos5l_decap_8
* cell instance sg13cmos5l_decap_8_3883 r0 *1 0,0
Xsg13cmos5l_decap_8_3883 VPWR VGND sg13cmos5l_decap_8
* cell instance sg13cmos5l_decap_8_3884 r0 *1 0,0
Xsg13cmos5l_decap_8_3884 VPWR VGND sg13cmos5l_decap_8
* cell instance sg13cmos5l_decap_8_3885 r0 *1 0,0
Xsg13cmos5l_decap_8_3885 VPWR VGND sg13cmos5l_decap_8
* cell instance sg13cmos5l_decap_8_3886 r0 *1 0,0
Xsg13cmos5l_decap_8_3886 VPWR VGND sg13cmos5l_decap_8
* cell instance sg13cmos5l_decap_8_3887 r0 *1 0,0
Xsg13cmos5l_decap_8_3887 VPWR VGND sg13cmos5l_decap_8
* cell instance sg13cmos5l_decap_8_3888 r0 *1 0,0
Xsg13cmos5l_decap_8_3888 VPWR VGND sg13cmos5l_decap_8
* cell instance sg13cmos5l_decap_8_3889 r0 *1 0,0
Xsg13cmos5l_decap_8_3889 VPWR VGND sg13cmos5l_decap_8
* cell instance sg13cmos5l_decap_8_3890 r0 *1 0,0
Xsg13cmos5l_decap_8_3890 VPWR VGND sg13cmos5l_decap_8
* cell instance sg13cmos5l_decap_8_3891 r0 *1 0,0
Xsg13cmos5l_decap_8_3891 VPWR VGND sg13cmos5l_decap_8
* cell instance sg13cmos5l_decap_8_3892 r0 *1 0,0
Xsg13cmos5l_decap_8_3892 VPWR VGND sg13cmos5l_decap_8
* cell instance sg13cmos5l_decap_8_3893 r0 *1 0,0
Xsg13cmos5l_decap_8_3893 VPWR VGND sg13cmos5l_decap_8
* cell instance sg13cmos5l_decap_8_3894 r0 *1 0,0
Xsg13cmos5l_decap_8_3894 VPWR VGND sg13cmos5l_decap_8
* cell instance sg13cmos5l_decap_8_3895 r0 *1 0,0
Xsg13cmos5l_decap_8_3895 VPWR VGND sg13cmos5l_decap_8
* cell instance sg13cmos5l_decap_8_3896 r0 *1 0,0
Xsg13cmos5l_decap_8_3896 VPWR VGND sg13cmos5l_decap_8
* cell instance sg13cmos5l_decap_8_3897 r0 *1 0,0
Xsg13cmos5l_decap_8_3897 VPWR VGND sg13cmos5l_decap_8
* cell instance sg13cmos5l_decap_8_3898 r0 *1 0,0
Xsg13cmos5l_decap_8_3898 VPWR VGND sg13cmos5l_decap_8
* cell instance sg13cmos5l_decap_8_3899 r0 *1 0,0
Xsg13cmos5l_decap_8_3899 VPWR VGND sg13cmos5l_decap_8
* cell instance sg13cmos5l_decap_8_3900 r0 *1 0,0
Xsg13cmos5l_decap_8_3900 VPWR VGND sg13cmos5l_decap_8
* cell instance sg13cmos5l_decap_8_3901 r0 *1 0,0
Xsg13cmos5l_decap_8_3901 VPWR VGND sg13cmos5l_decap_8
* cell instance sg13cmos5l_decap_8_3902 r0 *1 0,0
Xsg13cmos5l_decap_8_3902 VPWR VGND sg13cmos5l_decap_8
* cell instance sg13cmos5l_decap_8_3903 r0 *1 0,0
Xsg13cmos5l_decap_8_3903 VPWR VGND sg13cmos5l_decap_8
* cell instance sg13cmos5l_decap_8_3904 r0 *1 0,0
Xsg13cmos5l_decap_8_3904 VPWR VGND sg13cmos5l_decap_8
* cell instance sg13cmos5l_decap_8_3905 r0 *1 0,0
Xsg13cmos5l_decap_8_3905 VPWR VGND sg13cmos5l_decap_8
* cell instance sg13cmos5l_decap_8_3906 r0 *1 0,0
Xsg13cmos5l_decap_8_3906 VPWR VGND sg13cmos5l_decap_8
* cell instance sg13cmos5l_decap_8_3907 r0 *1 0,0
Xsg13cmos5l_decap_8_3907 VPWR VGND sg13cmos5l_decap_8
* cell instance sg13cmos5l_decap_8_3908 r0 *1 0,0
Xsg13cmos5l_decap_8_3908 VPWR VGND sg13cmos5l_decap_8
* cell instance sg13cmos5l_decap_8_3909 r0 *1 0,0
Xsg13cmos5l_decap_8_3909 VPWR VGND sg13cmos5l_decap_8
* cell instance sg13cmos5l_decap_8_3910 r0 *1 0,0
Xsg13cmos5l_decap_8_3910 VPWR VGND sg13cmos5l_decap_8
* cell instance sg13cmos5l_decap_8_3911 r0 *1 0,0
Xsg13cmos5l_decap_8_3911 VPWR VGND sg13cmos5l_decap_8
* cell instance sg13cmos5l_decap_8_3912 r0 *1 0,0
Xsg13cmos5l_decap_8_3912 VPWR VGND sg13cmos5l_decap_8
* cell instance sg13cmos5l_decap_8_3913 r0 *1 0,0
Xsg13cmos5l_decap_8_3913 VPWR VGND sg13cmos5l_decap_8
* cell instance sg13cmos5l_decap_8_3914 r0 *1 0,0
Xsg13cmos5l_decap_8_3914 VPWR VGND sg13cmos5l_decap_8
* cell instance sg13cmos5l_decap_8_3915 r0 *1 0,0
Xsg13cmos5l_decap_8_3915 VPWR VGND sg13cmos5l_decap_8
* cell instance sg13cmos5l_decap_8_3916 r0 *1 0,0
Xsg13cmos5l_decap_8_3916 VPWR VGND sg13cmos5l_decap_8
* cell instance sg13cmos5l_decap_8_3917 r0 *1 0,0
Xsg13cmos5l_decap_8_3917 VPWR VGND sg13cmos5l_decap_8
* cell instance sg13cmos5l_decap_8_3918 r0 *1 0,0
Xsg13cmos5l_decap_8_3918 VPWR VGND sg13cmos5l_decap_8
* cell instance sg13cmos5l_decap_8_3919 r0 *1 0,0
Xsg13cmos5l_decap_8_3919 VPWR VGND sg13cmos5l_decap_8
* cell instance sg13cmos5l_decap_8_3920 r0 *1 0,0
Xsg13cmos5l_decap_8_3920 VPWR VGND sg13cmos5l_decap_8
* cell instance sg13cmos5l_decap_8_3921 r0 *1 0,0
Xsg13cmos5l_decap_8_3921 VPWR VGND sg13cmos5l_decap_8
* cell instance sg13cmos5l_decap_8_3922 r0 *1 0,0
Xsg13cmos5l_decap_8_3922 VPWR VGND sg13cmos5l_decap_8
* cell instance sg13cmos5l_decap_8_3923 r0 *1 0,0
Xsg13cmos5l_decap_8_3923 VPWR VGND sg13cmos5l_decap_8
* cell instance sg13cmos5l_decap_8_3924 r0 *1 0,0
Xsg13cmos5l_decap_8_3924 VPWR VGND sg13cmos5l_decap_8
* cell instance sg13cmos5l_decap_8_3925 r0 *1 0,0
Xsg13cmos5l_decap_8_3925 VPWR VGND sg13cmos5l_decap_8
* cell instance sg13cmos5l_decap_8_3926 r0 *1 0,0
Xsg13cmos5l_decap_8_3926 VPWR VGND sg13cmos5l_decap_8
* cell instance sg13cmos5l_decap_8_3927 r0 *1 0,0
Xsg13cmos5l_decap_8_3927 VPWR VGND sg13cmos5l_decap_8
* cell instance sg13cmos5l_decap_8_3928 r0 *1 0,0
Xsg13cmos5l_decap_8_3928 VPWR VGND sg13cmos5l_decap_8
* cell instance sg13cmos5l_decap_8_3929 r0 *1 0,0
Xsg13cmos5l_decap_8_3929 VPWR VGND sg13cmos5l_decap_8
* cell instance sg13cmos5l_decap_8_3930 r0 *1 0,0
Xsg13cmos5l_decap_8_3930 VPWR VGND sg13cmos5l_decap_8
* cell instance sg13cmos5l_decap_8_3931 r0 *1 0,0
Xsg13cmos5l_decap_8_3931 VPWR VGND sg13cmos5l_decap_8
* cell instance sg13cmos5l_decap_8_3932 r0 *1 0,0
Xsg13cmos5l_decap_8_3932 VPWR VGND sg13cmos5l_decap_8
* cell instance sg13cmos5l_decap_8_3933 r0 *1 0,0
Xsg13cmos5l_decap_8_3933 VPWR VGND sg13cmos5l_decap_8
* cell instance sg13cmos5l_decap_8_3934 r0 *1 0,0
Xsg13cmos5l_decap_8_3934 VPWR VGND sg13cmos5l_decap_8
* cell instance sg13cmos5l_decap_8_3935 r0 *1 0,0
Xsg13cmos5l_decap_8_3935 VPWR VGND sg13cmos5l_decap_8
* cell instance sg13cmos5l_decap_8_3936 r0 *1 0,0
Xsg13cmos5l_decap_8_3936 VPWR VGND sg13cmos5l_decap_8
* cell instance sg13cmos5l_decap_8_3937 r0 *1 0,0
Xsg13cmos5l_decap_8_3937 VPWR VGND sg13cmos5l_decap_8
* cell instance sg13cmos5l_decap_8_3938 r0 *1 0,0
Xsg13cmos5l_decap_8_3938 VPWR VGND sg13cmos5l_decap_8
* cell instance sg13cmos5l_decap_8_3939 r0 *1 0,0
Xsg13cmos5l_decap_8_3939 VPWR VGND sg13cmos5l_decap_8
* cell instance sg13cmos5l_decap_8_3940 r0 *1 0,0
Xsg13cmos5l_decap_8_3940 VPWR VGND sg13cmos5l_decap_8
* cell instance sg13cmos5l_decap_8_3941 r0 *1 0,0
Xsg13cmos5l_decap_8_3941 VPWR VGND sg13cmos5l_decap_8
* cell instance sg13cmos5l_decap_8_3942 r0 *1 0,0
Xsg13cmos5l_decap_8_3942 VPWR VGND sg13cmos5l_decap_8
* cell instance sg13cmos5l_decap_8_3943 r0 *1 0,0
Xsg13cmos5l_decap_8_3943 VPWR VGND sg13cmos5l_decap_8
* cell instance sg13cmos5l_decap_8_3944 r0 *1 0,0
Xsg13cmos5l_decap_8_3944 VPWR VGND sg13cmos5l_decap_8
* cell instance sg13cmos5l_decap_8_3945 r0 *1 0,0
Xsg13cmos5l_decap_8_3945 VPWR VGND sg13cmos5l_decap_8
* cell instance sg13cmos5l_decap_8_3946 r0 *1 0,0
Xsg13cmos5l_decap_8_3946 VPWR VGND sg13cmos5l_decap_8
* cell instance sg13cmos5l_decap_8_3947 r0 *1 0,0
Xsg13cmos5l_decap_8_3947 VPWR VGND sg13cmos5l_decap_8
* cell instance sg13cmos5l_decap_8_3948 r0 *1 0,0
Xsg13cmos5l_decap_8_3948 VPWR VGND sg13cmos5l_decap_8
* cell instance sg13cmos5l_decap_8_3949 r0 *1 0,0
Xsg13cmos5l_decap_8_3949 VPWR VGND sg13cmos5l_decap_8
* cell instance sg13cmos5l_decap_8_3950 r0 *1 0,0
Xsg13cmos5l_decap_8_3950 VPWR VGND sg13cmos5l_decap_8
* cell instance sg13cmos5l_decap_8_3951 r0 *1 0,0
Xsg13cmos5l_decap_8_3951 VPWR VGND sg13cmos5l_decap_8
* cell instance sg13cmos5l_decap_8_3952 r0 *1 0,0
Xsg13cmos5l_decap_8_3952 VPWR VGND sg13cmos5l_decap_8
* cell instance sg13cmos5l_decap_8_3953 r0 *1 0,0
Xsg13cmos5l_decap_8_3953 VPWR VGND sg13cmos5l_decap_8
* cell instance sg13cmos5l_decap_8_3954 r0 *1 0,0
Xsg13cmos5l_decap_8_3954 VPWR VGND sg13cmos5l_decap_8
* cell instance sg13cmos5l_decap_8_3955 r0 *1 0,0
Xsg13cmos5l_decap_8_3955 VPWR VGND sg13cmos5l_decap_8
* cell instance sg13cmos5l_decap_8_3956 r0 *1 0,0
Xsg13cmos5l_decap_8_3956 VPWR VGND sg13cmos5l_decap_8
* cell instance sg13cmos5l_decap_8_3957 r0 *1 0,0
Xsg13cmos5l_decap_8_3957 VPWR VGND sg13cmos5l_decap_8
* cell instance sg13cmos5l_decap_8_3958 r0 *1 0,0
Xsg13cmos5l_decap_8_3958 VPWR VGND sg13cmos5l_decap_8
* cell instance sg13cmos5l_decap_8_3959 r0 *1 0,0
Xsg13cmos5l_decap_8_3959 VPWR VGND sg13cmos5l_decap_8
* cell instance sg13cmos5l_decap_8_3960 r0 *1 0,0
Xsg13cmos5l_decap_8_3960 VPWR VGND sg13cmos5l_decap_8
* cell instance sg13cmos5l_decap_8_3961 r0 *1 0,0
Xsg13cmos5l_decap_8_3961 VPWR VGND sg13cmos5l_decap_8
* cell instance sg13cmos5l_decap_8_3962 r0 *1 0,0
Xsg13cmos5l_decap_8_3962 VPWR VGND sg13cmos5l_decap_8
* cell instance sg13cmos5l_decap_8_3963 r0 *1 0,0
Xsg13cmos5l_decap_8_3963 VPWR VGND sg13cmos5l_decap_8
* cell instance sg13cmos5l_decap_8_3964 r0 *1 0,0
Xsg13cmos5l_decap_8_3964 VPWR VGND sg13cmos5l_decap_8
* cell instance sg13cmos5l_decap_8_3965 r0 *1 0,0
Xsg13cmos5l_decap_8_3965 VPWR VGND sg13cmos5l_decap_8
* cell instance sg13cmos5l_decap_8_3966 r0 *1 0,0
Xsg13cmos5l_decap_8_3966 VPWR VGND sg13cmos5l_decap_8
* cell instance sg13cmos5l_decap_8_3967 r0 *1 0,0
Xsg13cmos5l_decap_8_3967 VPWR VGND sg13cmos5l_decap_8
* cell instance sg13cmos5l_decap_8_3968 r0 *1 0,0
Xsg13cmos5l_decap_8_3968 VPWR VGND sg13cmos5l_decap_8
* cell instance sg13cmos5l_decap_8_3969 r0 *1 0,0
Xsg13cmos5l_decap_8_3969 VPWR VGND sg13cmos5l_decap_8
* cell instance sg13cmos5l_decap_8_3970 r0 *1 0,0
Xsg13cmos5l_decap_8_3970 VPWR VGND sg13cmos5l_decap_8
* cell instance sg13cmos5l_decap_8_3971 r0 *1 0,0
Xsg13cmos5l_decap_8_3971 VPWR VGND sg13cmos5l_decap_8
* cell instance sg13cmos5l_decap_8_3972 r0 *1 0,0
Xsg13cmos5l_decap_8_3972 VPWR VGND sg13cmos5l_decap_8
* cell instance sg13cmos5l_decap_8_3973 r0 *1 0,0
Xsg13cmos5l_decap_8_3973 VPWR VGND sg13cmos5l_decap_8
* cell instance sg13cmos5l_decap_8_3974 r0 *1 0,0
Xsg13cmos5l_decap_8_3974 VPWR VGND sg13cmos5l_decap_8
* cell instance sg13cmos5l_decap_8_3975 r0 *1 0,0
Xsg13cmos5l_decap_8_3975 VPWR VGND sg13cmos5l_decap_8
* cell instance sg13cmos5l_decap_8_3976 r0 *1 0,0
Xsg13cmos5l_decap_8_3976 VPWR VGND sg13cmos5l_decap_8
* cell instance sg13cmos5l_decap_8_3977 r0 *1 0,0
Xsg13cmos5l_decap_8_3977 VPWR VGND sg13cmos5l_decap_8
* cell instance sg13cmos5l_decap_8_3978 r0 *1 0,0
Xsg13cmos5l_decap_8_3978 VPWR VGND sg13cmos5l_decap_8
* cell instance sg13cmos5l_decap_8_3979 r0 *1 0,0
Xsg13cmos5l_decap_8_3979 VPWR VGND sg13cmos5l_decap_8
* cell instance sg13cmos5l_decap_8_3980 r0 *1 0,0
Xsg13cmos5l_decap_8_3980 VPWR VGND sg13cmos5l_decap_8
* cell instance sg13cmos5l_decap_8_3981 r0 *1 0,0
Xsg13cmos5l_decap_8_3981 VPWR VGND sg13cmos5l_decap_8
* cell instance sg13cmos5l_decap_8_3982 r0 *1 0,0
Xsg13cmos5l_decap_8_3982 VPWR VGND sg13cmos5l_decap_8
* cell instance sg13cmos5l_decap_8_3983 r0 *1 0,0
Xsg13cmos5l_decap_8_3983 VPWR VGND sg13cmos5l_decap_8
* cell instance sg13cmos5l_decap_8_3984 r0 *1 0,0
Xsg13cmos5l_decap_8_3984 VPWR VGND sg13cmos5l_decap_8
* cell instance sg13cmos5l_decap_8_3985 r0 *1 0,0
Xsg13cmos5l_decap_8_3985 VPWR VGND sg13cmos5l_decap_8
* cell instance sg13cmos5l_decap_8_3986 r0 *1 0,0
Xsg13cmos5l_decap_8_3986 VPWR VGND sg13cmos5l_decap_8
* cell instance sg13cmos5l_decap_8_3987 r0 *1 0,0
Xsg13cmos5l_decap_8_3987 VPWR VGND sg13cmos5l_decap_8
* cell instance sg13cmos5l_decap_8_3988 r0 *1 0,0
Xsg13cmos5l_decap_8_3988 VPWR VGND sg13cmos5l_decap_8
* cell instance sg13cmos5l_decap_8_3989 r0 *1 0,0
Xsg13cmos5l_decap_8_3989 VPWR VGND sg13cmos5l_decap_8
* cell instance sg13cmos5l_decap_8_3990 r0 *1 0,0
Xsg13cmos5l_decap_8_3990 VPWR VGND sg13cmos5l_decap_8
* cell instance sg13cmos5l_decap_8_3991 r0 *1 0,0
Xsg13cmos5l_decap_8_3991 VPWR VGND sg13cmos5l_decap_8
* cell instance sg13cmos5l_decap_8_3992 r0 *1 0,0
Xsg13cmos5l_decap_8_3992 VPWR VGND sg13cmos5l_decap_8
* cell instance sg13cmos5l_decap_8_3993 r0 *1 0,0
Xsg13cmos5l_decap_8_3993 VPWR VGND sg13cmos5l_decap_8
* cell instance sg13cmos5l_decap_8_3994 r0 *1 0,0
Xsg13cmos5l_decap_8_3994 VPWR VGND sg13cmos5l_decap_8
* cell instance sg13cmos5l_decap_8_3995 r0 *1 0,0
Xsg13cmos5l_decap_8_3995 VPWR VGND sg13cmos5l_decap_8
* cell instance sg13cmos5l_decap_8_3996 r0 *1 0,0
Xsg13cmos5l_decap_8_3996 VPWR VGND sg13cmos5l_decap_8
* cell instance sg13cmos5l_decap_8_3997 r0 *1 0,0
Xsg13cmos5l_decap_8_3997 VPWR VGND sg13cmos5l_decap_8
* cell instance sg13cmos5l_decap_8_3998 r0 *1 0,0
Xsg13cmos5l_decap_8_3998 VPWR VGND sg13cmos5l_decap_8
* cell instance sg13cmos5l_decap_8_3999 r0 *1 0,0
Xsg13cmos5l_decap_8_3999 VPWR VGND sg13cmos5l_decap_8
* cell instance sg13cmos5l_decap_8_4000 r0 *1 0,0
Xsg13cmos5l_decap_8_4000 VPWR VGND sg13cmos5l_decap_8
* cell instance sg13cmos5l_decap_8_4001 r0 *1 0,0
Xsg13cmos5l_decap_8_4001 VPWR VGND sg13cmos5l_decap_8
* cell instance sg13cmos5l_decap_8_4002 r0 *1 0,0
Xsg13cmos5l_decap_8_4002 VPWR VGND sg13cmos5l_decap_8
* cell instance sg13cmos5l_decap_8_4003 r0 *1 0,0
Xsg13cmos5l_decap_8_4003 VPWR VGND sg13cmos5l_decap_8
* cell instance sg13cmos5l_decap_8_4004 r0 *1 0,0
Xsg13cmos5l_decap_8_4004 VPWR VGND sg13cmos5l_decap_8
* cell instance sg13cmos5l_decap_8_4005 r0 *1 0,0
Xsg13cmos5l_decap_8_4005 VPWR VGND sg13cmos5l_decap_8
* cell instance sg13cmos5l_decap_8_4006 r0 *1 0,0
Xsg13cmos5l_decap_8_4006 VPWR VGND sg13cmos5l_decap_8
* cell instance sg13cmos5l_decap_8_4007 r0 *1 0,0
Xsg13cmos5l_decap_8_4007 VPWR VGND sg13cmos5l_decap_8
* cell instance sg13cmos5l_decap_8_4008 r0 *1 0,0
Xsg13cmos5l_decap_8_4008 VPWR VGND sg13cmos5l_decap_8
* cell instance sg13cmos5l_decap_8_4009 r0 *1 0,0
Xsg13cmos5l_decap_8_4009 VPWR VGND sg13cmos5l_decap_8
* cell instance sg13cmos5l_decap_8_4010 r0 *1 0,0
Xsg13cmos5l_decap_8_4010 VPWR VGND sg13cmos5l_decap_8
* cell instance sg13cmos5l_decap_8_4011 r0 *1 0,0
Xsg13cmos5l_decap_8_4011 VPWR VGND sg13cmos5l_decap_8
* cell instance sg13cmos5l_decap_8_4012 r0 *1 0,0
Xsg13cmos5l_decap_8_4012 VPWR VGND sg13cmos5l_decap_8
* cell instance sg13cmos5l_decap_8_4013 r0 *1 0,0
Xsg13cmos5l_decap_8_4013 VPWR VGND sg13cmos5l_decap_8
* cell instance sg13cmos5l_decap_8_4014 r0 *1 0,0
Xsg13cmos5l_decap_8_4014 VPWR VGND sg13cmos5l_decap_8
* cell instance sg13cmos5l_decap_8_4015 r0 *1 0,0
Xsg13cmos5l_decap_8_4015 VPWR VGND sg13cmos5l_decap_8
* cell instance sg13cmos5l_decap_8_4016 r0 *1 0,0
Xsg13cmos5l_decap_8_4016 VPWR VGND sg13cmos5l_decap_8
* cell instance sg13cmos5l_decap_8_4017 r0 *1 0,0
Xsg13cmos5l_decap_8_4017 VPWR VGND sg13cmos5l_decap_8
* cell instance sg13cmos5l_decap_8_4018 r0 *1 0,0
Xsg13cmos5l_decap_8_4018 VPWR VGND sg13cmos5l_decap_8
* cell instance sg13cmos5l_decap_8_4019 r0 *1 0,0
Xsg13cmos5l_decap_8_4019 VPWR VGND sg13cmos5l_decap_8
* cell instance sg13cmos5l_decap_8_4020 r0 *1 0,0
Xsg13cmos5l_decap_8_4020 VPWR VGND sg13cmos5l_decap_8
* cell instance sg13cmos5l_decap_8_4021 r0 *1 0,0
Xsg13cmos5l_decap_8_4021 VPWR VGND sg13cmos5l_decap_8
* cell instance sg13cmos5l_decap_8_4022 r0 *1 0,0
Xsg13cmos5l_decap_8_4022 VPWR VGND sg13cmos5l_decap_8
* cell instance sg13cmos5l_decap_8_4023 r0 *1 0,0
Xsg13cmos5l_decap_8_4023 VPWR VGND sg13cmos5l_decap_8
* cell instance sg13cmos5l_decap_8_4024 r0 *1 0,0
Xsg13cmos5l_decap_8_4024 VPWR VGND sg13cmos5l_decap_8
* cell instance sg13cmos5l_decap_8_4025 r0 *1 0,0
Xsg13cmos5l_decap_8_4025 VPWR VGND sg13cmos5l_decap_8
* cell instance sg13cmos5l_decap_8_4026 r0 *1 0,0
Xsg13cmos5l_decap_8_4026 VPWR VGND sg13cmos5l_decap_8
* cell instance sg13cmos5l_decap_8_4027 r0 *1 0,0
Xsg13cmos5l_decap_8_4027 VPWR VGND sg13cmos5l_decap_8
* cell instance sg13cmos5l_decap_8_4028 r0 *1 0,0
Xsg13cmos5l_decap_8_4028 VPWR VGND sg13cmos5l_decap_8
* cell instance sg13cmos5l_decap_8_4029 r0 *1 0,0
Xsg13cmos5l_decap_8_4029 VPWR VGND sg13cmos5l_decap_8
* cell instance sg13cmos5l_decap_8_4030 r0 *1 0,0
Xsg13cmos5l_decap_8_4030 VPWR VGND sg13cmos5l_decap_8
* cell instance sg13cmos5l_decap_8_4031 r0 *1 0,0
Xsg13cmos5l_decap_8_4031 VPWR VGND sg13cmos5l_decap_8
* cell instance sg13cmos5l_decap_8_4032 r0 *1 0,0
Xsg13cmos5l_decap_8_4032 VPWR VGND sg13cmos5l_decap_8
* cell instance sg13cmos5l_decap_8_4033 r0 *1 0,0
Xsg13cmos5l_decap_8_4033 VPWR VGND sg13cmos5l_decap_8
* cell instance sg13cmos5l_decap_8_4034 r0 *1 0,0
Xsg13cmos5l_decap_8_4034 VPWR VGND sg13cmos5l_decap_8
* cell instance sg13cmos5l_decap_8_4035 r0 *1 0,0
Xsg13cmos5l_decap_8_4035 VPWR VGND sg13cmos5l_decap_8
* cell instance sg13cmos5l_decap_8_4036 r0 *1 0,0
Xsg13cmos5l_decap_8_4036 VPWR VGND sg13cmos5l_decap_8
* cell instance sg13cmos5l_decap_8_4037 r0 *1 0,0
Xsg13cmos5l_decap_8_4037 VPWR VGND sg13cmos5l_decap_8
* cell instance sg13cmos5l_decap_8_4038 r0 *1 0,0
Xsg13cmos5l_decap_8_4038 VPWR VGND sg13cmos5l_decap_8
* cell instance sg13cmos5l_decap_8_4039 r0 *1 0,0
Xsg13cmos5l_decap_8_4039 VPWR VGND sg13cmos5l_decap_8
* cell instance sg13cmos5l_decap_8_4040 r0 *1 0,0
Xsg13cmos5l_decap_8_4040 VPWR VGND sg13cmos5l_decap_8
* cell instance sg13cmos5l_decap_8_4041 r0 *1 0,0
Xsg13cmos5l_decap_8_4041 VPWR VGND sg13cmos5l_decap_8
* cell instance sg13cmos5l_decap_8_4042 r0 *1 0,0
Xsg13cmos5l_decap_8_4042 VPWR VGND sg13cmos5l_decap_8
* cell instance sg13cmos5l_decap_8_4043 r0 *1 0,0
Xsg13cmos5l_decap_8_4043 VPWR VGND sg13cmos5l_decap_8
* cell instance sg13cmos5l_decap_8_4044 r0 *1 0,0
Xsg13cmos5l_decap_8_4044 VPWR VGND sg13cmos5l_decap_8
* cell instance sg13cmos5l_decap_8_4045 r0 *1 0,0
Xsg13cmos5l_decap_8_4045 VPWR VGND sg13cmos5l_decap_8
* cell instance sg13cmos5l_decap_8_4046 r0 *1 0,0
Xsg13cmos5l_decap_8_4046 VPWR VGND sg13cmos5l_decap_8
* cell instance sg13cmos5l_decap_8_4047 r0 *1 0,0
Xsg13cmos5l_decap_8_4047 VPWR VGND sg13cmos5l_decap_8
* cell instance sg13cmos5l_decap_8_4048 r0 *1 0,0
Xsg13cmos5l_decap_8_4048 VPWR VGND sg13cmos5l_decap_8
* cell instance sg13cmos5l_decap_8_4049 r0 *1 0,0
Xsg13cmos5l_decap_8_4049 VPWR VGND sg13cmos5l_decap_8
* cell instance sg13cmos5l_decap_8_4050 r0 *1 0,0
Xsg13cmos5l_decap_8_4050 VPWR VGND sg13cmos5l_decap_8
* cell instance sg13cmos5l_decap_8_4051 r0 *1 0,0
Xsg13cmos5l_decap_8_4051 VPWR VGND sg13cmos5l_decap_8
* cell instance sg13cmos5l_decap_8_4052 r0 *1 0,0
Xsg13cmos5l_decap_8_4052 VPWR VGND sg13cmos5l_decap_8
* cell instance sg13cmos5l_decap_8_4053 r0 *1 0,0
Xsg13cmos5l_decap_8_4053 VPWR VGND sg13cmos5l_decap_8
* cell instance sg13cmos5l_decap_8_4054 r0 *1 0,0
Xsg13cmos5l_decap_8_4054 VPWR VGND sg13cmos5l_decap_8
* cell instance sg13cmos5l_decap_8_4055 r0 *1 0,0
Xsg13cmos5l_decap_8_4055 VPWR VGND sg13cmos5l_decap_8
* cell instance sg13cmos5l_decap_8_4056 r0 *1 0,0
Xsg13cmos5l_decap_8_4056 VPWR VGND sg13cmos5l_decap_8
* cell instance sg13cmos5l_decap_8_4057 r0 *1 0,0
Xsg13cmos5l_decap_8_4057 VPWR VGND sg13cmos5l_decap_8
* cell instance sg13cmos5l_decap_8_4058 r0 *1 0,0
Xsg13cmos5l_decap_8_4058 VPWR VGND sg13cmos5l_decap_8
* cell instance sg13cmos5l_decap_8_4059 r0 *1 0,0
Xsg13cmos5l_decap_8_4059 VPWR VGND sg13cmos5l_decap_8
* cell instance sg13cmos5l_decap_8_4060 r0 *1 0,0
Xsg13cmos5l_decap_8_4060 VPWR VGND sg13cmos5l_decap_8
* cell instance sg13cmos5l_decap_8_4061 r0 *1 0,0
Xsg13cmos5l_decap_8_4061 VPWR VGND sg13cmos5l_decap_8
* cell instance sg13cmos5l_decap_8_4062 r0 *1 0,0
Xsg13cmos5l_decap_8_4062 VPWR VGND sg13cmos5l_decap_8
* cell instance sg13cmos5l_decap_8_4063 r0 *1 0,0
Xsg13cmos5l_decap_8_4063 VPWR VGND sg13cmos5l_decap_8
* cell instance sg13cmos5l_decap_8_4064 r0 *1 0,0
Xsg13cmos5l_decap_8_4064 VPWR VGND sg13cmos5l_decap_8
* cell instance sg13cmos5l_decap_8_4065 r0 *1 0,0
Xsg13cmos5l_decap_8_4065 VPWR VGND sg13cmos5l_decap_8
* cell instance sg13cmos5l_decap_8_4066 r0 *1 0,0
Xsg13cmos5l_decap_8_4066 VPWR VGND sg13cmos5l_decap_8
* cell instance sg13cmos5l_decap_8_4067 r0 *1 0,0
Xsg13cmos5l_decap_8_4067 VPWR VGND sg13cmos5l_decap_8
* cell instance sg13cmos5l_decap_8_4068 r0 *1 0,0
Xsg13cmos5l_decap_8_4068 VPWR VGND sg13cmos5l_decap_8
* cell instance sg13cmos5l_decap_8_4069 r0 *1 0,0
Xsg13cmos5l_decap_8_4069 VPWR VGND sg13cmos5l_decap_8
* cell instance sg13cmos5l_decap_8_4070 r0 *1 0,0
Xsg13cmos5l_decap_8_4070 VPWR VGND sg13cmos5l_decap_8
* cell instance sg13cmos5l_decap_8_4071 r0 *1 0,0
Xsg13cmos5l_decap_8_4071 VPWR VGND sg13cmos5l_decap_8
* cell instance sg13cmos5l_decap_8_4072 r0 *1 0,0
Xsg13cmos5l_decap_8_4072 VPWR VGND sg13cmos5l_decap_8
* cell instance sg13cmos5l_decap_8_4073 r0 *1 0,0
Xsg13cmos5l_decap_8_4073 VPWR VGND sg13cmos5l_decap_8
* cell instance sg13cmos5l_decap_8_4074 r0 *1 0,0
Xsg13cmos5l_decap_8_4074 VPWR VGND sg13cmos5l_decap_8
* cell instance sg13cmos5l_decap_8_4075 r0 *1 0,0
Xsg13cmos5l_decap_8_4075 VPWR VGND sg13cmos5l_decap_8
* cell instance sg13cmos5l_decap_8_4076 r0 *1 0,0
Xsg13cmos5l_decap_8_4076 VPWR VGND sg13cmos5l_decap_8
* cell instance sg13cmos5l_decap_8_4077 r0 *1 0,0
Xsg13cmos5l_decap_8_4077 VPWR VGND sg13cmos5l_decap_8
* cell instance sg13cmos5l_decap_8_4078 r0 *1 0,0
Xsg13cmos5l_decap_8_4078 VPWR VGND sg13cmos5l_decap_8
* cell instance sg13cmos5l_decap_8_4079 r0 *1 0,0
Xsg13cmos5l_decap_8_4079 VPWR VGND sg13cmos5l_decap_8
* cell instance sg13cmos5l_decap_8_4080 r0 *1 0,0
Xsg13cmos5l_decap_8_4080 VPWR VGND sg13cmos5l_decap_8
* cell instance sg13cmos5l_decap_8_4081 r0 *1 0,0
Xsg13cmos5l_decap_8_4081 VPWR VGND sg13cmos5l_decap_8
* cell instance sg13cmos5l_decap_8_4082 r0 *1 0,0
Xsg13cmos5l_decap_8_4082 VPWR VGND sg13cmos5l_decap_8
* cell instance sg13cmos5l_decap_8_4083 r0 *1 0,0
Xsg13cmos5l_decap_8_4083 VPWR VGND sg13cmos5l_decap_8
* cell instance sg13cmos5l_decap_8_4084 r0 *1 0,0
Xsg13cmos5l_decap_8_4084 VPWR VGND sg13cmos5l_decap_8
* cell instance sg13cmos5l_decap_8_4085 r0 *1 0,0
Xsg13cmos5l_decap_8_4085 VPWR VGND sg13cmos5l_decap_8
* cell instance sg13cmos5l_decap_8_4086 r0 *1 0,0
Xsg13cmos5l_decap_8_4086 VPWR VGND sg13cmos5l_decap_8
* cell instance sg13cmos5l_decap_8_4087 r0 *1 0,0
Xsg13cmos5l_decap_8_4087 VPWR VGND sg13cmos5l_decap_8
* cell instance sg13cmos5l_decap_8_4088 r0 *1 0,0
Xsg13cmos5l_decap_8_4088 VPWR VGND sg13cmos5l_decap_8
* cell instance sg13cmos5l_decap_8_4089 r0 *1 0,0
Xsg13cmos5l_decap_8_4089 VPWR VGND sg13cmos5l_decap_8
* cell instance sg13cmos5l_decap_8_4090 r0 *1 0,0
Xsg13cmos5l_decap_8_4090 VPWR VGND sg13cmos5l_decap_8
* cell instance sg13cmos5l_decap_8_4091 r0 *1 0,0
Xsg13cmos5l_decap_8_4091 VPWR VGND sg13cmos5l_decap_8
* cell instance sg13cmos5l_decap_8_4092 r0 *1 0,0
Xsg13cmos5l_decap_8_4092 VPWR VGND sg13cmos5l_decap_8
* cell instance sg13cmos5l_decap_8_4093 r0 *1 0,0
Xsg13cmos5l_decap_8_4093 VPWR VGND sg13cmos5l_decap_8
* cell instance sg13cmos5l_decap_8_4094 r0 *1 0,0
Xsg13cmos5l_decap_8_4094 VPWR VGND sg13cmos5l_decap_8
* cell instance sg13cmos5l_decap_8_4095 r0 *1 0,0
Xsg13cmos5l_decap_8_4095 VPWR VGND sg13cmos5l_decap_8
* cell instance sg13cmos5l_decap_8_4096 r0 *1 0,0
Xsg13cmos5l_decap_8_4096 VPWR VGND sg13cmos5l_decap_8
* cell instance sg13cmos5l_decap_8_4097 r0 *1 0,0
Xsg13cmos5l_decap_8_4097 VPWR VGND sg13cmos5l_decap_8
* cell instance sg13cmos5l_decap_8_4098 r0 *1 0,0
Xsg13cmos5l_decap_8_4098 VPWR VGND sg13cmos5l_decap_8
* cell instance sg13cmos5l_decap_8_4099 r0 *1 0,0
Xsg13cmos5l_decap_8_4099 VPWR VGND sg13cmos5l_decap_8
* cell instance sg13cmos5l_decap_8_4100 r0 *1 0,0
Xsg13cmos5l_decap_8_4100 VPWR VGND sg13cmos5l_decap_8
* cell instance sg13cmos5l_decap_8_4101 r0 *1 0,0
Xsg13cmos5l_decap_8_4101 VPWR VGND sg13cmos5l_decap_8
* cell instance sg13cmos5l_decap_8_4102 r0 *1 0,0
Xsg13cmos5l_decap_8_4102 VPWR VGND sg13cmos5l_decap_8
* cell instance sg13cmos5l_decap_8_4103 r0 *1 0,0
Xsg13cmos5l_decap_8_4103 VPWR VGND sg13cmos5l_decap_8
* cell instance sg13cmos5l_decap_8_4104 r0 *1 0,0
Xsg13cmos5l_decap_8_4104 VPWR VGND sg13cmos5l_decap_8
* cell instance sg13cmos5l_decap_8_4105 r0 *1 0,0
Xsg13cmos5l_decap_8_4105 VPWR VGND sg13cmos5l_decap_8
* cell instance sg13cmos5l_dfrbpq_1_0 r0 *1 0,0
Xsg13cmos5l_dfrbpq_1_0 \$5033 \$4961 \$4965 \$4133 VPWR VGND sg13cmos5l_dfrbpq_1
* cell instance sg13cmos5l_dfrbpq_1_1 r0 *1 0,0
Xsg13cmos5l_dfrbpq_1_1 \$5033 \$5042 \$5035 \$5231 VPWR VGND sg13cmos5l_dfrbpq_1
* cell instance sg13cmos5l_dfrbpq_1_2 r0 *1 0,0
Xsg13cmos5l_dfrbpq_1_2 \$5033 \$5596 \$5862 \$5231 VPWR VGND sg13cmos5l_dfrbpq_1
* cell instance sg13cmos5l_dfrbpq_1_3 r0 *1 0,0
Xsg13cmos5l_dfrbpq_1_3 \$5417 \$6011 \$5868 \$5231 VPWR VGND sg13cmos5l_dfrbpq_1
* cell instance sg13cmos5l_dfrbpq_1_4 r0 *1 0,0
Xsg13cmos5l_dfrbpq_1_4 \$5417 \$6383 \$6406 \$5231 VPWR VGND sg13cmos5l_dfrbpq_1
* cell instance sg13cmos5l_dfrbpq_1_5 r0 *1 0,0
Xsg13cmos5l_dfrbpq_1_5 \$7068 \$6856 \$6625 \$7067 VPWR VGND sg13cmos5l_dfrbpq_1
* cell instance sg13cmos5l_dfrbpq_1_6 r0 *1 0,0
Xsg13cmos5l_dfrbpq_1_6 \$7232 \$7171 \$7203 \$7067 VPWR VGND sg13cmos5l_dfrbpq_1
* cell instance sg13cmos5l_dfrbpq_1_7 r0 *1 0,0
Xsg13cmos5l_dfrbpq_1_7 \$7068 \$7338 \$7282 \$7067 VPWR VGND sg13cmos5l_dfrbpq_1
* cell instance sg13cmos5l_dfrbpq_1_8 r0 *1 0,0
Xsg13cmos5l_dfrbpq_1_8 \$7068 \$8396 \$8994 \$7067 VPWR VGND sg13cmos5l_dfrbpq_1
* cell instance sg13cmos5l_dfrbpq_1_9 r0 *1 0,0
Xsg13cmos5l_dfrbpq_1_9 \$7068 \$9421 \$9786 \$9906 VPWR VGND sg13cmos5l_dfrbpq_1
* cell instance sg13cmos5l_dfrbpq_1_10 r0 *1 0,0
Xsg13cmos5l_dfrbpq_1_10 \$1101 \$1095 \$1008 \$762 VPWR VGND sg13cmos5l_dfrbpq_1
* cell instance sg13cmos5l_dfrbpq_1_11 r0 *1 0,0
Xsg13cmos5l_dfrbpq_1_11 \$7068 \$10331 \$8995 \$9906 VPWR VGND
+ sg13cmos5l_dfrbpq_1
* cell instance sg13cmos5l_dfrbpq_1_12 r0 *1 0,0
Xsg13cmos5l_dfrbpq_1_12 \$5033 \$5351 \$5049 \$5231 VPWR VGND
+ sg13cmos5l_dfrbpq_1
* cell instance sg13cmos5l_dfrbpq_1_13 r0 *1 0,0
Xsg13cmos5l_dfrbpq_1_13 \$1101 \$1309 \$1212 \$762 VPWR VGND sg13cmos5l_dfrbpq_1
* cell instance sg13cmos5l_dfrbpq_1_14 r0 *1 0,0
Xsg13cmos5l_dfrbpq_1_14 \$11994 \$11544 \$11910 \$9906 VPWR VGND
+ sg13cmos5l_dfrbpq_1
* cell instance sg13cmos5l_dfrbpq_1_15 r0 *1 0,0
Xsg13cmos5l_dfrbpq_1_15 \$767 \$2000 \$2017 \$762 VPWR VGND sg13cmos5l_dfrbpq_1
* cell instance sg13cmos5l_dfrbpq_1_16 r0 *1 0,0
Xsg13cmos5l_dfrbpq_1_16 \$1101 \$1449 \$1666 \$762 VPWR VGND sg13cmos5l_dfrbpq_1
* cell instance sg13cmos5l_dfrbpq_1_17 r0 *1 0,0
Xsg13cmos5l_dfrbpq_1_17 \$5417 \$6859 \$6627 \$7067 VPWR VGND
+ sg13cmos5l_dfrbpq_1
* cell instance sg13cmos5l_dfrbpq_1_18 r0 *1 0,0
Xsg13cmos5l_dfrbpq_1_18 \$7232 \$7317 \$7239 \$7067 VPWR VGND
+ sg13cmos5l_dfrbpq_1
* cell instance sg13cmos5l_dfrbpq_1_19 r0 *1 0,0
Xsg13cmos5l_dfrbpq_1_19 \$5033 \$6016 \$6018 \$5231 VPWR VGND
+ sg13cmos5l_dfrbpq_1
* cell instance sg13cmos5l_dfrbpq_1_20 r0 *1 0,0
Xsg13cmos5l_dfrbpq_1_20 \$7068 \$9907 \$8996 \$9906 VPWR VGND
+ sg13cmos5l_dfrbpq_1
* cell instance sg13cmos5l_dfrbpq_1_21 r0 *1 0,0
Xsg13cmos5l_dfrbpq_1_21 \$7232 \$7783 \$7283 \$7950 VPWR VGND
+ sg13cmos5l_dfrbpq_1
* cell instance sg13cmos5l_dfrbpq_1_22 r0 *1 0,0
Xsg13cmos5l_dfrbpq_1_22 \$767 \$758 \$771 \$762 VPWR VGND sg13cmos5l_dfrbpq_1
* cell instance sg13cmos5l_dfrbpq_1_23 r0 *1 0,0
Xsg13cmos5l_dfrbpq_1_23 \$11994 \$12289 \$4290 \$9906 VPWR VGND
+ sg13cmos5l_dfrbpq_1
* cell instance sg13cmos5l_dfrbpq_1_24 r0 *1 0,0
Xsg13cmos5l_dfrbpq_1_24 \$767 \$1771 \$1782 \$762 VPWR VGND sg13cmos5l_dfrbpq_1
* cell instance sg13cmos5l_dfrbpq_1_25 r0 *1 0,0
Xsg13cmos5l_dfrbpq_1_25 \$5417 \$5091 \$5052 \$5231 VPWR VGND
+ sg13cmos5l_dfrbpq_1
* cell instance sg13cmos5l_dfrbpq_1_26 r0 *1 0,0
Xsg13cmos5l_dfrbpq_1_26 \$5033 \$5578 \$5584 \$5231 VPWR VGND
+ sg13cmos5l_dfrbpq_1
* cell instance sg13cmos5l_dfrbpq_1_27 r0 *1 0,0
Xsg13cmos5l_dfrbpq_1_27 \$11994 \$14823 \$3480 \$13502 VPWR VGND
+ sg13cmos5l_dfrbpq_1
* cell instance sg13cmos5l_dfrbpq_1_28 r0 *1 0,0
Xsg13cmos5l_dfrbpq_1_28 \$10517 \$10060 \$10345 \$10514 VPWR VGND
+ sg13cmos5l_dfrbpq_1
* cell instance sg13cmos5l_dfrbpq_1_29 r0 *1 0,0
Xsg13cmos5l_dfrbpq_1_29 \$7232 \$8406 \$9133 \$7067 VPWR VGND
+ sg13cmos5l_dfrbpq_1
* cell instance sg13cmos5l_dfrbpq_1_30 r0 *1 0,0
Xsg13cmos5l_dfrbpq_1_30 \$767 \$1453 \$1221 \$762 VPWR VGND sg13cmos5l_dfrbpq_1
* cell instance sg13cmos5l_dfrbpq_1_31 r0 *1 0,0
Xsg13cmos5l_dfrbpq_1_31 \$11994 \$13834 \$4144 \$10514 VPWR VGND
+ sg13cmos5l_dfrbpq_1
* cell instance sg13cmos5l_dfrbpq_1_32 r0 *1 0,0
Xsg13cmos5l_dfrbpq_1_32 \$11994 \$11913 \$4336 \$9906 VPWR VGND
+ sg13cmos5l_dfrbpq_1
* cell instance sg13cmos5l_dfrbpq_1_33 r0 *1 0,0
Xsg13cmos5l_dfrbpq_1_33 \$11994 \$16260 uio_out[5] \$13502 VPWR VGND
+ sg13cmos5l_dfrbpq_1
* cell instance sg13cmos5l_dfrbpq_1_34 r0 *1 0,0
Xsg13cmos5l_dfrbpq_1_34 \$10517 \$11384 \$5004 \$9906 VPWR VGND
+ sg13cmos5l_dfrbpq_1
* cell instance sg13cmos5l_dfrbpq_1_35 r0 *1 0,0
Xsg13cmos5l_dfrbpq_1_35 \$5417 \$6648 \$6586 \$7950 VPWR VGND
+ sg13cmos5l_dfrbpq_1
* cell instance sg13cmos5l_dfrbpq_1_36 r0 *1 0,0
Xsg13cmos5l_dfrbpq_1_36 \$5417 \$7161 \$7253 \$7067 VPWR VGND
+ sg13cmos5l_dfrbpq_1
* cell instance sg13cmos5l_dfrbpq_1_37 r0 *1 0,0
Xsg13cmos5l_dfrbpq_1_37 \$14807 \$16978 uio_out[6] \$13502 VPWR VGND
+ sg13cmos5l_dfrbpq_1
* cell instance sg13cmos5l_dfrbpq_1_38 r0 *1 0,0
Xsg13cmos5l_dfrbpq_1_38 \$7232 \$7339 \$7206 \$7950 VPWR VGND
+ sg13cmos5l_dfrbpq_1
* cell instance sg13cmos5l_dfrbpq_1_39 r0 *1 0,0
Xsg13cmos5l_dfrbpq_1_39 \$14807 \$16940 uio_out[7] \$13502 VPWR VGND
+ sg13cmos5l_dfrbpq_1
* cell instance sg13cmos5l_dfrbpq_1_40 r0 *1 0,0
Xsg13cmos5l_dfrbpq_1_40 \$767 \$655 \$667 \$762 VPWR VGND sg13cmos5l_dfrbpq_1
* cell instance sg13cmos5l_dfrbpq_1_41 r0 *1 0,0
Xsg13cmos5l_dfrbpq_1_41 \$12305 \$13019 \$4426 \$9906 VPWR VGND
+ sg13cmos5l_dfrbpq_1
* cell instance sg13cmos5l_dfrbpq_1_42 r0 *1 0,0
Xsg13cmos5l_dfrbpq_1_42 \$10517 \$9434 \$8548 \$10514 VPWR VGND
+ sg13cmos5l_dfrbpq_1
* cell instance sg13cmos5l_dfrbpq_1_43 r0 *1 0,0
Xsg13cmos5l_dfrbpq_1_43 \$14807 \$15261 uio_out[3] \$13502 VPWR VGND
+ sg13cmos5l_dfrbpq_1
* cell instance sg13cmos5l_dfrbpq_1_44 r0 *1 0,0
Xsg13cmos5l_dfrbpq_1_44 \$14807 \$17045 uo_out[1] \$13502 VPWR VGND
+ sg13cmos5l_dfrbpq_1
* cell instance sg13cmos5l_dfrbpq_1_45 r0 *1 0,0
Xsg13cmos5l_dfrbpq_1_45 \$12305 \$13929 \$3827 \$10514 VPWR VGND
+ sg13cmos5l_dfrbpq_1
* cell instance sg13cmos5l_dfrbpq_1_46 r0 *1 0,0
Xsg13cmos5l_dfrbpq_1_46 \$10517 \$11549 \$3648 \$9912 VPWR VGND
+ sg13cmos5l_dfrbpq_1
* cell instance sg13cmos5l_dfrbpq_1_47 r0 *1 0,0
Xsg13cmos5l_dfrbpq_1_47 \$14807 \$16850 uio_out[1] \$16501 VPWR VGND
+ sg13cmos5l_dfrbpq_1
* cell instance sg13cmos5l_dfrbpq_1_48 r0 *1 0,0
Xsg13cmos5l_dfrbpq_1_48 \$767 \$1554 \$1149 \$1542 VPWR VGND sg13cmos5l_dfrbpq_1
* cell instance sg13cmos5l_dfrbpq_1_49 r0 *1 0,0
Xsg13cmos5l_dfrbpq_1_49 \$5109 \$7340 \$7256 \$6085 VPWR VGND
+ sg13cmos5l_dfrbpq_1
* cell instance sg13cmos5l_dfrbpq_1_50 r0 *1 0,0
Xsg13cmos5l_dfrbpq_1_50 \$5109 \$6861 \$6863 \$6085 VPWR VGND
+ sg13cmos5l_dfrbpq_1
* cell instance sg13cmos5l_dfrbpq_1_51 r0 *1 0,0
Xsg13cmos5l_dfrbpq_1_51 \$5109 \$5038 \$5237 \$1542 VPWR VGND
+ sg13cmos5l_dfrbpq_1
* cell instance sg13cmos5l_dfrbpq_1_52 r0 *1 0,0
Xsg13cmos5l_dfrbpq_1_52 \$1101 \$534 \$545 \$468 VPWR VGND sg13cmos5l_dfrbpq_1
* cell instance sg13cmos5l_dfrbpq_1_53 r0 *1 0,0
Xsg13cmos5l_dfrbpq_1_53 \$1101 \$784 \$1001 \$468 VPWR VGND sg13cmos5l_dfrbpq_1
* cell instance sg13cmos5l_dfrbpq_1_54 r0 *1 0,0
Xsg13cmos5l_dfrbpq_1_54 \$681 \$1227 \$1111 \$468 VPWR VGND sg13cmos5l_dfrbpq_1
* cell instance sg13cmos5l_dfrbpq_1_55 r0 *1 0,0
Xsg13cmos5l_dfrbpq_1_55 \$5109 \$6394 \$6390 \$6085 VPWR VGND
+ sg13cmos5l_dfrbpq_1
* cell instance sg13cmos5l_dfrbpq_1_56 r0 *1 0,0
Xsg13cmos5l_dfrbpq_1_56 \$5109 \$6031 \$6208 \$6085 VPWR VGND
+ sg13cmos5l_dfrbpq_1
* cell instance sg13cmos5l_dfrbpq_1_57 r0 *1 0,0
Xsg13cmos5l_dfrbpq_1_57 \$10517 \$9795 \$8549 \$6085 VPWR VGND
+ sg13cmos5l_dfrbpq_1
* cell instance sg13cmos5l_dfrbpq_1_58 r0 *1 0,0
Xsg13cmos5l_dfrbpq_1_58 \$681 \$1087 \$1020 \$468 VPWR VGND sg13cmos5l_dfrbpq_1
* cell instance sg13cmos5l_dfrbpq_1_59 r0 *1 0,0
Xsg13cmos5l_dfrbpq_1_59 \$12305 \$12306 \$4293 \$9912 VPWR VGND
+ sg13cmos5l_dfrbpq_1
* cell instance sg13cmos5l_dfrbpq_1_60 r0 *1 0,0
Xsg13cmos5l_dfrbpq_1_60 \$14381 \$14974 uio_out[0] \$16501 VPWR VGND
+ sg13cmos5l_dfrbpq_1
* cell instance sg13cmos5l_dfrbpq_1_61 r0 *1 0,0
Xsg13cmos5l_dfrbpq_1_61 \$14807 \$16988 uo_out[7] \$16501 VPWR VGND
+ sg13cmos5l_dfrbpq_1
* cell instance sg13cmos5l_dfrbpq_1_62 r0 *1 0,0
Xsg13cmos5l_dfrbpq_1_62 \$14381 \$14369 uio_out[2] \$9912 VPWR VGND
+ sg13cmos5l_dfrbpq_1
* cell instance sg13cmos5l_dfrbpq_1_63 r0 *1 0,0
Xsg13cmos5l_dfrbpq_1_63 \$12305 \$11921 \$3976 \$9912 VPWR VGND
+ sg13cmos5l_dfrbpq_1
* cell instance sg13cmos5l_dfrbpq_1_64 r0 *1 0,0
Xsg13cmos5l_dfrbpq_1_64 \$14381 \$16269 uio_out[4] \$16501 VPWR VGND
+ sg13cmos5l_dfrbpq_1
* cell instance sg13cmos5l_dfrbpq_1_65 r0 *1 0,0
Xsg13cmos5l_dfrbpq_1_65 \$5109 \$10356 \$4335 \$9912 VPWR VGND
+ sg13cmos5l_dfrbpq_1
* cell instance sg13cmos5l_dfrbpq_1_66 r0 *1 0,0
Xsg13cmos5l_dfrbpq_1_66 \$5031 \$5065 \$5238 \$4133 VPWR VGND
+ sg13cmos5l_dfrbpq_1
* cell instance sg13cmos5l_dfrbpq_1_67 r0 *1 0,0
Xsg13cmos5l_dfrbpq_1_67 \$5031 \$7341 \$7260 \$6085 VPWR VGND
+ sg13cmos5l_dfrbpq_1
* cell instance sg13cmos5l_dfrbpq_1_68 r0 *1 0,0
Xsg13cmos5l_dfrbpq_1_68 \$14381 \$17029 uo_out[6] \$16501 VPWR VGND
+ sg13cmos5l_dfrbpq_1
* cell instance sg13cmos5l_dfrbpq_1_69 r0 *1 0,0
Xsg13cmos5l_dfrbpq_1_69 \$681 \$673 \$686 \$468 VPWR VGND sg13cmos5l_dfrbpq_1
* cell instance sg13cmos5l_dfrbpq_1_70 r0 *1 0,0
Xsg13cmos5l_dfrbpq_1_70 \$5031 \$6869 \$6629 \$6939 VPWR VGND
+ sg13cmos5l_dfrbpq_1
* cell instance sg13cmos5l_dfrbpq_1_71 r0 *1 0,0
Xsg13cmos5l_dfrbpq_1_71 \$681 \$467 \$480 \$468 VPWR VGND sg13cmos5l_dfrbpq_1
* cell instance sg13cmos5l_dfrbpq_1_72 r0 *1 0,0
Xsg13cmos5l_dfrbpq_1_72 \$681 \$1357 \$1531 \$468 VPWR VGND sg13cmos5l_dfrbpq_1
* cell instance sg13cmos5l_dfrbpq_1_73 r0 *1 0,0
Xsg13cmos5l_dfrbpq_1_73 \$5031 \$4694 \$4454 \$1542 VPWR VGND
+ sg13cmos5l_dfrbpq_1
* cell instance sg13cmos5l_dfrbpq_1_74 r0 *1 0,0
Xsg13cmos5l_dfrbpq_1_74 \$5031 \$9439 \$9578 \$9912 VPWR VGND
+ sg13cmos5l_dfrbpq_1
* cell instance sg13cmos5l_dfrbpq_1_75 r0 *1 0,0
Xsg13cmos5l_dfrbpq_1_75 \$11554 \$11375 \$10959 \$9912 VPWR VGND
+ sg13cmos5l_dfrbpq_1
* cell instance sg13cmos5l_dfrbpq_1_76 r0 *1 0,0
Xsg13cmos5l_dfrbpq_1_76 \$11554 \$12311 \$12001 \$9912 VPWR VGND
+ sg13cmos5l_dfrbpq_1
* cell instance sg13cmos5l_dfrbpq_1_77 r0 *1 0,0
Xsg13cmos5l_dfrbpq_1_77 \$11554 \$13849 \$4453 \$13939 VPWR VGND
+ sg13cmos5l_dfrbpq_1
* cell instance sg13cmos5l_dfrbpq_1_78 r0 *1 0,0
Xsg13cmos5l_dfrbpq_1_78 \$12305 \$14836 uo_out[2] \$16501 VPWR VGND
+ sg13cmos5l_dfrbpq_1
* cell instance sg13cmos5l_dfrbpq_1_79 r0 *1 0,0
Xsg13cmos5l_dfrbpq_1_79 \$14381 \$15763 uo_out[3] \$16501 VPWR VGND
+ sg13cmos5l_dfrbpq_1
* cell instance sg13cmos5l_dfrbpq_1_80 r0 *1 0,0
Xsg13cmos5l_dfrbpq_1_80 \$14381 \$16962 uo_out[5] \$13939 VPWR VGND
+ sg13cmos5l_dfrbpq_1
* cell instance sg13cmos5l_dfrbpq_1_81 r0 *1 0,0
Xsg13cmos5l_dfrbpq_1_81 \$681 \$1569 \$1472 \$1542 VPWR VGND sg13cmos5l_dfrbpq_1
* cell instance sg13cmos5l_dfrbpq_1_82 r0 *1 0,0
Xsg13cmos5l_dfrbpq_1_82 \$2781 \$4118 \$3973 \$1542 VPWR VGND
+ sg13cmos5l_dfrbpq_1
* cell instance sg13cmos5l_dfrbpq_1_83 r0 *1 0,0
Xsg13cmos5l_dfrbpq_1_83 \$11554 \$17036 uo_out[4] \$16501 VPWR VGND
+ sg13cmos5l_dfrbpq_1
* cell instance sg13cmos5l_dfrbpq_1_84 r0 *1 0,0
Xsg13cmos5l_dfrbpq_1_84 \$687 \$105 \$632 \$468 VPWR VGND sg13cmos5l_dfrbpq_1
* cell instance sg13cmos5l_dfrbpq_1_85 r0 *1 0,0
Xsg13cmos5l_dfrbpq_1_85 \$2781 \$4585 \$4456 \$1542 VPWR VGND
+ sg13cmos5l_dfrbpq_1
* cell instance sg13cmos5l_dfrbpq_1_86 r0 *1 0,0
Xsg13cmos5l_dfrbpq_1_86 \$2781 \$2161 \$2173 \$1492 VPWR VGND
+ sg13cmos5l_dfrbpq_1
* cell instance sg13cmos5l_dfrbpq_1_87 r0 *1 0,0
Xsg13cmos5l_dfrbpq_1_87 \$573 \$1887 \$1889 \$488 VPWR VGND sg13cmos5l_dfrbpq_1
* cell instance sg13cmos5l_dfrbpq_1_88 r0 *1 0,0
Xsg13cmos5l_dfrbpq_1_88 \$687 \$485 \$497 \$488 VPWR VGND sg13cmos5l_dfrbpq_1
* cell instance sg13cmos5l_dfrbpq_1_89 r0 *1 0,0
Xsg13cmos5l_dfrbpq_1_89 \$687 \$345 \$701 \$488 VPWR VGND sg13cmos5l_dfrbpq_1
* cell instance sg13cmos5l_dfrbpq_1_90 r0 *1 0,0
Xsg13cmos5l_dfrbpq_1_90 \$2781 \$3647 \$3837 \$3320 VPWR VGND
+ sg13cmos5l_dfrbpq_1
* cell instance sg13cmos5l_dfrbpq_1_91 r0 *1 0,0
Xsg13cmos5l_dfrbpq_1_91 \$2781 \$4459 \$4344 \$3320 VPWR VGND
+ sg13cmos5l_dfrbpq_1
* cell instance sg13cmos5l_dfrbpq_1_92 r0 *1 0,0
Xsg13cmos5l_dfrbpq_1_92 \$11554 \$17082 uo_out[0] \$4463 VPWR VGND
+ sg13cmos5l_dfrbpq_1
* cell instance sg13cmos5l_dfrbpq_1_93 r0 *1 0,0
Xsg13cmos5l_dfrbpq_1_93 \$687 \$406 \$509 \$488 VPWR VGND sg13cmos5l_dfrbpq_1
* cell instance sg13cmos5l_dfrbpq_1_94 r0 *1 0,0
Xsg13cmos5l_dfrbpq_1_94 \$687 \$557 \$568 \$488 VPWR VGND sg13cmos5l_dfrbpq_1
* cell instance sg13cmos5l_dfrbpq_1_95 r0 *1 0,0
Xsg13cmos5l_dfrbpq_1_95 \$573 \$705 \$716 \$488 VPWR VGND sg13cmos5l_dfrbpq_1
* cell instance sg13cmos5l_dfrbpq_1_96 r0 *1 0,0
Xsg13cmos5l_dfrbpq_1_96 \$2781 \$2448 \$2568 \$3320 VPWR VGND
+ sg13cmos5l_dfrbpq_1
* cell instance sg13cmos5l_dfrbpq_1_97 r0 *1 0,0
Xsg13cmos5l_dfrbpq_1_97 \$573 \$569 \$704 \$488 VPWR VGND sg13cmos5l_dfrbpq_1
* cell instance sg13cmos5l_dfrbpq_1_98 r0 *1 0,0
Xsg13cmos5l_dfrbpq_1_98 \$2301 \$2188 \$2444 \$488 VPWR VGND sg13cmos5l_dfrbpq_1
* cell instance sg13cmos5l_dfrbpq_1_99 r0 *1 0,0
Xsg13cmos5l_dfrbpq_1_99 \$573 \$811 \$823 \$815 VPWR VGND sg13cmos5l_dfrbpq_1
* cell instance sg13cmos5l_dfrbpq_1_100 r0 *1 0,0
Xsg13cmos5l_dfrbpq_1_100 \$2301 \$3316 \$3144 \$3320 VPWR VGND
+ sg13cmos5l_dfrbpq_1
* cell instance sg13cmos5l_dfrbpq_1_101 r0 *1 0,0
Xsg13cmos5l_dfrbpq_1_101 \$2301 \$4151 \$4145 \$3320 VPWR VGND
+ sg13cmos5l_dfrbpq_1
* cell instance sg13cmos5l_dfrbpq_1_102 r0 *1 0,0
Xsg13cmos5l_dfrbpq_1_102 \$2301 \$3653 \$3501 \$3320 VPWR VGND
+ sg13cmos5l_dfrbpq_1
* cell instance sg13cmos5l_dfrbpq_1_103 r0 *1 0,0
Xsg13cmos5l_dfrbpq_1_103 \$573 \$103 \$1596 \$1492 VPWR VGND sg13cmos5l_dfrbpq_1
* cell instance sg13cmos5l_dfrbpq_1_104 r0 *1 0,0
Xsg13cmos5l_dfrbpq_1_104 \$2301 \$1944 \$2003 \$815 VPWR VGND
+ sg13cmos5l_dfrbpq_1
* cell instance sg13cmos5l_dfrbpq_1_105 r0 *1 0,0
Xsg13cmos5l_dfrbpq_1_105 \$573 \$54 \$1151 \$815 VPWR VGND sg13cmos5l_dfrbpq_1
* cell instance sg13cmos5l_dfrbpq_1_106 r0 *1 0,0
Xsg13cmos5l_dfrbpq_1_106 \$1264 \$106 \$1483 \$815 VPWR VGND sg13cmos5l_dfrbpq_1
* cell instance sg13cmos5l_dfrbpq_1_107 r0 *1 0,0
Xsg13cmos5l_dfrbpq_1_107 \$1264 \$1427 \$1788 \$1492 VPWR VGND
+ sg13cmos5l_dfrbpq_1
* cell instance sg13cmos5l_dfrbpq_1_108 r0 *1 0,0
Xsg13cmos5l_dfrbpq_1_108 \$2971 \$2964 \$2793 \$3320 VPWR VGND
+ sg13cmos5l_dfrbpq_1
* cell instance sg13cmos5l_dfrbpq_1_109 r0 *1 0,0
Xsg13cmos5l_dfrbpq_1_109 \$2971 \$3330 \$3308 \$3320 VPWR VGND
+ sg13cmos5l_dfrbpq_1
* cell instance sg13cmos5l_dfrbpq_1_110 r0 *1 0,0
Xsg13cmos5l_dfrbpq_1_110 \$1264 \$36 \$1368 \$815 VPWR VGND sg13cmos5l_dfrbpq_1
* cell instance sg13cmos5l_dfrbpq_1_111 r0 *1 0,0
Xsg13cmos5l_dfrbpq_1_111 \$1264 \$1721 \$1619 \$815 VPWR VGND
+ sg13cmos5l_dfrbpq_1
* cell instance sg13cmos5l_dfrbpq_1_112 r0 *1 0,0
Xsg13cmos5l_dfrbpq_1_112 \$1264 \$1957 \$1967 \$815 VPWR VGND
+ sg13cmos5l_dfrbpq_1
* cell instance sg13cmos5l_dfrbpq_1_113 r0 *1 0,0
Xsg13cmos5l_dfrbpq_1_113 \$1264 \$1501 \$1513 \$1492 VPWR VGND
+ sg13cmos5l_dfrbpq_1
* cell instance sg13cmos5l_dfrbpq_1_114 r0 *1 0,0
Xsg13cmos5l_dfrbpq_1_114 \$2971 \$4166 \$4136 \$1827 VPWR VGND
+ sg13cmos5l_dfrbpq_1
* cell instance sg13cmos5l_dfrbpq_1_115 r0 *1 0,0
Xsg13cmos5l_dfrbpq_1_115 \$2971 \$3668 \$3664 \$1827 VPWR VGND
+ sg13cmos5l_dfrbpq_1
* cell instance sg13cmos5l_dfrbpq_1_116 r0 *1 0,0
Xsg13cmos5l_dfrbpq_1_116 \$1741 \$1733 \$1617 \$815 VPWR VGND
+ sg13cmos5l_dfrbpq_1
* cell instance sg13cmos5l_dfrbpq_1_117 r0 *1 0,0
Xsg13cmos5l_dfrbpq_1_117 \$2971 \$3161 \$3164 \$2805 VPWR VGND
+ sg13cmos5l_dfrbpq_1
* cell instance sg13cmos5l_dfrbpq_1_118 r0 *1 0,0
Xsg13cmos5l_dfrbpq_1_118 \$3353 \$3346 \$3171 \$2805 VPWR VGND
+ sg13cmos5l_dfrbpq_1
* cell instance sg13cmos5l_dfrbpq_1_119 r0 *1 0,0
Xsg13cmos5l_dfrbpq_1_119 \$1741 \$1832 \$1978 \$1835 VPWR VGND
+ sg13cmos5l_dfrbpq_1
* cell instance sg13cmos5l_dfrbpq_1_120 r0 *1 0,0
Xsg13cmos5l_dfrbpq_1_120 \$2971 \$2803 \$2908 \$2805 VPWR VGND
+ sg13cmos5l_dfrbpq_1
* cell instance sg13cmos5l_dfrbpq_1_121 r0 *1 0,0
Xsg13cmos5l_dfrbpq_1_121 \$1741 \$2073 \$1974 \$1835 VPWR VGND
+ sg13cmos5l_dfrbpq_1
* cell instance sg13cmos5l_dfrbpq_1_122 r0 *1 0,0
Xsg13cmos5l_dfrbpq_1_122 \$1741 \$2318 \$2456 \$1835 VPWR VGND
+ sg13cmos5l_dfrbpq_1
* cell instance sg13cmos5l_dfrbpq_1_123 r0 *1 0,0
Xsg13cmos5l_dfrbpq_1_123 \$3353 \$4180 \$4139 \$2805 VPWR VGND
+ sg13cmos5l_dfrbpq_1
* cell instance sg13cmos5l_dfrbpq_1_124 r0 *1 0,0
Xsg13cmos5l_dfrbpq_1_124 \$1741 \$2660 \$3001 \$2805 VPWR VGND
+ sg13cmos5l_dfrbpq_1
* cell instance sg13cmos5l_dfrbpq_1_125 r0 *1 0,0
Xsg13cmos5l_dfrbpq_1_125 \$1741 \$1746 \$1818 \$1835 VPWR VGND
+ sg13cmos5l_dfrbpq_1
* cell instance sg13cmos5l_dfrbpq_1_126 r0 *1 0,0
Xsg13cmos5l_dfrbpq_1_126 \$3353 \$4186 \$3990 \$2805 VPWR VGND
+ sg13cmos5l_dfrbpq_1
* cell instance sg13cmos5l_dfrbpq_1_127 r0 *1 0,0
Xsg13cmos5l_dfrbpq_1_127 \$2096 \$1987 \$2053 \$1835 VPWR VGND
+ sg13cmos5l_dfrbpq_1
* cell instance sg13cmos5l_dfrbpq_1_128 r0 *1 0,0
Xsg13cmos5l_dfrbpq_1_128 \$2096 \$2817 \$2961 \$2805 VPWR VGND
+ sg13cmos5l_dfrbpq_1
* cell instance sg13cmos5l_dfrbpq_1_129 r0 *1 0,0
Xsg13cmos5l_dfrbpq_1_129 \$2096 \$2333 \$2344 \$1835 VPWR VGND
+ sg13cmos5l_dfrbpq_1
* cell instance sg13cmos5l_dfrbpq_1_130 r0 *1 0,0
Xsg13cmos5l_dfrbpq_1_130 \$2096 \$2210 \$2221 \$1835 VPWR VGND
+ sg13cmos5l_dfrbpq_1
* cell instance sg13cmos5l_dfrbpq_1_131 r0 *1 0,0
Xsg13cmos5l_dfrbpq_1_131 \$3353 \$3526 \$3690 \$2805 VPWR VGND
+ sg13cmos5l_dfrbpq_1
* cell instance sg13cmos5l_dfrbpq_1_132 r0 *1 0,0
Xsg13cmos5l_dfrbpq_1_132 \$3353 \$3183 \$3151 \$3022 VPWR VGND
+ sg13cmos5l_dfrbpq_1
* cell instance sg13cmos5l_dfrbpq_1_133 r0 *1 0,0
Xsg13cmos5l_dfrbpq_1_133 \$2096 \$2348 \$2361 \$1835 VPWR VGND
+ sg13cmos5l_dfrbpq_1
* cell instance sg13cmos5l_dfrbpq_1_134 r0 *1 0,0
Xsg13cmos5l_dfrbpq_1_134 \$2367 \$2836 \$2909 \$3022 VPWR VGND
+ sg13cmos5l_dfrbpq_1
* cell instance sg13cmos5l_dfrbpq_1_135 r0 *1 0,0
Xsg13cmos5l_dfrbpq_1_135 \$3217 \$4214 \$4025 \$2571 VPWR VGND
+ sg13cmos5l_dfrbpq_1
* cell instance sg13cmos5l_dfrbpq_1_136 r0 *1 0,0
Xsg13cmos5l_dfrbpq_1_136 \$2367 \$2839 \$2687 \$3022 VPWR VGND
+ sg13cmos5l_dfrbpq_1
* cell instance sg13cmos5l_dfrbpq_1_137 r0 *1 0,0
Xsg13cmos5l_dfrbpq_1_137 \$2367 \$2232 \$2371 \$2571 VPWR VGND
+ sg13cmos5l_dfrbpq_1
* cell instance sg13cmos5l_dfrbpq_1_138 r0 *1 0,0
Xsg13cmos5l_dfrbpq_1_138 \$3217 \$3877 \$3870 \$3022 VPWR VGND
+ sg13cmos5l_dfrbpq_1
* cell instance sg13cmos5l_dfrbpq_1_139 r0 *1 0,0
Xsg13cmos5l_dfrbpq_1_139 \$3217 \$3203 \$3385 \$3022 VPWR VGND
+ sg13cmos5l_dfrbpq_1
* cell instance sg13cmos5l_dfrbpq_1_140 r0 *1 0,0
Xsg13cmos5l_dfrbpq_1_140 \$3217 \$3534 \$3499 \$3022 VPWR VGND
+ sg13cmos5l_dfrbpq_1
* cell instance sg13cmos5l_dfrbpq_1_141 r0 *1 0,0
Xsg13cmos5l_dfrbpq_1_141 \$2367 \$2238 \$2514 \$3022 VPWR VGND
+ sg13cmos5l_dfrbpq_1
* cell instance sg13cmos5l_dfrbpq_1_142 r0 *1 0,0
Xsg13cmos5l_dfrbpq_1_142 \$3217 \$3037 \$3225 \$3022 VPWR VGND
+ sg13cmos5l_dfrbpq_1
* cell instance sg13cmos5l_dfrbpq_1_143 r0 *1 0,0
Xsg13cmos5l_dfrbpq_1_143 \$3217 \$2919 \$2917 \$2856 VPWR VGND
+ sg13cmos5l_dfrbpq_1
* cell instance sg13cmos5l_dfrbpq_1_144 r0 *1 0,0
Xsg13cmos5l_dfrbpq_1_144 \$3400 \$4229 \$4388 \$3726 VPWR VGND
+ sg13cmos5l_dfrbpq_1
* cell instance sg13cmos5l_dfrbpq_1_145 r0 *1 0,0
Xsg13cmos5l_dfrbpq_1_145 \$3400 \$3393 \$3456 \$2856 VPWR VGND
+ sg13cmos5l_dfrbpq_1
* cell instance sg13cmos5l_dfrbpq_1_146 r0 *1 0,0
Xsg13cmos5l_dfrbpq_1_146 \$2367 \$2385 \$2379 \$2518 VPWR VGND
+ sg13cmos5l_dfrbpq_1
* cell instance sg13cmos5l_dfrbpq_1_147 r0 *1 0,0
Xsg13cmos5l_dfrbpq_1_147 \$3400 \$4385 \$4512 \$3726 VPWR VGND
+ sg13cmos5l_dfrbpq_1
* cell instance sg13cmos5l_dfrbpq_1_148 r0 *1 0,0
Xsg13cmos5l_dfrbpq_1_148 \$3400 \$3730 \$3728 \$2856 VPWR VGND
+ sg13cmos5l_dfrbpq_1
* cell instance sg13cmos5l_dfrbpq_1_149 r0 *1 0,0
Xsg13cmos5l_dfrbpq_1_149 \$3400 \$3896 \$4058 \$3726 VPWR VGND
+ sg13cmos5l_dfrbpq_1
* cell instance sg13cmos5l_dfrbpq_1_150 r0 *1 0,0
Xsg13cmos5l_dfrbpq_1_150 \$2367 \$3048 \$2871 \$2856 VPWR VGND
+ sg13cmos5l_dfrbpq_1
* cell instance sg13cmos5l_dfrbpq_1_151 r0 *1 0,0
Xsg13cmos5l_dfrbpq_1_151 \$3234 \$3232 \$3457 \$2856 VPWR VGND
+ sg13cmos5l_dfrbpq_1
* cell instance sg13cmos5l_dfrbpq_1_152 r0 *1 0,0
Xsg13cmos5l_dfrbpq_1_152 \$3234 \$2581 \$2695 \$2518 VPWR VGND
+ sg13cmos5l_dfrbpq_1
* cell instance sg13cmos5l_dfrbpq_1_153 r0 *1 0,0
Xsg13cmos5l_dfrbpq_1_153 \$3581 \$3571 \$3573 \$2856 VPWR VGND
+ sg13cmos5l_dfrbpq_1
* cell instance sg13cmos5l_dfrbpq_1_154 r0 *1 0,0
Xsg13cmos5l_dfrbpq_1_154 \$3234 \$1863 \$2748 \$2856 VPWR VGND
+ sg13cmos5l_dfrbpq_1
* cell instance sg13cmos5l_dfrbpq_1_155 r0 *1 0,0
Xsg13cmos5l_dfrbpq_1_155 \$3581 \$4516 \$4528 \$3726 VPWR VGND
+ sg13cmos5l_dfrbpq_1
* cell instance sg13cmos5l_dfrbpq_1_156 r0 *1 0,0
Xsg13cmos5l_dfrbpq_1_156 \$3234 \$3060 \$2874 \$2856 VPWR VGND
+ sg13cmos5l_dfrbpq_1
* cell instance sg13cmos5l_dfrbpq_1_157 r0 *1 0,0
Xsg13cmos5l_dfrbpq_1_157 \$3581 \$4061 \$4310 \$3726 VPWR VGND
+ sg13cmos5l_dfrbpq_1
* cell instance sg13cmos5l_dfrbpq_1_158 r0 *1 0,0
Xsg13cmos5l_dfrbpq_1_158 \$3234 \$981 \$3249 \$2726 VPWR VGND
+ sg13cmos5l_dfrbpq_1
* cell instance sg13cmos5l_dfrbpq_1_159 r0 *1 0,0
Xsg13cmos5l_dfrbpq_1_159 \$2541 \$3238 \$3576 \$2726 VPWR VGND
+ sg13cmos5l_dfrbpq_1
* cell instance sg13cmos5l_dfrbpq_1_160 r0 *1 0,0
Xsg13cmos5l_dfrbpq_1_160 \$2541 \$1297 \$2276 \$2518 VPWR VGND
+ sg13cmos5l_dfrbpq_1
* cell instance sg13cmos5l_dfrbpq_1_161 r0 *1 0,0
Xsg13cmos5l_dfrbpq_1_161 \$3581 \$3905 \$3915 \$2726 VPWR VGND
+ sg13cmos5l_dfrbpq_1
* cell instance sg13cmos5l_dfrbpq_1_162 r0 *1 0,0
Xsg13cmos5l_dfrbpq_1_162 \$3581 \$4398 \$4540 \$4078 VPWR VGND
+ sg13cmos5l_dfrbpq_1
* cell instance sg13cmos5l_dfrbpq_1_163 r0 *1 0,0
Xsg13cmos5l_dfrbpq_1_163 \$3581 \$4069 \$4071 \$4078 VPWR VGND
+ sg13cmos5l_dfrbpq_1
* cell instance sg13cmos5l_dfrbpq_1_164 r0 *1 0,0
Xsg13cmos5l_dfrbpq_1_164 \$2541 \$3753 \$3765 \$2726 VPWR VGND
+ sg13cmos5l_dfrbpq_1
* cell instance sg13cmos5l_dfrbpq_1_165 r0 *1 0,0
Xsg13cmos5l_dfrbpq_1_165 \$2541 \$2722 \$2731 \$2726 VPWR VGND
+ sg13cmos5l_dfrbpq_1
* cell instance sg13cmos5l_dfrbpq_1_166 r0 *1 0,0
Xsg13cmos5l_dfrbpq_1_166 \$2541 \$3071 \$3082 \$2726 VPWR VGND
+ sg13cmos5l_dfrbpq_1
* cell instance sg13cmos5l_dfrbpq_1_167 r0 *1 0,0
Xsg13cmos5l_dfrbpq_1_167 \$2541 \$3429 \$3440 \$2726 VPWR VGND
+ sg13cmos5l_dfrbpq_1
* cell instance sg13cmos5l_dfrbpq_1_168 r0 *1 0,0
Xsg13cmos5l_dfrbpq_1_168 \$2883 \$4543 \$4666 \$4078 VPWR VGND
+ sg13cmos5l_dfrbpq_1
* cell instance sg13cmos5l_dfrbpq_1_169 r0 *1 0,0
Xsg13cmos5l_dfrbpq_1_169 \$2883 \$4077 \$4277 \$4078 VPWR VGND
+ sg13cmos5l_dfrbpq_1
* cell instance sg13cmos5l_dfrbpq_1_170 r0 *1 0,0
Xsg13cmos5l_dfrbpq_1_170 \$2883 \$4548 \$4560 \$4078 VPWR VGND
+ sg13cmos5l_dfrbpq_1
* cell instance sg13cmos5l_dfrbpq_1_171 r0 *1 0,0
Xsg13cmos5l_dfrbpq_1_171 \$2546 \$3255 \$3257 \$3092 VPWR VGND
+ sg13cmos5l_dfrbpq_1
* cell instance sg13cmos5l_dfrbpq_1_172 r0 *1 0,0
Xsg13cmos5l_dfrbpq_1_172 \$2546 \$3769 \$3780 \$3092 VPWR VGND
+ sg13cmos5l_dfrbpq_1
* cell instance sg13cmos5l_dfrbpq_1_173 r0 *1 0,0
Xsg13cmos5l_dfrbpq_1_173 \$2546 \$2894 \$2739 \$3092 VPWR VGND
+ sg13cmos5l_dfrbpq_1
* cell instance sg13cmos5l_dfrbpq_1_174 r0 *1 0,0
Xsg13cmos5l_dfrbpq_1_174 \$2546 \$2587 \$2738 \$3092 VPWR VGND
+ sg13cmos5l_dfrbpq_1
* cell instance sg13cmos5l_dfrbpq_1_175 r0 *1 0,0
Xsg13cmos5l_dfrbpq_1_175 \$2546 \$3589 \$3609 \$2726 VPWR VGND
+ sg13cmos5l_dfrbpq_1
* cell instance sg13cmos5l_dfrbpq_1_176 r0 *1 0,0
Xsg13cmos5l_dfrbpq_1_176 \$2883 \$3928 \$4081 \$4078 VPWR VGND
+ sg13cmos5l_dfrbpq_1
* cell instance sg13cmos5l_dfrbpq_1_177 r0 *1 0,0
Xsg13cmos5l_dfrbpq_1_177 \$2883 \$4282 \$4420 \$3725 VPWR VGND
+ sg13cmos5l_dfrbpq_1
* cell instance sg13cmos5l_dlygate4sd3_1_0 r0 *1 0,0
Xsg13cmos5l_dlygate4sd3_1_0 \$4965 VPWR VGND \$4970 sg13cmos5l_dlygate4sd3_1
* cell instance sg13cmos5l_dlygate4sd3_1_1 r0 *1 0,0
Xsg13cmos5l_dlygate4sd3_1_1 \$7203 VPWR VGND \$7154 sg13cmos5l_dlygate4sd3_1
* cell instance sg13cmos5l_dlygate4sd3_1_2 r0 *1 0,0
Xsg13cmos5l_dlygate4sd3_1_2 \$8994 VPWR VGND \$9412 sg13cmos5l_dlygate4sd3_1
* cell instance sg13cmos5l_dlygate4sd3_1_3 r0 *1 0,0
Xsg13cmos5l_dlygate4sd3_1_3 \$9786 VPWR VGND \$10328 sg13cmos5l_dlygate4sd3_1
* cell instance sg13cmos5l_dlygate4sd3_1_4 r0 *1 0,0
Xsg13cmos5l_dlygate4sd3_1_4 \$7282 VPWR VGND \$7408 sg13cmos5l_dlygate4sd3_1
* cell instance sg13cmos5l_dlygate4sd3_1_5 r0 *1 0,0
Xsg13cmos5l_dlygate4sd3_1_5 \$6625 VPWR VGND \$6857 sg13cmos5l_dlygate4sd3_1
* cell instance sg13cmos5l_dlygate4sd3_1_6 r0 *1 0,0
Xsg13cmos5l_dlygate4sd3_1_6 \$1008 VPWR VGND \$1012 sg13cmos5l_dlygate4sd3_1
* cell instance sg13cmos5l_dlygate4sd3_1_7 r0 *1 0,0
Xsg13cmos5l_dlygate4sd3_1_7 \$5035 VPWR VGND \$5045 sg13cmos5l_dlygate4sd3_1
* cell instance sg13cmos5l_dlygate4sd3_1_8 r0 *1 0,0
Xsg13cmos5l_dlygate4sd3_1_8 \$5862 VPWR VGND \$5598 sg13cmos5l_dlygate4sd3_1
* cell instance sg13cmos5l_dlygate4sd3_1_9 r0 *1 0,0
Xsg13cmos5l_dlygate4sd3_1_9 \$5868 VPWR VGND \$6079 sg13cmos5l_dlygate4sd3_1
* cell instance sg13cmos5l_dlygate4sd3_1_10 r0 *1 0,0
Xsg13cmos5l_dlygate4sd3_1_10 \$5049 VPWR VGND \$5350 sg13cmos5l_dlygate4sd3_1
* cell instance sg13cmos5l_dlygate4sd3_1_11 r0 *1 0,0
Xsg13cmos5l_dlygate4sd3_1_11 \$6406 VPWR VGND \$6405 sg13cmos5l_dlygate4sd3_1
* cell instance sg13cmos5l_dlygate4sd3_1_12 r0 *1 0,0
Xsg13cmos5l_dlygate4sd3_1_12 \$8995 VPWR VGND \$10512 sg13cmos5l_dlygate4sd3_1
* cell instance sg13cmos5l_dlygate4sd3_1_13 r0 *1 0,0
Xsg13cmos5l_dlygate4sd3_1_13 \$7283 VPWR VGND \$7599 sg13cmos5l_dlygate4sd3_1
* cell instance sg13cmos5l_dlygate4sd3_1_14 r0 *1 0,0
Xsg13cmos5l_dlygate4sd3_1_14 \$1212 VPWR VGND \$1216 sg13cmos5l_dlygate4sd3_1
* cell instance sg13cmos5l_dlygate4sd3_1_15 r0 *1 0,0
Xsg13cmos5l_dlygate4sd3_1_15 \$757 VPWR VGND \$758 sg13cmos5l_dlygate4sd3_1
* cell instance sg13cmos5l_dlygate4sd3_1_16 r0 *1 0,0
Xsg13cmos5l_dlygate4sd3_1_16 \$648 VPWR VGND \$644 sg13cmos5l_dlygate4sd3_1
* cell instance sg13cmos5l_dlygate4sd3_1_17 r0 *1 0,0
Xsg13cmos5l_dlygate4sd3_1_17 \$1016 VPWR VGND \$1095 sg13cmos5l_dlygate4sd3_1
* cell instance sg13cmos5l_dlygate4sd3_1_18 r0 *1 0,0
Xsg13cmos5l_dlygate4sd3_1_18 \$7239 VPWR VGND \$7409 sg13cmos5l_dlygate4sd3_1
* cell instance sg13cmos5l_dlygate4sd3_1_19 r0 *1 0,0
Xsg13cmos5l_dlygate4sd3_1_19 \$8996 VPWR VGND \$10513 sg13cmos5l_dlygate4sd3_1
* cell instance sg13cmos5l_dlygate4sd3_1_20 r0 *1 0,0
Xsg13cmos5l_dlygate4sd3_1_20 \$6627 VPWR VGND \$6858 sg13cmos5l_dlygate4sd3_1
* cell instance sg13cmos5l_dlygate4sd3_1_21 r0 *1 0,0
Xsg13cmos5l_dlygate4sd3_1_21 \$11910 VPWR VGND \$11545 sg13cmos5l_dlygate4sd3_1
* cell instance sg13cmos5l_dlygate4sd3_1_22 r0 *1 0,0
Xsg13cmos5l_dlygate4sd3_1_22 \$6018 VPWR VGND \$6080 sg13cmos5l_dlygate4sd3_1
* cell instance sg13cmos5l_dlygate4sd3_1_23 r0 *1 0,0
Xsg13cmos5l_dlygate4sd3_1_23 \$4290 VPWR VGND \$12462 sg13cmos5l_dlygate4sd3_1
* cell instance sg13cmos5l_dlygate4sd3_1_24 r0 *1 0,0
Xsg13cmos5l_dlygate4sd3_1_24 \$771 VPWR VGND \$651 sg13cmos5l_dlygate4sd3_1
* cell instance sg13cmos5l_dlygate4sd3_1_25 r0 *1 0,0
Xsg13cmos5l_dlygate4sd3_1_25 \$5584 VPWR VGND \$5599 sg13cmos5l_dlygate4sd3_1
* cell instance sg13cmos5l_dlygate4sd3_1_26 r0 *1 0,0
Xsg13cmos5l_dlygate4sd3_1_26 \$1221 VPWR VGND \$1329 sg13cmos5l_dlygate4sd3_1
* cell instance sg13cmos5l_dlygate4sd3_1_27 r0 *1 0,0
Xsg13cmos5l_dlygate4sd3_1_27 \$5052 VPWR VGND \$5236 sg13cmos5l_dlygate4sd3_1
* cell instance sg13cmos5l_dlygate4sd3_1_28 r0 *1 0,0
Xsg13cmos5l_dlygate4sd3_1_28 \$3480 VPWR VGND \$14512 sg13cmos5l_dlygate4sd3_1
* cell instance sg13cmos5l_dlygate4sd3_1_29 r0 *1 0,0
Xsg13cmos5l_dlygate4sd3_1_29 \$4144 VPWR VGND \$13922 sg13cmos5l_dlygate4sd3_1
* cell instance sg13cmos5l_dlygate4sd3_1_30 r0 *1 0,0
Xsg13cmos5l_dlygate4sd3_1_30 \$4336 VPWR VGND \$11996 sg13cmos5l_dlygate4sd3_1
* cell instance sg13cmos5l_dlygate4sd3_1_31 r0 *1 0,0
Xsg13cmos5l_dlygate4sd3_1_31 \$775 VPWR VGND \$655 sg13cmos5l_dlygate4sd3_1
* cell instance sg13cmos5l_dlygate4sd3_1_32 r0 *1 0,0
Xsg13cmos5l_dlygate4sd3_1_32 \$5004 VPWR VGND \$11546 sg13cmos5l_dlygate4sd3_1
* cell instance sg13cmos5l_dlygate4sd3_1_33 r0 *1 0,0
Xsg13cmos5l_dlygate4sd3_1_33 \$1782 VPWR VGND \$1894 sg13cmos5l_dlygate4sd3_1
* cell instance sg13cmos5l_dlygate4sd3_1_34 r0 *1 0,0
Xsg13cmos5l_dlygate4sd3_1_34 \$9133 VPWR VGND \$8547 sg13cmos5l_dlygate4sd3_1
* cell instance sg13cmos5l_dlygate4sd3_1_35 r0 *1 0,0
Xsg13cmos5l_dlygate4sd3_1_35 \$10345 VPWR VGND \$9910 sg13cmos5l_dlygate4sd3_1
* cell instance sg13cmos5l_dlygate4sd3_1_36 r0 *1 0,0
Xsg13cmos5l_dlygate4sd3_1_36 \$6586 VPWR VGND \$6646 sg13cmos5l_dlygate4sd3_1
* cell instance sg13cmos5l_dlygate4sd3_1_37 r0 *1 0,0
Xsg13cmos5l_dlygate4sd3_1_37 uio_out[6] VPWR VGND \$16979
+ sg13cmos5l_dlygate4sd3_1
* cell instance sg13cmos5l_dlygate4sd3_1_38 r0 *1 0,0
Xsg13cmos5l_dlygate4sd3_1_38 uio_out[5] VPWR VGND \$15961
+ sg13cmos5l_dlygate4sd3_1
* cell instance sg13cmos5l_dlygate4sd3_1_39 r0 *1 0,0
Xsg13cmos5l_dlygate4sd3_1_39 uio_out[7] VPWR VGND \$16939
+ sg13cmos5l_dlygate4sd3_1
* cell instance sg13cmos5l_dlygate4sd3_1_40 r0 *1 0,0
Xsg13cmos5l_dlygate4sd3_1_40 \$667 VPWR VGND \$776 sg13cmos5l_dlygate4sd3_1
* cell instance sg13cmos5l_dlygate4sd3_1_41 r0 *1 0,0
Xsg13cmos5l_dlygate4sd3_1_41 \$7253 VPWR VGND \$7205 sg13cmos5l_dlygate4sd3_1
* cell instance sg13cmos5l_dlygate4sd3_1_42 r0 *1 0,0
Xsg13cmos5l_dlygate4sd3_1_42 \$3648 VPWR VGND \$11998 sg13cmos5l_dlygate4sd3_1
* cell instance sg13cmos5l_dlygate4sd3_1_43 r0 *1 0,0
Xsg13cmos5l_dlygate4sd3_1_43 \$780 VPWR VGND \$783 sg13cmos5l_dlygate4sd3_1
* cell instance sg13cmos5l_dlygate4sd3_1_44 r0 *1 0,0
Xsg13cmos5l_dlygate4sd3_1_44 \$8548 VPWR VGND \$9575 sg13cmos5l_dlygate4sd3_1
* cell instance sg13cmos5l_dlygate4sd3_1_45 r0 *1 0,0
Xsg13cmos5l_dlygate4sd3_1_45 \$4426 VPWR VGND \$12464 sg13cmos5l_dlygate4sd3_1
* cell instance sg13cmos5l_dlygate4sd3_1_46 r0 *1 0,0
Xsg13cmos5l_dlygate4sd3_1_46 \$4997 VPWR VGND \$5038 sg13cmos5l_dlygate4sd3_1
* cell instance sg13cmos5l_dlygate4sd3_1_47 r0 *1 0,0
Xsg13cmos5l_dlygate4sd3_1_47 \$7206 VPWR VGND \$7411 sg13cmos5l_dlygate4sd3_1
* cell instance sg13cmos5l_dlygate4sd3_1_48 r0 *1 0,0
Xsg13cmos5l_dlygate4sd3_1_48 uio_out[3] VPWR VGND \$15962
+ sg13cmos5l_dlygate4sd3_1
* cell instance sg13cmos5l_dlygate4sd3_1_49 r0 *1 0,0
Xsg13cmos5l_dlygate4sd3_1_49 \$782 VPWR VGND \$784 sg13cmos5l_dlygate4sd3_1
* cell instance sg13cmos5l_dlygate4sd3_1_50 r0 *1 0,0
Xsg13cmos5l_dlygate4sd3_1_50 \$1344 VPWR VGND \$1227 sg13cmos5l_dlygate4sd3_1
* cell instance sg13cmos5l_dlygate4sd3_1_51 r0 *1 0,0
Xsg13cmos5l_dlygate4sd3_1_51 \$1020 VPWR VGND \$1115 sg13cmos5l_dlygate4sd3_1
* cell instance sg13cmos5l_dlygate4sd3_1_52 r0 *1 0,0
Xsg13cmos5l_dlygate4sd3_1_52 uo_out[1] VPWR VGND \$16953
+ sg13cmos5l_dlygate4sd3_1
* cell instance sg13cmos5l_dlygate4sd3_1_53 r0 *1 0,0
Xsg13cmos5l_dlygate4sd3_1_53 \$7256 VPWR VGND \$7496 sg13cmos5l_dlygate4sd3_1
* cell instance sg13cmos5l_dlygate4sd3_1_54 r0 *1 0,0
Xsg13cmos5l_dlygate4sd3_1_54 \$6863 VPWR VGND \$6860 sg13cmos5l_dlygate4sd3_1
* cell instance sg13cmos5l_dlygate4sd3_1_55 r0 *1 0,0
Xsg13cmos5l_dlygate4sd3_1_55 uio_out[1] VPWR VGND \$16499
+ sg13cmos5l_dlygate4sd3_1
* cell instance sg13cmos5l_dlygate4sd3_1_56 r0 *1 0,0
Xsg13cmos5l_dlygate4sd3_1_56 \$5237 VPWR VGND \$5058 sg13cmos5l_dlygate4sd3_1
* cell instance sg13cmos5l_dlygate4sd3_1_57 r0 *1 0,0
Xsg13cmos5l_dlygate4sd3_1_57 \$4293 VPWR VGND \$12465 sg13cmos5l_dlygate4sd3_1
* cell instance sg13cmos5l_dlygate4sd3_1_58 r0 *1 0,0
Xsg13cmos5l_dlygate4sd3_1_58 \$3827 VPWR VGND \$13503 sg13cmos5l_dlygate4sd3_1
* cell instance sg13cmos5l_dlygate4sd3_1_59 r0 *1 0,0
Xsg13cmos5l_dlygate4sd3_1_59 \$1001 VPWR VGND \$781 sg13cmos5l_dlygate4sd3_1
* cell instance sg13cmos5l_dlygate4sd3_1_60 r0 *1 0,0
Xsg13cmos5l_dlygate4sd3_1_60 \$1111 VPWR VGND \$1335 sg13cmos5l_dlygate4sd3_1
* cell instance sg13cmos5l_dlygate4sd3_1_61 r0 *1 0,0
Xsg13cmos5l_dlygate4sd3_1_61 \$1149 VPWR VGND \$1694 sg13cmos5l_dlygate4sd3_1
* cell instance sg13cmos5l_dlygate4sd3_1_62 r0 *1 0,0
Xsg13cmos5l_dlygate4sd3_1_62 \$6390 VPWR VGND \$6407 sg13cmos5l_dlygate4sd3_1
* cell instance sg13cmos5l_dlygate4sd3_1_63 r0 *1 0,0
Xsg13cmos5l_dlygate4sd3_1_63 \$8549 VPWR VGND \$9419 sg13cmos5l_dlygate4sd3_1
* cell instance sg13cmos5l_dlygate4sd3_1_64 r0 *1 0,0
Xsg13cmos5l_dlygate4sd3_1_64 \$6208 VPWR VGND \$6084 sg13cmos5l_dlygate4sd3_1
* cell instance sg13cmos5l_dlygate4sd3_1_65 r0 *1 0,0
Xsg13cmos5l_dlygate4sd3_1_65 \$1093 VPWR VGND \$1087 sg13cmos5l_dlygate4sd3_1
* cell instance sg13cmos5l_dlygate4sd3_1_66 r0 *1 0,0
Xsg13cmos5l_dlygate4sd3_1_66 uo_out[7] VPWR VGND \$16961
+ sg13cmos5l_dlygate4sd3_1
* cell instance sg13cmos5l_dlygate4sd3_1_67 r0 *1 0,0
Xsg13cmos5l_dlygate4sd3_1_67 \$6629 VPWR VGND \$6862 sg13cmos5l_dlygate4sd3_1
* cell instance sg13cmos5l_dlygate4sd3_1_68 r0 *1 0,0
Xsg13cmos5l_dlygate4sd3_1_68 \$5238 VPWR VGND \$5064 sg13cmos5l_dlygate4sd3_1
* cell instance sg13cmos5l_dlygate4sd3_1_69 r0 *1 0,0
Xsg13cmos5l_dlygate4sd3_1_69 \$3976 VPWR VGND \$10956 sg13cmos5l_dlygate4sd3_1
* cell instance sg13cmos5l_dlygate4sd3_1_70 r0 *1 0,0
Xsg13cmos5l_dlygate4sd3_1_70 uio_out[2] VPWR VGND \$14514
+ sg13cmos5l_dlygate4sd3_1
* cell instance sg13cmos5l_dlygate4sd3_1_71 r0 *1 0,0
Xsg13cmos5l_dlygate4sd3_1_71 uio_out[0] VPWR VGND \$14834
+ sg13cmos5l_dlygate4sd3_1
* cell instance sg13cmos5l_dlygate4sd3_1_72 r0 *1 0,0
Xsg13cmos5l_dlygate4sd3_1_72 uio_out[4] VPWR VGND \$16574
+ sg13cmos5l_dlygate4sd3_1
* cell instance sg13cmos5l_dlygate4sd3_1_73 r0 *1 0,0
Xsg13cmos5l_dlygate4sd3_1_73 \$4335 VPWR VGND \$10518 sg13cmos5l_dlygate4sd3_1
* cell instance sg13cmos5l_dlygate4sd3_1_74 r0 *1 0,0
Xsg13cmos5l_dlygate4sd3_1_74 \$7260 VPWR VGND \$7412 sg13cmos5l_dlygate4sd3_1
* cell instance sg13cmos5l_dlygate4sd3_1_75 r0 *1 0,0
Xsg13cmos5l_dlygate4sd3_1_75 uo_out[6] VPWR VGND \$17028
+ sg13cmos5l_dlygate4sd3_1
* cell instance sg13cmos5l_dlygate4sd3_1_76 r0 *1 0,0
Xsg13cmos5l_dlygate4sd3_1_76 \$4453 VPWR VGND \$13937 sg13cmos5l_dlygate4sd3_1
* cell instance sg13cmos5l_dlygate4sd3_1_77 r0 *1 0,0
Xsg13cmos5l_dlygate4sd3_1_77 \$2173 VPWR VGND \$2036 sg13cmos5l_dlygate4sd3_1
* cell instance sg13cmos5l_dlygate4sd3_1_78 r0 *1 0,0
Xsg13cmos5l_dlygate4sd3_1_78 \$4577 VPWR VGND \$4694 sg13cmos5l_dlygate4sd3_1
* cell instance sg13cmos5l_dlygate4sd3_1_79 r0 *1 0,0
Xsg13cmos5l_dlygate4sd3_1_79 \$1531 VPWR VGND \$1467 sg13cmos5l_dlygate4sd3_1
* cell instance sg13cmos5l_dlygate4sd3_1_80 r0 *1 0,0
Xsg13cmos5l_dlygate4sd3_1_80 \$9578 VPWR VGND \$9577 sg13cmos5l_dlygate4sd3_1
* cell instance sg13cmos5l_dlygate4sd3_1_81 r0 *1 0,0
Xsg13cmos5l_dlygate4sd3_1_81 uo_out[2] VPWR VGND \$15527
+ sg13cmos5l_dlygate4sd3_1
* cell instance sg13cmos5l_dlygate4sd3_1_82 r0 *1 0,0
Xsg13cmos5l_dlygate4sd3_1_82 \$10959 VPWR VGND \$10958 sg13cmos5l_dlygate4sd3_1
* cell instance sg13cmos5l_dlygate4sd3_1_83 r0 *1 0,0
Xsg13cmos5l_dlygate4sd3_1_83 \$12001 VPWR VGND \$12466 sg13cmos5l_dlygate4sd3_1
* cell instance sg13cmos5l_dlygate4sd3_1_84 r0 *1 0,0
Xsg13cmos5l_dlygate4sd3_1_84 uo_out[3] VPWR VGND \$15856
+ sg13cmos5l_dlygate4sd3_1
* cell instance sg13cmos5l_dlygate4sd3_1_85 r0 *1 0,0
Xsg13cmos5l_dlygate4sd3_1_85 uo_out[5] VPWR VGND \$16861
+ sg13cmos5l_dlygate4sd3_1
* cell instance sg13cmos5l_dlygate4sd3_1_86 r0 *1 0,0
Xsg13cmos5l_dlygate4sd3_1_86 uo_out[4] VPWR VGND \$17008
+ sg13cmos5l_dlygate4sd3_1
* cell instance sg13cmos5l_dlygate4sd3_1_87 r0 *1 0,0
Xsg13cmos5l_dlygate4sd3_1_87 \$2173 VPWR VGND \$3495 sg13cmos5l_dlygate4sd3_1
* cell instance sg13cmos5l_dlygate4sd3_1_88 r0 *1 0,0
Xsg13cmos5l_dlygate4sd3_1_88 \$1472 VPWR VGND \$1474 sg13cmos5l_dlygate4sd3_1
* cell instance sg13cmos5l_dlygate4sd3_1_89 r0 *1 0,0
Xsg13cmos5l_dlygate4sd3_1_89 \$4454 VPWR VGND \$4584 sg13cmos5l_dlygate4sd3_1
* cell instance sg13cmos5l_dlygate4sd3_1_90 r0 *1 0,0
Xsg13cmos5l_dlygate4sd3_1_90 \$3973 VPWR VGND \$4131 sg13cmos5l_dlygate4sd3_1
* cell instance sg13cmos5l_dlygate4sd3_1_91 r0 *1 0,0
Xsg13cmos5l_dlygate4sd3_1_91 \$1889 VPWR VGND \$1919 sg13cmos5l_dlygate4sd3_1
* cell instance sg13cmos5l_dlygate4sd3_1_92 r0 *1 0,0
Xsg13cmos5l_dlygate4sd3_1_92 \$4456 VPWR VGND \$4593 sg13cmos5l_dlygate4sd3_1
* cell instance sg13cmos5l_dlygate4sd3_1_93 r0 *1 0,0
Xsg13cmos5l_dlygate4sd3_1_93 \$3837 VPWR VGND \$3982 sg13cmos5l_dlygate4sd3_1
* cell instance sg13cmos5l_dlygate4sd3_1_94 r0 *1 0,0
Xsg13cmos5l_dlygate4sd3_1_94 \$4344 VPWR VGND \$4462 sg13cmos5l_dlygate4sd3_1
* cell instance sg13cmos5l_dlygate4sd3_1_95 r0 *1 0,0
Xsg13cmos5l_dlygate4sd3_1_95 uo_out[0] VPWR VGND \$17081
+ sg13cmos5l_dlygate4sd3_1
* cell instance sg13cmos5l_dlygate4sd3_1_96 r0 *1 0,0
Xsg13cmos5l_dlygate4sd3_1_96 \$2620 VPWR VGND \$2448 sg13cmos5l_dlygate4sd3_1
* cell instance sg13cmos5l_dlygate4sd3_1_97 r0 *1 0,0
Xsg13cmos5l_dlygate4sd3_1_97 \$2568 VPWR VGND \$2452 sg13cmos5l_dlygate4sd3_1
* cell instance sg13cmos5l_dlygate4sd3_1_98 r0 *1 0,0
Xsg13cmos5l_dlygate4sd3_1_98 \$3848 VPWR VGND \$4717 sg13cmos5l_dlygate4sd3_1
* cell instance sg13cmos5l_dlygate4sd3_1_99 r0 *1 0,0
Xsg13cmos5l_dlygate4sd3_1_99 \$2291 VPWR VGND \$2188 sg13cmos5l_dlygate4sd3_1
* cell instance sg13cmos5l_dlygate4sd3_1_100 r0 *1 0,0
Xsg13cmos5l_dlygate4sd3_1_100 \$4145 VPWR VGND \$4149 sg13cmos5l_dlygate4sd3_1
* cell instance sg13cmos5l_dlygate4sd3_1_101 r0 *1 0,0
Xsg13cmos5l_dlygate4sd3_1_101 \$2444 VPWR VGND \$2205 sg13cmos5l_dlygate4sd3_1
* cell instance sg13cmos5l_dlygate4sd3_1_102 r0 *1 0,0
Xsg13cmos5l_dlygate4sd3_1_102 \$3144 VPWR VGND \$3315 sg13cmos5l_dlygate4sd3_1
* cell instance sg13cmos5l_dlygate4sd3_1_103 r0 *1 0,0
Xsg13cmos5l_dlygate4sd3_1_103 \$3501 VPWR VGND \$3652 sg13cmos5l_dlygate4sd3_1
* cell instance sg13cmos5l_dlygate4sd3_1_104 r0 *1 0,0
Xsg13cmos5l_dlygate4sd3_1_104 \$2003 VPWR VGND \$1815 sg13cmos5l_dlygate4sd3_1
* cell instance sg13cmos5l_dlygate4sd3_1_105 r0 *1 0,0
Xsg13cmos5l_dlygate4sd3_1_105 \$2788 VPWR VGND \$2964 sg13cmos5l_dlygate4sd3_1
* cell instance sg13cmos5l_dlygate4sd3_1_106 r0 *1 0,0
Xsg13cmos5l_dlygate4sd3_1_106 \$2195 VPWR VGND \$1820 sg13cmos5l_dlygate4sd3_1
* cell instance sg13cmos5l_dlygate4sd3_1_107 r0 *1 0,0
Xsg13cmos5l_dlygate4sd3_1_107 \$1819 VPWR VGND \$1957 sg13cmos5l_dlygate4sd3_1
* cell instance sg13cmos5l_dlygate4sd3_1_108 r0 *1 0,0
Xsg13cmos5l_dlygate4sd3_1_108 \$2793 VPWR VGND \$2639 sg13cmos5l_dlygate4sd3_1
* cell instance sg13cmos5l_dlygate4sd3_1_109 r0 *1 0,0
Xsg13cmos5l_dlygate4sd3_1_109 \$3308 VPWR VGND \$3508 sg13cmos5l_dlygate4sd3_1
* cell instance sg13cmos5l_dlygate4sd3_1_110 r0 *1 0,0
Xsg13cmos5l_dlygate4sd3_1_110 \$1967 VPWR VGND \$2194 sg13cmos5l_dlygate4sd3_1
* cell instance sg13cmos5l_dlygate4sd3_1_111 r0 *1 0,0
Xsg13cmos5l_dlygate4sd3_1_111 \$3155 VPWR VGND \$3330 sg13cmos5l_dlygate4sd3_1
* cell instance sg13cmos5l_dlygate4sd3_1_112 r0 *1 0,0
Xsg13cmos5l_dlygate4sd3_1_112 \$1617 VPWR VGND \$1721 sg13cmos5l_dlygate4sd3_1
* cell instance sg13cmos5l_dlygate4sd3_1_113 r0 *1 0,0
Xsg13cmos5l_dlygate4sd3_1_113 \$2646 VPWR VGND \$2649 sg13cmos5l_dlygate4sd3_1
* cell instance sg13cmos5l_dlygate4sd3_1_114 r0 *1 0,0
Xsg13cmos5l_dlygate4sd3_1_114 \$2648 VPWR VGND \$2803 sg13cmos5l_dlygate4sd3_1
* cell instance sg13cmos5l_dlygate4sd3_1_115 r0 *1 0,0
Xsg13cmos5l_dlygate4sd3_1_115 \$2313 VPWR VGND \$2318 sg13cmos5l_dlygate4sd3_1
* cell instance sg13cmos5l_dlygate4sd3_1_116 r0 *1 0,0
Xsg13cmos5l_dlygate4sd3_1_116 \$4136 VPWR VGND \$4353 sg13cmos5l_dlygate4sd3_1
* cell instance sg13cmos5l_dlygate4sd3_1_117 r0 *1 0,0
Xsg13cmos5l_dlygate4sd3_1_117 \$2463 VPWR VGND \$2314 sg13cmos5l_dlygate4sd3_1
* cell instance sg13cmos5l_dlygate4sd3_1_118 r0 *1 0,0
Xsg13cmos5l_dlygate4sd3_1_118 \$3664 VPWR VGND \$3672 sg13cmos5l_dlygate4sd3_1
* cell instance sg13cmos5l_dlygate4sd3_1_119 r0 *1 0,0
Xsg13cmos5l_dlygate4sd3_1_119 \$3164 VPWR VGND \$2979 sg13cmos5l_dlygate4sd3_1
* cell instance sg13cmos5l_dlygate4sd3_1_120 r0 *1 0,0
Xsg13cmos5l_dlygate4sd3_1_120 \$1974 VPWR VGND \$2068 sg13cmos5l_dlygate4sd3_1
* cell instance sg13cmos5l_dlygate4sd3_1_121 r0 *1 0,0
Xsg13cmos5l_dlygate4sd3_1_121 \$2908 VPWR VGND \$2470 sg13cmos5l_dlygate4sd3_1
* cell instance sg13cmos5l_dlygate4sd3_1_122 r0 *1 0,0
Xsg13cmos5l_dlygate4sd3_1_122 \$3171 VPWR VGND \$3163 sg13cmos5l_dlygate4sd3_1
* cell instance sg13cmos5l_dlygate4sd3_1_123 r0 *1 0,0
Xsg13cmos5l_dlygate4sd3_1_123 \$2456 VPWR VGND \$2308 sg13cmos5l_dlygate4sd3_1
* cell instance sg13cmos5l_dlygate4sd3_1_124 r0 *1 0,0
Xsg13cmos5l_dlygate4sd3_1_124 \$1978 VPWR VGND \$2076 sg13cmos5l_dlygate4sd3_1
* cell instance sg13cmos5l_dlygate4sd3_1_125 r0 *1 0,0
Xsg13cmos5l_dlygate4sd3_1_125 \$3858 VPWR VGND \$4812 sg13cmos5l_dlygate4sd3_1
* cell instance sg13cmos5l_dlygate4sd3_1_126 r0 *1 0,0
Xsg13cmos5l_dlygate4sd3_1_126 \$2915 VPWR VGND \$2179 sg13cmos5l_dlygate4sd3_1
* cell instance sg13cmos5l_dlygate4sd3_1_127 r0 *1 0,0
Xsg13cmos5l_dlygate4sd3_1_127 \$4139 VPWR VGND \$4183 sg13cmos5l_dlygate4sd3_1
* cell instance sg13cmos5l_dlygate4sd3_1_128 r0 *1 0,0
Xsg13cmos5l_dlygate4sd3_1_128 \$3001 VPWR VGND \$3266 sg13cmos5l_dlygate4sd3_1
* cell instance sg13cmos5l_dlygate4sd3_1_129 r0 *1 0,0
Xsg13cmos5l_dlygate4sd3_1_129 \$4013 VPWR VGND \$4617 sg13cmos5l_dlygate4sd3_1
* cell instance sg13cmos5l_dlygate4sd3_1_130 r0 *1 0,0
Xsg13cmos5l_dlygate4sd3_1_130 \$3990 VPWR VGND \$4185 sg13cmos5l_dlygate4sd3_1
* cell instance sg13cmos5l_dlygate4sd3_1_131 r0 *1 0,0
Xsg13cmos5l_dlygate4sd3_1_131 \$2670 VPWR VGND \$4002 sg13cmos5l_dlygate4sd3_1
* cell instance sg13cmos5l_dlygate4sd3_1_132 r0 *1 0,0
Xsg13cmos5l_dlygate4sd3_1_132 \$2573 VPWR VGND \$3867 sg13cmos5l_dlygate4sd3_1
* cell instance sg13cmos5l_dlygate4sd3_1_133 r0 *1 0,0
Xsg13cmos5l_dlygate4sd3_1_133 \$2476 VPWR VGND \$2480 sg13cmos5l_dlygate4sd3_1
* cell instance sg13cmos5l_dlygate4sd3_1_134 r0 *1 0,0
Xsg13cmos5l_dlygate4sd3_1_134 \$3944 VPWR VGND \$4628 sg13cmos5l_dlygate4sd3_1
* cell instance sg13cmos5l_dlygate4sd3_1_135 r0 *1 0,0
Xsg13cmos5l_dlygate4sd3_1_135 \$2961 VPWR VGND \$3008 sg13cmos5l_dlygate4sd3_1
* cell instance sg13cmos5l_dlygate4sd3_1_136 r0 *1 0,0
Xsg13cmos5l_dlygate4sd3_1_136 \$4197 VPWR VGND \$4487 sg13cmos5l_dlygate4sd3_1
* cell instance sg13cmos5l_dlygate4sd3_1_137 r0 *1 0,0
Xsg13cmos5l_dlygate4sd3_1_137 \$2673 VPWR VGND \$4011 sg13cmos5l_dlygate4sd3_1
* cell instance sg13cmos5l_dlygate4sd3_1_138 r0 *1 0,0
Xsg13cmos5l_dlygate4sd3_1_138 \$2828 VPWR VGND \$4204 sg13cmos5l_dlygate4sd3_1
* cell instance sg13cmos5l_dlygate4sd3_1_139 r0 *1 0,0
Xsg13cmos5l_dlygate4sd3_1_139 \$3709 VPWR VGND \$4491 sg13cmos5l_dlygate4sd3_1
* cell instance sg13cmos5l_dlygate4sd3_1_140 r0 *1 0,0
Xsg13cmos5l_dlygate4sd3_1_140 \$3857 VPWR VGND \$4635 sg13cmos5l_dlygate4sd3_1
* cell instance sg13cmos5l_dlygate4sd3_1_141 r0 *1 0,0
Xsg13cmos5l_dlygate4sd3_1_141 \$3690 VPWR VGND \$3692 sg13cmos5l_dlygate4sd3_1
* cell instance sg13cmos5l_dlygate4sd3_1_142 r0 *1 0,0
Xsg13cmos5l_dlygate4sd3_1_142 \$2344 VPWR VGND \$2397 sg13cmos5l_dlygate4sd3_1
* cell instance sg13cmos5l_dlygate4sd3_1_143 r0 *1 0,0
Xsg13cmos5l_dlygate4sd3_1_143 \$3151 VPWR VGND \$3186 sg13cmos5l_dlygate4sd3_1
* cell instance sg13cmos5l_dlygate4sd3_1_144 r0 *1 0,0
Xsg13cmos5l_dlygate4sd3_1_144 \$3521 VPWR VGND \$4495 sg13cmos5l_dlygate4sd3_1
* cell instance sg13cmos5l_dlygate4sd3_1_145 r0 *1 0,0
Xsg13cmos5l_dlygate4sd3_1_145 \$2830 VPWR VGND \$4208 sg13cmos5l_dlygate4sd3_1
* cell instance sg13cmos5l_dlygate4sd3_1_146 r0 *1 0,0
Xsg13cmos5l_dlygate4sd3_1_146 \$2487 VPWR VGND \$4018 sg13cmos5l_dlygate4sd3_1
* cell instance sg13cmos5l_dlygate4sd3_1_147 r0 *1 0,0
Xsg13cmos5l_dlygate4sd3_1_147 \$2832 VPWR VGND \$2831 sg13cmos5l_dlygate4sd3_1
* cell instance sg13cmos5l_dlygate4sd3_1_148 r0 *1 0,0
Xsg13cmos5l_dlygate4sd3_1_148 \$2677 VPWR VGND \$2676 sg13cmos5l_dlygate4sd3_1
* cell instance sg13cmos5l_dlygate4sd3_1_149 r0 *1 0,0
Xsg13cmos5l_dlygate4sd3_1_149 \$2675 VPWR VGND \$4213 sg13cmos5l_dlygate4sd3_1
* cell instance sg13cmos5l_dlygate4sd3_1_150 r0 *1 0,0
Xsg13cmos5l_dlygate4sd3_1_150 \$2489 VPWR VGND \$4022 sg13cmos5l_dlygate4sd3_1
* cell instance sg13cmos5l_dlygate4sd3_1_151 r0 *1 0,0
Xsg13cmos5l_dlygate4sd3_1_151 \$2225 VPWR VGND \$2490 sg13cmos5l_dlygate4sd3_1
* cell instance sg13cmos5l_dlygate4sd3_1_152 r0 *1 0,0
Xsg13cmos5l_dlygate4sd3_1_152 \$2228 VPWR VGND \$2488 sg13cmos5l_dlygate4sd3_1
* cell instance sg13cmos5l_dlygate4sd3_1_153 r0 *1 0,0
Xsg13cmos5l_dlygate4sd3_1_153 \$2909 VPWR VGND \$3015 sg13cmos5l_dlygate4sd3_1
* cell instance sg13cmos5l_dlygate4sd3_1_154 r0 *1 0,0
Xsg13cmos5l_dlygate4sd3_1_154 \$2361 VPWR VGND \$2750 sg13cmos5l_dlygate4sd3_1
* cell instance sg13cmos5l_dlygate4sd3_1_155 r0 *1 0,0
Xsg13cmos5l_dlygate4sd3_1_155 \$2377 VPWR VGND \$2475 sg13cmos5l_dlygate4sd3_1
* cell instance sg13cmos5l_dlygate4sd3_1_156 r0 *1 0,0
Xsg13cmos5l_dlygate4sd3_1_156 \$2687 VPWR VGND \$2364 sg13cmos5l_dlygate4sd3_1
* cell instance sg13cmos5l_dlygate4sd3_1_157 r0 *1 0,0
Xsg13cmos5l_dlygate4sd3_1_157 \$4025 VPWR VGND \$4024 sg13cmos5l_dlygate4sd3_1
* cell instance sg13cmos5l_dlygate4sd3_1_158 r0 *1 0,0
Xsg13cmos5l_dlygate4sd3_1_158 \$2917 VPWR VGND \$2834 sg13cmos5l_dlygate4sd3_1
* cell instance sg13cmos5l_dlygate4sd3_1_159 r0 *1 0,0
Xsg13cmos5l_dlygate4sd3_1_159 \$2498 VPWR VGND \$2484 sg13cmos5l_dlygate4sd3_1
* cell instance sg13cmos5l_dlygate4sd3_1_160 r0 *1 0,0
Xsg13cmos5l_dlygate4sd3_1_160 \$2886 VPWR VGND \$2798 sg13cmos5l_dlygate4sd3_1
* cell instance sg13cmos5l_dlygate4sd3_1_161 r0 *1 0,0
Xsg13cmos5l_dlygate4sd3_1_161 \$3385 VPWR VGND \$3382 sg13cmos5l_dlygate4sd3_1
* cell instance sg13cmos5l_dlygate4sd3_1_162 r0 *1 0,0
Xsg13cmos5l_dlygate4sd3_1_162 \$3870 VPWR VGND \$3711 sg13cmos5l_dlygate4sd3_1
* cell instance sg13cmos5l_dlygate4sd3_1_163 r0 *1 0,0
Xsg13cmos5l_dlygate4sd3_1_163 \$2371 VPWR VGND \$2226 sg13cmos5l_dlygate4sd3_1
* cell instance sg13cmos5l_dlygate4sd3_1_164 r0 *1 0,0
Xsg13cmos5l_dlygate4sd3_1_164 \$2695 VPWR VGND \$2389 sg13cmos5l_dlygate4sd3_1
* cell instance sg13cmos5l_dlygate4sd3_1_165 r0 *1 0,0
Xsg13cmos5l_dlygate4sd3_1_165 \$3499 VPWR VGND \$3536 sg13cmos5l_dlygate4sd3_1
* cell instance sg13cmos5l_dlygate4sd3_1_166 r0 *1 0,0
Xsg13cmos5l_dlygate4sd3_1_166 \$2514 VPWR VGND \$2229 sg13cmos5l_dlygate4sd3_1
* cell instance sg13cmos5l_dlygate4sd3_1_167 r0 *1 0,0
Xsg13cmos5l_dlygate4sd3_1_167 \$2865 VPWR VGND \$2829 sg13cmos5l_dlygate4sd3_1
* cell instance sg13cmos5l_dlygate4sd3_1_168 r0 *1 0,0
Xsg13cmos5l_dlygate4sd3_1_168 \$3179 VPWR VGND \$4499 sg13cmos5l_dlygate4sd3_1
* cell instance sg13cmos5l_dlygate4sd3_1_169 r0 *1 0,0
Xsg13cmos5l_dlygate4sd3_1_169 \$3889 VPWR VGND \$4036 sg13cmos5l_dlygate4sd3_1
* cell instance sg13cmos5l_dlygate4sd3_1_170 r0 *1 0,0
Xsg13cmos5l_dlygate4sd3_1_170 \$4041 VPWR VGND \$3890 sg13cmos5l_dlygate4sd3_1
* cell instance sg13cmos5l_dlygate4sd3_1_171 r0 *1 0,0
Xsg13cmos5l_dlygate4sd3_1_171 \$2379 VPWR VGND \$2378 sg13cmos5l_dlygate4sd3_1
* cell instance sg13cmos5l_dlygate4sd3_1_172 r0 *1 0,0
Xsg13cmos5l_dlygate4sd3_1_172 \$3225 VPWR VGND \$3036 sg13cmos5l_dlygate4sd3_1
* cell instance sg13cmos5l_dlygate4sd3_1_173 r0 *1 0,0
Xsg13cmos5l_dlygate4sd3_1_173 \$3728 VPWR VGND \$3723 sg13cmos5l_dlygate4sd3_1
* cell instance sg13cmos5l_dlygate4sd3_1_174 r0 *1 0,0
Xsg13cmos5l_dlygate4sd3_1_174 \$4388 VPWR VGND \$3888 sg13cmos5l_dlygate4sd3_1
* cell instance sg13cmos5l_dlygate4sd3_1_175 r0 *1 0,0
Xsg13cmos5l_dlygate4sd3_1_175 \$3456 VPWR VGND \$3553 sg13cmos5l_dlygate4sd3_1
* cell instance sg13cmos5l_dlygate4sd3_1_176 r0 *1 0,0
Xsg13cmos5l_dlygate4sd3_1_176 \$4199 VPWR VGND \$4876 sg13cmos5l_dlygate4sd3_1
* cell instance sg13cmos5l_dlygate4sd3_1_177 r0 *1 0,0
Xsg13cmos5l_dlygate4sd3_1_177 \$3457 VPWR VGND \$3231 sg13cmos5l_dlygate4sd3_1
* cell instance sg13cmos5l_dlygate4sd3_1_178 r0 *1 0,0
Xsg13cmos5l_dlygate4sd3_1_178 \$4058 VPWR VGND \$4047 sg13cmos5l_dlygate4sd3_1
* cell instance sg13cmos5l_dlygate4sd3_1_179 r0 *1 0,0
Xsg13cmos5l_dlygate4sd3_1_179 \$2871 VPWR VGND \$2866 sg13cmos5l_dlygate4sd3_1
* cell instance sg13cmos5l_dlygate4sd3_1_180 r0 *1 0,0
Xsg13cmos5l_dlygate4sd3_1_180 \$4512 VPWR VGND \$4392 sg13cmos5l_dlygate4sd3_1
* cell instance sg13cmos5l_dlygate4sd3_1_181 r0 *1 0,0
Xsg13cmos5l_dlygate4sd3_1_181 \$4033 VPWR VGND \$4907 sg13cmos5l_dlygate4sd3_1
* cell instance sg13cmos5l_dlygate4sd3_1_182 r0 *1 0,0
Xsg13cmos5l_dlygate4sd3_1_182 \$2874 VPWR VGND \$2864 sg13cmos5l_dlygate4sd3_1
* cell instance sg13cmos5l_dlygate4sd3_1_183 r0 *1 0,0
Xsg13cmos5l_dlygate4sd3_1_183 \$3901 VPWR VGND \$4243 sg13cmos5l_dlygate4sd3_1
* cell instance sg13cmos5l_dlygate4sd3_1_184 r0 *1 0,0
Xsg13cmos5l_dlygate4sd3_1_184 \$3573 VPWR VGND \$3569 sg13cmos5l_dlygate4sd3_1
* cell instance sg13cmos5l_dlygate4sd3_1_185 r0 *1 0,0
Xsg13cmos5l_dlygate4sd3_1_185 \$3915 VPWR VGND \$3570 sg13cmos5l_dlygate4sd3_1
* cell instance sg13cmos5l_dlygate4sd3_1_186 r0 *1 0,0
Xsg13cmos5l_dlygate4sd3_1_186 \$3576 VPWR VGND \$3237 sg13cmos5l_dlygate4sd3_1
* cell instance sg13cmos5l_dlygate4sd3_1_187 r0 *1 0,0
Xsg13cmos5l_dlygate4sd3_1_187 \$4528 VPWR VGND \$4515 sg13cmos5l_dlygate4sd3_1
* cell instance sg13cmos5l_dlygate4sd3_1_188 r0 *1 0,0
Xsg13cmos5l_dlygate4sd3_1_188 \$3549 VPWR VGND \$4923 sg13cmos5l_dlygate4sd3_1
* cell instance sg13cmos5l_dlygate4sd3_1_189 r0 *1 0,0
Xsg13cmos5l_dlygate4sd3_1_189 \$4310 VPWR VGND \$3900 sg13cmos5l_dlygate4sd3_1
* cell instance sg13cmos5l_dlygate4sd3_1_190 r0 *1 0,0
Xsg13cmos5l_dlygate4sd3_1_190 \$4071 VPWR VGND \$4066 sg13cmos5l_dlygate4sd3_1
* cell instance sg13cmos5l_dlygate4sd3_1_191 r0 *1 0,0
Xsg13cmos5l_dlygate4sd3_1_191 \$3559 VPWR VGND \$4653 sg13cmos5l_dlygate4sd3_1
* cell instance sg13cmos5l_dlygate4sd3_1_192 r0 *1 0,0
Xsg13cmos5l_dlygate4sd3_1_192 \$3362 VPWR VGND \$4939 sg13cmos5l_dlygate4sd3_1
* cell instance sg13cmos5l_dlygate4sd3_1_193 r0 *1 0,0
Xsg13cmos5l_dlygate4sd3_1_193 \$2731 VPWR VGND \$2719 sg13cmos5l_dlygate4sd3_1
* cell instance sg13cmos5l_dlygate4sd3_1_194 r0 *1 0,0
Xsg13cmos5l_dlygate4sd3_1_194 \$4540 VPWR VGND \$4403 sg13cmos5l_dlygate4sd3_1
* cell instance sg13cmos5l_dlygate4sd3_1_195 r0 *1 0,0
Xsg13cmos5l_dlygate4sd3_1_195 \$3765 VPWR VGND \$3582 sg13cmos5l_dlygate4sd3_1
* cell instance sg13cmos5l_dlygate4sd3_1_196 r0 *1 0,0
Xsg13cmos5l_dlygate4sd3_1_196 \$3082 VPWR VGND \$2880 sg13cmos5l_dlygate4sd3_1
* cell instance sg13cmos5l_dlygate4sd3_1_197 r0 *1 0,0
Xsg13cmos5l_dlygate4sd3_1_197 \$4226 VPWR VGND \$4949 sg13cmos5l_dlygate4sd3_1
* cell instance sg13cmos5l_dlygate4sd3_1_198 r0 *1 0,0
Xsg13cmos5l_dlygate4sd3_1_198 \$3257 VPWR VGND \$2888 sg13cmos5l_dlygate4sd3_1
* cell instance sg13cmos5l_dlygate4sd3_1_199 r0 *1 0,0
Xsg13cmos5l_dlygate4sd3_1_199 \$3440 VPWR VGND \$3428 sg13cmos5l_dlygate4sd3_1
* cell instance sg13cmos5l_dlygate4sd3_1_200 r0 *1 0,0
Xsg13cmos5l_dlygate4sd3_1_200 \$4666 VPWR VGND \$4544 sg13cmos5l_dlygate4sd3_1
* cell instance sg13cmos5l_dlygate4sd3_1_201 r0 *1 0,0
Xsg13cmos5l_dlygate4sd3_1_201 \$4560 VPWR VGND \$4414 sg13cmos5l_dlygate4sd3_1
* cell instance sg13cmos5l_dlygate4sd3_1_202 r0 *1 0,0
Xsg13cmos5l_dlygate4sd3_1_202 \$3088 VPWR VGND \$2894 sg13cmos5l_dlygate4sd3_1
* cell instance sg13cmos5l_dlygate4sd3_1_203 r0 *1 0,0
Xsg13cmos5l_dlygate4sd3_1_203 \$2552 VPWR VGND \$2587 sg13cmos5l_dlygate4sd3_1
* cell instance sg13cmos5l_dlygate4sd3_1_204 r0 *1 0,0
Xsg13cmos5l_dlygate4sd3_1_204 \$4082 VPWR VGND \$3928 sg13cmos5l_dlygate4sd3_1
* cell instance sg13cmos5l_dlygate4sd3_1_205 r0 *1 0,0
Xsg13cmos5l_dlygate4sd3_1_205 \$3719 VPWR VGND \$4956 sg13cmos5l_dlygate4sd3_1
* cell instance sg13cmos5l_dlygate4sd3_1_206 r0 *1 0,0
Xsg13cmos5l_dlygate4sd3_1_206 \$4277 VPWR VGND \$4076 sg13cmos5l_dlygate4sd3_1
* cell instance sg13cmos5l_dlygate4sd3_1_207 r0 *1 0,0
Xsg13cmos5l_dlygate4sd3_1_207 \$3923 VPWR VGND \$3589 sg13cmos5l_dlygate4sd3_1
* cell instance sg13cmos5l_dlygate4sd3_1_208 r0 *1 0,0
Xsg13cmos5l_dlygate4sd3_1_208 \$2739 VPWR VGND \$2740 sg13cmos5l_dlygate4sd3_1
* cell instance sg13cmos5l_dlygate4sd3_1_209 r0 *1 0,0
Xsg13cmos5l_dlygate4sd3_1_209 \$2738 VPWR VGND \$2392 sg13cmos5l_dlygate4sd3_1
* cell instance sg13cmos5l_dlygate4sd3_1_210 r0 *1 0,0
Xsg13cmos5l_dlygate4sd3_1_210 \$4420 VPWR VGND \$4278 sg13cmos5l_dlygate4sd3_1
* cell instance sg13cmos5l_dlygate4sd3_1_211 r0 *1 0,0
Xsg13cmos5l_dlygate4sd3_1_211 \$4081 VPWR VGND \$4281 sg13cmos5l_dlygate4sd3_1
* cell instance sg13cmos5l_dlygate4sd3_1_212 r0 *1 0,0
Xsg13cmos5l_dlygate4sd3_1_212 \$3609 VPWR VGND \$3768 sg13cmos5l_dlygate4sd3_1
* cell instance sg13cmos5l_dlygate4sd3_1_213 r0 *1 0,0
Xsg13cmos5l_dlygate4sd3_1_213 \$3780 VPWR VGND \$3960 sg13cmos5l_dlygate4sd3_1
* cell instance sg13cmos5l_fill_1_0 r0 *1 0,0
Xsg13cmos5l_fill_1_0 VPWR VGND sg13cmos5l_fill_1
* cell instance sg13cmos5l_fill_1_1 r0 *1 0,0
Xsg13cmos5l_fill_1_1 VPWR VGND sg13cmos5l_fill_1
* cell instance sg13cmos5l_fill_1_2 r0 *1 0,0
Xsg13cmos5l_fill_1_2 VPWR VGND sg13cmos5l_fill_1
* cell instance sg13cmos5l_fill_1_3 r0 *1 0,0
Xsg13cmos5l_fill_1_3 VPWR VGND sg13cmos5l_fill_1
* cell instance sg13cmos5l_fill_1_4 r0 *1 0,0
Xsg13cmos5l_fill_1_4 VPWR VGND sg13cmos5l_fill_1
* cell instance sg13cmos5l_fill_1_5 r0 *1 0,0
Xsg13cmos5l_fill_1_5 VPWR VGND sg13cmos5l_fill_1
* cell instance sg13cmos5l_fill_1_6 r0 *1 0,0
Xsg13cmos5l_fill_1_6 VPWR VGND sg13cmos5l_fill_1
* cell instance sg13cmos5l_fill_1_7 r0 *1 0,0
Xsg13cmos5l_fill_1_7 VPWR VGND sg13cmos5l_fill_1
* cell instance sg13cmos5l_fill_1_8 r0 *1 0,0
Xsg13cmos5l_fill_1_8 VPWR VGND sg13cmos5l_fill_1
* cell instance sg13cmos5l_fill_1_9 r0 *1 0,0
Xsg13cmos5l_fill_1_9 VPWR VGND sg13cmos5l_fill_1
* cell instance sg13cmos5l_fill_1_10 r0 *1 0,0
Xsg13cmos5l_fill_1_10 VPWR VGND sg13cmos5l_fill_1
* cell instance sg13cmos5l_fill_1_11 r0 *1 0,0
Xsg13cmos5l_fill_1_11 VPWR VGND sg13cmos5l_fill_1
* cell instance sg13cmos5l_fill_1_12 r0 *1 0,0
Xsg13cmos5l_fill_1_12 VPWR VGND sg13cmos5l_fill_1
* cell instance sg13cmos5l_fill_1_13 r0 *1 0,0
Xsg13cmos5l_fill_1_13 VPWR VGND sg13cmos5l_fill_1
* cell instance sg13cmos5l_fill_1_14 r0 *1 0,0
Xsg13cmos5l_fill_1_14 VPWR VGND sg13cmos5l_fill_1
* cell instance sg13cmos5l_fill_1_15 r0 *1 0,0
Xsg13cmos5l_fill_1_15 VPWR VGND sg13cmos5l_fill_1
* cell instance sg13cmos5l_fill_1_16 r0 *1 0,0
Xsg13cmos5l_fill_1_16 VPWR VGND sg13cmos5l_fill_1
* cell instance sg13cmos5l_fill_1_17 r0 *1 0,0
Xsg13cmos5l_fill_1_17 VPWR VGND sg13cmos5l_fill_1
* cell instance sg13cmos5l_fill_1_18 r0 *1 0,0
Xsg13cmos5l_fill_1_18 VPWR VGND sg13cmos5l_fill_1
* cell instance sg13cmos5l_fill_1_19 r0 *1 0,0
Xsg13cmos5l_fill_1_19 VPWR VGND sg13cmos5l_fill_1
* cell instance sg13cmos5l_fill_1_20 r0 *1 0,0
Xsg13cmos5l_fill_1_20 VPWR VGND sg13cmos5l_fill_1
* cell instance sg13cmos5l_fill_1_21 r0 *1 0,0
Xsg13cmos5l_fill_1_21 VPWR VGND sg13cmos5l_fill_1
* cell instance sg13cmos5l_fill_1_22 r0 *1 0,0
Xsg13cmos5l_fill_1_22 VPWR VGND sg13cmos5l_fill_1
* cell instance sg13cmos5l_fill_1_23 r0 *1 0,0
Xsg13cmos5l_fill_1_23 VPWR VGND sg13cmos5l_fill_1
* cell instance sg13cmos5l_fill_1_24 r0 *1 0,0
Xsg13cmos5l_fill_1_24 VPWR VGND sg13cmos5l_fill_1
* cell instance sg13cmos5l_fill_1_25 r0 *1 0,0
Xsg13cmos5l_fill_1_25 VPWR VGND sg13cmos5l_fill_1
* cell instance sg13cmos5l_fill_1_26 r0 *1 0,0
Xsg13cmos5l_fill_1_26 VPWR VGND sg13cmos5l_fill_1
* cell instance sg13cmos5l_fill_1_27 r0 *1 0,0
Xsg13cmos5l_fill_1_27 VPWR VGND sg13cmos5l_fill_1
* cell instance sg13cmos5l_fill_1_28 r0 *1 0,0
Xsg13cmos5l_fill_1_28 VPWR VGND sg13cmos5l_fill_1
* cell instance sg13cmos5l_fill_1_29 r0 *1 0,0
Xsg13cmos5l_fill_1_29 VPWR VGND sg13cmos5l_fill_1
* cell instance sg13cmos5l_fill_1_30 r0 *1 0,0
Xsg13cmos5l_fill_1_30 VPWR VGND sg13cmos5l_fill_1
* cell instance sg13cmos5l_fill_1_31 r0 *1 0,0
Xsg13cmos5l_fill_1_31 VPWR VGND sg13cmos5l_fill_1
* cell instance sg13cmos5l_fill_1_32 r0 *1 0,0
Xsg13cmos5l_fill_1_32 VPWR VGND sg13cmos5l_fill_1
* cell instance sg13cmos5l_fill_1_33 r0 *1 0,0
Xsg13cmos5l_fill_1_33 VPWR VGND sg13cmos5l_fill_1
* cell instance sg13cmos5l_fill_1_34 r0 *1 0,0
Xsg13cmos5l_fill_1_34 VPWR VGND sg13cmos5l_fill_1
* cell instance sg13cmos5l_fill_1_35 r0 *1 0,0
Xsg13cmos5l_fill_1_35 VPWR VGND sg13cmos5l_fill_1
* cell instance sg13cmos5l_fill_1_36 r0 *1 0,0
Xsg13cmos5l_fill_1_36 VPWR VGND sg13cmos5l_fill_1
* cell instance sg13cmos5l_fill_1_37 r0 *1 0,0
Xsg13cmos5l_fill_1_37 VPWR VGND sg13cmos5l_fill_1
* cell instance sg13cmos5l_fill_1_38 r0 *1 0,0
Xsg13cmos5l_fill_1_38 VPWR VGND sg13cmos5l_fill_1
* cell instance sg13cmos5l_fill_1_39 r0 *1 0,0
Xsg13cmos5l_fill_1_39 VPWR VGND sg13cmos5l_fill_1
* cell instance sg13cmos5l_fill_1_40 r0 *1 0,0
Xsg13cmos5l_fill_1_40 VPWR VGND sg13cmos5l_fill_1
* cell instance sg13cmos5l_fill_1_41 r0 *1 0,0
Xsg13cmos5l_fill_1_41 VPWR VGND sg13cmos5l_fill_1
* cell instance sg13cmos5l_fill_1_42 r0 *1 0,0
Xsg13cmos5l_fill_1_42 VPWR VGND sg13cmos5l_fill_1
* cell instance sg13cmos5l_fill_1_43 r0 *1 0,0
Xsg13cmos5l_fill_1_43 VPWR VGND sg13cmos5l_fill_1
* cell instance sg13cmos5l_fill_1_44 r0 *1 0,0
Xsg13cmos5l_fill_1_44 VPWR VGND sg13cmos5l_fill_1
* cell instance sg13cmos5l_fill_1_45 r0 *1 0,0
Xsg13cmos5l_fill_1_45 VPWR VGND sg13cmos5l_fill_1
* cell instance sg13cmos5l_fill_1_46 r0 *1 0,0
Xsg13cmos5l_fill_1_46 VPWR VGND sg13cmos5l_fill_1
* cell instance sg13cmos5l_fill_1_47 r0 *1 0,0
Xsg13cmos5l_fill_1_47 VPWR VGND sg13cmos5l_fill_1
* cell instance sg13cmos5l_fill_1_48 r0 *1 0,0
Xsg13cmos5l_fill_1_48 VPWR VGND sg13cmos5l_fill_1
* cell instance sg13cmos5l_fill_1_49 r0 *1 0,0
Xsg13cmos5l_fill_1_49 VPWR VGND sg13cmos5l_fill_1
* cell instance sg13cmos5l_fill_1_50 r0 *1 0,0
Xsg13cmos5l_fill_1_50 VPWR VGND sg13cmos5l_fill_1
* cell instance sg13cmos5l_fill_1_51 r0 *1 0,0
Xsg13cmos5l_fill_1_51 VPWR VGND sg13cmos5l_fill_1
* cell instance sg13cmos5l_fill_1_52 r0 *1 0,0
Xsg13cmos5l_fill_1_52 VPWR VGND sg13cmos5l_fill_1
* cell instance sg13cmos5l_fill_1_53 r0 *1 0,0
Xsg13cmos5l_fill_1_53 VPWR VGND sg13cmos5l_fill_1
* cell instance sg13cmos5l_fill_1_54 r0 *1 0,0
Xsg13cmos5l_fill_1_54 VPWR VGND sg13cmos5l_fill_1
* cell instance sg13cmos5l_fill_1_55 r0 *1 0,0
Xsg13cmos5l_fill_1_55 VPWR VGND sg13cmos5l_fill_1
* cell instance sg13cmos5l_fill_1_56 r0 *1 0,0
Xsg13cmos5l_fill_1_56 VPWR VGND sg13cmos5l_fill_1
* cell instance sg13cmos5l_fill_1_57 r0 *1 0,0
Xsg13cmos5l_fill_1_57 VPWR VGND sg13cmos5l_fill_1
* cell instance sg13cmos5l_fill_1_58 r0 *1 0,0
Xsg13cmos5l_fill_1_58 VPWR VGND sg13cmos5l_fill_1
* cell instance sg13cmos5l_fill_1_59 r0 *1 0,0
Xsg13cmos5l_fill_1_59 VPWR VGND sg13cmos5l_fill_1
* cell instance sg13cmos5l_fill_1_60 r0 *1 0,0
Xsg13cmos5l_fill_1_60 VPWR VGND sg13cmos5l_fill_1
* cell instance sg13cmos5l_fill_1_61 r0 *1 0,0
Xsg13cmos5l_fill_1_61 VPWR VGND sg13cmos5l_fill_1
* cell instance sg13cmos5l_fill_1_62 r0 *1 0,0
Xsg13cmos5l_fill_1_62 VPWR VGND sg13cmos5l_fill_1
* cell instance sg13cmos5l_fill_1_63 r0 *1 0,0
Xsg13cmos5l_fill_1_63 VPWR VGND sg13cmos5l_fill_1
* cell instance sg13cmos5l_fill_1_64 r0 *1 0,0
Xsg13cmos5l_fill_1_64 VPWR VGND sg13cmos5l_fill_1
* cell instance sg13cmos5l_fill_1_65 r0 *1 0,0
Xsg13cmos5l_fill_1_65 VPWR VGND sg13cmos5l_fill_1
* cell instance sg13cmos5l_fill_1_66 r0 *1 0,0
Xsg13cmos5l_fill_1_66 VPWR VGND sg13cmos5l_fill_1
* cell instance sg13cmos5l_fill_1_67 r0 *1 0,0
Xsg13cmos5l_fill_1_67 VPWR VGND sg13cmos5l_fill_1
* cell instance sg13cmos5l_fill_1_68 r0 *1 0,0
Xsg13cmos5l_fill_1_68 VPWR VGND sg13cmos5l_fill_1
* cell instance sg13cmos5l_fill_1_69 r0 *1 0,0
Xsg13cmos5l_fill_1_69 VPWR VGND sg13cmos5l_fill_1
* cell instance sg13cmos5l_fill_1_70 r0 *1 0,0
Xsg13cmos5l_fill_1_70 VPWR VGND sg13cmos5l_fill_1
* cell instance sg13cmos5l_fill_1_71 r0 *1 0,0
Xsg13cmos5l_fill_1_71 VPWR VGND sg13cmos5l_fill_1
* cell instance sg13cmos5l_fill_1_72 r0 *1 0,0
Xsg13cmos5l_fill_1_72 VPWR VGND sg13cmos5l_fill_1
* cell instance sg13cmos5l_fill_1_73 r0 *1 0,0
Xsg13cmos5l_fill_1_73 VPWR VGND sg13cmos5l_fill_1
* cell instance sg13cmos5l_fill_1_74 r0 *1 0,0
Xsg13cmos5l_fill_1_74 VPWR VGND sg13cmos5l_fill_1
* cell instance sg13cmos5l_fill_1_75 r0 *1 0,0
Xsg13cmos5l_fill_1_75 VPWR VGND sg13cmos5l_fill_1
* cell instance sg13cmos5l_fill_1_76 r0 *1 0,0
Xsg13cmos5l_fill_1_76 VPWR VGND sg13cmos5l_fill_1
* cell instance sg13cmos5l_fill_1_77 r0 *1 0,0
Xsg13cmos5l_fill_1_77 VPWR VGND sg13cmos5l_fill_1
* cell instance sg13cmos5l_fill_1_78 r0 *1 0,0
Xsg13cmos5l_fill_1_78 VPWR VGND sg13cmos5l_fill_1
* cell instance sg13cmos5l_fill_1_79 r0 *1 0,0
Xsg13cmos5l_fill_1_79 VPWR VGND sg13cmos5l_fill_1
* cell instance sg13cmos5l_fill_1_80 r0 *1 0,0
Xsg13cmos5l_fill_1_80 VPWR VGND sg13cmos5l_fill_1
* cell instance sg13cmos5l_fill_1_81 r0 *1 0,0
Xsg13cmos5l_fill_1_81 VPWR VGND sg13cmos5l_fill_1
* cell instance sg13cmos5l_fill_1_82 r0 *1 0,0
Xsg13cmos5l_fill_1_82 VPWR VGND sg13cmos5l_fill_1
* cell instance sg13cmos5l_fill_1_83 r0 *1 0,0
Xsg13cmos5l_fill_1_83 VPWR VGND sg13cmos5l_fill_1
* cell instance sg13cmos5l_fill_1_84 r0 *1 0,0
Xsg13cmos5l_fill_1_84 VPWR VGND sg13cmos5l_fill_1
* cell instance sg13cmos5l_fill_1_85 r0 *1 0,0
Xsg13cmos5l_fill_1_85 VPWR VGND sg13cmos5l_fill_1
* cell instance sg13cmos5l_fill_1_86 r0 *1 0,0
Xsg13cmos5l_fill_1_86 VPWR VGND sg13cmos5l_fill_1
* cell instance sg13cmos5l_fill_1_87 r0 *1 0,0
Xsg13cmos5l_fill_1_87 VPWR VGND sg13cmos5l_fill_1
* cell instance sg13cmos5l_fill_1_88 r0 *1 0,0
Xsg13cmos5l_fill_1_88 VPWR VGND sg13cmos5l_fill_1
* cell instance sg13cmos5l_fill_1_89 r0 *1 0,0
Xsg13cmos5l_fill_1_89 VPWR VGND sg13cmos5l_fill_1
* cell instance sg13cmos5l_fill_1_90 r0 *1 0,0
Xsg13cmos5l_fill_1_90 VPWR VGND sg13cmos5l_fill_1
* cell instance sg13cmos5l_fill_1_91 r0 *1 0,0
Xsg13cmos5l_fill_1_91 VPWR VGND sg13cmos5l_fill_1
* cell instance sg13cmos5l_fill_1_92 r0 *1 0,0
Xsg13cmos5l_fill_1_92 VPWR VGND sg13cmos5l_fill_1
* cell instance sg13cmos5l_fill_1_93 r0 *1 0,0
Xsg13cmos5l_fill_1_93 VPWR VGND sg13cmos5l_fill_1
* cell instance sg13cmos5l_fill_1_94 r0 *1 0,0
Xsg13cmos5l_fill_1_94 VPWR VGND sg13cmos5l_fill_1
* cell instance sg13cmos5l_fill_1_95 r0 *1 0,0
Xsg13cmos5l_fill_1_95 VPWR VGND sg13cmos5l_fill_1
* cell instance sg13cmos5l_fill_1_96 r0 *1 0,0
Xsg13cmos5l_fill_1_96 VPWR VGND sg13cmos5l_fill_1
* cell instance sg13cmos5l_fill_1_97 r0 *1 0,0
Xsg13cmos5l_fill_1_97 VPWR VGND sg13cmos5l_fill_1
* cell instance sg13cmos5l_fill_1_98 r0 *1 0,0
Xsg13cmos5l_fill_1_98 VPWR VGND sg13cmos5l_fill_1
* cell instance sg13cmos5l_fill_1_99 r0 *1 0,0
Xsg13cmos5l_fill_1_99 VPWR VGND sg13cmos5l_fill_1
* cell instance sg13cmos5l_fill_1_100 r0 *1 0,0
Xsg13cmos5l_fill_1_100 VPWR VGND sg13cmos5l_fill_1
* cell instance sg13cmos5l_fill_1_101 r0 *1 0,0
Xsg13cmos5l_fill_1_101 VPWR VGND sg13cmos5l_fill_1
* cell instance sg13cmos5l_fill_1_102 r0 *1 0,0
Xsg13cmos5l_fill_1_102 VPWR VGND sg13cmos5l_fill_1
* cell instance sg13cmos5l_fill_1_103 r0 *1 0,0
Xsg13cmos5l_fill_1_103 VPWR VGND sg13cmos5l_fill_1
* cell instance sg13cmos5l_fill_1_104 r0 *1 0,0
Xsg13cmos5l_fill_1_104 VPWR VGND sg13cmos5l_fill_1
* cell instance sg13cmos5l_fill_1_105 r0 *1 0,0
Xsg13cmos5l_fill_1_105 VPWR VGND sg13cmos5l_fill_1
* cell instance sg13cmos5l_fill_1_106 r0 *1 0,0
Xsg13cmos5l_fill_1_106 VPWR VGND sg13cmos5l_fill_1
* cell instance sg13cmos5l_fill_1_107 r0 *1 0,0
Xsg13cmos5l_fill_1_107 VPWR VGND sg13cmos5l_fill_1
* cell instance sg13cmos5l_fill_1_108 r0 *1 0,0
Xsg13cmos5l_fill_1_108 VPWR VGND sg13cmos5l_fill_1
* cell instance sg13cmos5l_fill_1_109 r0 *1 0,0
Xsg13cmos5l_fill_1_109 VPWR VGND sg13cmos5l_fill_1
* cell instance sg13cmos5l_fill_1_110 r0 *1 0,0
Xsg13cmos5l_fill_1_110 VPWR VGND sg13cmos5l_fill_1
* cell instance sg13cmos5l_fill_1_111 r0 *1 0,0
Xsg13cmos5l_fill_1_111 VPWR VGND sg13cmos5l_fill_1
* cell instance sg13cmos5l_fill_1_112 r0 *1 0,0
Xsg13cmos5l_fill_1_112 VPWR VGND sg13cmos5l_fill_1
* cell instance sg13cmos5l_fill_1_113 r0 *1 0,0
Xsg13cmos5l_fill_1_113 VPWR VGND sg13cmos5l_fill_1
* cell instance sg13cmos5l_fill_1_114 r0 *1 0,0
Xsg13cmos5l_fill_1_114 VPWR VGND sg13cmos5l_fill_1
* cell instance sg13cmos5l_fill_1_115 r0 *1 0,0
Xsg13cmos5l_fill_1_115 VPWR VGND sg13cmos5l_fill_1
* cell instance sg13cmos5l_fill_1_116 r0 *1 0,0
Xsg13cmos5l_fill_1_116 VPWR VGND sg13cmos5l_fill_1
* cell instance sg13cmos5l_fill_1_117 r0 *1 0,0
Xsg13cmos5l_fill_1_117 VPWR VGND sg13cmos5l_fill_1
* cell instance sg13cmos5l_fill_1_118 r0 *1 0,0
Xsg13cmos5l_fill_1_118 VPWR VGND sg13cmos5l_fill_1
* cell instance sg13cmos5l_fill_1_119 r0 *1 0,0
Xsg13cmos5l_fill_1_119 VPWR VGND sg13cmos5l_fill_1
* cell instance sg13cmos5l_fill_1_120 r0 *1 0,0
Xsg13cmos5l_fill_1_120 VPWR VGND sg13cmos5l_fill_1
* cell instance sg13cmos5l_fill_1_121 r0 *1 0,0
Xsg13cmos5l_fill_1_121 VPWR VGND sg13cmos5l_fill_1
* cell instance sg13cmos5l_fill_1_122 r0 *1 0,0
Xsg13cmos5l_fill_1_122 VPWR VGND sg13cmos5l_fill_1
* cell instance sg13cmos5l_fill_1_123 r0 *1 0,0
Xsg13cmos5l_fill_1_123 VPWR VGND sg13cmos5l_fill_1
* cell instance sg13cmos5l_fill_1_124 r0 *1 0,0
Xsg13cmos5l_fill_1_124 VPWR VGND sg13cmos5l_fill_1
* cell instance sg13cmos5l_fill_1_125 r0 *1 0,0
Xsg13cmos5l_fill_1_125 VPWR VGND sg13cmos5l_fill_1
* cell instance sg13cmos5l_fill_1_126 r0 *1 0,0
Xsg13cmos5l_fill_1_126 VPWR VGND sg13cmos5l_fill_1
* cell instance sg13cmos5l_fill_1_127 r0 *1 0,0
Xsg13cmos5l_fill_1_127 VPWR VGND sg13cmos5l_fill_1
* cell instance sg13cmos5l_fill_1_128 r0 *1 0,0
Xsg13cmos5l_fill_1_128 VPWR VGND sg13cmos5l_fill_1
* cell instance sg13cmos5l_fill_1_129 r0 *1 0,0
Xsg13cmos5l_fill_1_129 VPWR VGND sg13cmos5l_fill_1
* cell instance sg13cmos5l_fill_1_130 r0 *1 0,0
Xsg13cmos5l_fill_1_130 VPWR VGND sg13cmos5l_fill_1
* cell instance sg13cmos5l_fill_1_131 r0 *1 0,0
Xsg13cmos5l_fill_1_131 VPWR VGND sg13cmos5l_fill_1
* cell instance sg13cmos5l_fill_1_132 r0 *1 0,0
Xsg13cmos5l_fill_1_132 VPWR VGND sg13cmos5l_fill_1
* cell instance sg13cmos5l_fill_1_133 r0 *1 0,0
Xsg13cmos5l_fill_1_133 VPWR VGND sg13cmos5l_fill_1
* cell instance sg13cmos5l_fill_1_134 r0 *1 0,0
Xsg13cmos5l_fill_1_134 VPWR VGND sg13cmos5l_fill_1
* cell instance sg13cmos5l_fill_1_135 r0 *1 0,0
Xsg13cmos5l_fill_1_135 VPWR VGND sg13cmos5l_fill_1
* cell instance sg13cmos5l_fill_1_136 r0 *1 0,0
Xsg13cmos5l_fill_1_136 VPWR VGND sg13cmos5l_fill_1
* cell instance sg13cmos5l_fill_1_137 r0 *1 0,0
Xsg13cmos5l_fill_1_137 VPWR VGND sg13cmos5l_fill_1
* cell instance sg13cmos5l_fill_1_138 r0 *1 0,0
Xsg13cmos5l_fill_1_138 VPWR VGND sg13cmos5l_fill_1
* cell instance sg13cmos5l_fill_1_139 r0 *1 0,0
Xsg13cmos5l_fill_1_139 VPWR VGND sg13cmos5l_fill_1
* cell instance sg13cmos5l_fill_1_140 r0 *1 0,0
Xsg13cmos5l_fill_1_140 VPWR VGND sg13cmos5l_fill_1
* cell instance sg13cmos5l_fill_1_141 r0 *1 0,0
Xsg13cmos5l_fill_1_141 VPWR VGND sg13cmos5l_fill_1
* cell instance sg13cmos5l_fill_1_142 r0 *1 0,0
Xsg13cmos5l_fill_1_142 VPWR VGND sg13cmos5l_fill_1
* cell instance sg13cmos5l_fill_1_143 r0 *1 0,0
Xsg13cmos5l_fill_1_143 VPWR VGND sg13cmos5l_fill_1
* cell instance sg13cmos5l_fill_1_144 r0 *1 0,0
Xsg13cmos5l_fill_1_144 VPWR VGND sg13cmos5l_fill_1
* cell instance sg13cmos5l_fill_1_145 r0 *1 0,0
Xsg13cmos5l_fill_1_145 VPWR VGND sg13cmos5l_fill_1
* cell instance sg13cmos5l_fill_1_146 r0 *1 0,0
Xsg13cmos5l_fill_1_146 VPWR VGND sg13cmos5l_fill_1
* cell instance sg13cmos5l_fill_1_147 r0 *1 0,0
Xsg13cmos5l_fill_1_147 VPWR VGND sg13cmos5l_fill_1
* cell instance sg13cmos5l_fill_1_148 r0 *1 0,0
Xsg13cmos5l_fill_1_148 VPWR VGND sg13cmos5l_fill_1
* cell instance sg13cmos5l_fill_1_149 r0 *1 0,0
Xsg13cmos5l_fill_1_149 VPWR VGND sg13cmos5l_fill_1
* cell instance sg13cmos5l_fill_1_150 r0 *1 0,0
Xsg13cmos5l_fill_1_150 VPWR VGND sg13cmos5l_fill_1
* cell instance sg13cmos5l_fill_1_151 r0 *1 0,0
Xsg13cmos5l_fill_1_151 VPWR VGND sg13cmos5l_fill_1
* cell instance sg13cmos5l_fill_1_152 r0 *1 0,0
Xsg13cmos5l_fill_1_152 VPWR VGND sg13cmos5l_fill_1
* cell instance sg13cmos5l_fill_1_153 r0 *1 0,0
Xsg13cmos5l_fill_1_153 VPWR VGND sg13cmos5l_fill_1
* cell instance sg13cmos5l_fill_1_154 r0 *1 0,0
Xsg13cmos5l_fill_1_154 VPWR VGND sg13cmos5l_fill_1
* cell instance sg13cmos5l_fill_1_155 r0 *1 0,0
Xsg13cmos5l_fill_1_155 VPWR VGND sg13cmos5l_fill_1
* cell instance sg13cmos5l_fill_1_156 r0 *1 0,0
Xsg13cmos5l_fill_1_156 VPWR VGND sg13cmos5l_fill_1
* cell instance sg13cmos5l_fill_1_157 r0 *1 0,0
Xsg13cmos5l_fill_1_157 VPWR VGND sg13cmos5l_fill_1
* cell instance sg13cmos5l_fill_1_158 r0 *1 0,0
Xsg13cmos5l_fill_1_158 VPWR VGND sg13cmos5l_fill_1
* cell instance sg13cmos5l_fill_1_159 r0 *1 0,0
Xsg13cmos5l_fill_1_159 VPWR VGND sg13cmos5l_fill_1
* cell instance sg13cmos5l_fill_1_160 r0 *1 0,0
Xsg13cmos5l_fill_1_160 VPWR VGND sg13cmos5l_fill_1
* cell instance sg13cmos5l_fill_1_161 r0 *1 0,0
Xsg13cmos5l_fill_1_161 VPWR VGND sg13cmos5l_fill_1
* cell instance sg13cmos5l_fill_1_162 r0 *1 0,0
Xsg13cmos5l_fill_1_162 VPWR VGND sg13cmos5l_fill_1
* cell instance sg13cmos5l_fill_1_163 r0 *1 0,0
Xsg13cmos5l_fill_1_163 VPWR VGND sg13cmos5l_fill_1
* cell instance sg13cmos5l_fill_1_164 r0 *1 0,0
Xsg13cmos5l_fill_1_164 VPWR VGND sg13cmos5l_fill_1
* cell instance sg13cmos5l_fill_1_165 r0 *1 0,0
Xsg13cmos5l_fill_1_165 VPWR VGND sg13cmos5l_fill_1
* cell instance sg13cmos5l_fill_1_166 r0 *1 0,0
Xsg13cmos5l_fill_1_166 VPWR VGND sg13cmos5l_fill_1
* cell instance sg13cmos5l_fill_1_167 r0 *1 0,0
Xsg13cmos5l_fill_1_167 VPWR VGND sg13cmos5l_fill_1
* cell instance sg13cmos5l_fill_1_168 r0 *1 0,0
Xsg13cmos5l_fill_1_168 VPWR VGND sg13cmos5l_fill_1
* cell instance sg13cmos5l_fill_1_169 r0 *1 0,0
Xsg13cmos5l_fill_1_169 VPWR VGND sg13cmos5l_fill_1
* cell instance sg13cmos5l_fill_1_170 r0 *1 0,0
Xsg13cmos5l_fill_1_170 VPWR VGND sg13cmos5l_fill_1
* cell instance sg13cmos5l_fill_1_171 r0 *1 0,0
Xsg13cmos5l_fill_1_171 VPWR VGND sg13cmos5l_fill_1
* cell instance sg13cmos5l_fill_1_172 r0 *1 0,0
Xsg13cmos5l_fill_1_172 VPWR VGND sg13cmos5l_fill_1
* cell instance sg13cmos5l_fill_1_173 r0 *1 0,0
Xsg13cmos5l_fill_1_173 VPWR VGND sg13cmos5l_fill_1
* cell instance sg13cmos5l_fill_1_174 r0 *1 0,0
Xsg13cmos5l_fill_1_174 VPWR VGND sg13cmos5l_fill_1
* cell instance sg13cmos5l_fill_1_175 r0 *1 0,0
Xsg13cmos5l_fill_1_175 VPWR VGND sg13cmos5l_fill_1
* cell instance sg13cmos5l_fill_1_176 r0 *1 0,0
Xsg13cmos5l_fill_1_176 VPWR VGND sg13cmos5l_fill_1
* cell instance sg13cmos5l_fill_1_177 r0 *1 0,0
Xsg13cmos5l_fill_1_177 VPWR VGND sg13cmos5l_fill_1
* cell instance sg13cmos5l_fill_1_178 r0 *1 0,0
Xsg13cmos5l_fill_1_178 VPWR VGND sg13cmos5l_fill_1
* cell instance sg13cmos5l_fill_1_179 r0 *1 0,0
Xsg13cmos5l_fill_1_179 VPWR VGND sg13cmos5l_fill_1
* cell instance sg13cmos5l_fill_1_180 r0 *1 0,0
Xsg13cmos5l_fill_1_180 VPWR VGND sg13cmos5l_fill_1
* cell instance sg13cmos5l_fill_1_181 r0 *1 0,0
Xsg13cmos5l_fill_1_181 VPWR VGND sg13cmos5l_fill_1
* cell instance sg13cmos5l_fill_1_182 r0 *1 0,0
Xsg13cmos5l_fill_1_182 VPWR VGND sg13cmos5l_fill_1
* cell instance sg13cmos5l_fill_1_183 r0 *1 0,0
Xsg13cmos5l_fill_1_183 VPWR VGND sg13cmos5l_fill_1
* cell instance sg13cmos5l_fill_1_184 r0 *1 0,0
Xsg13cmos5l_fill_1_184 VPWR VGND sg13cmos5l_fill_1
* cell instance sg13cmos5l_fill_1_185 r0 *1 0,0
Xsg13cmos5l_fill_1_185 VPWR VGND sg13cmos5l_fill_1
* cell instance sg13cmos5l_fill_1_186 r0 *1 0,0
Xsg13cmos5l_fill_1_186 VPWR VGND sg13cmos5l_fill_1
* cell instance sg13cmos5l_fill_1_187 r0 *1 0,0
Xsg13cmos5l_fill_1_187 VPWR VGND sg13cmos5l_fill_1
* cell instance sg13cmos5l_fill_1_188 r0 *1 0,0
Xsg13cmos5l_fill_1_188 VPWR VGND sg13cmos5l_fill_1
* cell instance sg13cmos5l_fill_1_189 r0 *1 0,0
Xsg13cmos5l_fill_1_189 VPWR VGND sg13cmos5l_fill_1
* cell instance sg13cmos5l_fill_1_190 r0 *1 0,0
Xsg13cmos5l_fill_1_190 VPWR VGND sg13cmos5l_fill_1
* cell instance sg13cmos5l_fill_1_191 r0 *1 0,0
Xsg13cmos5l_fill_1_191 VPWR VGND sg13cmos5l_fill_1
* cell instance sg13cmos5l_fill_1_192 r0 *1 0,0
Xsg13cmos5l_fill_1_192 VPWR VGND sg13cmos5l_fill_1
* cell instance sg13cmos5l_fill_1_193 r0 *1 0,0
Xsg13cmos5l_fill_1_193 VPWR VGND sg13cmos5l_fill_1
* cell instance sg13cmos5l_fill_1_194 r0 *1 0,0
Xsg13cmos5l_fill_1_194 VPWR VGND sg13cmos5l_fill_1
* cell instance sg13cmos5l_fill_1_195 r0 *1 0,0
Xsg13cmos5l_fill_1_195 VPWR VGND sg13cmos5l_fill_1
* cell instance sg13cmos5l_fill_1_196 r0 *1 0,0
Xsg13cmos5l_fill_1_196 VPWR VGND sg13cmos5l_fill_1
* cell instance sg13cmos5l_fill_1_197 r0 *1 0,0
Xsg13cmos5l_fill_1_197 VPWR VGND sg13cmos5l_fill_1
* cell instance sg13cmos5l_fill_1_198 r0 *1 0,0
Xsg13cmos5l_fill_1_198 VPWR VGND sg13cmos5l_fill_1
* cell instance sg13cmos5l_fill_1_199 r0 *1 0,0
Xsg13cmos5l_fill_1_199 VPWR VGND sg13cmos5l_fill_1
* cell instance sg13cmos5l_fill_1_200 r0 *1 0,0
Xsg13cmos5l_fill_1_200 VPWR VGND sg13cmos5l_fill_1
* cell instance sg13cmos5l_fill_1_201 r0 *1 0,0
Xsg13cmos5l_fill_1_201 VPWR VGND sg13cmos5l_fill_1
* cell instance sg13cmos5l_fill_1_202 r0 *1 0,0
Xsg13cmos5l_fill_1_202 VPWR VGND sg13cmos5l_fill_1
* cell instance sg13cmos5l_fill_1_203 r0 *1 0,0
Xsg13cmos5l_fill_1_203 VPWR VGND sg13cmos5l_fill_1
* cell instance sg13cmos5l_fill_1_204 r0 *1 0,0
Xsg13cmos5l_fill_1_204 VPWR VGND sg13cmos5l_fill_1
* cell instance sg13cmos5l_fill_1_205 r0 *1 0,0
Xsg13cmos5l_fill_1_205 VPWR VGND sg13cmos5l_fill_1
* cell instance sg13cmos5l_fill_1_206 r0 *1 0,0
Xsg13cmos5l_fill_1_206 VPWR VGND sg13cmos5l_fill_1
* cell instance sg13cmos5l_fill_1_207 r0 *1 0,0
Xsg13cmos5l_fill_1_207 VPWR VGND sg13cmos5l_fill_1
* cell instance sg13cmos5l_fill_1_208 r0 *1 0,0
Xsg13cmos5l_fill_1_208 VPWR VGND sg13cmos5l_fill_1
* cell instance sg13cmos5l_fill_1_209 r0 *1 0,0
Xsg13cmos5l_fill_1_209 VPWR VGND sg13cmos5l_fill_1
* cell instance sg13cmos5l_fill_1_210 r0 *1 0,0
Xsg13cmos5l_fill_1_210 VPWR VGND sg13cmos5l_fill_1
* cell instance sg13cmos5l_fill_1_211 r0 *1 0,0
Xsg13cmos5l_fill_1_211 VPWR VGND sg13cmos5l_fill_1
* cell instance sg13cmos5l_fill_1_212 r0 *1 0,0
Xsg13cmos5l_fill_1_212 VPWR VGND sg13cmos5l_fill_1
* cell instance sg13cmos5l_fill_1_213 r0 *1 0,0
Xsg13cmos5l_fill_1_213 VPWR VGND sg13cmos5l_fill_1
* cell instance sg13cmos5l_fill_1_214 r0 *1 0,0
Xsg13cmos5l_fill_1_214 VPWR VGND sg13cmos5l_fill_1
* cell instance sg13cmos5l_fill_1_215 r0 *1 0,0
Xsg13cmos5l_fill_1_215 VPWR VGND sg13cmos5l_fill_1
* cell instance sg13cmos5l_fill_1_216 r0 *1 0,0
Xsg13cmos5l_fill_1_216 VPWR VGND sg13cmos5l_fill_1
* cell instance sg13cmos5l_fill_1_217 r0 *1 0,0
Xsg13cmos5l_fill_1_217 VPWR VGND sg13cmos5l_fill_1
* cell instance sg13cmos5l_fill_1_218 r0 *1 0,0
Xsg13cmos5l_fill_1_218 VPWR VGND sg13cmos5l_fill_1
* cell instance sg13cmos5l_fill_1_219 r0 *1 0,0
Xsg13cmos5l_fill_1_219 VPWR VGND sg13cmos5l_fill_1
* cell instance sg13cmos5l_fill_1_220 r0 *1 0,0
Xsg13cmos5l_fill_1_220 VPWR VGND sg13cmos5l_fill_1
* cell instance sg13cmos5l_fill_1_221 r0 *1 0,0
Xsg13cmos5l_fill_1_221 VPWR VGND sg13cmos5l_fill_1
* cell instance sg13cmos5l_fill_1_222 r0 *1 0,0
Xsg13cmos5l_fill_1_222 VPWR VGND sg13cmos5l_fill_1
* cell instance sg13cmos5l_fill_1_223 r0 *1 0,0
Xsg13cmos5l_fill_1_223 VPWR VGND sg13cmos5l_fill_1
* cell instance sg13cmos5l_fill_1_224 r0 *1 0,0
Xsg13cmos5l_fill_1_224 VPWR VGND sg13cmos5l_fill_1
* cell instance sg13cmos5l_fill_1_225 r0 *1 0,0
Xsg13cmos5l_fill_1_225 VPWR VGND sg13cmos5l_fill_1
* cell instance sg13cmos5l_fill_1_226 r0 *1 0,0
Xsg13cmos5l_fill_1_226 VPWR VGND sg13cmos5l_fill_1
* cell instance sg13cmos5l_fill_1_227 r0 *1 0,0
Xsg13cmos5l_fill_1_227 VPWR VGND sg13cmos5l_fill_1
* cell instance sg13cmos5l_fill_1_228 r0 *1 0,0
Xsg13cmos5l_fill_1_228 VPWR VGND sg13cmos5l_fill_1
* cell instance sg13cmos5l_fill_1_229 r0 *1 0,0
Xsg13cmos5l_fill_1_229 VPWR VGND sg13cmos5l_fill_1
* cell instance sg13cmos5l_fill_1_230 r0 *1 0,0
Xsg13cmos5l_fill_1_230 VPWR VGND sg13cmos5l_fill_1
* cell instance sg13cmos5l_fill_1_231 r0 *1 0,0
Xsg13cmos5l_fill_1_231 VPWR VGND sg13cmos5l_fill_1
* cell instance sg13cmos5l_fill_1_232 r0 *1 0,0
Xsg13cmos5l_fill_1_232 VPWR VGND sg13cmos5l_fill_1
* cell instance sg13cmos5l_fill_1_233 r0 *1 0,0
Xsg13cmos5l_fill_1_233 VPWR VGND sg13cmos5l_fill_1
* cell instance sg13cmos5l_fill_1_234 r0 *1 0,0
Xsg13cmos5l_fill_1_234 VPWR VGND sg13cmos5l_fill_1
* cell instance sg13cmos5l_fill_1_235 r0 *1 0,0
Xsg13cmos5l_fill_1_235 VPWR VGND sg13cmos5l_fill_1
* cell instance sg13cmos5l_fill_1_236 r0 *1 0,0
Xsg13cmos5l_fill_1_236 VPWR VGND sg13cmos5l_fill_1
* cell instance sg13cmos5l_fill_1_237 r0 *1 0,0
Xsg13cmos5l_fill_1_237 VPWR VGND sg13cmos5l_fill_1
* cell instance sg13cmos5l_fill_1_238 r0 *1 0,0
Xsg13cmos5l_fill_1_238 VPWR VGND sg13cmos5l_fill_1
* cell instance sg13cmos5l_fill_1_239 r0 *1 0,0
Xsg13cmos5l_fill_1_239 VPWR VGND sg13cmos5l_fill_1
* cell instance sg13cmos5l_fill_1_240 r0 *1 0,0
Xsg13cmos5l_fill_1_240 VPWR VGND sg13cmos5l_fill_1
* cell instance sg13cmos5l_fill_1_241 r0 *1 0,0
Xsg13cmos5l_fill_1_241 VPWR VGND sg13cmos5l_fill_1
* cell instance sg13cmos5l_fill_1_242 r0 *1 0,0
Xsg13cmos5l_fill_1_242 VPWR VGND sg13cmos5l_fill_1
* cell instance sg13cmos5l_fill_1_243 r0 *1 0,0
Xsg13cmos5l_fill_1_243 VPWR VGND sg13cmos5l_fill_1
* cell instance sg13cmos5l_fill_1_244 r0 *1 0,0
Xsg13cmos5l_fill_1_244 VPWR VGND sg13cmos5l_fill_1
* cell instance sg13cmos5l_fill_1_245 r0 *1 0,0
Xsg13cmos5l_fill_1_245 VPWR VGND sg13cmos5l_fill_1
* cell instance sg13cmos5l_fill_1_246 r0 *1 0,0
Xsg13cmos5l_fill_1_246 VPWR VGND sg13cmos5l_fill_1
* cell instance sg13cmos5l_fill_1_247 r0 *1 0,0
Xsg13cmos5l_fill_1_247 VPWR VGND sg13cmos5l_fill_1
* cell instance sg13cmos5l_fill_1_248 r0 *1 0,0
Xsg13cmos5l_fill_1_248 VPWR VGND sg13cmos5l_fill_1
* cell instance sg13cmos5l_fill_1_249 r0 *1 0,0
Xsg13cmos5l_fill_1_249 VPWR VGND sg13cmos5l_fill_1
* cell instance sg13cmos5l_fill_1_250 r0 *1 0,0
Xsg13cmos5l_fill_1_250 VPWR VGND sg13cmos5l_fill_1
* cell instance sg13cmos5l_fill_1_251 r0 *1 0,0
Xsg13cmos5l_fill_1_251 VPWR VGND sg13cmos5l_fill_1
* cell instance sg13cmos5l_fill_1_252 r0 *1 0,0
Xsg13cmos5l_fill_1_252 VPWR VGND sg13cmos5l_fill_1
* cell instance sg13cmos5l_fill_1_253 r0 *1 0,0
Xsg13cmos5l_fill_1_253 VPWR VGND sg13cmos5l_fill_1
* cell instance sg13cmos5l_fill_1_254 r0 *1 0,0
Xsg13cmos5l_fill_1_254 VPWR VGND sg13cmos5l_fill_1
* cell instance sg13cmos5l_fill_1_255 r0 *1 0,0
Xsg13cmos5l_fill_1_255 VPWR VGND sg13cmos5l_fill_1
* cell instance sg13cmos5l_fill_1_256 r0 *1 0,0
Xsg13cmos5l_fill_1_256 VPWR VGND sg13cmos5l_fill_1
* cell instance sg13cmos5l_fill_1_257 r0 *1 0,0
Xsg13cmos5l_fill_1_257 VPWR VGND sg13cmos5l_fill_1
* cell instance sg13cmos5l_fill_1_258 r0 *1 0,0
Xsg13cmos5l_fill_1_258 VPWR VGND sg13cmos5l_fill_1
* cell instance sg13cmos5l_fill_1_259 r0 *1 0,0
Xsg13cmos5l_fill_1_259 VPWR VGND sg13cmos5l_fill_1
* cell instance sg13cmos5l_fill_1_260 r0 *1 0,0
Xsg13cmos5l_fill_1_260 VPWR VGND sg13cmos5l_fill_1
* cell instance sg13cmos5l_fill_1_261 r0 *1 0,0
Xsg13cmos5l_fill_1_261 VPWR VGND sg13cmos5l_fill_1
* cell instance sg13cmos5l_fill_1_262 r0 *1 0,0
Xsg13cmos5l_fill_1_262 VPWR VGND sg13cmos5l_fill_1
* cell instance sg13cmos5l_fill_1_263 r0 *1 0,0
Xsg13cmos5l_fill_1_263 VPWR VGND sg13cmos5l_fill_1
* cell instance sg13cmos5l_fill_1_264 r0 *1 0,0
Xsg13cmos5l_fill_1_264 VPWR VGND sg13cmos5l_fill_1
* cell instance sg13cmos5l_fill_1_265 r0 *1 0,0
Xsg13cmos5l_fill_1_265 VPWR VGND sg13cmos5l_fill_1
* cell instance sg13cmos5l_fill_1_266 r0 *1 0,0
Xsg13cmos5l_fill_1_266 VPWR VGND sg13cmos5l_fill_1
* cell instance sg13cmos5l_fill_1_267 r0 *1 0,0
Xsg13cmos5l_fill_1_267 VPWR VGND sg13cmos5l_fill_1
* cell instance sg13cmos5l_fill_1_268 r0 *1 0,0
Xsg13cmos5l_fill_1_268 VPWR VGND sg13cmos5l_fill_1
* cell instance sg13cmos5l_fill_1_269 r0 *1 0,0
Xsg13cmos5l_fill_1_269 VPWR VGND sg13cmos5l_fill_1
* cell instance sg13cmos5l_fill_1_270 r0 *1 0,0
Xsg13cmos5l_fill_1_270 VPWR VGND sg13cmos5l_fill_1
* cell instance sg13cmos5l_fill_1_271 r0 *1 0,0
Xsg13cmos5l_fill_1_271 VPWR VGND sg13cmos5l_fill_1
* cell instance sg13cmos5l_fill_1_272 r0 *1 0,0
Xsg13cmos5l_fill_1_272 VPWR VGND sg13cmos5l_fill_1
* cell instance sg13cmos5l_fill_1_273 r0 *1 0,0
Xsg13cmos5l_fill_1_273 VPWR VGND sg13cmos5l_fill_1
* cell instance sg13cmos5l_fill_1_274 r0 *1 0,0
Xsg13cmos5l_fill_1_274 VPWR VGND sg13cmos5l_fill_1
* cell instance sg13cmos5l_fill_1_275 r0 *1 0,0
Xsg13cmos5l_fill_1_275 VPWR VGND sg13cmos5l_fill_1
* cell instance sg13cmos5l_fill_1_276 r0 *1 0,0
Xsg13cmos5l_fill_1_276 VPWR VGND sg13cmos5l_fill_1
* cell instance sg13cmos5l_fill_1_277 r0 *1 0,0
Xsg13cmos5l_fill_1_277 VPWR VGND sg13cmos5l_fill_1
* cell instance sg13cmos5l_fill_1_278 r0 *1 0,0
Xsg13cmos5l_fill_1_278 VPWR VGND sg13cmos5l_fill_1
* cell instance sg13cmos5l_fill_1_279 r0 *1 0,0
Xsg13cmos5l_fill_1_279 VPWR VGND sg13cmos5l_fill_1
* cell instance sg13cmos5l_fill_1_280 r0 *1 0,0
Xsg13cmos5l_fill_1_280 VPWR VGND sg13cmos5l_fill_1
* cell instance sg13cmos5l_fill_1_281 r0 *1 0,0
Xsg13cmos5l_fill_1_281 VPWR VGND sg13cmos5l_fill_1
* cell instance sg13cmos5l_fill_1_282 r0 *1 0,0
Xsg13cmos5l_fill_1_282 VPWR VGND sg13cmos5l_fill_1
* cell instance sg13cmos5l_fill_1_283 r0 *1 0,0
Xsg13cmos5l_fill_1_283 VPWR VGND sg13cmos5l_fill_1
* cell instance sg13cmos5l_fill_1_284 r0 *1 0,0
Xsg13cmos5l_fill_1_284 VPWR VGND sg13cmos5l_fill_1
* cell instance sg13cmos5l_fill_1_285 r0 *1 0,0
Xsg13cmos5l_fill_1_285 VPWR VGND sg13cmos5l_fill_1
* cell instance sg13cmos5l_fill_1_286 r0 *1 0,0
Xsg13cmos5l_fill_1_286 VPWR VGND sg13cmos5l_fill_1
* cell instance sg13cmos5l_fill_1_287 r0 *1 0,0
Xsg13cmos5l_fill_1_287 VPWR VGND sg13cmos5l_fill_1
* cell instance sg13cmos5l_fill_1_288 r0 *1 0,0
Xsg13cmos5l_fill_1_288 VPWR VGND sg13cmos5l_fill_1
* cell instance sg13cmos5l_fill_1_289 r0 *1 0,0
Xsg13cmos5l_fill_1_289 VPWR VGND sg13cmos5l_fill_1
* cell instance sg13cmos5l_fill_1_290 r0 *1 0,0
Xsg13cmos5l_fill_1_290 VPWR VGND sg13cmos5l_fill_1
* cell instance sg13cmos5l_fill_1_291 r0 *1 0,0
Xsg13cmos5l_fill_1_291 VPWR VGND sg13cmos5l_fill_1
* cell instance sg13cmos5l_fill_1_292 r0 *1 0,0
Xsg13cmos5l_fill_1_292 VPWR VGND sg13cmos5l_fill_1
* cell instance sg13cmos5l_fill_1_293 r0 *1 0,0
Xsg13cmos5l_fill_1_293 VPWR VGND sg13cmos5l_fill_1
* cell instance sg13cmos5l_fill_1_294 r0 *1 0,0
Xsg13cmos5l_fill_1_294 VPWR VGND sg13cmos5l_fill_1
* cell instance sg13cmos5l_fill_1_295 r0 *1 0,0
Xsg13cmos5l_fill_1_295 VPWR VGND sg13cmos5l_fill_1
* cell instance sg13cmos5l_fill_1_296 r0 *1 0,0
Xsg13cmos5l_fill_1_296 VPWR VGND sg13cmos5l_fill_1
* cell instance sg13cmos5l_fill_1_297 r0 *1 0,0
Xsg13cmos5l_fill_1_297 VPWR VGND sg13cmos5l_fill_1
* cell instance sg13cmos5l_fill_1_298 r0 *1 0,0
Xsg13cmos5l_fill_1_298 VPWR VGND sg13cmos5l_fill_1
* cell instance sg13cmos5l_fill_1_299 r0 *1 0,0
Xsg13cmos5l_fill_1_299 VPWR VGND sg13cmos5l_fill_1
* cell instance sg13cmos5l_fill_1_300 r0 *1 0,0
Xsg13cmos5l_fill_1_300 VPWR VGND sg13cmos5l_fill_1
* cell instance sg13cmos5l_fill_1_301 r0 *1 0,0
Xsg13cmos5l_fill_1_301 VPWR VGND sg13cmos5l_fill_1
* cell instance sg13cmos5l_fill_1_302 r0 *1 0,0
Xsg13cmos5l_fill_1_302 VPWR VGND sg13cmos5l_fill_1
* cell instance sg13cmos5l_fill_1_303 r0 *1 0,0
Xsg13cmos5l_fill_1_303 VPWR VGND sg13cmos5l_fill_1
* cell instance sg13cmos5l_fill_1_304 r0 *1 0,0
Xsg13cmos5l_fill_1_304 VPWR VGND sg13cmos5l_fill_1
* cell instance sg13cmos5l_fill_1_305 r0 *1 0,0
Xsg13cmos5l_fill_1_305 VPWR VGND sg13cmos5l_fill_1
* cell instance sg13cmos5l_fill_1_306 r0 *1 0,0
Xsg13cmos5l_fill_1_306 VPWR VGND sg13cmos5l_fill_1
* cell instance sg13cmos5l_fill_1_307 r0 *1 0,0
Xsg13cmos5l_fill_1_307 VPWR VGND sg13cmos5l_fill_1
* cell instance sg13cmos5l_fill_1_308 r0 *1 0,0
Xsg13cmos5l_fill_1_308 VPWR VGND sg13cmos5l_fill_1
* cell instance sg13cmos5l_fill_1_309 r0 *1 0,0
Xsg13cmos5l_fill_1_309 VPWR VGND sg13cmos5l_fill_1
* cell instance sg13cmos5l_fill_1_310 r0 *1 0,0
Xsg13cmos5l_fill_1_310 VPWR VGND sg13cmos5l_fill_1
* cell instance sg13cmos5l_fill_1_311 r0 *1 0,0
Xsg13cmos5l_fill_1_311 VPWR VGND sg13cmos5l_fill_1
* cell instance sg13cmos5l_fill_1_312 r0 *1 0,0
Xsg13cmos5l_fill_1_312 VPWR VGND sg13cmos5l_fill_1
* cell instance sg13cmos5l_fill_1_313 r0 *1 0,0
Xsg13cmos5l_fill_1_313 VPWR VGND sg13cmos5l_fill_1
* cell instance sg13cmos5l_fill_1_314 r0 *1 0,0
Xsg13cmos5l_fill_1_314 VPWR VGND sg13cmos5l_fill_1
* cell instance sg13cmos5l_fill_1_315 r0 *1 0,0
Xsg13cmos5l_fill_1_315 VPWR VGND sg13cmos5l_fill_1
* cell instance sg13cmos5l_fill_1_316 r0 *1 0,0
Xsg13cmos5l_fill_1_316 VPWR VGND sg13cmos5l_fill_1
* cell instance sg13cmos5l_fill_1_317 r0 *1 0,0
Xsg13cmos5l_fill_1_317 VPWR VGND sg13cmos5l_fill_1
* cell instance sg13cmos5l_fill_1_318 r0 *1 0,0
Xsg13cmos5l_fill_1_318 VPWR VGND sg13cmos5l_fill_1
* cell instance sg13cmos5l_fill_1_319 r0 *1 0,0
Xsg13cmos5l_fill_1_319 VPWR VGND sg13cmos5l_fill_1
* cell instance sg13cmos5l_fill_1_320 r0 *1 0,0
Xsg13cmos5l_fill_1_320 VPWR VGND sg13cmos5l_fill_1
* cell instance sg13cmos5l_fill_1_321 r0 *1 0,0
Xsg13cmos5l_fill_1_321 VPWR VGND sg13cmos5l_fill_1
* cell instance sg13cmos5l_fill_1_322 r0 *1 0,0
Xsg13cmos5l_fill_1_322 VPWR VGND sg13cmos5l_fill_1
* cell instance sg13cmos5l_fill_1_323 r0 *1 0,0
Xsg13cmos5l_fill_1_323 VPWR VGND sg13cmos5l_fill_1
* cell instance sg13cmos5l_fill_1_324 r0 *1 0,0
Xsg13cmos5l_fill_1_324 VPWR VGND sg13cmos5l_fill_1
* cell instance sg13cmos5l_fill_1_325 r0 *1 0,0
Xsg13cmos5l_fill_1_325 VPWR VGND sg13cmos5l_fill_1
* cell instance sg13cmos5l_fill_1_326 r0 *1 0,0
Xsg13cmos5l_fill_1_326 VPWR VGND sg13cmos5l_fill_1
* cell instance sg13cmos5l_fill_1_327 r0 *1 0,0
Xsg13cmos5l_fill_1_327 VPWR VGND sg13cmos5l_fill_1
* cell instance sg13cmos5l_fill_1_328 r0 *1 0,0
Xsg13cmos5l_fill_1_328 VPWR VGND sg13cmos5l_fill_1
* cell instance sg13cmos5l_fill_1_329 r0 *1 0,0
Xsg13cmos5l_fill_1_329 VPWR VGND sg13cmos5l_fill_1
* cell instance sg13cmos5l_fill_1_330 r0 *1 0,0
Xsg13cmos5l_fill_1_330 VPWR VGND sg13cmos5l_fill_1
* cell instance sg13cmos5l_fill_1_331 r0 *1 0,0
Xsg13cmos5l_fill_1_331 VPWR VGND sg13cmos5l_fill_1
* cell instance sg13cmos5l_fill_1_332 r0 *1 0,0
Xsg13cmos5l_fill_1_332 VPWR VGND sg13cmos5l_fill_1
* cell instance sg13cmos5l_fill_1_333 r0 *1 0,0
Xsg13cmos5l_fill_1_333 VPWR VGND sg13cmos5l_fill_1
* cell instance sg13cmos5l_fill_1_334 r0 *1 0,0
Xsg13cmos5l_fill_1_334 VPWR VGND sg13cmos5l_fill_1
* cell instance sg13cmos5l_fill_1_335 r0 *1 0,0
Xsg13cmos5l_fill_1_335 VPWR VGND sg13cmos5l_fill_1
* cell instance sg13cmos5l_fill_1_336 r0 *1 0,0
Xsg13cmos5l_fill_1_336 VPWR VGND sg13cmos5l_fill_1
* cell instance sg13cmos5l_fill_1_337 r0 *1 0,0
Xsg13cmos5l_fill_1_337 VPWR VGND sg13cmos5l_fill_1
* cell instance sg13cmos5l_fill_1_338 r0 *1 0,0
Xsg13cmos5l_fill_1_338 VPWR VGND sg13cmos5l_fill_1
* cell instance sg13cmos5l_fill_1_339 r0 *1 0,0
Xsg13cmos5l_fill_1_339 VPWR VGND sg13cmos5l_fill_1
* cell instance sg13cmos5l_fill_1_340 r0 *1 0,0
Xsg13cmos5l_fill_1_340 VPWR VGND sg13cmos5l_fill_1
* cell instance sg13cmos5l_fill_1_341 r0 *1 0,0
Xsg13cmos5l_fill_1_341 VPWR VGND sg13cmos5l_fill_1
* cell instance sg13cmos5l_fill_1_342 r0 *1 0,0
Xsg13cmos5l_fill_1_342 VPWR VGND sg13cmos5l_fill_1
* cell instance sg13cmos5l_fill_1_343 r0 *1 0,0
Xsg13cmos5l_fill_1_343 VPWR VGND sg13cmos5l_fill_1
* cell instance sg13cmos5l_fill_1_344 r0 *1 0,0
Xsg13cmos5l_fill_1_344 VPWR VGND sg13cmos5l_fill_1
* cell instance sg13cmos5l_fill_1_345 r0 *1 0,0
Xsg13cmos5l_fill_1_345 VPWR VGND sg13cmos5l_fill_1
* cell instance sg13cmos5l_fill_1_346 r0 *1 0,0
Xsg13cmos5l_fill_1_346 VPWR VGND sg13cmos5l_fill_1
* cell instance sg13cmos5l_fill_1_347 r0 *1 0,0
Xsg13cmos5l_fill_1_347 VPWR VGND sg13cmos5l_fill_1
* cell instance sg13cmos5l_fill_1_348 r0 *1 0,0
Xsg13cmos5l_fill_1_348 VPWR VGND sg13cmos5l_fill_1
* cell instance sg13cmos5l_fill_1_349 r0 *1 0,0
Xsg13cmos5l_fill_1_349 VPWR VGND sg13cmos5l_fill_1
* cell instance sg13cmos5l_fill_1_350 r0 *1 0,0
Xsg13cmos5l_fill_1_350 VPWR VGND sg13cmos5l_fill_1
* cell instance sg13cmos5l_fill_1_351 r0 *1 0,0
Xsg13cmos5l_fill_1_351 VPWR VGND sg13cmos5l_fill_1
* cell instance sg13cmos5l_fill_1_352 r0 *1 0,0
Xsg13cmos5l_fill_1_352 VPWR VGND sg13cmos5l_fill_1
* cell instance sg13cmos5l_fill_1_353 r0 *1 0,0
Xsg13cmos5l_fill_1_353 VPWR VGND sg13cmos5l_fill_1
* cell instance sg13cmos5l_fill_1_354 r0 *1 0,0
Xsg13cmos5l_fill_1_354 VPWR VGND sg13cmos5l_fill_1
* cell instance sg13cmos5l_fill_1_355 r0 *1 0,0
Xsg13cmos5l_fill_1_355 VPWR VGND sg13cmos5l_fill_1
* cell instance sg13cmos5l_fill_1_356 r0 *1 0,0
Xsg13cmos5l_fill_1_356 VPWR VGND sg13cmos5l_fill_1
* cell instance sg13cmos5l_fill_1_357 r0 *1 0,0
Xsg13cmos5l_fill_1_357 VPWR VGND sg13cmos5l_fill_1
* cell instance sg13cmos5l_fill_1_358 r0 *1 0,0
Xsg13cmos5l_fill_1_358 VPWR VGND sg13cmos5l_fill_1
* cell instance sg13cmos5l_fill_1_359 r0 *1 0,0
Xsg13cmos5l_fill_1_359 VPWR VGND sg13cmos5l_fill_1
* cell instance sg13cmos5l_fill_1_360 r0 *1 0,0
Xsg13cmos5l_fill_1_360 VPWR VGND sg13cmos5l_fill_1
* cell instance sg13cmos5l_fill_1_361 r0 *1 0,0
Xsg13cmos5l_fill_1_361 VPWR VGND sg13cmos5l_fill_1
* cell instance sg13cmos5l_fill_1_362 r0 *1 0,0
Xsg13cmos5l_fill_1_362 VPWR VGND sg13cmos5l_fill_1
* cell instance sg13cmos5l_fill_1_363 r0 *1 0,0
Xsg13cmos5l_fill_1_363 VPWR VGND sg13cmos5l_fill_1
* cell instance sg13cmos5l_fill_1_364 r0 *1 0,0
Xsg13cmos5l_fill_1_364 VPWR VGND sg13cmos5l_fill_1
* cell instance sg13cmos5l_fill_1_365 r0 *1 0,0
Xsg13cmos5l_fill_1_365 VPWR VGND sg13cmos5l_fill_1
* cell instance sg13cmos5l_fill_1_366 r0 *1 0,0
Xsg13cmos5l_fill_1_366 VPWR VGND sg13cmos5l_fill_1
* cell instance sg13cmos5l_fill_1_367 r0 *1 0,0
Xsg13cmos5l_fill_1_367 VPWR VGND sg13cmos5l_fill_1
* cell instance sg13cmos5l_fill_1_368 r0 *1 0,0
Xsg13cmos5l_fill_1_368 VPWR VGND sg13cmos5l_fill_1
* cell instance sg13cmos5l_fill_1_369 r0 *1 0,0
Xsg13cmos5l_fill_1_369 VPWR VGND sg13cmos5l_fill_1
* cell instance sg13cmos5l_fill_1_370 r0 *1 0,0
Xsg13cmos5l_fill_1_370 VPWR VGND sg13cmos5l_fill_1
* cell instance sg13cmos5l_fill_1_371 r0 *1 0,0
Xsg13cmos5l_fill_1_371 VPWR VGND sg13cmos5l_fill_1
* cell instance sg13cmos5l_fill_1_372 r0 *1 0,0
Xsg13cmos5l_fill_1_372 VPWR VGND sg13cmos5l_fill_1
* cell instance sg13cmos5l_fill_1_373 r0 *1 0,0
Xsg13cmos5l_fill_1_373 VPWR VGND sg13cmos5l_fill_1
* cell instance sg13cmos5l_fill_1_374 r0 *1 0,0
Xsg13cmos5l_fill_1_374 VPWR VGND sg13cmos5l_fill_1
* cell instance sg13cmos5l_fill_1_375 r0 *1 0,0
Xsg13cmos5l_fill_1_375 VPWR VGND sg13cmos5l_fill_1
* cell instance sg13cmos5l_fill_1_376 r0 *1 0,0
Xsg13cmos5l_fill_1_376 VPWR VGND sg13cmos5l_fill_1
* cell instance sg13cmos5l_fill_1_377 r0 *1 0,0
Xsg13cmos5l_fill_1_377 VPWR VGND sg13cmos5l_fill_1
* cell instance sg13cmos5l_fill_1_378 r0 *1 0,0
Xsg13cmos5l_fill_1_378 VPWR VGND sg13cmos5l_fill_1
* cell instance sg13cmos5l_fill_1_379 r0 *1 0,0
Xsg13cmos5l_fill_1_379 VPWR VGND sg13cmos5l_fill_1
* cell instance sg13cmos5l_fill_1_380 r0 *1 0,0
Xsg13cmos5l_fill_1_380 VPWR VGND sg13cmos5l_fill_1
* cell instance sg13cmos5l_fill_1_381 r0 *1 0,0
Xsg13cmos5l_fill_1_381 VPWR VGND sg13cmos5l_fill_1
* cell instance sg13cmos5l_fill_1_382 r0 *1 0,0
Xsg13cmos5l_fill_1_382 VPWR VGND sg13cmos5l_fill_1
* cell instance sg13cmos5l_fill_1_383 r0 *1 0,0
Xsg13cmos5l_fill_1_383 VPWR VGND sg13cmos5l_fill_1
* cell instance sg13cmos5l_fill_1_384 r0 *1 0,0
Xsg13cmos5l_fill_1_384 VPWR VGND sg13cmos5l_fill_1
* cell instance sg13cmos5l_fill_1_385 r0 *1 0,0
Xsg13cmos5l_fill_1_385 VPWR VGND sg13cmos5l_fill_1
* cell instance sg13cmos5l_fill_1_386 r0 *1 0,0
Xsg13cmos5l_fill_1_386 VPWR VGND sg13cmos5l_fill_1
* cell instance sg13cmos5l_fill_1_387 r0 *1 0,0
Xsg13cmos5l_fill_1_387 VPWR VGND sg13cmos5l_fill_1
* cell instance sg13cmos5l_fill_1_388 r0 *1 0,0
Xsg13cmos5l_fill_1_388 VPWR VGND sg13cmos5l_fill_1
* cell instance sg13cmos5l_fill_1_389 r0 *1 0,0
Xsg13cmos5l_fill_1_389 VPWR VGND sg13cmos5l_fill_1
* cell instance sg13cmos5l_fill_1_390 r0 *1 0,0
Xsg13cmos5l_fill_1_390 VPWR VGND sg13cmos5l_fill_1
* cell instance sg13cmos5l_fill_1_391 r0 *1 0,0
Xsg13cmos5l_fill_1_391 VPWR VGND sg13cmos5l_fill_1
* cell instance sg13cmos5l_fill_1_392 r0 *1 0,0
Xsg13cmos5l_fill_1_392 VPWR VGND sg13cmos5l_fill_1
* cell instance sg13cmos5l_fill_1_393 r0 *1 0,0
Xsg13cmos5l_fill_1_393 VPWR VGND sg13cmos5l_fill_1
* cell instance sg13cmos5l_fill_1_394 r0 *1 0,0
Xsg13cmos5l_fill_1_394 VPWR VGND sg13cmos5l_fill_1
* cell instance sg13cmos5l_fill_1_395 r0 *1 0,0
Xsg13cmos5l_fill_1_395 VPWR VGND sg13cmos5l_fill_1
* cell instance sg13cmos5l_fill_1_396 r0 *1 0,0
Xsg13cmos5l_fill_1_396 VPWR VGND sg13cmos5l_fill_1
* cell instance sg13cmos5l_fill_1_397 r0 *1 0,0
Xsg13cmos5l_fill_1_397 VPWR VGND sg13cmos5l_fill_1
* cell instance sg13cmos5l_fill_1_398 r0 *1 0,0
Xsg13cmos5l_fill_1_398 VPWR VGND sg13cmos5l_fill_1
* cell instance sg13cmos5l_fill_1_399 r0 *1 0,0
Xsg13cmos5l_fill_1_399 VPWR VGND sg13cmos5l_fill_1
* cell instance sg13cmos5l_fill_1_400 r0 *1 0,0
Xsg13cmos5l_fill_1_400 VPWR VGND sg13cmos5l_fill_1
* cell instance sg13cmos5l_fill_1_401 r0 *1 0,0
Xsg13cmos5l_fill_1_401 VPWR VGND sg13cmos5l_fill_1
* cell instance sg13cmos5l_fill_1_402 r0 *1 0,0
Xsg13cmos5l_fill_1_402 VPWR VGND sg13cmos5l_fill_1
* cell instance sg13cmos5l_fill_1_403 r0 *1 0,0
Xsg13cmos5l_fill_1_403 VPWR VGND sg13cmos5l_fill_1
* cell instance sg13cmos5l_fill_1_404 r0 *1 0,0
Xsg13cmos5l_fill_1_404 VPWR VGND sg13cmos5l_fill_1
* cell instance sg13cmos5l_fill_1_405 r0 *1 0,0
Xsg13cmos5l_fill_1_405 VPWR VGND sg13cmos5l_fill_1
* cell instance sg13cmos5l_fill_1_406 r0 *1 0,0
Xsg13cmos5l_fill_1_406 VPWR VGND sg13cmos5l_fill_1
* cell instance sg13cmos5l_fill_1_407 r0 *1 0,0
Xsg13cmos5l_fill_1_407 VPWR VGND sg13cmos5l_fill_1
* cell instance sg13cmos5l_fill_1_408 r0 *1 0,0
Xsg13cmos5l_fill_1_408 VPWR VGND sg13cmos5l_fill_1
* cell instance sg13cmos5l_fill_1_409 r0 *1 0,0
Xsg13cmos5l_fill_1_409 VPWR VGND sg13cmos5l_fill_1
* cell instance sg13cmos5l_fill_1_410 r0 *1 0,0
Xsg13cmos5l_fill_1_410 VPWR VGND sg13cmos5l_fill_1
* cell instance sg13cmos5l_fill_1_411 r0 *1 0,0
Xsg13cmos5l_fill_1_411 VPWR VGND sg13cmos5l_fill_1
* cell instance sg13cmos5l_fill_1_412 r0 *1 0,0
Xsg13cmos5l_fill_1_412 VPWR VGND sg13cmos5l_fill_1
* cell instance sg13cmos5l_fill_1_413 r0 *1 0,0
Xsg13cmos5l_fill_1_413 VPWR VGND sg13cmos5l_fill_1
* cell instance sg13cmos5l_fill_1_414 r0 *1 0,0
Xsg13cmos5l_fill_1_414 VPWR VGND sg13cmos5l_fill_1
* cell instance sg13cmos5l_fill_1_415 r0 *1 0,0
Xsg13cmos5l_fill_1_415 VPWR VGND sg13cmos5l_fill_1
* cell instance sg13cmos5l_fill_1_416 r0 *1 0,0
Xsg13cmos5l_fill_1_416 VPWR VGND sg13cmos5l_fill_1
* cell instance sg13cmos5l_fill_1_417 r0 *1 0,0
Xsg13cmos5l_fill_1_417 VPWR VGND sg13cmos5l_fill_1
* cell instance sg13cmos5l_fill_1_418 r0 *1 0,0
Xsg13cmos5l_fill_1_418 VPWR VGND sg13cmos5l_fill_1
* cell instance sg13cmos5l_fill_1_419 r0 *1 0,0
Xsg13cmos5l_fill_1_419 VPWR VGND sg13cmos5l_fill_1
* cell instance sg13cmos5l_fill_1_420 r0 *1 0,0
Xsg13cmos5l_fill_1_420 VPWR VGND sg13cmos5l_fill_1
* cell instance sg13cmos5l_fill_1_421 r0 *1 0,0
Xsg13cmos5l_fill_1_421 VPWR VGND sg13cmos5l_fill_1
* cell instance sg13cmos5l_fill_1_422 r0 *1 0,0
Xsg13cmos5l_fill_1_422 VPWR VGND sg13cmos5l_fill_1
* cell instance sg13cmos5l_fill_1_423 r0 *1 0,0
Xsg13cmos5l_fill_1_423 VPWR VGND sg13cmos5l_fill_1
* cell instance sg13cmos5l_fill_1_424 r0 *1 0,0
Xsg13cmos5l_fill_1_424 VPWR VGND sg13cmos5l_fill_1
* cell instance sg13cmos5l_fill_1_425 r0 *1 0,0
Xsg13cmos5l_fill_1_425 VPWR VGND sg13cmos5l_fill_1
* cell instance sg13cmos5l_fill_1_426 r0 *1 0,0
Xsg13cmos5l_fill_1_426 VPWR VGND sg13cmos5l_fill_1
* cell instance sg13cmos5l_fill_1_427 r0 *1 0,0
Xsg13cmos5l_fill_1_427 VPWR VGND sg13cmos5l_fill_1
* cell instance sg13cmos5l_fill_1_428 r0 *1 0,0
Xsg13cmos5l_fill_1_428 VPWR VGND sg13cmos5l_fill_1
* cell instance sg13cmos5l_fill_1_429 r0 *1 0,0
Xsg13cmos5l_fill_1_429 VPWR VGND sg13cmos5l_fill_1
* cell instance sg13cmos5l_fill_1_430 r0 *1 0,0
Xsg13cmos5l_fill_1_430 VPWR VGND sg13cmos5l_fill_1
* cell instance sg13cmos5l_fill_1_431 r0 *1 0,0
Xsg13cmos5l_fill_1_431 VPWR VGND sg13cmos5l_fill_1
* cell instance sg13cmos5l_fill_1_432 r0 *1 0,0
Xsg13cmos5l_fill_1_432 VPWR VGND sg13cmos5l_fill_1
* cell instance sg13cmos5l_fill_1_433 r0 *1 0,0
Xsg13cmos5l_fill_1_433 VPWR VGND sg13cmos5l_fill_1
* cell instance sg13cmos5l_fill_1_434 r0 *1 0,0
Xsg13cmos5l_fill_1_434 VPWR VGND sg13cmos5l_fill_1
* cell instance sg13cmos5l_fill_1_435 r0 *1 0,0
Xsg13cmos5l_fill_1_435 VPWR VGND sg13cmos5l_fill_1
* cell instance sg13cmos5l_fill_1_436 r0 *1 0,0
Xsg13cmos5l_fill_1_436 VPWR VGND sg13cmos5l_fill_1
* cell instance sg13cmos5l_fill_1_437 r0 *1 0,0
Xsg13cmos5l_fill_1_437 VPWR VGND sg13cmos5l_fill_1
* cell instance sg13cmos5l_fill_1_438 r0 *1 0,0
Xsg13cmos5l_fill_1_438 VPWR VGND sg13cmos5l_fill_1
* cell instance sg13cmos5l_fill_1_439 r0 *1 0,0
Xsg13cmos5l_fill_1_439 VPWR VGND sg13cmos5l_fill_1
* cell instance sg13cmos5l_fill_1_440 r0 *1 0,0
Xsg13cmos5l_fill_1_440 VPWR VGND sg13cmos5l_fill_1
* cell instance sg13cmos5l_fill_1_441 r0 *1 0,0
Xsg13cmos5l_fill_1_441 VPWR VGND sg13cmos5l_fill_1
* cell instance sg13cmos5l_fill_1_442 r0 *1 0,0
Xsg13cmos5l_fill_1_442 VPWR VGND sg13cmos5l_fill_1
* cell instance sg13cmos5l_fill_1_443 r0 *1 0,0
Xsg13cmos5l_fill_1_443 VPWR VGND sg13cmos5l_fill_1
* cell instance sg13cmos5l_fill_1_444 r0 *1 0,0
Xsg13cmos5l_fill_1_444 VPWR VGND sg13cmos5l_fill_1
* cell instance sg13cmos5l_fill_1_445 r0 *1 0,0
Xsg13cmos5l_fill_1_445 VPWR VGND sg13cmos5l_fill_1
* cell instance sg13cmos5l_fill_1_446 r0 *1 0,0
Xsg13cmos5l_fill_1_446 VPWR VGND sg13cmos5l_fill_1
* cell instance sg13cmos5l_fill_1_447 r0 *1 0,0
Xsg13cmos5l_fill_1_447 VPWR VGND sg13cmos5l_fill_1
* cell instance sg13cmos5l_fill_1_448 r0 *1 0,0
Xsg13cmos5l_fill_1_448 VPWR VGND sg13cmos5l_fill_1
* cell instance sg13cmos5l_fill_1_449 r0 *1 0,0
Xsg13cmos5l_fill_1_449 VPWR VGND sg13cmos5l_fill_1
* cell instance sg13cmos5l_fill_1_450 r0 *1 0,0
Xsg13cmos5l_fill_1_450 VPWR VGND sg13cmos5l_fill_1
* cell instance sg13cmos5l_fill_1_451 r0 *1 0,0
Xsg13cmos5l_fill_1_451 VPWR VGND sg13cmos5l_fill_1
* cell instance sg13cmos5l_fill_1_452 r0 *1 0,0
Xsg13cmos5l_fill_1_452 VPWR VGND sg13cmos5l_fill_1
* cell instance sg13cmos5l_fill_1_453 r0 *1 0,0
Xsg13cmos5l_fill_1_453 VPWR VGND sg13cmos5l_fill_1
* cell instance sg13cmos5l_fill_1_454 r0 *1 0,0
Xsg13cmos5l_fill_1_454 VPWR VGND sg13cmos5l_fill_1
* cell instance sg13cmos5l_fill_1_455 r0 *1 0,0
Xsg13cmos5l_fill_1_455 VPWR VGND sg13cmos5l_fill_1
* cell instance sg13cmos5l_fill_1_456 r0 *1 0,0
Xsg13cmos5l_fill_1_456 VPWR VGND sg13cmos5l_fill_1
* cell instance sg13cmos5l_fill_1_457 r0 *1 0,0
Xsg13cmos5l_fill_1_457 VPWR VGND sg13cmos5l_fill_1
* cell instance sg13cmos5l_fill_1_458 r0 *1 0,0
Xsg13cmos5l_fill_1_458 VPWR VGND sg13cmos5l_fill_1
* cell instance sg13cmos5l_fill_1_459 r0 *1 0,0
Xsg13cmos5l_fill_1_459 VPWR VGND sg13cmos5l_fill_1
* cell instance sg13cmos5l_fill_1_460 r0 *1 0,0
Xsg13cmos5l_fill_1_460 VPWR VGND sg13cmos5l_fill_1
* cell instance sg13cmos5l_fill_1_461 r0 *1 0,0
Xsg13cmos5l_fill_1_461 VPWR VGND sg13cmos5l_fill_1
* cell instance sg13cmos5l_fill_1_462 r0 *1 0,0
Xsg13cmos5l_fill_1_462 VPWR VGND sg13cmos5l_fill_1
* cell instance sg13cmos5l_fill_1_463 r0 *1 0,0
Xsg13cmos5l_fill_1_463 VPWR VGND sg13cmos5l_fill_1
* cell instance sg13cmos5l_fill_1_464 r0 *1 0,0
Xsg13cmos5l_fill_1_464 VPWR VGND sg13cmos5l_fill_1
* cell instance sg13cmos5l_fill_1_465 r0 *1 0,0
Xsg13cmos5l_fill_1_465 VPWR VGND sg13cmos5l_fill_1
* cell instance sg13cmos5l_fill_1_466 r0 *1 0,0
Xsg13cmos5l_fill_1_466 VPWR VGND sg13cmos5l_fill_1
* cell instance sg13cmos5l_fill_1_467 r0 *1 0,0
Xsg13cmos5l_fill_1_467 VPWR VGND sg13cmos5l_fill_1
* cell instance sg13cmos5l_fill_1_468 r0 *1 0,0
Xsg13cmos5l_fill_1_468 VPWR VGND sg13cmos5l_fill_1
* cell instance sg13cmos5l_fill_1_469 r0 *1 0,0
Xsg13cmos5l_fill_1_469 VPWR VGND sg13cmos5l_fill_1
* cell instance sg13cmos5l_fill_1_470 r0 *1 0,0
Xsg13cmos5l_fill_1_470 VPWR VGND sg13cmos5l_fill_1
* cell instance sg13cmos5l_fill_1_471 r0 *1 0,0
Xsg13cmos5l_fill_1_471 VPWR VGND sg13cmos5l_fill_1
* cell instance sg13cmos5l_fill_1_472 r0 *1 0,0
Xsg13cmos5l_fill_1_472 VPWR VGND sg13cmos5l_fill_1
* cell instance sg13cmos5l_fill_1_473 r0 *1 0,0
Xsg13cmos5l_fill_1_473 VPWR VGND sg13cmos5l_fill_1
* cell instance sg13cmos5l_fill_1_474 r0 *1 0,0
Xsg13cmos5l_fill_1_474 VPWR VGND sg13cmos5l_fill_1
* cell instance sg13cmos5l_fill_1_475 r0 *1 0,0
Xsg13cmos5l_fill_1_475 VPWR VGND sg13cmos5l_fill_1
* cell instance sg13cmos5l_fill_1_476 r0 *1 0,0
Xsg13cmos5l_fill_1_476 VPWR VGND sg13cmos5l_fill_1
* cell instance sg13cmos5l_fill_1_477 r0 *1 0,0
Xsg13cmos5l_fill_1_477 VPWR VGND sg13cmos5l_fill_1
* cell instance sg13cmos5l_fill_1_478 r0 *1 0,0
Xsg13cmos5l_fill_1_478 VPWR VGND sg13cmos5l_fill_1
* cell instance sg13cmos5l_fill_1_479 r0 *1 0,0
Xsg13cmos5l_fill_1_479 VPWR VGND sg13cmos5l_fill_1
* cell instance sg13cmos5l_fill_1_480 r0 *1 0,0
Xsg13cmos5l_fill_1_480 VPWR VGND sg13cmos5l_fill_1
* cell instance sg13cmos5l_fill_1_481 r0 *1 0,0
Xsg13cmos5l_fill_1_481 VPWR VGND sg13cmos5l_fill_1
* cell instance sg13cmos5l_fill_1_482 r0 *1 0,0
Xsg13cmos5l_fill_1_482 VPWR VGND sg13cmos5l_fill_1
* cell instance sg13cmos5l_fill_1_483 r0 *1 0,0
Xsg13cmos5l_fill_1_483 VPWR VGND sg13cmos5l_fill_1
* cell instance sg13cmos5l_fill_1_484 r0 *1 0,0
Xsg13cmos5l_fill_1_484 VPWR VGND sg13cmos5l_fill_1
* cell instance sg13cmos5l_fill_1_485 r0 *1 0,0
Xsg13cmos5l_fill_1_485 VPWR VGND sg13cmos5l_fill_1
* cell instance sg13cmos5l_fill_1_486 r0 *1 0,0
Xsg13cmos5l_fill_1_486 VPWR VGND sg13cmos5l_fill_1
* cell instance sg13cmos5l_fill_1_487 r0 *1 0,0
Xsg13cmos5l_fill_1_487 VPWR VGND sg13cmos5l_fill_1
* cell instance sg13cmos5l_fill_1_488 r0 *1 0,0
Xsg13cmos5l_fill_1_488 VPWR VGND sg13cmos5l_fill_1
* cell instance sg13cmos5l_fill_1_489 r0 *1 0,0
Xsg13cmos5l_fill_1_489 VPWR VGND sg13cmos5l_fill_1
* cell instance sg13cmos5l_fill_1_490 r0 *1 0,0
Xsg13cmos5l_fill_1_490 VPWR VGND sg13cmos5l_fill_1
* cell instance sg13cmos5l_fill_1_491 r0 *1 0,0
Xsg13cmos5l_fill_1_491 VPWR VGND sg13cmos5l_fill_1
* cell instance sg13cmos5l_fill_1_492 r0 *1 0,0
Xsg13cmos5l_fill_1_492 VPWR VGND sg13cmos5l_fill_1
* cell instance sg13cmos5l_fill_1_493 r0 *1 0,0
Xsg13cmos5l_fill_1_493 VPWR VGND sg13cmos5l_fill_1
* cell instance sg13cmos5l_fill_1_494 r0 *1 0,0
Xsg13cmos5l_fill_1_494 VPWR VGND sg13cmos5l_fill_1
* cell instance sg13cmos5l_fill_1_495 r0 *1 0,0
Xsg13cmos5l_fill_1_495 VPWR VGND sg13cmos5l_fill_1
* cell instance sg13cmos5l_fill_1_496 r0 *1 0,0
Xsg13cmos5l_fill_1_496 VPWR VGND sg13cmos5l_fill_1
* cell instance sg13cmos5l_fill_1_497 r0 *1 0,0
Xsg13cmos5l_fill_1_497 VPWR VGND sg13cmos5l_fill_1
* cell instance sg13cmos5l_fill_1_498 r0 *1 0,0
Xsg13cmos5l_fill_1_498 VPWR VGND sg13cmos5l_fill_1
* cell instance sg13cmos5l_fill_1_499 r0 *1 0,0
Xsg13cmos5l_fill_1_499 VPWR VGND sg13cmos5l_fill_1
* cell instance sg13cmos5l_fill_1_500 r0 *1 0,0
Xsg13cmos5l_fill_1_500 VPWR VGND sg13cmos5l_fill_1
* cell instance sg13cmos5l_fill_1_501 r0 *1 0,0
Xsg13cmos5l_fill_1_501 VPWR VGND sg13cmos5l_fill_1
* cell instance sg13cmos5l_fill_1_502 r0 *1 0,0
Xsg13cmos5l_fill_1_502 VPWR VGND sg13cmos5l_fill_1
* cell instance sg13cmos5l_fill_1_503 r0 *1 0,0
Xsg13cmos5l_fill_1_503 VPWR VGND sg13cmos5l_fill_1
* cell instance sg13cmos5l_fill_1_504 r0 *1 0,0
Xsg13cmos5l_fill_1_504 VPWR VGND sg13cmos5l_fill_1
* cell instance sg13cmos5l_fill_1_505 r0 *1 0,0
Xsg13cmos5l_fill_1_505 VPWR VGND sg13cmos5l_fill_1
* cell instance sg13cmos5l_fill_1_506 r0 *1 0,0
Xsg13cmos5l_fill_1_506 VPWR VGND sg13cmos5l_fill_1
* cell instance sg13cmos5l_fill_1_507 r0 *1 0,0
Xsg13cmos5l_fill_1_507 VPWR VGND sg13cmos5l_fill_1
* cell instance sg13cmos5l_fill_1_508 r0 *1 0,0
Xsg13cmos5l_fill_1_508 VPWR VGND sg13cmos5l_fill_1
* cell instance sg13cmos5l_fill_1_509 r0 *1 0,0
Xsg13cmos5l_fill_1_509 VPWR VGND sg13cmos5l_fill_1
* cell instance sg13cmos5l_fill_1_510 r0 *1 0,0
Xsg13cmos5l_fill_1_510 VPWR VGND sg13cmos5l_fill_1
* cell instance sg13cmos5l_fill_1_511 r0 *1 0,0
Xsg13cmos5l_fill_1_511 VPWR VGND sg13cmos5l_fill_1
* cell instance sg13cmos5l_fill_1_512 r0 *1 0,0
Xsg13cmos5l_fill_1_512 VPWR VGND sg13cmos5l_fill_1
* cell instance sg13cmos5l_fill_1_513 r0 *1 0,0
Xsg13cmos5l_fill_1_513 VPWR VGND sg13cmos5l_fill_1
* cell instance sg13cmos5l_fill_1_514 r0 *1 0,0
Xsg13cmos5l_fill_1_514 VPWR VGND sg13cmos5l_fill_1
* cell instance sg13cmos5l_fill_1_515 r0 *1 0,0
Xsg13cmos5l_fill_1_515 VPWR VGND sg13cmos5l_fill_1
* cell instance sg13cmos5l_fill_1_516 r0 *1 0,0
Xsg13cmos5l_fill_1_516 VPWR VGND sg13cmos5l_fill_1
* cell instance sg13cmos5l_fill_1_517 r0 *1 0,0
Xsg13cmos5l_fill_1_517 VPWR VGND sg13cmos5l_fill_1
* cell instance sg13cmos5l_fill_1_518 r0 *1 0,0
Xsg13cmos5l_fill_1_518 VPWR VGND sg13cmos5l_fill_1
* cell instance sg13cmos5l_fill_1_519 r0 *1 0,0
Xsg13cmos5l_fill_1_519 VPWR VGND sg13cmos5l_fill_1
* cell instance sg13cmos5l_fill_1_520 r0 *1 0,0
Xsg13cmos5l_fill_1_520 VPWR VGND sg13cmos5l_fill_1
* cell instance sg13cmos5l_fill_1_521 r0 *1 0,0
Xsg13cmos5l_fill_1_521 VPWR VGND sg13cmos5l_fill_1
* cell instance sg13cmos5l_fill_1_522 r0 *1 0,0
Xsg13cmos5l_fill_1_522 VPWR VGND sg13cmos5l_fill_1
* cell instance sg13cmos5l_fill_1_523 r0 *1 0,0
Xsg13cmos5l_fill_1_523 VPWR VGND sg13cmos5l_fill_1
* cell instance sg13cmos5l_fill_1_524 r0 *1 0,0
Xsg13cmos5l_fill_1_524 VPWR VGND sg13cmos5l_fill_1
* cell instance sg13cmos5l_fill_1_525 r0 *1 0,0
Xsg13cmos5l_fill_1_525 VPWR VGND sg13cmos5l_fill_1
* cell instance sg13cmos5l_fill_1_526 r0 *1 0,0
Xsg13cmos5l_fill_1_526 VPWR VGND sg13cmos5l_fill_1
* cell instance sg13cmos5l_fill_1_527 r0 *1 0,0
Xsg13cmos5l_fill_1_527 VPWR VGND sg13cmos5l_fill_1
* cell instance sg13cmos5l_fill_1_528 r0 *1 0,0
Xsg13cmos5l_fill_1_528 VPWR VGND sg13cmos5l_fill_1
* cell instance sg13cmos5l_fill_1_529 r0 *1 0,0
Xsg13cmos5l_fill_1_529 VPWR VGND sg13cmos5l_fill_1
* cell instance sg13cmos5l_fill_1_530 r0 *1 0,0
Xsg13cmos5l_fill_1_530 VPWR VGND sg13cmos5l_fill_1
* cell instance sg13cmos5l_fill_1_531 r0 *1 0,0
Xsg13cmos5l_fill_1_531 VPWR VGND sg13cmos5l_fill_1
* cell instance sg13cmos5l_fill_1_532 r0 *1 0,0
Xsg13cmos5l_fill_1_532 VPWR VGND sg13cmos5l_fill_1
* cell instance sg13cmos5l_fill_1_533 r0 *1 0,0
Xsg13cmos5l_fill_1_533 VPWR VGND sg13cmos5l_fill_1
* cell instance sg13cmos5l_fill_1_534 r0 *1 0,0
Xsg13cmos5l_fill_1_534 VPWR VGND sg13cmos5l_fill_1
* cell instance sg13cmos5l_fill_1_535 r0 *1 0,0
Xsg13cmos5l_fill_1_535 VPWR VGND sg13cmos5l_fill_1
* cell instance sg13cmos5l_fill_1_536 r0 *1 0,0
Xsg13cmos5l_fill_1_536 VPWR VGND sg13cmos5l_fill_1
* cell instance sg13cmos5l_fill_1_537 r0 *1 0,0
Xsg13cmos5l_fill_1_537 VPWR VGND sg13cmos5l_fill_1
* cell instance sg13cmos5l_fill_1_538 r0 *1 0,0
Xsg13cmos5l_fill_1_538 VPWR VGND sg13cmos5l_fill_1
* cell instance sg13cmos5l_fill_1_539 r0 *1 0,0
Xsg13cmos5l_fill_1_539 VPWR VGND sg13cmos5l_fill_1
* cell instance sg13cmos5l_fill_1_540 r0 *1 0,0
Xsg13cmos5l_fill_1_540 VPWR VGND sg13cmos5l_fill_1
* cell instance sg13cmos5l_fill_1_541 r0 *1 0,0
Xsg13cmos5l_fill_1_541 VPWR VGND sg13cmos5l_fill_1
* cell instance sg13cmos5l_fill_1_542 r0 *1 0,0
Xsg13cmos5l_fill_1_542 VPWR VGND sg13cmos5l_fill_1
* cell instance sg13cmos5l_fill_1_543 r0 *1 0,0
Xsg13cmos5l_fill_1_543 VPWR VGND sg13cmos5l_fill_1
* cell instance sg13cmos5l_fill_1_544 r0 *1 0,0
Xsg13cmos5l_fill_1_544 VPWR VGND sg13cmos5l_fill_1
* cell instance sg13cmos5l_fill_1_545 r0 *1 0,0
Xsg13cmos5l_fill_1_545 VPWR VGND sg13cmos5l_fill_1
* cell instance sg13cmos5l_fill_1_546 r0 *1 0,0
Xsg13cmos5l_fill_1_546 VPWR VGND sg13cmos5l_fill_1
* cell instance sg13cmos5l_fill_1_547 r0 *1 0,0
Xsg13cmos5l_fill_1_547 VPWR VGND sg13cmos5l_fill_1
* cell instance sg13cmos5l_fill_1_548 r0 *1 0,0
Xsg13cmos5l_fill_1_548 VPWR VGND sg13cmos5l_fill_1
* cell instance sg13cmos5l_fill_1_549 r0 *1 0,0
Xsg13cmos5l_fill_1_549 VPWR VGND sg13cmos5l_fill_1
* cell instance sg13cmos5l_fill_1_550 r0 *1 0,0
Xsg13cmos5l_fill_1_550 VPWR VGND sg13cmos5l_fill_1
* cell instance sg13cmos5l_fill_1_551 r0 *1 0,0
Xsg13cmos5l_fill_1_551 VPWR VGND sg13cmos5l_fill_1
* cell instance sg13cmos5l_fill_1_552 r0 *1 0,0
Xsg13cmos5l_fill_1_552 VPWR VGND sg13cmos5l_fill_1
* cell instance sg13cmos5l_fill_1_553 r0 *1 0,0
Xsg13cmos5l_fill_1_553 VPWR VGND sg13cmos5l_fill_1
* cell instance sg13cmos5l_fill_1_554 r0 *1 0,0
Xsg13cmos5l_fill_1_554 VPWR VGND sg13cmos5l_fill_1
* cell instance sg13cmos5l_fill_1_555 r0 *1 0,0
Xsg13cmos5l_fill_1_555 VPWR VGND sg13cmos5l_fill_1
* cell instance sg13cmos5l_fill_1_556 r0 *1 0,0
Xsg13cmos5l_fill_1_556 VPWR VGND sg13cmos5l_fill_1
* cell instance sg13cmos5l_fill_1_557 r0 *1 0,0
Xsg13cmos5l_fill_1_557 VPWR VGND sg13cmos5l_fill_1
* cell instance sg13cmos5l_fill_1_558 r0 *1 0,0
Xsg13cmos5l_fill_1_558 VPWR VGND sg13cmos5l_fill_1
* cell instance sg13cmos5l_fill_1_559 r0 *1 0,0
Xsg13cmos5l_fill_1_559 VPWR VGND sg13cmos5l_fill_1
* cell instance sg13cmos5l_fill_1_560 r0 *1 0,0
Xsg13cmos5l_fill_1_560 VPWR VGND sg13cmos5l_fill_1
* cell instance sg13cmos5l_fill_1_561 r0 *1 0,0
Xsg13cmos5l_fill_1_561 VPWR VGND sg13cmos5l_fill_1
* cell instance sg13cmos5l_fill_1_562 r0 *1 0,0
Xsg13cmos5l_fill_1_562 VPWR VGND sg13cmos5l_fill_1
* cell instance sg13cmos5l_fill_1_563 r0 *1 0,0
Xsg13cmos5l_fill_1_563 VPWR VGND sg13cmos5l_fill_1
* cell instance sg13cmos5l_fill_1_564 r0 *1 0,0
Xsg13cmos5l_fill_1_564 VPWR VGND sg13cmos5l_fill_1
* cell instance sg13cmos5l_fill_1_565 r0 *1 0,0
Xsg13cmos5l_fill_1_565 VPWR VGND sg13cmos5l_fill_1
* cell instance sg13cmos5l_fill_1_566 r0 *1 0,0
Xsg13cmos5l_fill_1_566 VPWR VGND sg13cmos5l_fill_1
* cell instance sg13cmos5l_fill_1_567 r0 *1 0,0
Xsg13cmos5l_fill_1_567 VPWR VGND sg13cmos5l_fill_1
* cell instance sg13cmos5l_fill_1_568 r0 *1 0,0
Xsg13cmos5l_fill_1_568 VPWR VGND sg13cmos5l_fill_1
* cell instance sg13cmos5l_fill_1_569 r0 *1 0,0
Xsg13cmos5l_fill_1_569 VPWR VGND sg13cmos5l_fill_1
* cell instance sg13cmos5l_fill_1_570 r0 *1 0,0
Xsg13cmos5l_fill_1_570 VPWR VGND sg13cmos5l_fill_1
* cell instance sg13cmos5l_fill_1_571 r0 *1 0,0
Xsg13cmos5l_fill_1_571 VPWR VGND sg13cmos5l_fill_1
* cell instance sg13cmos5l_fill_1_572 r0 *1 0,0
Xsg13cmos5l_fill_1_572 VPWR VGND sg13cmos5l_fill_1
* cell instance sg13cmos5l_fill_1_573 r0 *1 0,0
Xsg13cmos5l_fill_1_573 VPWR VGND sg13cmos5l_fill_1
* cell instance sg13cmos5l_fill_1_574 r0 *1 0,0
Xsg13cmos5l_fill_1_574 VPWR VGND sg13cmos5l_fill_1
* cell instance sg13cmos5l_fill_1_575 r0 *1 0,0
Xsg13cmos5l_fill_1_575 VPWR VGND sg13cmos5l_fill_1
* cell instance sg13cmos5l_fill_1_576 r0 *1 0,0
Xsg13cmos5l_fill_1_576 VPWR VGND sg13cmos5l_fill_1
* cell instance sg13cmos5l_fill_1_577 r0 *1 0,0
Xsg13cmos5l_fill_1_577 VPWR VGND sg13cmos5l_fill_1
* cell instance sg13cmos5l_fill_1_578 r0 *1 0,0
Xsg13cmos5l_fill_1_578 VPWR VGND sg13cmos5l_fill_1
* cell instance sg13cmos5l_fill_1_579 r0 *1 0,0
Xsg13cmos5l_fill_1_579 VPWR VGND sg13cmos5l_fill_1
* cell instance sg13cmos5l_fill_1_580 r0 *1 0,0
Xsg13cmos5l_fill_1_580 VPWR VGND sg13cmos5l_fill_1
* cell instance sg13cmos5l_fill_1_581 r0 *1 0,0
Xsg13cmos5l_fill_1_581 VPWR VGND sg13cmos5l_fill_1
* cell instance sg13cmos5l_fill_1_582 r0 *1 0,0
Xsg13cmos5l_fill_1_582 VPWR VGND sg13cmos5l_fill_1
* cell instance sg13cmos5l_fill_1_583 r0 *1 0,0
Xsg13cmos5l_fill_1_583 VPWR VGND sg13cmos5l_fill_1
* cell instance sg13cmos5l_fill_1_584 r0 *1 0,0
Xsg13cmos5l_fill_1_584 VPWR VGND sg13cmos5l_fill_1
* cell instance sg13cmos5l_fill_1_585 r0 *1 0,0
Xsg13cmos5l_fill_1_585 VPWR VGND sg13cmos5l_fill_1
* cell instance sg13cmos5l_fill_1_586 r0 *1 0,0
Xsg13cmos5l_fill_1_586 VPWR VGND sg13cmos5l_fill_1
* cell instance sg13cmos5l_fill_1_587 r0 *1 0,0
Xsg13cmos5l_fill_1_587 VPWR VGND sg13cmos5l_fill_1
* cell instance sg13cmos5l_fill_1_588 r0 *1 0,0
Xsg13cmos5l_fill_1_588 VPWR VGND sg13cmos5l_fill_1
* cell instance sg13cmos5l_fill_1_589 r0 *1 0,0
Xsg13cmos5l_fill_1_589 VPWR VGND sg13cmos5l_fill_1
* cell instance sg13cmos5l_fill_1_590 r0 *1 0,0
Xsg13cmos5l_fill_1_590 VPWR VGND sg13cmos5l_fill_1
* cell instance sg13cmos5l_fill_1_591 r0 *1 0,0
Xsg13cmos5l_fill_1_591 VPWR VGND sg13cmos5l_fill_1
* cell instance sg13cmos5l_fill_1_592 r0 *1 0,0
Xsg13cmos5l_fill_1_592 VPWR VGND sg13cmos5l_fill_1
* cell instance sg13cmos5l_fill_1_593 r0 *1 0,0
Xsg13cmos5l_fill_1_593 VPWR VGND sg13cmos5l_fill_1
* cell instance sg13cmos5l_fill_1_594 r0 *1 0,0
Xsg13cmos5l_fill_1_594 VPWR VGND sg13cmos5l_fill_1
* cell instance sg13cmos5l_fill_1_595 r0 *1 0,0
Xsg13cmos5l_fill_1_595 VPWR VGND sg13cmos5l_fill_1
* cell instance sg13cmos5l_fill_1_596 r0 *1 0,0
Xsg13cmos5l_fill_1_596 VPWR VGND sg13cmos5l_fill_1
* cell instance sg13cmos5l_fill_1_597 r0 *1 0,0
Xsg13cmos5l_fill_1_597 VPWR VGND sg13cmos5l_fill_1
* cell instance sg13cmos5l_fill_1_598 r0 *1 0,0
Xsg13cmos5l_fill_1_598 VPWR VGND sg13cmos5l_fill_1
* cell instance sg13cmos5l_fill_2_0 r0 *1 0,0
Xsg13cmos5l_fill_2_0 VPWR VGND sg13cmos5l_fill_2
* cell instance sg13cmos5l_fill_2_1 r0 *1 0,0
Xsg13cmos5l_fill_2_1 VPWR VGND sg13cmos5l_fill_2
* cell instance sg13cmos5l_fill_2_2 r0 *1 0,0
Xsg13cmos5l_fill_2_2 VPWR VGND sg13cmos5l_fill_2
* cell instance sg13cmos5l_fill_2_3 r0 *1 0,0
Xsg13cmos5l_fill_2_3 VPWR VGND sg13cmos5l_fill_2
* cell instance sg13cmos5l_fill_2_4 r0 *1 0,0
Xsg13cmos5l_fill_2_4 VPWR VGND sg13cmos5l_fill_2
* cell instance sg13cmos5l_fill_2_5 r0 *1 0,0
Xsg13cmos5l_fill_2_5 VPWR VGND sg13cmos5l_fill_2
* cell instance sg13cmos5l_fill_2_6 r0 *1 0,0
Xsg13cmos5l_fill_2_6 VPWR VGND sg13cmos5l_fill_2
* cell instance sg13cmos5l_fill_2_7 r0 *1 0,0
Xsg13cmos5l_fill_2_7 VPWR VGND sg13cmos5l_fill_2
* cell instance sg13cmos5l_fill_2_8 r0 *1 0,0
Xsg13cmos5l_fill_2_8 VPWR VGND sg13cmos5l_fill_2
* cell instance sg13cmos5l_fill_2_9 r0 *1 0,0
Xsg13cmos5l_fill_2_9 VPWR VGND sg13cmos5l_fill_2
* cell instance sg13cmos5l_fill_2_10 r0 *1 0,0
Xsg13cmos5l_fill_2_10 VPWR VGND sg13cmos5l_fill_2
* cell instance sg13cmos5l_fill_2_11 r0 *1 0,0
Xsg13cmos5l_fill_2_11 VPWR VGND sg13cmos5l_fill_2
* cell instance sg13cmos5l_fill_2_12 r0 *1 0,0
Xsg13cmos5l_fill_2_12 VPWR VGND sg13cmos5l_fill_2
* cell instance sg13cmos5l_fill_2_13 r0 *1 0,0
Xsg13cmos5l_fill_2_13 VPWR VGND sg13cmos5l_fill_2
* cell instance sg13cmos5l_fill_2_14 r0 *1 0,0
Xsg13cmos5l_fill_2_14 VPWR VGND sg13cmos5l_fill_2
* cell instance sg13cmos5l_fill_2_15 r0 *1 0,0
Xsg13cmos5l_fill_2_15 VPWR VGND sg13cmos5l_fill_2
* cell instance sg13cmos5l_fill_2_16 r0 *1 0,0
Xsg13cmos5l_fill_2_16 VPWR VGND sg13cmos5l_fill_2
* cell instance sg13cmos5l_fill_2_17 r0 *1 0,0
Xsg13cmos5l_fill_2_17 VPWR VGND sg13cmos5l_fill_2
* cell instance sg13cmos5l_fill_2_18 r0 *1 0,0
Xsg13cmos5l_fill_2_18 VPWR VGND sg13cmos5l_fill_2
* cell instance sg13cmos5l_fill_2_19 r0 *1 0,0
Xsg13cmos5l_fill_2_19 VPWR VGND sg13cmos5l_fill_2
* cell instance sg13cmos5l_fill_2_20 r0 *1 0,0
Xsg13cmos5l_fill_2_20 VPWR VGND sg13cmos5l_fill_2
* cell instance sg13cmos5l_fill_2_21 r0 *1 0,0
Xsg13cmos5l_fill_2_21 VPWR VGND sg13cmos5l_fill_2
* cell instance sg13cmos5l_fill_2_22 r0 *1 0,0
Xsg13cmos5l_fill_2_22 VPWR VGND sg13cmos5l_fill_2
* cell instance sg13cmos5l_fill_2_23 r0 *1 0,0
Xsg13cmos5l_fill_2_23 VPWR VGND sg13cmos5l_fill_2
* cell instance sg13cmos5l_fill_2_24 r0 *1 0,0
Xsg13cmos5l_fill_2_24 VPWR VGND sg13cmos5l_fill_2
* cell instance sg13cmos5l_fill_2_25 r0 *1 0,0
Xsg13cmos5l_fill_2_25 VPWR VGND sg13cmos5l_fill_2
* cell instance sg13cmos5l_fill_2_26 r0 *1 0,0
Xsg13cmos5l_fill_2_26 VPWR VGND sg13cmos5l_fill_2
* cell instance sg13cmos5l_fill_2_27 r0 *1 0,0
Xsg13cmos5l_fill_2_27 VPWR VGND sg13cmos5l_fill_2
* cell instance sg13cmos5l_fill_2_28 r0 *1 0,0
Xsg13cmos5l_fill_2_28 VPWR VGND sg13cmos5l_fill_2
* cell instance sg13cmos5l_fill_2_29 r0 *1 0,0
Xsg13cmos5l_fill_2_29 VPWR VGND sg13cmos5l_fill_2
* cell instance sg13cmos5l_fill_2_30 r0 *1 0,0
Xsg13cmos5l_fill_2_30 VPWR VGND sg13cmos5l_fill_2
* cell instance sg13cmos5l_fill_2_31 r0 *1 0,0
Xsg13cmos5l_fill_2_31 VPWR VGND sg13cmos5l_fill_2
* cell instance sg13cmos5l_fill_2_32 r0 *1 0,0
Xsg13cmos5l_fill_2_32 VPWR VGND sg13cmos5l_fill_2
* cell instance sg13cmos5l_fill_2_33 r0 *1 0,0
Xsg13cmos5l_fill_2_33 VPWR VGND sg13cmos5l_fill_2
* cell instance sg13cmos5l_fill_2_34 r0 *1 0,0
Xsg13cmos5l_fill_2_34 VPWR VGND sg13cmos5l_fill_2
* cell instance sg13cmos5l_fill_2_35 r0 *1 0,0
Xsg13cmos5l_fill_2_35 VPWR VGND sg13cmos5l_fill_2
* cell instance sg13cmos5l_fill_2_36 r0 *1 0,0
Xsg13cmos5l_fill_2_36 VPWR VGND sg13cmos5l_fill_2
* cell instance sg13cmos5l_fill_2_37 r0 *1 0,0
Xsg13cmos5l_fill_2_37 VPWR VGND sg13cmos5l_fill_2
* cell instance sg13cmos5l_fill_2_38 r0 *1 0,0
Xsg13cmos5l_fill_2_38 VPWR VGND sg13cmos5l_fill_2
* cell instance sg13cmos5l_fill_2_39 r0 *1 0,0
Xsg13cmos5l_fill_2_39 VPWR VGND sg13cmos5l_fill_2
* cell instance sg13cmos5l_fill_2_40 r0 *1 0,0
Xsg13cmos5l_fill_2_40 VPWR VGND sg13cmos5l_fill_2
* cell instance sg13cmos5l_fill_2_41 r0 *1 0,0
Xsg13cmos5l_fill_2_41 VPWR VGND sg13cmos5l_fill_2
* cell instance sg13cmos5l_fill_2_42 r0 *1 0,0
Xsg13cmos5l_fill_2_42 VPWR VGND sg13cmos5l_fill_2
* cell instance sg13cmos5l_fill_2_43 r0 *1 0,0
Xsg13cmos5l_fill_2_43 VPWR VGND sg13cmos5l_fill_2
* cell instance sg13cmos5l_fill_2_44 r0 *1 0,0
Xsg13cmos5l_fill_2_44 VPWR VGND sg13cmos5l_fill_2
* cell instance sg13cmos5l_fill_2_45 r0 *1 0,0
Xsg13cmos5l_fill_2_45 VPWR VGND sg13cmos5l_fill_2
* cell instance sg13cmos5l_fill_2_46 r0 *1 0,0
Xsg13cmos5l_fill_2_46 VPWR VGND sg13cmos5l_fill_2
* cell instance sg13cmos5l_fill_2_47 r0 *1 0,0
Xsg13cmos5l_fill_2_47 VPWR VGND sg13cmos5l_fill_2
* cell instance sg13cmos5l_fill_2_48 r0 *1 0,0
Xsg13cmos5l_fill_2_48 VPWR VGND sg13cmos5l_fill_2
* cell instance sg13cmos5l_fill_2_49 r0 *1 0,0
Xsg13cmos5l_fill_2_49 VPWR VGND sg13cmos5l_fill_2
* cell instance sg13cmos5l_fill_2_50 r0 *1 0,0
Xsg13cmos5l_fill_2_50 VPWR VGND sg13cmos5l_fill_2
* cell instance sg13cmos5l_fill_2_51 r0 *1 0,0
Xsg13cmos5l_fill_2_51 VPWR VGND sg13cmos5l_fill_2
* cell instance sg13cmos5l_fill_2_52 r0 *1 0,0
Xsg13cmos5l_fill_2_52 VPWR VGND sg13cmos5l_fill_2
* cell instance sg13cmos5l_fill_2_53 r0 *1 0,0
Xsg13cmos5l_fill_2_53 VPWR VGND sg13cmos5l_fill_2
* cell instance sg13cmos5l_fill_2_54 r0 *1 0,0
Xsg13cmos5l_fill_2_54 VPWR VGND sg13cmos5l_fill_2
* cell instance sg13cmos5l_fill_2_55 r0 *1 0,0
Xsg13cmos5l_fill_2_55 VPWR VGND sg13cmos5l_fill_2
* cell instance sg13cmos5l_fill_2_56 r0 *1 0,0
Xsg13cmos5l_fill_2_56 VPWR VGND sg13cmos5l_fill_2
* cell instance sg13cmos5l_fill_2_57 r0 *1 0,0
Xsg13cmos5l_fill_2_57 VPWR VGND sg13cmos5l_fill_2
* cell instance sg13cmos5l_fill_2_58 r0 *1 0,0
Xsg13cmos5l_fill_2_58 VPWR VGND sg13cmos5l_fill_2
* cell instance sg13cmos5l_fill_2_59 r0 *1 0,0
Xsg13cmos5l_fill_2_59 VPWR VGND sg13cmos5l_fill_2
* cell instance sg13cmos5l_fill_2_60 r0 *1 0,0
Xsg13cmos5l_fill_2_60 VPWR VGND sg13cmos5l_fill_2
* cell instance sg13cmos5l_fill_2_61 r0 *1 0,0
Xsg13cmos5l_fill_2_61 VPWR VGND sg13cmos5l_fill_2
* cell instance sg13cmos5l_fill_2_62 r0 *1 0,0
Xsg13cmos5l_fill_2_62 VPWR VGND sg13cmos5l_fill_2
* cell instance sg13cmos5l_fill_2_63 r0 *1 0,0
Xsg13cmos5l_fill_2_63 VPWR VGND sg13cmos5l_fill_2
* cell instance sg13cmos5l_fill_2_64 r0 *1 0,0
Xsg13cmos5l_fill_2_64 VPWR VGND sg13cmos5l_fill_2
* cell instance sg13cmos5l_fill_2_65 r0 *1 0,0
Xsg13cmos5l_fill_2_65 VPWR VGND sg13cmos5l_fill_2
* cell instance sg13cmos5l_fill_2_66 r0 *1 0,0
Xsg13cmos5l_fill_2_66 VPWR VGND sg13cmos5l_fill_2
* cell instance sg13cmos5l_fill_2_67 r0 *1 0,0
Xsg13cmos5l_fill_2_67 VPWR VGND sg13cmos5l_fill_2
* cell instance sg13cmos5l_fill_2_68 r0 *1 0,0
Xsg13cmos5l_fill_2_68 VPWR VGND sg13cmos5l_fill_2
* cell instance sg13cmos5l_fill_2_69 r0 *1 0,0
Xsg13cmos5l_fill_2_69 VPWR VGND sg13cmos5l_fill_2
* cell instance sg13cmos5l_fill_2_70 r0 *1 0,0
Xsg13cmos5l_fill_2_70 VPWR VGND sg13cmos5l_fill_2
* cell instance sg13cmos5l_fill_2_71 r0 *1 0,0
Xsg13cmos5l_fill_2_71 VPWR VGND sg13cmos5l_fill_2
* cell instance sg13cmos5l_fill_2_72 r0 *1 0,0
Xsg13cmos5l_fill_2_72 VPWR VGND sg13cmos5l_fill_2
* cell instance sg13cmos5l_fill_2_73 r0 *1 0,0
Xsg13cmos5l_fill_2_73 VPWR VGND sg13cmos5l_fill_2
* cell instance sg13cmos5l_fill_2_74 r0 *1 0,0
Xsg13cmos5l_fill_2_74 VPWR VGND sg13cmos5l_fill_2
* cell instance sg13cmos5l_fill_2_75 r0 *1 0,0
Xsg13cmos5l_fill_2_75 VPWR VGND sg13cmos5l_fill_2
* cell instance sg13cmos5l_fill_2_76 r0 *1 0,0
Xsg13cmos5l_fill_2_76 VPWR VGND sg13cmos5l_fill_2
* cell instance sg13cmos5l_fill_2_77 r0 *1 0,0
Xsg13cmos5l_fill_2_77 VPWR VGND sg13cmos5l_fill_2
* cell instance sg13cmos5l_fill_2_78 r0 *1 0,0
Xsg13cmos5l_fill_2_78 VPWR VGND sg13cmos5l_fill_2
* cell instance sg13cmos5l_fill_2_79 r0 *1 0,0
Xsg13cmos5l_fill_2_79 VPWR VGND sg13cmos5l_fill_2
* cell instance sg13cmos5l_fill_2_80 r0 *1 0,0
Xsg13cmos5l_fill_2_80 VPWR VGND sg13cmos5l_fill_2
* cell instance sg13cmos5l_fill_2_81 r0 *1 0,0
Xsg13cmos5l_fill_2_81 VPWR VGND sg13cmos5l_fill_2
* cell instance sg13cmos5l_fill_2_82 r0 *1 0,0
Xsg13cmos5l_fill_2_82 VPWR VGND sg13cmos5l_fill_2
* cell instance sg13cmos5l_fill_2_83 r0 *1 0,0
Xsg13cmos5l_fill_2_83 VPWR VGND sg13cmos5l_fill_2
* cell instance sg13cmos5l_fill_2_84 r0 *1 0,0
Xsg13cmos5l_fill_2_84 VPWR VGND sg13cmos5l_fill_2
* cell instance sg13cmos5l_fill_2_85 r0 *1 0,0
Xsg13cmos5l_fill_2_85 VPWR VGND sg13cmos5l_fill_2
* cell instance sg13cmos5l_fill_2_86 r0 *1 0,0
Xsg13cmos5l_fill_2_86 VPWR VGND sg13cmos5l_fill_2
* cell instance sg13cmos5l_fill_2_87 r0 *1 0,0
Xsg13cmos5l_fill_2_87 VPWR VGND sg13cmos5l_fill_2
* cell instance sg13cmos5l_fill_2_88 r0 *1 0,0
Xsg13cmos5l_fill_2_88 VPWR VGND sg13cmos5l_fill_2
* cell instance sg13cmos5l_fill_2_89 r0 *1 0,0
Xsg13cmos5l_fill_2_89 VPWR VGND sg13cmos5l_fill_2
* cell instance sg13cmos5l_fill_2_90 r0 *1 0,0
Xsg13cmos5l_fill_2_90 VPWR VGND sg13cmos5l_fill_2
* cell instance sg13cmos5l_fill_2_91 r0 *1 0,0
Xsg13cmos5l_fill_2_91 VPWR VGND sg13cmos5l_fill_2
* cell instance sg13cmos5l_fill_2_92 r0 *1 0,0
Xsg13cmos5l_fill_2_92 VPWR VGND sg13cmos5l_fill_2
* cell instance sg13cmos5l_fill_2_93 r0 *1 0,0
Xsg13cmos5l_fill_2_93 VPWR VGND sg13cmos5l_fill_2
* cell instance sg13cmos5l_fill_2_94 r0 *1 0,0
Xsg13cmos5l_fill_2_94 VPWR VGND sg13cmos5l_fill_2
* cell instance sg13cmos5l_fill_2_95 r0 *1 0,0
Xsg13cmos5l_fill_2_95 VPWR VGND sg13cmos5l_fill_2
* cell instance sg13cmos5l_fill_2_96 r0 *1 0,0
Xsg13cmos5l_fill_2_96 VPWR VGND sg13cmos5l_fill_2
* cell instance sg13cmos5l_fill_2_97 r0 *1 0,0
Xsg13cmos5l_fill_2_97 VPWR VGND sg13cmos5l_fill_2
* cell instance sg13cmos5l_fill_2_98 r0 *1 0,0
Xsg13cmos5l_fill_2_98 VPWR VGND sg13cmos5l_fill_2
* cell instance sg13cmos5l_fill_2_99 r0 *1 0,0
Xsg13cmos5l_fill_2_99 VPWR VGND sg13cmos5l_fill_2
* cell instance sg13cmos5l_fill_2_100 r0 *1 0,0
Xsg13cmos5l_fill_2_100 VPWR VGND sg13cmos5l_fill_2
* cell instance sg13cmos5l_fill_2_101 r0 *1 0,0
Xsg13cmos5l_fill_2_101 VPWR VGND sg13cmos5l_fill_2
* cell instance sg13cmos5l_fill_2_102 r0 *1 0,0
Xsg13cmos5l_fill_2_102 VPWR VGND sg13cmos5l_fill_2
* cell instance sg13cmos5l_fill_2_103 r0 *1 0,0
Xsg13cmos5l_fill_2_103 VPWR VGND sg13cmos5l_fill_2
* cell instance sg13cmos5l_fill_2_104 r0 *1 0,0
Xsg13cmos5l_fill_2_104 VPWR VGND sg13cmos5l_fill_2
* cell instance sg13cmos5l_fill_2_105 r0 *1 0,0
Xsg13cmos5l_fill_2_105 VPWR VGND sg13cmos5l_fill_2
* cell instance sg13cmos5l_fill_2_106 r0 *1 0,0
Xsg13cmos5l_fill_2_106 VPWR VGND sg13cmos5l_fill_2
* cell instance sg13cmos5l_fill_2_107 r0 *1 0,0
Xsg13cmos5l_fill_2_107 VPWR VGND sg13cmos5l_fill_2
* cell instance sg13cmos5l_fill_2_108 r0 *1 0,0
Xsg13cmos5l_fill_2_108 VPWR VGND sg13cmos5l_fill_2
* cell instance sg13cmos5l_fill_2_109 r0 *1 0,0
Xsg13cmos5l_fill_2_109 VPWR VGND sg13cmos5l_fill_2
* cell instance sg13cmos5l_fill_2_110 r0 *1 0,0
Xsg13cmos5l_fill_2_110 VPWR VGND sg13cmos5l_fill_2
* cell instance sg13cmos5l_fill_2_111 r0 *1 0,0
Xsg13cmos5l_fill_2_111 VPWR VGND sg13cmos5l_fill_2
* cell instance sg13cmos5l_fill_2_112 r0 *1 0,0
Xsg13cmos5l_fill_2_112 VPWR VGND sg13cmos5l_fill_2
* cell instance sg13cmos5l_fill_2_113 r0 *1 0,0
Xsg13cmos5l_fill_2_113 VPWR VGND sg13cmos5l_fill_2
* cell instance sg13cmos5l_fill_2_114 r0 *1 0,0
Xsg13cmos5l_fill_2_114 VPWR VGND sg13cmos5l_fill_2
* cell instance sg13cmos5l_fill_2_115 r0 *1 0,0
Xsg13cmos5l_fill_2_115 VPWR VGND sg13cmos5l_fill_2
* cell instance sg13cmos5l_fill_2_116 r0 *1 0,0
Xsg13cmos5l_fill_2_116 VPWR VGND sg13cmos5l_fill_2
* cell instance sg13cmos5l_fill_2_117 r0 *1 0,0
Xsg13cmos5l_fill_2_117 VPWR VGND sg13cmos5l_fill_2
* cell instance sg13cmos5l_fill_2_118 r0 *1 0,0
Xsg13cmos5l_fill_2_118 VPWR VGND sg13cmos5l_fill_2
* cell instance sg13cmos5l_fill_2_119 r0 *1 0,0
Xsg13cmos5l_fill_2_119 VPWR VGND sg13cmos5l_fill_2
* cell instance sg13cmos5l_fill_2_120 r0 *1 0,0
Xsg13cmos5l_fill_2_120 VPWR VGND sg13cmos5l_fill_2
* cell instance sg13cmos5l_fill_2_121 r0 *1 0,0
Xsg13cmos5l_fill_2_121 VPWR VGND sg13cmos5l_fill_2
* cell instance sg13cmos5l_fill_2_122 r0 *1 0,0
Xsg13cmos5l_fill_2_122 VPWR VGND sg13cmos5l_fill_2
* cell instance sg13cmos5l_fill_2_123 r0 *1 0,0
Xsg13cmos5l_fill_2_123 VPWR VGND sg13cmos5l_fill_2
* cell instance sg13cmos5l_fill_2_124 r0 *1 0,0
Xsg13cmos5l_fill_2_124 VPWR VGND sg13cmos5l_fill_2
* cell instance sg13cmos5l_fill_2_125 r0 *1 0,0
Xsg13cmos5l_fill_2_125 VPWR VGND sg13cmos5l_fill_2
* cell instance sg13cmos5l_fill_2_126 r0 *1 0,0
Xsg13cmos5l_fill_2_126 VPWR VGND sg13cmos5l_fill_2
* cell instance sg13cmos5l_fill_2_127 r0 *1 0,0
Xsg13cmos5l_fill_2_127 VPWR VGND sg13cmos5l_fill_2
* cell instance sg13cmos5l_fill_2_128 r0 *1 0,0
Xsg13cmos5l_fill_2_128 VPWR VGND sg13cmos5l_fill_2
* cell instance sg13cmos5l_fill_2_129 r0 *1 0,0
Xsg13cmos5l_fill_2_129 VPWR VGND sg13cmos5l_fill_2
* cell instance sg13cmos5l_fill_2_130 r0 *1 0,0
Xsg13cmos5l_fill_2_130 VPWR VGND sg13cmos5l_fill_2
* cell instance sg13cmos5l_fill_2_131 r0 *1 0,0
Xsg13cmos5l_fill_2_131 VPWR VGND sg13cmos5l_fill_2
* cell instance sg13cmos5l_fill_2_132 r0 *1 0,0
Xsg13cmos5l_fill_2_132 VPWR VGND sg13cmos5l_fill_2
* cell instance sg13cmos5l_fill_2_133 r0 *1 0,0
Xsg13cmos5l_fill_2_133 VPWR VGND sg13cmos5l_fill_2
* cell instance sg13cmos5l_fill_2_134 r0 *1 0,0
Xsg13cmos5l_fill_2_134 VPWR VGND sg13cmos5l_fill_2
* cell instance sg13cmos5l_fill_2_135 r0 *1 0,0
Xsg13cmos5l_fill_2_135 VPWR VGND sg13cmos5l_fill_2
* cell instance sg13cmos5l_fill_2_136 r0 *1 0,0
Xsg13cmos5l_fill_2_136 VPWR VGND sg13cmos5l_fill_2
* cell instance sg13cmos5l_fill_2_137 r0 *1 0,0
Xsg13cmos5l_fill_2_137 VPWR VGND sg13cmos5l_fill_2
* cell instance sg13cmos5l_fill_2_138 r0 *1 0,0
Xsg13cmos5l_fill_2_138 VPWR VGND sg13cmos5l_fill_2
* cell instance sg13cmos5l_fill_2_139 r0 *1 0,0
Xsg13cmos5l_fill_2_139 VPWR VGND sg13cmos5l_fill_2
* cell instance sg13cmos5l_fill_2_140 r0 *1 0,0
Xsg13cmos5l_fill_2_140 VPWR VGND sg13cmos5l_fill_2
* cell instance sg13cmos5l_fill_2_141 r0 *1 0,0
Xsg13cmos5l_fill_2_141 VPWR VGND sg13cmos5l_fill_2
* cell instance sg13cmos5l_fill_2_142 r0 *1 0,0
Xsg13cmos5l_fill_2_142 VPWR VGND sg13cmos5l_fill_2
* cell instance sg13cmos5l_fill_2_143 r0 *1 0,0
Xsg13cmos5l_fill_2_143 VPWR VGND sg13cmos5l_fill_2
* cell instance sg13cmos5l_fill_2_144 r0 *1 0,0
Xsg13cmos5l_fill_2_144 VPWR VGND sg13cmos5l_fill_2
* cell instance sg13cmos5l_fill_2_145 r0 *1 0,0
Xsg13cmos5l_fill_2_145 VPWR VGND sg13cmos5l_fill_2
* cell instance sg13cmos5l_fill_2_146 r0 *1 0,0
Xsg13cmos5l_fill_2_146 VPWR VGND sg13cmos5l_fill_2
* cell instance sg13cmos5l_fill_2_147 r0 *1 0,0
Xsg13cmos5l_fill_2_147 VPWR VGND sg13cmos5l_fill_2
* cell instance sg13cmos5l_fill_2_148 r0 *1 0,0
Xsg13cmos5l_fill_2_148 VPWR VGND sg13cmos5l_fill_2
* cell instance sg13cmos5l_fill_2_149 r0 *1 0,0
Xsg13cmos5l_fill_2_149 VPWR VGND sg13cmos5l_fill_2
* cell instance sg13cmos5l_fill_2_150 r0 *1 0,0
Xsg13cmos5l_fill_2_150 VPWR VGND sg13cmos5l_fill_2
* cell instance sg13cmos5l_fill_2_151 r0 *1 0,0
Xsg13cmos5l_fill_2_151 VPWR VGND sg13cmos5l_fill_2
* cell instance sg13cmos5l_fill_2_152 r0 *1 0,0
Xsg13cmos5l_fill_2_152 VPWR VGND sg13cmos5l_fill_2
* cell instance sg13cmos5l_fill_2_153 r0 *1 0,0
Xsg13cmos5l_fill_2_153 VPWR VGND sg13cmos5l_fill_2
* cell instance sg13cmos5l_fill_2_154 r0 *1 0,0
Xsg13cmos5l_fill_2_154 VPWR VGND sg13cmos5l_fill_2
* cell instance sg13cmos5l_fill_2_155 r0 *1 0,0
Xsg13cmos5l_fill_2_155 VPWR VGND sg13cmos5l_fill_2
* cell instance sg13cmos5l_fill_2_156 r0 *1 0,0
Xsg13cmos5l_fill_2_156 VPWR VGND sg13cmos5l_fill_2
* cell instance sg13cmos5l_fill_2_157 r0 *1 0,0
Xsg13cmos5l_fill_2_157 VPWR VGND sg13cmos5l_fill_2
* cell instance sg13cmos5l_fill_2_158 r0 *1 0,0
Xsg13cmos5l_fill_2_158 VPWR VGND sg13cmos5l_fill_2
* cell instance sg13cmos5l_fill_2_159 r0 *1 0,0
Xsg13cmos5l_fill_2_159 VPWR VGND sg13cmos5l_fill_2
* cell instance sg13cmos5l_fill_2_160 r0 *1 0,0
Xsg13cmos5l_fill_2_160 VPWR VGND sg13cmos5l_fill_2
* cell instance sg13cmos5l_fill_2_161 r0 *1 0,0
Xsg13cmos5l_fill_2_161 VPWR VGND sg13cmos5l_fill_2
* cell instance sg13cmos5l_fill_2_162 r0 *1 0,0
Xsg13cmos5l_fill_2_162 VPWR VGND sg13cmos5l_fill_2
* cell instance sg13cmos5l_fill_2_163 r0 *1 0,0
Xsg13cmos5l_fill_2_163 VPWR VGND sg13cmos5l_fill_2
* cell instance sg13cmos5l_fill_2_164 r0 *1 0,0
Xsg13cmos5l_fill_2_164 VPWR VGND sg13cmos5l_fill_2
* cell instance sg13cmos5l_fill_2_165 r0 *1 0,0
Xsg13cmos5l_fill_2_165 VPWR VGND sg13cmos5l_fill_2
* cell instance sg13cmos5l_fill_2_166 r0 *1 0,0
Xsg13cmos5l_fill_2_166 VPWR VGND sg13cmos5l_fill_2
* cell instance sg13cmos5l_fill_2_167 r0 *1 0,0
Xsg13cmos5l_fill_2_167 VPWR VGND sg13cmos5l_fill_2
* cell instance sg13cmos5l_fill_2_168 r0 *1 0,0
Xsg13cmos5l_fill_2_168 VPWR VGND sg13cmos5l_fill_2
* cell instance sg13cmos5l_fill_2_169 r0 *1 0,0
Xsg13cmos5l_fill_2_169 VPWR VGND sg13cmos5l_fill_2
* cell instance sg13cmos5l_fill_2_170 r0 *1 0,0
Xsg13cmos5l_fill_2_170 VPWR VGND sg13cmos5l_fill_2
* cell instance sg13cmos5l_fill_2_171 r0 *1 0,0
Xsg13cmos5l_fill_2_171 VPWR VGND sg13cmos5l_fill_2
* cell instance sg13cmos5l_fill_2_172 r0 *1 0,0
Xsg13cmos5l_fill_2_172 VPWR VGND sg13cmos5l_fill_2
* cell instance sg13cmos5l_fill_2_173 r0 *1 0,0
Xsg13cmos5l_fill_2_173 VPWR VGND sg13cmos5l_fill_2
* cell instance sg13cmos5l_fill_2_174 r0 *1 0,0
Xsg13cmos5l_fill_2_174 VPWR VGND sg13cmos5l_fill_2
* cell instance sg13cmos5l_fill_2_175 r0 *1 0,0
Xsg13cmos5l_fill_2_175 VPWR VGND sg13cmos5l_fill_2
* cell instance sg13cmos5l_fill_2_176 r0 *1 0,0
Xsg13cmos5l_fill_2_176 VPWR VGND sg13cmos5l_fill_2
* cell instance sg13cmos5l_fill_2_177 r0 *1 0,0
Xsg13cmos5l_fill_2_177 VPWR VGND sg13cmos5l_fill_2
* cell instance sg13cmos5l_fill_2_178 r0 *1 0,0
Xsg13cmos5l_fill_2_178 VPWR VGND sg13cmos5l_fill_2
* cell instance sg13cmos5l_fill_2_179 r0 *1 0,0
Xsg13cmos5l_fill_2_179 VPWR VGND sg13cmos5l_fill_2
* cell instance sg13cmos5l_fill_2_180 r0 *1 0,0
Xsg13cmos5l_fill_2_180 VPWR VGND sg13cmos5l_fill_2
* cell instance sg13cmos5l_fill_2_181 r0 *1 0,0
Xsg13cmos5l_fill_2_181 VPWR VGND sg13cmos5l_fill_2
* cell instance sg13cmos5l_fill_2_182 r0 *1 0,0
Xsg13cmos5l_fill_2_182 VPWR VGND sg13cmos5l_fill_2
* cell instance sg13cmos5l_fill_2_183 r0 *1 0,0
Xsg13cmos5l_fill_2_183 VPWR VGND sg13cmos5l_fill_2
* cell instance sg13cmos5l_fill_2_184 r0 *1 0,0
Xsg13cmos5l_fill_2_184 VPWR VGND sg13cmos5l_fill_2
* cell instance sg13cmos5l_fill_2_185 r0 *1 0,0
Xsg13cmos5l_fill_2_185 VPWR VGND sg13cmos5l_fill_2
* cell instance sg13cmos5l_fill_2_186 r0 *1 0,0
Xsg13cmos5l_fill_2_186 VPWR VGND sg13cmos5l_fill_2
* cell instance sg13cmos5l_fill_2_187 r0 *1 0,0
Xsg13cmos5l_fill_2_187 VPWR VGND sg13cmos5l_fill_2
* cell instance sg13cmos5l_fill_2_188 r0 *1 0,0
Xsg13cmos5l_fill_2_188 VPWR VGND sg13cmos5l_fill_2
* cell instance sg13cmos5l_fill_2_189 r0 *1 0,0
Xsg13cmos5l_fill_2_189 VPWR VGND sg13cmos5l_fill_2
* cell instance sg13cmos5l_fill_2_190 r0 *1 0,0
Xsg13cmos5l_fill_2_190 VPWR VGND sg13cmos5l_fill_2
* cell instance sg13cmos5l_fill_2_191 r0 *1 0,0
Xsg13cmos5l_fill_2_191 VPWR VGND sg13cmos5l_fill_2
* cell instance sg13cmos5l_fill_2_192 r0 *1 0,0
Xsg13cmos5l_fill_2_192 VPWR VGND sg13cmos5l_fill_2
* cell instance sg13cmos5l_fill_2_193 r0 *1 0,0
Xsg13cmos5l_fill_2_193 VPWR VGND sg13cmos5l_fill_2
* cell instance sg13cmos5l_fill_2_194 r0 *1 0,0
Xsg13cmos5l_fill_2_194 VPWR VGND sg13cmos5l_fill_2
* cell instance sg13cmos5l_fill_2_195 r0 *1 0,0
Xsg13cmos5l_fill_2_195 VPWR VGND sg13cmos5l_fill_2
* cell instance sg13cmos5l_fill_2_196 r0 *1 0,0
Xsg13cmos5l_fill_2_196 VPWR VGND sg13cmos5l_fill_2
* cell instance sg13cmos5l_fill_2_197 r0 *1 0,0
Xsg13cmos5l_fill_2_197 VPWR VGND sg13cmos5l_fill_2
* cell instance sg13cmos5l_fill_2_198 r0 *1 0,0
Xsg13cmos5l_fill_2_198 VPWR VGND sg13cmos5l_fill_2
* cell instance sg13cmos5l_fill_2_199 r0 *1 0,0
Xsg13cmos5l_fill_2_199 VPWR VGND sg13cmos5l_fill_2
* cell instance sg13cmos5l_fill_2_200 r0 *1 0,0
Xsg13cmos5l_fill_2_200 VPWR VGND sg13cmos5l_fill_2
* cell instance sg13cmos5l_fill_2_201 r0 *1 0,0
Xsg13cmos5l_fill_2_201 VPWR VGND sg13cmos5l_fill_2
* cell instance sg13cmos5l_fill_2_202 r0 *1 0,0
Xsg13cmos5l_fill_2_202 VPWR VGND sg13cmos5l_fill_2
* cell instance sg13cmos5l_fill_2_203 r0 *1 0,0
Xsg13cmos5l_fill_2_203 VPWR VGND sg13cmos5l_fill_2
* cell instance sg13cmos5l_fill_2_204 r0 *1 0,0
Xsg13cmos5l_fill_2_204 VPWR VGND sg13cmos5l_fill_2
* cell instance sg13cmos5l_fill_2_205 r0 *1 0,0
Xsg13cmos5l_fill_2_205 VPWR VGND sg13cmos5l_fill_2
* cell instance sg13cmos5l_fill_2_206 r0 *1 0,0
Xsg13cmos5l_fill_2_206 VPWR VGND sg13cmos5l_fill_2
* cell instance sg13cmos5l_fill_2_207 r0 *1 0,0
Xsg13cmos5l_fill_2_207 VPWR VGND sg13cmos5l_fill_2
* cell instance sg13cmos5l_fill_2_208 r0 *1 0,0
Xsg13cmos5l_fill_2_208 VPWR VGND sg13cmos5l_fill_2
* cell instance sg13cmos5l_fill_2_209 r0 *1 0,0
Xsg13cmos5l_fill_2_209 VPWR VGND sg13cmos5l_fill_2
* cell instance sg13cmos5l_fill_2_210 r0 *1 0,0
Xsg13cmos5l_fill_2_210 VPWR VGND sg13cmos5l_fill_2
* cell instance sg13cmos5l_fill_2_211 r0 *1 0,0
Xsg13cmos5l_fill_2_211 VPWR VGND sg13cmos5l_fill_2
* cell instance sg13cmos5l_fill_2_212 r0 *1 0,0
Xsg13cmos5l_fill_2_212 VPWR VGND sg13cmos5l_fill_2
* cell instance sg13cmos5l_fill_2_213 r0 *1 0,0
Xsg13cmos5l_fill_2_213 VPWR VGND sg13cmos5l_fill_2
* cell instance sg13cmos5l_fill_2_214 r0 *1 0,0
Xsg13cmos5l_fill_2_214 VPWR VGND sg13cmos5l_fill_2
* cell instance sg13cmos5l_fill_2_215 r0 *1 0,0
Xsg13cmos5l_fill_2_215 VPWR VGND sg13cmos5l_fill_2
* cell instance sg13cmos5l_fill_2_216 r0 *1 0,0
Xsg13cmos5l_fill_2_216 VPWR VGND sg13cmos5l_fill_2
* cell instance sg13cmos5l_fill_2_217 r0 *1 0,0
Xsg13cmos5l_fill_2_217 VPWR VGND sg13cmos5l_fill_2
* cell instance sg13cmos5l_fill_2_218 r0 *1 0,0
Xsg13cmos5l_fill_2_218 VPWR VGND sg13cmos5l_fill_2
* cell instance sg13cmos5l_fill_2_219 r0 *1 0,0
Xsg13cmos5l_fill_2_219 VPWR VGND sg13cmos5l_fill_2
* cell instance sg13cmos5l_fill_2_220 r0 *1 0,0
Xsg13cmos5l_fill_2_220 VPWR VGND sg13cmos5l_fill_2
* cell instance sg13cmos5l_fill_2_221 r0 *1 0,0
Xsg13cmos5l_fill_2_221 VPWR VGND sg13cmos5l_fill_2
* cell instance sg13cmos5l_fill_2_222 r0 *1 0,0
Xsg13cmos5l_fill_2_222 VPWR VGND sg13cmos5l_fill_2
* cell instance sg13cmos5l_fill_2_223 r0 *1 0,0
Xsg13cmos5l_fill_2_223 VPWR VGND sg13cmos5l_fill_2
* cell instance sg13cmos5l_fill_2_224 r0 *1 0,0
Xsg13cmos5l_fill_2_224 VPWR VGND sg13cmos5l_fill_2
* cell instance sg13cmos5l_fill_2_225 r0 *1 0,0
Xsg13cmos5l_fill_2_225 VPWR VGND sg13cmos5l_fill_2
* cell instance sg13cmos5l_fill_2_226 r0 *1 0,0
Xsg13cmos5l_fill_2_226 VPWR VGND sg13cmos5l_fill_2
* cell instance sg13cmos5l_fill_2_227 r0 *1 0,0
Xsg13cmos5l_fill_2_227 VPWR VGND sg13cmos5l_fill_2
* cell instance sg13cmos5l_fill_2_228 r0 *1 0,0
Xsg13cmos5l_fill_2_228 VPWR VGND sg13cmos5l_fill_2
* cell instance sg13cmos5l_fill_2_229 r0 *1 0,0
Xsg13cmos5l_fill_2_229 VPWR VGND sg13cmos5l_fill_2
* cell instance sg13cmos5l_fill_2_230 r0 *1 0,0
Xsg13cmos5l_fill_2_230 VPWR VGND sg13cmos5l_fill_2
* cell instance sg13cmos5l_fill_2_231 r0 *1 0,0
Xsg13cmos5l_fill_2_231 VPWR VGND sg13cmos5l_fill_2
* cell instance sg13cmos5l_fill_2_232 r0 *1 0,0
Xsg13cmos5l_fill_2_232 VPWR VGND sg13cmos5l_fill_2
* cell instance sg13cmos5l_fill_2_233 r0 *1 0,0
Xsg13cmos5l_fill_2_233 VPWR VGND sg13cmos5l_fill_2
* cell instance sg13cmos5l_fill_2_234 r0 *1 0,0
Xsg13cmos5l_fill_2_234 VPWR VGND sg13cmos5l_fill_2
* cell instance sg13cmos5l_fill_2_235 r0 *1 0,0
Xsg13cmos5l_fill_2_235 VPWR VGND sg13cmos5l_fill_2
* cell instance sg13cmos5l_fill_2_236 r0 *1 0,0
Xsg13cmos5l_fill_2_236 VPWR VGND sg13cmos5l_fill_2
* cell instance sg13cmos5l_fill_2_237 r0 *1 0,0
Xsg13cmos5l_fill_2_237 VPWR VGND sg13cmos5l_fill_2
* cell instance sg13cmos5l_fill_2_238 r0 *1 0,0
Xsg13cmos5l_fill_2_238 VPWR VGND sg13cmos5l_fill_2
* cell instance sg13cmos5l_fill_2_239 r0 *1 0,0
Xsg13cmos5l_fill_2_239 VPWR VGND sg13cmos5l_fill_2
* cell instance sg13cmos5l_fill_2_240 r0 *1 0,0
Xsg13cmos5l_fill_2_240 VPWR VGND sg13cmos5l_fill_2
* cell instance sg13cmos5l_fill_2_241 r0 *1 0,0
Xsg13cmos5l_fill_2_241 VPWR VGND sg13cmos5l_fill_2
* cell instance sg13cmos5l_fill_2_242 r0 *1 0,0
Xsg13cmos5l_fill_2_242 VPWR VGND sg13cmos5l_fill_2
* cell instance sg13cmos5l_fill_2_243 r0 *1 0,0
Xsg13cmos5l_fill_2_243 VPWR VGND sg13cmos5l_fill_2
* cell instance sg13cmos5l_fill_2_244 r0 *1 0,0
Xsg13cmos5l_fill_2_244 VPWR VGND sg13cmos5l_fill_2
* cell instance sg13cmos5l_fill_2_245 r0 *1 0,0
Xsg13cmos5l_fill_2_245 VPWR VGND sg13cmos5l_fill_2
* cell instance sg13cmos5l_fill_2_246 r0 *1 0,0
Xsg13cmos5l_fill_2_246 VPWR VGND sg13cmos5l_fill_2
* cell instance sg13cmos5l_fill_2_247 r0 *1 0,0
Xsg13cmos5l_fill_2_247 VPWR VGND sg13cmos5l_fill_2
* cell instance sg13cmos5l_fill_2_248 r0 *1 0,0
Xsg13cmos5l_fill_2_248 VPWR VGND sg13cmos5l_fill_2
* cell instance sg13cmos5l_fill_2_249 r0 *1 0,0
Xsg13cmos5l_fill_2_249 VPWR VGND sg13cmos5l_fill_2
* cell instance sg13cmos5l_fill_2_250 r0 *1 0,0
Xsg13cmos5l_fill_2_250 VPWR VGND sg13cmos5l_fill_2
* cell instance sg13cmos5l_fill_2_251 r0 *1 0,0
Xsg13cmos5l_fill_2_251 VPWR VGND sg13cmos5l_fill_2
* cell instance sg13cmos5l_fill_2_252 r0 *1 0,0
Xsg13cmos5l_fill_2_252 VPWR VGND sg13cmos5l_fill_2
* cell instance sg13cmos5l_fill_2_253 r0 *1 0,0
Xsg13cmos5l_fill_2_253 VPWR VGND sg13cmos5l_fill_2
* cell instance sg13cmos5l_fill_2_254 r0 *1 0,0
Xsg13cmos5l_fill_2_254 VPWR VGND sg13cmos5l_fill_2
* cell instance sg13cmos5l_fill_2_255 r0 *1 0,0
Xsg13cmos5l_fill_2_255 VPWR VGND sg13cmos5l_fill_2
* cell instance sg13cmos5l_fill_2_256 r0 *1 0,0
Xsg13cmos5l_fill_2_256 VPWR VGND sg13cmos5l_fill_2
* cell instance sg13cmos5l_fill_2_257 r0 *1 0,0
Xsg13cmos5l_fill_2_257 VPWR VGND sg13cmos5l_fill_2
* cell instance sg13cmos5l_fill_2_258 r0 *1 0,0
Xsg13cmos5l_fill_2_258 VPWR VGND sg13cmos5l_fill_2
* cell instance sg13cmos5l_fill_2_259 r0 *1 0,0
Xsg13cmos5l_fill_2_259 VPWR VGND sg13cmos5l_fill_2
* cell instance sg13cmos5l_fill_2_260 r0 *1 0,0
Xsg13cmos5l_fill_2_260 VPWR VGND sg13cmos5l_fill_2
* cell instance sg13cmos5l_fill_2_261 r0 *1 0,0
Xsg13cmos5l_fill_2_261 VPWR VGND sg13cmos5l_fill_2
* cell instance sg13cmos5l_fill_2_262 r0 *1 0,0
Xsg13cmos5l_fill_2_262 VPWR VGND sg13cmos5l_fill_2
* cell instance sg13cmos5l_fill_2_263 r0 *1 0,0
Xsg13cmos5l_fill_2_263 VPWR VGND sg13cmos5l_fill_2
* cell instance sg13cmos5l_fill_2_264 r0 *1 0,0
Xsg13cmos5l_fill_2_264 VPWR VGND sg13cmos5l_fill_2
* cell instance sg13cmos5l_fill_2_265 r0 *1 0,0
Xsg13cmos5l_fill_2_265 VPWR VGND sg13cmos5l_fill_2
* cell instance sg13cmos5l_fill_2_266 r0 *1 0,0
Xsg13cmos5l_fill_2_266 VPWR VGND sg13cmos5l_fill_2
* cell instance sg13cmos5l_fill_2_267 r0 *1 0,0
Xsg13cmos5l_fill_2_267 VPWR VGND sg13cmos5l_fill_2
* cell instance sg13cmos5l_fill_2_268 r0 *1 0,0
Xsg13cmos5l_fill_2_268 VPWR VGND sg13cmos5l_fill_2
* cell instance sg13cmos5l_fill_2_269 r0 *1 0,0
Xsg13cmos5l_fill_2_269 VPWR VGND sg13cmos5l_fill_2
* cell instance sg13cmos5l_fill_2_270 r0 *1 0,0
Xsg13cmos5l_fill_2_270 VPWR VGND sg13cmos5l_fill_2
* cell instance sg13cmos5l_fill_2_271 r0 *1 0,0
Xsg13cmos5l_fill_2_271 VPWR VGND sg13cmos5l_fill_2
* cell instance sg13cmos5l_fill_2_272 r0 *1 0,0
Xsg13cmos5l_fill_2_272 VPWR VGND sg13cmos5l_fill_2
* cell instance sg13cmos5l_fill_2_273 r0 *1 0,0
Xsg13cmos5l_fill_2_273 VPWR VGND sg13cmos5l_fill_2
* cell instance sg13cmos5l_fill_2_274 r0 *1 0,0
Xsg13cmos5l_fill_2_274 VPWR VGND sg13cmos5l_fill_2
* cell instance sg13cmos5l_fill_2_275 r0 *1 0,0
Xsg13cmos5l_fill_2_275 VPWR VGND sg13cmos5l_fill_2
* cell instance sg13cmos5l_fill_2_276 r0 *1 0,0
Xsg13cmos5l_fill_2_276 VPWR VGND sg13cmos5l_fill_2
* cell instance sg13cmos5l_fill_2_277 r0 *1 0,0
Xsg13cmos5l_fill_2_277 VPWR VGND sg13cmos5l_fill_2
* cell instance sg13cmos5l_fill_2_278 r0 *1 0,0
Xsg13cmos5l_fill_2_278 VPWR VGND sg13cmos5l_fill_2
* cell instance sg13cmos5l_fill_2_279 r0 *1 0,0
Xsg13cmos5l_fill_2_279 VPWR VGND sg13cmos5l_fill_2
* cell instance sg13cmos5l_fill_2_280 r0 *1 0,0
Xsg13cmos5l_fill_2_280 VPWR VGND sg13cmos5l_fill_2
* cell instance sg13cmos5l_fill_2_281 r0 *1 0,0
Xsg13cmos5l_fill_2_281 VPWR VGND sg13cmos5l_fill_2
* cell instance sg13cmos5l_fill_2_282 r0 *1 0,0
Xsg13cmos5l_fill_2_282 VPWR VGND sg13cmos5l_fill_2
* cell instance sg13cmos5l_fill_2_283 r0 *1 0,0
Xsg13cmos5l_fill_2_283 VPWR VGND sg13cmos5l_fill_2
* cell instance sg13cmos5l_fill_2_284 r0 *1 0,0
Xsg13cmos5l_fill_2_284 VPWR VGND sg13cmos5l_fill_2
* cell instance sg13cmos5l_fill_2_285 r0 *1 0,0
Xsg13cmos5l_fill_2_285 VPWR VGND sg13cmos5l_fill_2
* cell instance sg13cmos5l_fill_2_286 r0 *1 0,0
Xsg13cmos5l_fill_2_286 VPWR VGND sg13cmos5l_fill_2
* cell instance sg13cmos5l_fill_2_287 r0 *1 0,0
Xsg13cmos5l_fill_2_287 VPWR VGND sg13cmos5l_fill_2
* cell instance sg13cmos5l_fill_2_288 r0 *1 0,0
Xsg13cmos5l_fill_2_288 VPWR VGND sg13cmos5l_fill_2
* cell instance sg13cmos5l_fill_2_289 r0 *1 0,0
Xsg13cmos5l_fill_2_289 VPWR VGND sg13cmos5l_fill_2
* cell instance sg13cmos5l_fill_2_290 r0 *1 0,0
Xsg13cmos5l_fill_2_290 VPWR VGND sg13cmos5l_fill_2
* cell instance sg13cmos5l_fill_2_291 r0 *1 0,0
Xsg13cmos5l_fill_2_291 VPWR VGND sg13cmos5l_fill_2
* cell instance sg13cmos5l_fill_2_292 r0 *1 0,0
Xsg13cmos5l_fill_2_292 VPWR VGND sg13cmos5l_fill_2
* cell instance sg13cmos5l_fill_2_293 r0 *1 0,0
Xsg13cmos5l_fill_2_293 VPWR VGND sg13cmos5l_fill_2
* cell instance sg13cmos5l_fill_2_294 r0 *1 0,0
Xsg13cmos5l_fill_2_294 VPWR VGND sg13cmos5l_fill_2
* cell instance sg13cmos5l_fill_2_295 r0 *1 0,0
Xsg13cmos5l_fill_2_295 VPWR VGND sg13cmos5l_fill_2
* cell instance sg13cmos5l_fill_2_296 r0 *1 0,0
Xsg13cmos5l_fill_2_296 VPWR VGND sg13cmos5l_fill_2
* cell instance sg13cmos5l_fill_2_297 r0 *1 0,0
Xsg13cmos5l_fill_2_297 VPWR VGND sg13cmos5l_fill_2
* cell instance sg13cmos5l_fill_2_298 r0 *1 0,0
Xsg13cmos5l_fill_2_298 VPWR VGND sg13cmos5l_fill_2
* cell instance sg13cmos5l_fill_2_299 r0 *1 0,0
Xsg13cmos5l_fill_2_299 VPWR VGND sg13cmos5l_fill_2
* cell instance sg13cmos5l_fill_2_300 r0 *1 0,0
Xsg13cmos5l_fill_2_300 VPWR VGND sg13cmos5l_fill_2
* cell instance sg13cmos5l_fill_2_301 r0 *1 0,0
Xsg13cmos5l_fill_2_301 VPWR VGND sg13cmos5l_fill_2
* cell instance sg13cmos5l_fill_2_302 r0 *1 0,0
Xsg13cmos5l_fill_2_302 VPWR VGND sg13cmos5l_fill_2
* cell instance sg13cmos5l_fill_2_303 r0 *1 0,0
Xsg13cmos5l_fill_2_303 VPWR VGND sg13cmos5l_fill_2
* cell instance sg13cmos5l_fill_2_304 r0 *1 0,0
Xsg13cmos5l_fill_2_304 VPWR VGND sg13cmos5l_fill_2
* cell instance sg13cmos5l_fill_2_305 r0 *1 0,0
Xsg13cmos5l_fill_2_305 VPWR VGND sg13cmos5l_fill_2
* cell instance sg13cmos5l_fill_2_306 r0 *1 0,0
Xsg13cmos5l_fill_2_306 VPWR VGND sg13cmos5l_fill_2
* cell instance sg13cmos5l_fill_2_307 r0 *1 0,0
Xsg13cmos5l_fill_2_307 VPWR VGND sg13cmos5l_fill_2
* cell instance sg13cmos5l_fill_2_308 r0 *1 0,0
Xsg13cmos5l_fill_2_308 VPWR VGND sg13cmos5l_fill_2
* cell instance sg13cmos5l_fill_2_309 r0 *1 0,0
Xsg13cmos5l_fill_2_309 VPWR VGND sg13cmos5l_fill_2
* cell instance sg13cmos5l_fill_2_310 r0 *1 0,0
Xsg13cmos5l_fill_2_310 VPWR VGND sg13cmos5l_fill_2
* cell instance sg13cmos5l_fill_2_311 r0 *1 0,0
Xsg13cmos5l_fill_2_311 VPWR VGND sg13cmos5l_fill_2
* cell instance sg13cmos5l_fill_2_312 r0 *1 0,0
Xsg13cmos5l_fill_2_312 VPWR VGND sg13cmos5l_fill_2
* cell instance sg13cmos5l_fill_2_313 r0 *1 0,0
Xsg13cmos5l_fill_2_313 VPWR VGND sg13cmos5l_fill_2
* cell instance sg13cmos5l_fill_2_314 r0 *1 0,0
Xsg13cmos5l_fill_2_314 VPWR VGND sg13cmos5l_fill_2
* cell instance sg13cmos5l_fill_2_315 r0 *1 0,0
Xsg13cmos5l_fill_2_315 VPWR VGND sg13cmos5l_fill_2
* cell instance sg13cmos5l_fill_2_316 r0 *1 0,0
Xsg13cmos5l_fill_2_316 VPWR VGND sg13cmos5l_fill_2
* cell instance sg13cmos5l_fill_2_317 r0 *1 0,0
Xsg13cmos5l_fill_2_317 VPWR VGND sg13cmos5l_fill_2
* cell instance sg13cmos5l_fill_2_318 r0 *1 0,0
Xsg13cmos5l_fill_2_318 VPWR VGND sg13cmos5l_fill_2
* cell instance sg13cmos5l_fill_2_319 r0 *1 0,0
Xsg13cmos5l_fill_2_319 VPWR VGND sg13cmos5l_fill_2
* cell instance sg13cmos5l_fill_2_320 r0 *1 0,0
Xsg13cmos5l_fill_2_320 VPWR VGND sg13cmos5l_fill_2
* cell instance sg13cmos5l_fill_2_321 r0 *1 0,0
Xsg13cmos5l_fill_2_321 VPWR VGND sg13cmos5l_fill_2
* cell instance sg13cmos5l_fill_2_322 r0 *1 0,0
Xsg13cmos5l_fill_2_322 VPWR VGND sg13cmos5l_fill_2
* cell instance sg13cmos5l_fill_2_323 r0 *1 0,0
Xsg13cmos5l_fill_2_323 VPWR VGND sg13cmos5l_fill_2
* cell instance sg13cmos5l_fill_2_324 r0 *1 0,0
Xsg13cmos5l_fill_2_324 VPWR VGND sg13cmos5l_fill_2
* cell instance sg13cmos5l_fill_2_325 r0 *1 0,0
Xsg13cmos5l_fill_2_325 VPWR VGND sg13cmos5l_fill_2
* cell instance sg13cmos5l_fill_2_326 r0 *1 0,0
Xsg13cmos5l_fill_2_326 VPWR VGND sg13cmos5l_fill_2
* cell instance sg13cmos5l_fill_2_327 r0 *1 0,0
Xsg13cmos5l_fill_2_327 VPWR VGND sg13cmos5l_fill_2
* cell instance sg13cmos5l_fill_2_328 r0 *1 0,0
Xsg13cmos5l_fill_2_328 VPWR VGND sg13cmos5l_fill_2
* cell instance sg13cmos5l_fill_2_329 r0 *1 0,0
Xsg13cmos5l_fill_2_329 VPWR VGND sg13cmos5l_fill_2
* cell instance sg13cmos5l_fill_2_330 r0 *1 0,0
Xsg13cmos5l_fill_2_330 VPWR VGND sg13cmos5l_fill_2
* cell instance sg13cmos5l_fill_2_331 r0 *1 0,0
Xsg13cmos5l_fill_2_331 VPWR VGND sg13cmos5l_fill_2
* cell instance sg13cmos5l_fill_2_332 r0 *1 0,0
Xsg13cmos5l_fill_2_332 VPWR VGND sg13cmos5l_fill_2
* cell instance sg13cmos5l_fill_2_333 r0 *1 0,0
Xsg13cmos5l_fill_2_333 VPWR VGND sg13cmos5l_fill_2
* cell instance sg13cmos5l_fill_2_334 r0 *1 0,0
Xsg13cmos5l_fill_2_334 VPWR VGND sg13cmos5l_fill_2
* cell instance sg13cmos5l_fill_2_335 r0 *1 0,0
Xsg13cmos5l_fill_2_335 VPWR VGND sg13cmos5l_fill_2
* cell instance sg13cmos5l_fill_2_336 r0 *1 0,0
Xsg13cmos5l_fill_2_336 VPWR VGND sg13cmos5l_fill_2
* cell instance sg13cmos5l_fill_2_337 r0 *1 0,0
Xsg13cmos5l_fill_2_337 VPWR VGND sg13cmos5l_fill_2
* cell instance sg13cmos5l_fill_2_338 r0 *1 0,0
Xsg13cmos5l_fill_2_338 VPWR VGND sg13cmos5l_fill_2
* cell instance sg13cmos5l_fill_2_339 r0 *1 0,0
Xsg13cmos5l_fill_2_339 VPWR VGND sg13cmos5l_fill_2
* cell instance sg13cmos5l_fill_2_340 r0 *1 0,0
Xsg13cmos5l_fill_2_340 VPWR VGND sg13cmos5l_fill_2
* cell instance sg13cmos5l_fill_2_341 r0 *1 0,0
Xsg13cmos5l_fill_2_341 VPWR VGND sg13cmos5l_fill_2
* cell instance sg13cmos5l_fill_2_342 r0 *1 0,0
Xsg13cmos5l_fill_2_342 VPWR VGND sg13cmos5l_fill_2
* cell instance sg13cmos5l_fill_2_343 r0 *1 0,0
Xsg13cmos5l_fill_2_343 VPWR VGND sg13cmos5l_fill_2
* cell instance sg13cmos5l_fill_2_344 r0 *1 0,0
Xsg13cmos5l_fill_2_344 VPWR VGND sg13cmos5l_fill_2
* cell instance sg13cmos5l_fill_2_345 r0 *1 0,0
Xsg13cmos5l_fill_2_345 VPWR VGND sg13cmos5l_fill_2
* cell instance sg13cmos5l_fill_2_346 r0 *1 0,0
Xsg13cmos5l_fill_2_346 VPWR VGND sg13cmos5l_fill_2
* cell instance sg13cmos5l_fill_2_347 r0 *1 0,0
Xsg13cmos5l_fill_2_347 VPWR VGND sg13cmos5l_fill_2
* cell instance sg13cmos5l_fill_2_348 r0 *1 0,0
Xsg13cmos5l_fill_2_348 VPWR VGND sg13cmos5l_fill_2
* cell instance sg13cmos5l_fill_2_349 r0 *1 0,0
Xsg13cmos5l_fill_2_349 VPWR VGND sg13cmos5l_fill_2
* cell instance sg13cmos5l_fill_2_350 r0 *1 0,0
Xsg13cmos5l_fill_2_350 VPWR VGND sg13cmos5l_fill_2
* cell instance sg13cmos5l_fill_2_351 r0 *1 0,0
Xsg13cmos5l_fill_2_351 VPWR VGND sg13cmos5l_fill_2
* cell instance sg13cmos5l_fill_2_352 r0 *1 0,0
Xsg13cmos5l_fill_2_352 VPWR VGND sg13cmos5l_fill_2
* cell instance sg13cmos5l_fill_2_353 r0 *1 0,0
Xsg13cmos5l_fill_2_353 VPWR VGND sg13cmos5l_fill_2
* cell instance sg13cmos5l_fill_2_354 r0 *1 0,0
Xsg13cmos5l_fill_2_354 VPWR VGND sg13cmos5l_fill_2
* cell instance sg13cmos5l_fill_2_355 r0 *1 0,0
Xsg13cmos5l_fill_2_355 VPWR VGND sg13cmos5l_fill_2
* cell instance sg13cmos5l_fill_2_356 r0 *1 0,0
Xsg13cmos5l_fill_2_356 VPWR VGND sg13cmos5l_fill_2
* cell instance sg13cmos5l_fill_2_357 r0 *1 0,0
Xsg13cmos5l_fill_2_357 VPWR VGND sg13cmos5l_fill_2
* cell instance sg13cmos5l_fill_2_358 r0 *1 0,0
Xsg13cmos5l_fill_2_358 VPWR VGND sg13cmos5l_fill_2
* cell instance sg13cmos5l_fill_2_359 r0 *1 0,0
Xsg13cmos5l_fill_2_359 VPWR VGND sg13cmos5l_fill_2
* cell instance sg13cmos5l_fill_2_360 r0 *1 0,0
Xsg13cmos5l_fill_2_360 VPWR VGND sg13cmos5l_fill_2
* cell instance sg13cmos5l_fill_2_361 r0 *1 0,0
Xsg13cmos5l_fill_2_361 VPWR VGND sg13cmos5l_fill_2
* cell instance sg13cmos5l_fill_2_362 r0 *1 0,0
Xsg13cmos5l_fill_2_362 VPWR VGND sg13cmos5l_fill_2
* cell instance sg13cmos5l_fill_2_363 r0 *1 0,0
Xsg13cmos5l_fill_2_363 VPWR VGND sg13cmos5l_fill_2
* cell instance sg13cmos5l_fill_2_364 r0 *1 0,0
Xsg13cmos5l_fill_2_364 VPWR VGND sg13cmos5l_fill_2
* cell instance sg13cmos5l_fill_2_365 r0 *1 0,0
Xsg13cmos5l_fill_2_365 VPWR VGND sg13cmos5l_fill_2
* cell instance sg13cmos5l_fill_2_366 r0 *1 0,0
Xsg13cmos5l_fill_2_366 VPWR VGND sg13cmos5l_fill_2
* cell instance sg13cmos5l_fill_2_367 r0 *1 0,0
Xsg13cmos5l_fill_2_367 VPWR VGND sg13cmos5l_fill_2
* cell instance sg13cmos5l_fill_2_368 r0 *1 0,0
Xsg13cmos5l_fill_2_368 VPWR VGND sg13cmos5l_fill_2
* cell instance sg13cmos5l_fill_2_369 r0 *1 0,0
Xsg13cmos5l_fill_2_369 VPWR VGND sg13cmos5l_fill_2
* cell instance sg13cmos5l_fill_2_370 r0 *1 0,0
Xsg13cmos5l_fill_2_370 VPWR VGND sg13cmos5l_fill_2
* cell instance sg13cmos5l_fill_2_371 r0 *1 0,0
Xsg13cmos5l_fill_2_371 VPWR VGND sg13cmos5l_fill_2
* cell instance sg13cmos5l_fill_2_372 r0 *1 0,0
Xsg13cmos5l_fill_2_372 VPWR VGND sg13cmos5l_fill_2
* cell instance sg13cmos5l_fill_2_373 r0 *1 0,0
Xsg13cmos5l_fill_2_373 VPWR VGND sg13cmos5l_fill_2
* cell instance sg13cmos5l_fill_2_374 r0 *1 0,0
Xsg13cmos5l_fill_2_374 VPWR VGND sg13cmos5l_fill_2
* cell instance sg13cmos5l_fill_2_375 r0 *1 0,0
Xsg13cmos5l_fill_2_375 VPWR VGND sg13cmos5l_fill_2
* cell instance sg13cmos5l_fill_2_376 r0 *1 0,0
Xsg13cmos5l_fill_2_376 VPWR VGND sg13cmos5l_fill_2
* cell instance sg13cmos5l_fill_2_377 r0 *1 0,0
Xsg13cmos5l_fill_2_377 VPWR VGND sg13cmos5l_fill_2
* cell instance sg13cmos5l_fill_2_378 r0 *1 0,0
Xsg13cmos5l_fill_2_378 VPWR VGND sg13cmos5l_fill_2
* cell instance sg13cmos5l_fill_2_379 r0 *1 0,0
Xsg13cmos5l_fill_2_379 VPWR VGND sg13cmos5l_fill_2
* cell instance sg13cmos5l_fill_2_380 r0 *1 0,0
Xsg13cmos5l_fill_2_380 VPWR VGND sg13cmos5l_fill_2
* cell instance sg13cmos5l_fill_2_381 r0 *1 0,0
Xsg13cmos5l_fill_2_381 VPWR VGND sg13cmos5l_fill_2
* cell instance sg13cmos5l_fill_2_382 r0 *1 0,0
Xsg13cmos5l_fill_2_382 VPWR VGND sg13cmos5l_fill_2
* cell instance sg13cmos5l_fill_2_383 r0 *1 0,0
Xsg13cmos5l_fill_2_383 VPWR VGND sg13cmos5l_fill_2
* cell instance sg13cmos5l_fill_2_384 r0 *1 0,0
Xsg13cmos5l_fill_2_384 VPWR VGND sg13cmos5l_fill_2
* cell instance sg13cmos5l_fill_2_385 r0 *1 0,0
Xsg13cmos5l_fill_2_385 VPWR VGND sg13cmos5l_fill_2
* cell instance sg13cmos5l_fill_2_386 r0 *1 0,0
Xsg13cmos5l_fill_2_386 VPWR VGND sg13cmos5l_fill_2
* cell instance sg13cmos5l_fill_2_387 r0 *1 0,0
Xsg13cmos5l_fill_2_387 VPWR VGND sg13cmos5l_fill_2
* cell instance sg13cmos5l_fill_2_388 r0 *1 0,0
Xsg13cmos5l_fill_2_388 VPWR VGND sg13cmos5l_fill_2
* cell instance sg13cmos5l_fill_2_389 r0 *1 0,0
Xsg13cmos5l_fill_2_389 VPWR VGND sg13cmos5l_fill_2
* cell instance sg13cmos5l_fill_2_390 r0 *1 0,0
Xsg13cmos5l_fill_2_390 VPWR VGND sg13cmos5l_fill_2
* cell instance sg13cmos5l_fill_2_391 r0 *1 0,0
Xsg13cmos5l_fill_2_391 VPWR VGND sg13cmos5l_fill_2
* cell instance sg13cmos5l_fill_2_392 r0 *1 0,0
Xsg13cmos5l_fill_2_392 VPWR VGND sg13cmos5l_fill_2
* cell instance sg13cmos5l_fill_2_393 r0 *1 0,0
Xsg13cmos5l_fill_2_393 VPWR VGND sg13cmos5l_fill_2
* cell instance sg13cmos5l_fill_2_394 r0 *1 0,0
Xsg13cmos5l_fill_2_394 VPWR VGND sg13cmos5l_fill_2
* cell instance sg13cmos5l_fill_2_395 r0 *1 0,0
Xsg13cmos5l_fill_2_395 VPWR VGND sg13cmos5l_fill_2
* cell instance sg13cmos5l_fill_2_396 r0 *1 0,0
Xsg13cmos5l_fill_2_396 VPWR VGND sg13cmos5l_fill_2
* cell instance sg13cmos5l_fill_2_397 r0 *1 0,0
Xsg13cmos5l_fill_2_397 VPWR VGND sg13cmos5l_fill_2
* cell instance sg13cmos5l_fill_2_398 r0 *1 0,0
Xsg13cmos5l_fill_2_398 VPWR VGND sg13cmos5l_fill_2
* cell instance sg13cmos5l_fill_2_399 r0 *1 0,0
Xsg13cmos5l_fill_2_399 VPWR VGND sg13cmos5l_fill_2
* cell instance sg13cmos5l_fill_2_400 r0 *1 0,0
Xsg13cmos5l_fill_2_400 VPWR VGND sg13cmos5l_fill_2
* cell instance sg13cmos5l_fill_2_401 r0 *1 0,0
Xsg13cmos5l_fill_2_401 VPWR VGND sg13cmos5l_fill_2
* cell instance sg13cmos5l_fill_2_402 r0 *1 0,0
Xsg13cmos5l_fill_2_402 VPWR VGND sg13cmos5l_fill_2
* cell instance sg13cmos5l_fill_2_403 r0 *1 0,0
Xsg13cmos5l_fill_2_403 VPWR VGND sg13cmos5l_fill_2
* cell instance sg13cmos5l_fill_2_404 r0 *1 0,0
Xsg13cmos5l_fill_2_404 VPWR VGND sg13cmos5l_fill_2
* cell instance sg13cmos5l_fill_2_405 r0 *1 0,0
Xsg13cmos5l_fill_2_405 VPWR VGND sg13cmos5l_fill_2
* cell instance sg13cmos5l_fill_2_406 r0 *1 0,0
Xsg13cmos5l_fill_2_406 VPWR VGND sg13cmos5l_fill_2
* cell instance sg13cmos5l_fill_2_407 r0 *1 0,0
Xsg13cmos5l_fill_2_407 VPWR VGND sg13cmos5l_fill_2
* cell instance sg13cmos5l_fill_2_408 r0 *1 0,0
Xsg13cmos5l_fill_2_408 VPWR VGND sg13cmos5l_fill_2
* cell instance sg13cmos5l_fill_2_409 r0 *1 0,0
Xsg13cmos5l_fill_2_409 VPWR VGND sg13cmos5l_fill_2
* cell instance sg13cmos5l_fill_2_410 r0 *1 0,0
Xsg13cmos5l_fill_2_410 VPWR VGND sg13cmos5l_fill_2
* cell instance sg13cmos5l_fill_2_411 r0 *1 0,0
Xsg13cmos5l_fill_2_411 VPWR VGND sg13cmos5l_fill_2
* cell instance sg13cmos5l_fill_2_412 r0 *1 0,0
Xsg13cmos5l_fill_2_412 VPWR VGND sg13cmos5l_fill_2
* cell instance sg13cmos5l_fill_2_413 r0 *1 0,0
Xsg13cmos5l_fill_2_413 VPWR VGND sg13cmos5l_fill_2
* cell instance sg13cmos5l_fill_2_414 r0 *1 0,0
Xsg13cmos5l_fill_2_414 VPWR VGND sg13cmos5l_fill_2
* cell instance sg13cmos5l_fill_2_415 r0 *1 0,0
Xsg13cmos5l_fill_2_415 VPWR VGND sg13cmos5l_fill_2
* cell instance sg13cmos5l_fill_2_416 r0 *1 0,0
Xsg13cmos5l_fill_2_416 VPWR VGND sg13cmos5l_fill_2
* cell instance sg13cmos5l_fill_2_417 r0 *1 0,0
Xsg13cmos5l_fill_2_417 VPWR VGND sg13cmos5l_fill_2
* cell instance sg13cmos5l_fill_2_418 r0 *1 0,0
Xsg13cmos5l_fill_2_418 VPWR VGND sg13cmos5l_fill_2
* cell instance sg13cmos5l_fill_2_419 r0 *1 0,0
Xsg13cmos5l_fill_2_419 VPWR VGND sg13cmos5l_fill_2
* cell instance sg13cmos5l_fill_2_420 r0 *1 0,0
Xsg13cmos5l_fill_2_420 VPWR VGND sg13cmos5l_fill_2
* cell instance sg13cmos5l_fill_2_421 r0 *1 0,0
Xsg13cmos5l_fill_2_421 VPWR VGND sg13cmos5l_fill_2
* cell instance sg13cmos5l_fill_2_422 r0 *1 0,0
Xsg13cmos5l_fill_2_422 VPWR VGND sg13cmos5l_fill_2
* cell instance sg13cmos5l_fill_2_423 r0 *1 0,0
Xsg13cmos5l_fill_2_423 VPWR VGND sg13cmos5l_fill_2
* cell instance sg13cmos5l_fill_2_424 r0 *1 0,0
Xsg13cmos5l_fill_2_424 VPWR VGND sg13cmos5l_fill_2
* cell instance sg13cmos5l_fill_2_425 r0 *1 0,0
Xsg13cmos5l_fill_2_425 VPWR VGND sg13cmos5l_fill_2
* cell instance sg13cmos5l_fill_2_426 r0 *1 0,0
Xsg13cmos5l_fill_2_426 VPWR VGND sg13cmos5l_fill_2
* cell instance sg13cmos5l_fill_2_427 r0 *1 0,0
Xsg13cmos5l_fill_2_427 VPWR VGND sg13cmos5l_fill_2
* cell instance sg13cmos5l_fill_2_428 r0 *1 0,0
Xsg13cmos5l_fill_2_428 VPWR VGND sg13cmos5l_fill_2
* cell instance sg13cmos5l_fill_2_429 r0 *1 0,0
Xsg13cmos5l_fill_2_429 VPWR VGND sg13cmos5l_fill_2
* cell instance sg13cmos5l_fill_2_430 r0 *1 0,0
Xsg13cmos5l_fill_2_430 VPWR VGND sg13cmos5l_fill_2
* cell instance sg13cmos5l_fill_2_431 r0 *1 0,0
Xsg13cmos5l_fill_2_431 VPWR VGND sg13cmos5l_fill_2
* cell instance sg13cmos5l_fill_2_432 r0 *1 0,0
Xsg13cmos5l_fill_2_432 VPWR VGND sg13cmos5l_fill_2
* cell instance sg13cmos5l_fill_2_433 r0 *1 0,0
Xsg13cmos5l_fill_2_433 VPWR VGND sg13cmos5l_fill_2
* cell instance sg13cmos5l_fill_2_434 r0 *1 0,0
Xsg13cmos5l_fill_2_434 VPWR VGND sg13cmos5l_fill_2
* cell instance sg13cmos5l_fill_2_435 r0 *1 0,0
Xsg13cmos5l_fill_2_435 VPWR VGND sg13cmos5l_fill_2
* cell instance sg13cmos5l_fill_2_436 r0 *1 0,0
Xsg13cmos5l_fill_2_436 VPWR VGND sg13cmos5l_fill_2
* cell instance sg13cmos5l_fill_2_437 r0 *1 0,0
Xsg13cmos5l_fill_2_437 VPWR VGND sg13cmos5l_fill_2
* cell instance sg13cmos5l_fill_2_438 r0 *1 0,0
Xsg13cmos5l_fill_2_438 VPWR VGND sg13cmos5l_fill_2
* cell instance sg13cmos5l_fill_2_439 r0 *1 0,0
Xsg13cmos5l_fill_2_439 VPWR VGND sg13cmos5l_fill_2
* cell instance sg13cmos5l_fill_2_440 r0 *1 0,0
Xsg13cmos5l_fill_2_440 VPWR VGND sg13cmos5l_fill_2
* cell instance sg13cmos5l_fill_2_441 r0 *1 0,0
Xsg13cmos5l_fill_2_441 VPWR VGND sg13cmos5l_fill_2
* cell instance sg13cmos5l_fill_2_442 r0 *1 0,0
Xsg13cmos5l_fill_2_442 VPWR VGND sg13cmos5l_fill_2
* cell instance sg13cmos5l_fill_2_443 r0 *1 0,0
Xsg13cmos5l_fill_2_443 VPWR VGND sg13cmos5l_fill_2
* cell instance sg13cmos5l_fill_2_444 r0 *1 0,0
Xsg13cmos5l_fill_2_444 VPWR VGND sg13cmos5l_fill_2
* cell instance sg13cmos5l_fill_2_445 r0 *1 0,0
Xsg13cmos5l_fill_2_445 VPWR VGND sg13cmos5l_fill_2
* cell instance sg13cmos5l_fill_2_446 r0 *1 0,0
Xsg13cmos5l_fill_2_446 VPWR VGND sg13cmos5l_fill_2
* cell instance sg13cmos5l_fill_2_447 r0 *1 0,0
Xsg13cmos5l_fill_2_447 VPWR VGND sg13cmos5l_fill_2
* cell instance sg13cmos5l_fill_2_448 r0 *1 0,0
Xsg13cmos5l_fill_2_448 VPWR VGND sg13cmos5l_fill_2
* cell instance sg13cmos5l_fill_2_449 r0 *1 0,0
Xsg13cmos5l_fill_2_449 VPWR VGND sg13cmos5l_fill_2
* cell instance sg13cmos5l_fill_2_450 r0 *1 0,0
Xsg13cmos5l_fill_2_450 VPWR VGND sg13cmos5l_fill_2
* cell instance sg13cmos5l_fill_2_451 r0 *1 0,0
Xsg13cmos5l_fill_2_451 VPWR VGND sg13cmos5l_fill_2
* cell instance sg13cmos5l_fill_2_452 r0 *1 0,0
Xsg13cmos5l_fill_2_452 VPWR VGND sg13cmos5l_fill_2
* cell instance sg13cmos5l_fill_2_453 r0 *1 0,0
Xsg13cmos5l_fill_2_453 VPWR VGND sg13cmos5l_fill_2
* cell instance sg13cmos5l_fill_2_454 r0 *1 0,0
Xsg13cmos5l_fill_2_454 VPWR VGND sg13cmos5l_fill_2
* cell instance sg13cmos5l_fill_2_455 r0 *1 0,0
Xsg13cmos5l_fill_2_455 VPWR VGND sg13cmos5l_fill_2
* cell instance sg13cmos5l_fill_2_456 r0 *1 0,0
Xsg13cmos5l_fill_2_456 VPWR VGND sg13cmos5l_fill_2
* cell instance sg13cmos5l_fill_2_457 r0 *1 0,0
Xsg13cmos5l_fill_2_457 VPWR VGND sg13cmos5l_fill_2
* cell instance sg13cmos5l_fill_2_458 r0 *1 0,0
Xsg13cmos5l_fill_2_458 VPWR VGND sg13cmos5l_fill_2
* cell instance sg13cmos5l_fill_2_459 r0 *1 0,0
Xsg13cmos5l_fill_2_459 VPWR VGND sg13cmos5l_fill_2
* cell instance sg13cmos5l_fill_2_460 r0 *1 0,0
Xsg13cmos5l_fill_2_460 VPWR VGND sg13cmos5l_fill_2
* cell instance sg13cmos5l_fill_2_461 r0 *1 0,0
Xsg13cmos5l_fill_2_461 VPWR VGND sg13cmos5l_fill_2
* cell instance sg13cmos5l_fill_2_462 r0 *1 0,0
Xsg13cmos5l_fill_2_462 VPWR VGND sg13cmos5l_fill_2
* cell instance sg13cmos5l_fill_2_463 r0 *1 0,0
Xsg13cmos5l_fill_2_463 VPWR VGND sg13cmos5l_fill_2
* cell instance sg13cmos5l_fill_2_464 r0 *1 0,0
Xsg13cmos5l_fill_2_464 VPWR VGND sg13cmos5l_fill_2
* cell instance sg13cmos5l_fill_2_465 r0 *1 0,0
Xsg13cmos5l_fill_2_465 VPWR VGND sg13cmos5l_fill_2
* cell instance sg13cmos5l_fill_2_466 r0 *1 0,0
Xsg13cmos5l_fill_2_466 VPWR VGND sg13cmos5l_fill_2
* cell instance sg13cmos5l_fill_2_467 r0 *1 0,0
Xsg13cmos5l_fill_2_467 VPWR VGND sg13cmos5l_fill_2
* cell instance sg13cmos5l_fill_2_468 r0 *1 0,0
Xsg13cmos5l_fill_2_468 VPWR VGND sg13cmos5l_fill_2
* cell instance sg13cmos5l_fill_2_469 r0 *1 0,0
Xsg13cmos5l_fill_2_469 VPWR VGND sg13cmos5l_fill_2
* cell instance sg13cmos5l_fill_2_470 r0 *1 0,0
Xsg13cmos5l_fill_2_470 VPWR VGND sg13cmos5l_fill_2
* cell instance sg13cmos5l_fill_2_471 r0 *1 0,0
Xsg13cmos5l_fill_2_471 VPWR VGND sg13cmos5l_fill_2
* cell instance sg13cmos5l_fill_2_472 r0 *1 0,0
Xsg13cmos5l_fill_2_472 VPWR VGND sg13cmos5l_fill_2
* cell instance sg13cmos5l_fill_2_473 r0 *1 0,0
Xsg13cmos5l_fill_2_473 VPWR VGND sg13cmos5l_fill_2
* cell instance sg13cmos5l_fill_2_474 r0 *1 0,0
Xsg13cmos5l_fill_2_474 VPWR VGND sg13cmos5l_fill_2
* cell instance sg13cmos5l_fill_2_475 r0 *1 0,0
Xsg13cmos5l_fill_2_475 VPWR VGND sg13cmos5l_fill_2
* cell instance sg13cmos5l_fill_2_476 r0 *1 0,0
Xsg13cmos5l_fill_2_476 VPWR VGND sg13cmos5l_fill_2
* cell instance sg13cmos5l_fill_2_477 r0 *1 0,0
Xsg13cmos5l_fill_2_477 VPWR VGND sg13cmos5l_fill_2
* cell instance sg13cmos5l_fill_2_478 r0 *1 0,0
Xsg13cmos5l_fill_2_478 VPWR VGND sg13cmos5l_fill_2
* cell instance sg13cmos5l_fill_2_479 r0 *1 0,0
Xsg13cmos5l_fill_2_479 VPWR VGND sg13cmos5l_fill_2
* cell instance sg13cmos5l_fill_2_480 r0 *1 0,0
Xsg13cmos5l_fill_2_480 VPWR VGND sg13cmos5l_fill_2
* cell instance sg13cmos5l_fill_2_481 r0 *1 0,0
Xsg13cmos5l_fill_2_481 VPWR VGND sg13cmos5l_fill_2
* cell instance sg13cmos5l_fill_2_482 r0 *1 0,0
Xsg13cmos5l_fill_2_482 VPWR VGND sg13cmos5l_fill_2
* cell instance sg13cmos5l_fill_2_483 r0 *1 0,0
Xsg13cmos5l_fill_2_483 VPWR VGND sg13cmos5l_fill_2
* cell instance sg13cmos5l_fill_2_484 r0 *1 0,0
Xsg13cmos5l_fill_2_484 VPWR VGND sg13cmos5l_fill_2
* cell instance sg13cmos5l_fill_2_485 r0 *1 0,0
Xsg13cmos5l_fill_2_485 VPWR VGND sg13cmos5l_fill_2
* cell instance sg13cmos5l_fill_2_486 r0 *1 0,0
Xsg13cmos5l_fill_2_486 VPWR VGND sg13cmos5l_fill_2
* cell instance sg13cmos5l_fill_2_487 r0 *1 0,0
Xsg13cmos5l_fill_2_487 VPWR VGND sg13cmos5l_fill_2
* cell instance sg13cmos5l_fill_2_488 r0 *1 0,0
Xsg13cmos5l_fill_2_488 VPWR VGND sg13cmos5l_fill_2
* cell instance sg13cmos5l_fill_2_489 r0 *1 0,0
Xsg13cmos5l_fill_2_489 VPWR VGND sg13cmos5l_fill_2
* cell instance sg13cmos5l_fill_2_490 r0 *1 0,0
Xsg13cmos5l_fill_2_490 VPWR VGND sg13cmos5l_fill_2
* cell instance sg13cmos5l_fill_2_491 r0 *1 0,0
Xsg13cmos5l_fill_2_491 VPWR VGND sg13cmos5l_fill_2
* cell instance sg13cmos5l_fill_2_492 r0 *1 0,0
Xsg13cmos5l_fill_2_492 VPWR VGND sg13cmos5l_fill_2
* cell instance sg13cmos5l_fill_2_493 r0 *1 0,0
Xsg13cmos5l_fill_2_493 VPWR VGND sg13cmos5l_fill_2
* cell instance sg13cmos5l_fill_2_494 r0 *1 0,0
Xsg13cmos5l_fill_2_494 VPWR VGND sg13cmos5l_fill_2
* cell instance sg13cmos5l_fill_2_495 r0 *1 0,0
Xsg13cmos5l_fill_2_495 VPWR VGND sg13cmos5l_fill_2
* cell instance sg13cmos5l_fill_2_496 r0 *1 0,0
Xsg13cmos5l_fill_2_496 VPWR VGND sg13cmos5l_fill_2
* cell instance sg13cmos5l_fill_2_497 r0 *1 0,0
Xsg13cmos5l_fill_2_497 VPWR VGND sg13cmos5l_fill_2
* cell instance sg13cmos5l_fill_2_498 r0 *1 0,0
Xsg13cmos5l_fill_2_498 VPWR VGND sg13cmos5l_fill_2
* cell instance sg13cmos5l_fill_2_499 r0 *1 0,0
Xsg13cmos5l_fill_2_499 VPWR VGND sg13cmos5l_fill_2
* cell instance sg13cmos5l_fill_2_500 r0 *1 0,0
Xsg13cmos5l_fill_2_500 VPWR VGND sg13cmos5l_fill_2
* cell instance sg13cmos5l_fill_2_501 r0 *1 0,0
Xsg13cmos5l_fill_2_501 VPWR VGND sg13cmos5l_fill_2
* cell instance sg13cmos5l_fill_2_502 r0 *1 0,0
Xsg13cmos5l_fill_2_502 VPWR VGND sg13cmos5l_fill_2
* cell instance sg13cmos5l_fill_2_503 r0 *1 0,0
Xsg13cmos5l_fill_2_503 VPWR VGND sg13cmos5l_fill_2
* cell instance sg13cmos5l_fill_2_504 r0 *1 0,0
Xsg13cmos5l_fill_2_504 VPWR VGND sg13cmos5l_fill_2
* cell instance sg13cmos5l_fill_2_505 r0 *1 0,0
Xsg13cmos5l_fill_2_505 VPWR VGND sg13cmos5l_fill_2
* cell instance sg13cmos5l_fill_2_506 r0 *1 0,0
Xsg13cmos5l_fill_2_506 VPWR VGND sg13cmos5l_fill_2
* cell instance sg13cmos5l_fill_2_507 r0 *1 0,0
Xsg13cmos5l_fill_2_507 VPWR VGND sg13cmos5l_fill_2
* cell instance sg13cmos5l_fill_2_508 r0 *1 0,0
Xsg13cmos5l_fill_2_508 VPWR VGND sg13cmos5l_fill_2
* cell instance sg13cmos5l_fill_2_509 r0 *1 0,0
Xsg13cmos5l_fill_2_509 VPWR VGND sg13cmos5l_fill_2
* cell instance sg13cmos5l_fill_2_510 r0 *1 0,0
Xsg13cmos5l_fill_2_510 VPWR VGND sg13cmos5l_fill_2
* cell instance sg13cmos5l_fill_2_511 r0 *1 0,0
Xsg13cmos5l_fill_2_511 VPWR VGND sg13cmos5l_fill_2
* cell instance sg13cmos5l_fill_2_512 r0 *1 0,0
Xsg13cmos5l_fill_2_512 VPWR VGND sg13cmos5l_fill_2
* cell instance sg13cmos5l_fill_2_513 r0 *1 0,0
Xsg13cmos5l_fill_2_513 VPWR VGND sg13cmos5l_fill_2
* cell instance sg13cmos5l_fill_2_514 r0 *1 0,0
Xsg13cmos5l_fill_2_514 VPWR VGND sg13cmos5l_fill_2
* cell instance sg13cmos5l_fill_2_515 r0 *1 0,0
Xsg13cmos5l_fill_2_515 VPWR VGND sg13cmos5l_fill_2
* cell instance sg13cmos5l_fill_2_516 r0 *1 0,0
Xsg13cmos5l_fill_2_516 VPWR VGND sg13cmos5l_fill_2
* cell instance sg13cmos5l_fill_2_517 r0 *1 0,0
Xsg13cmos5l_fill_2_517 VPWR VGND sg13cmos5l_fill_2
* cell instance sg13cmos5l_fill_2_518 r0 *1 0,0
Xsg13cmos5l_fill_2_518 VPWR VGND sg13cmos5l_fill_2
* cell instance sg13cmos5l_fill_2_519 r0 *1 0,0
Xsg13cmos5l_fill_2_519 VPWR VGND sg13cmos5l_fill_2
* cell instance sg13cmos5l_fill_2_520 r0 *1 0,0
Xsg13cmos5l_fill_2_520 VPWR VGND sg13cmos5l_fill_2
* cell instance sg13cmos5l_fill_2_521 r0 *1 0,0
Xsg13cmos5l_fill_2_521 VPWR VGND sg13cmos5l_fill_2
* cell instance sg13cmos5l_fill_2_522 r0 *1 0,0
Xsg13cmos5l_fill_2_522 VPWR VGND sg13cmos5l_fill_2
* cell instance sg13cmos5l_fill_2_523 r0 *1 0,0
Xsg13cmos5l_fill_2_523 VPWR VGND sg13cmos5l_fill_2
* cell instance sg13cmos5l_fill_2_524 r0 *1 0,0
Xsg13cmos5l_fill_2_524 VPWR VGND sg13cmos5l_fill_2
* cell instance sg13cmos5l_fill_2_525 r0 *1 0,0
Xsg13cmos5l_fill_2_525 VPWR VGND sg13cmos5l_fill_2
* cell instance sg13cmos5l_fill_2_526 r0 *1 0,0
Xsg13cmos5l_fill_2_526 VPWR VGND sg13cmos5l_fill_2
* cell instance sg13cmos5l_fill_2_527 r0 *1 0,0
Xsg13cmos5l_fill_2_527 VPWR VGND sg13cmos5l_fill_2
* cell instance sg13cmos5l_fill_2_528 r0 *1 0,0
Xsg13cmos5l_fill_2_528 VPWR VGND sg13cmos5l_fill_2
* cell instance sg13cmos5l_fill_2_529 r0 *1 0,0
Xsg13cmos5l_fill_2_529 VPWR VGND sg13cmos5l_fill_2
* cell instance sg13cmos5l_fill_2_530 r0 *1 0,0
Xsg13cmos5l_fill_2_530 VPWR VGND sg13cmos5l_fill_2
* cell instance sg13cmos5l_fill_2_531 r0 *1 0,0
Xsg13cmos5l_fill_2_531 VPWR VGND sg13cmos5l_fill_2
* cell instance sg13cmos5l_fill_2_532 r0 *1 0,0
Xsg13cmos5l_fill_2_532 VPWR VGND sg13cmos5l_fill_2
* cell instance sg13cmos5l_fill_2_533 r0 *1 0,0
Xsg13cmos5l_fill_2_533 VPWR VGND sg13cmos5l_fill_2
* cell instance sg13cmos5l_fill_2_534 r0 *1 0,0
Xsg13cmos5l_fill_2_534 VPWR VGND sg13cmos5l_fill_2
* cell instance sg13cmos5l_fill_2_535 r0 *1 0,0
Xsg13cmos5l_fill_2_535 VPWR VGND sg13cmos5l_fill_2
* cell instance sg13cmos5l_fill_2_536 r0 *1 0,0
Xsg13cmos5l_fill_2_536 VPWR VGND sg13cmos5l_fill_2
* cell instance sg13cmos5l_fill_2_537 r0 *1 0,0
Xsg13cmos5l_fill_2_537 VPWR VGND sg13cmos5l_fill_2
* cell instance sg13cmos5l_fill_2_538 r0 *1 0,0
Xsg13cmos5l_fill_2_538 VPWR VGND sg13cmos5l_fill_2
* cell instance sg13cmos5l_fill_2_539 r0 *1 0,0
Xsg13cmos5l_fill_2_539 VPWR VGND sg13cmos5l_fill_2
* cell instance sg13cmos5l_fill_2_540 r0 *1 0,0
Xsg13cmos5l_fill_2_540 VPWR VGND sg13cmos5l_fill_2
* cell instance sg13cmos5l_fill_2_541 r0 *1 0,0
Xsg13cmos5l_fill_2_541 VPWR VGND sg13cmos5l_fill_2
* cell instance sg13cmos5l_fill_2_542 r0 *1 0,0
Xsg13cmos5l_fill_2_542 VPWR VGND sg13cmos5l_fill_2
* cell instance sg13cmos5l_fill_2_543 r0 *1 0,0
Xsg13cmos5l_fill_2_543 VPWR VGND sg13cmos5l_fill_2
* cell instance sg13cmos5l_fill_2_544 r0 *1 0,0
Xsg13cmos5l_fill_2_544 VPWR VGND sg13cmos5l_fill_2
* cell instance sg13cmos5l_fill_2_545 r0 *1 0,0
Xsg13cmos5l_fill_2_545 VPWR VGND sg13cmos5l_fill_2
* cell instance sg13cmos5l_fill_2_546 r0 *1 0,0
Xsg13cmos5l_fill_2_546 VPWR VGND sg13cmos5l_fill_2
* cell instance sg13cmos5l_fill_2_547 r0 *1 0,0
Xsg13cmos5l_fill_2_547 VPWR VGND sg13cmos5l_fill_2
* cell instance sg13cmos5l_fill_2_548 r0 *1 0,0
Xsg13cmos5l_fill_2_548 VPWR VGND sg13cmos5l_fill_2
* cell instance sg13cmos5l_fill_2_549 r0 *1 0,0
Xsg13cmos5l_fill_2_549 VPWR VGND sg13cmos5l_fill_2
* cell instance sg13cmos5l_fill_2_550 r0 *1 0,0
Xsg13cmos5l_fill_2_550 VPWR VGND sg13cmos5l_fill_2
* cell instance sg13cmos5l_fill_2_551 r0 *1 0,0
Xsg13cmos5l_fill_2_551 VPWR VGND sg13cmos5l_fill_2
* cell instance sg13cmos5l_fill_2_552 r0 *1 0,0
Xsg13cmos5l_fill_2_552 VPWR VGND sg13cmos5l_fill_2
* cell instance sg13cmos5l_fill_2_553 r0 *1 0,0
Xsg13cmos5l_fill_2_553 VPWR VGND sg13cmos5l_fill_2
* cell instance sg13cmos5l_fill_2_554 r0 *1 0,0
Xsg13cmos5l_fill_2_554 VPWR VGND sg13cmos5l_fill_2
* cell instance sg13cmos5l_fill_2_555 r0 *1 0,0
Xsg13cmos5l_fill_2_555 VPWR VGND sg13cmos5l_fill_2
* cell instance sg13cmos5l_fill_2_556 r0 *1 0,0
Xsg13cmos5l_fill_2_556 VPWR VGND sg13cmos5l_fill_2
* cell instance sg13cmos5l_fill_2_557 r0 *1 0,0
Xsg13cmos5l_fill_2_557 VPWR VGND sg13cmos5l_fill_2
* cell instance sg13cmos5l_fill_2_558 r0 *1 0,0
Xsg13cmos5l_fill_2_558 VPWR VGND sg13cmos5l_fill_2
* cell instance sg13cmos5l_fill_2_559 r0 *1 0,0
Xsg13cmos5l_fill_2_559 VPWR VGND sg13cmos5l_fill_2
* cell instance sg13cmos5l_fill_2_560 r0 *1 0,0
Xsg13cmos5l_fill_2_560 VPWR VGND sg13cmos5l_fill_2
* cell instance sg13cmos5l_fill_2_561 r0 *1 0,0
Xsg13cmos5l_fill_2_561 VPWR VGND sg13cmos5l_fill_2
* cell instance sg13cmos5l_fill_2_562 r0 *1 0,0
Xsg13cmos5l_fill_2_562 VPWR VGND sg13cmos5l_fill_2
* cell instance sg13cmos5l_fill_2_563 r0 *1 0,0
Xsg13cmos5l_fill_2_563 VPWR VGND sg13cmos5l_fill_2
* cell instance sg13cmos5l_fill_2_564 r0 *1 0,0
Xsg13cmos5l_fill_2_564 VPWR VGND sg13cmos5l_fill_2
* cell instance sg13cmos5l_fill_2_565 r0 *1 0,0
Xsg13cmos5l_fill_2_565 VPWR VGND sg13cmos5l_fill_2
* cell instance sg13cmos5l_fill_2_566 r0 *1 0,0
Xsg13cmos5l_fill_2_566 VPWR VGND sg13cmos5l_fill_2
* cell instance sg13cmos5l_fill_2_567 r0 *1 0,0
Xsg13cmos5l_fill_2_567 VPWR VGND sg13cmos5l_fill_2
* cell instance sg13cmos5l_fill_2_568 r0 *1 0,0
Xsg13cmos5l_fill_2_568 VPWR VGND sg13cmos5l_fill_2
* cell instance sg13cmos5l_fill_2_569 r0 *1 0,0
Xsg13cmos5l_fill_2_569 VPWR VGND sg13cmos5l_fill_2
* cell instance sg13cmos5l_fill_2_570 r0 *1 0,0
Xsg13cmos5l_fill_2_570 VPWR VGND sg13cmos5l_fill_2
* cell instance sg13cmos5l_fill_2_571 r0 *1 0,0
Xsg13cmos5l_fill_2_571 VPWR VGND sg13cmos5l_fill_2
* cell instance sg13cmos5l_fill_2_572 r0 *1 0,0
Xsg13cmos5l_fill_2_572 VPWR VGND sg13cmos5l_fill_2
* cell instance sg13cmos5l_fill_2_573 r0 *1 0,0
Xsg13cmos5l_fill_2_573 VPWR VGND sg13cmos5l_fill_2
* cell instance sg13cmos5l_fill_2_574 r0 *1 0,0
Xsg13cmos5l_fill_2_574 VPWR VGND sg13cmos5l_fill_2
* cell instance sg13cmos5l_fill_2_575 r0 *1 0,0
Xsg13cmos5l_fill_2_575 VPWR VGND sg13cmos5l_fill_2
* cell instance sg13cmos5l_fill_2_576 r0 *1 0,0
Xsg13cmos5l_fill_2_576 VPWR VGND sg13cmos5l_fill_2
* cell instance sg13cmos5l_fill_2_577 r0 *1 0,0
Xsg13cmos5l_fill_2_577 VPWR VGND sg13cmos5l_fill_2
* cell instance sg13cmos5l_fill_2_578 r0 *1 0,0
Xsg13cmos5l_fill_2_578 VPWR VGND sg13cmos5l_fill_2
* cell instance sg13cmos5l_fill_2_579 r0 *1 0,0
Xsg13cmos5l_fill_2_579 VPWR VGND sg13cmos5l_fill_2
* cell instance sg13cmos5l_fill_2_580 r0 *1 0,0
Xsg13cmos5l_fill_2_580 VPWR VGND sg13cmos5l_fill_2
* cell instance sg13cmos5l_fill_2_581 r0 *1 0,0
Xsg13cmos5l_fill_2_581 VPWR VGND sg13cmos5l_fill_2
* cell instance sg13cmos5l_fill_2_582 r0 *1 0,0
Xsg13cmos5l_fill_2_582 VPWR VGND sg13cmos5l_fill_2
* cell instance sg13cmos5l_fill_2_583 r0 *1 0,0
Xsg13cmos5l_fill_2_583 VPWR VGND sg13cmos5l_fill_2
* cell instance sg13cmos5l_fill_2_584 r0 *1 0,0
Xsg13cmos5l_fill_2_584 VPWR VGND sg13cmos5l_fill_2
* cell instance sg13cmos5l_fill_2_585 r0 *1 0,0
Xsg13cmos5l_fill_2_585 VPWR VGND sg13cmos5l_fill_2
* cell instance sg13cmos5l_fill_2_586 r0 *1 0,0
Xsg13cmos5l_fill_2_586 VPWR VGND sg13cmos5l_fill_2
* cell instance sg13cmos5l_fill_2_587 r0 *1 0,0
Xsg13cmos5l_fill_2_587 VPWR VGND sg13cmos5l_fill_2
* cell instance sg13cmos5l_fill_2_588 r0 *1 0,0
Xsg13cmos5l_fill_2_588 VPWR VGND sg13cmos5l_fill_2
* cell instance sg13cmos5l_fill_2_589 r0 *1 0,0
Xsg13cmos5l_fill_2_589 VPWR VGND sg13cmos5l_fill_2
* cell instance sg13cmos5l_fill_2_590 r0 *1 0,0
Xsg13cmos5l_fill_2_590 VPWR VGND sg13cmos5l_fill_2
* cell instance sg13cmos5l_fill_2_591 r0 *1 0,0
Xsg13cmos5l_fill_2_591 VPWR VGND sg13cmos5l_fill_2
* cell instance sg13cmos5l_fill_2_592 r0 *1 0,0
Xsg13cmos5l_fill_2_592 VPWR VGND sg13cmos5l_fill_2
* cell instance sg13cmos5l_fill_2_593 r0 *1 0,0
Xsg13cmos5l_fill_2_593 VPWR VGND sg13cmos5l_fill_2
* cell instance sg13cmos5l_fill_2_594 r0 *1 0,0
Xsg13cmos5l_fill_2_594 VPWR VGND sg13cmos5l_fill_2
* cell instance sg13cmos5l_fill_2_595 r0 *1 0,0
Xsg13cmos5l_fill_2_595 VPWR VGND sg13cmos5l_fill_2
* cell instance sg13cmos5l_fill_2_596 r0 *1 0,0
Xsg13cmos5l_fill_2_596 VPWR VGND sg13cmos5l_fill_2
* cell instance sg13cmos5l_fill_2_597 r0 *1 0,0
Xsg13cmos5l_fill_2_597 VPWR VGND sg13cmos5l_fill_2
* cell instance sg13cmos5l_fill_2_598 r0 *1 0,0
Xsg13cmos5l_fill_2_598 VPWR VGND sg13cmos5l_fill_2
* cell instance sg13cmos5l_fill_2_599 r0 *1 0,0
Xsg13cmos5l_fill_2_599 VPWR VGND sg13cmos5l_fill_2
* cell instance sg13cmos5l_fill_2_600 r0 *1 0,0
Xsg13cmos5l_fill_2_600 VPWR VGND sg13cmos5l_fill_2
* cell instance sg13cmos5l_fill_2_601 r0 *1 0,0
Xsg13cmos5l_fill_2_601 VPWR VGND sg13cmos5l_fill_2
* cell instance sg13cmos5l_fill_2_602 r0 *1 0,0
Xsg13cmos5l_fill_2_602 VPWR VGND sg13cmos5l_fill_2
* cell instance sg13cmos5l_fill_2_603 r0 *1 0,0
Xsg13cmos5l_fill_2_603 VPWR VGND sg13cmos5l_fill_2
* cell instance sg13cmos5l_fill_2_604 r0 *1 0,0
Xsg13cmos5l_fill_2_604 VPWR VGND sg13cmos5l_fill_2
* cell instance sg13cmos5l_fill_2_605 r0 *1 0,0
Xsg13cmos5l_fill_2_605 VPWR VGND sg13cmos5l_fill_2
* cell instance sg13cmos5l_fill_2_606 r0 *1 0,0
Xsg13cmos5l_fill_2_606 VPWR VGND sg13cmos5l_fill_2
* cell instance sg13cmos5l_fill_2_607 r0 *1 0,0
Xsg13cmos5l_fill_2_607 VPWR VGND sg13cmos5l_fill_2
* cell instance sg13cmos5l_fill_2_608 r0 *1 0,0
Xsg13cmos5l_fill_2_608 VPWR VGND sg13cmos5l_fill_2
* cell instance sg13cmos5l_fill_2_609 r0 *1 0,0
Xsg13cmos5l_fill_2_609 VPWR VGND sg13cmos5l_fill_2
* cell instance sg13cmos5l_fill_2_610 r0 *1 0,0
Xsg13cmos5l_fill_2_610 VPWR VGND sg13cmos5l_fill_2
* cell instance sg13cmos5l_fill_2_611 r0 *1 0,0
Xsg13cmos5l_fill_2_611 VPWR VGND sg13cmos5l_fill_2
* cell instance sg13cmos5l_fill_2_612 r0 *1 0,0
Xsg13cmos5l_fill_2_612 VPWR VGND sg13cmos5l_fill_2
* cell instance sg13cmos5l_fill_2_613 r0 *1 0,0
Xsg13cmos5l_fill_2_613 VPWR VGND sg13cmos5l_fill_2
* cell instance sg13cmos5l_fill_2_614 r0 *1 0,0
Xsg13cmos5l_fill_2_614 VPWR VGND sg13cmos5l_fill_2
* cell instance sg13cmos5l_fill_2_615 r0 *1 0,0
Xsg13cmos5l_fill_2_615 VPWR VGND sg13cmos5l_fill_2
* cell instance sg13cmos5l_fill_2_616 r0 *1 0,0
Xsg13cmos5l_fill_2_616 VPWR VGND sg13cmos5l_fill_2
* cell instance sg13cmos5l_fill_2_617 r0 *1 0,0
Xsg13cmos5l_fill_2_617 VPWR VGND sg13cmos5l_fill_2
* cell instance sg13cmos5l_fill_2_618 r0 *1 0,0
Xsg13cmos5l_fill_2_618 VPWR VGND sg13cmos5l_fill_2
* cell instance sg13cmos5l_fill_2_619 r0 *1 0,0
Xsg13cmos5l_fill_2_619 VPWR VGND sg13cmos5l_fill_2
* cell instance sg13cmos5l_fill_2_620 r0 *1 0,0
Xsg13cmos5l_fill_2_620 VPWR VGND sg13cmos5l_fill_2
* cell instance sg13cmos5l_fill_2_621 r0 *1 0,0
Xsg13cmos5l_fill_2_621 VPWR VGND sg13cmos5l_fill_2
* cell instance sg13cmos5l_fill_2_622 r0 *1 0,0
Xsg13cmos5l_fill_2_622 VPWR VGND sg13cmos5l_fill_2
* cell instance sg13cmos5l_fill_2_623 r0 *1 0,0
Xsg13cmos5l_fill_2_623 VPWR VGND sg13cmos5l_fill_2
* cell instance sg13cmos5l_fill_2_624 r0 *1 0,0
Xsg13cmos5l_fill_2_624 VPWR VGND sg13cmos5l_fill_2
* cell instance sg13cmos5l_fill_2_625 r0 *1 0,0
Xsg13cmos5l_fill_2_625 VPWR VGND sg13cmos5l_fill_2
* cell instance sg13cmos5l_inv_1_0 r0 *1 0,0
Xsg13cmos5l_inv_1_0 \$2753 VPWR VGND \$3610 sg13cmos5l_inv_1
* cell instance sg13cmos5l_inv_1_1 r0 *1 0,0
Xsg13cmos5l_inv_1_1 \$6625 VPWR VGND \$6626 sg13cmos5l_inv_1
* cell instance sg13cmos5l_inv_1_2 r0 *1 0,0
Xsg13cmos5l_inv_1_2 \$5862 VPWR VGND \$5865 sg13cmos5l_inv_1
* cell instance sg13cmos5l_inv_1_3 r0 *1 0,0
Xsg13cmos5l_inv_1_3 \$1012 VPWR VGND \$1013 sg13cmos5l_inv_1
* cell instance sg13cmos5l_inv_1_4 r0 *1 0,0
Xsg13cmos5l_inv_1_4 \$2405 VPWR VGND \$2598 sg13cmos5l_inv_1
* cell instance sg13cmos5l_inv_1_5 r0 *1 0,0
Xsg13cmos5l_inv_1_5 \$7232 VPWR VGND \$8846 sg13cmos5l_inv_1
* cell instance sg13cmos5l_inv_1_6 r0 *1 0,0
Xsg13cmos5l_inv_1_6 \$7282 VPWR VGND \$7204 sg13cmos5l_inv_1
* cell instance sg13cmos5l_inv_1_7 r0 *1 0,0
Xsg13cmos5l_inv_1_7 \$645 VPWR VGND \$899 sg13cmos5l_inv_1
* cell instance sg13cmos5l_inv_1_8 r0 *1 0,0
Xsg13cmos5l_inv_1_8 \$1894 VPWR VGND \$1895 sg13cmos5l_inv_1
* cell instance sg13cmos5l_inv_1_9 r0 *1 0,0
Xsg13cmos5l_inv_1_9 \$3811 VPWR VGND \$3123 sg13cmos5l_inv_1
* cell instance sg13cmos5l_inv_1_10 r0 *1 0,0
Xsg13cmos5l_inv_1_10 \$12305 VPWR VGND \$13329 sg13cmos5l_inv_1
* cell instance sg13cmos5l_inv_1_11 r0 *1 0,0
Xsg13cmos5l_inv_1_11 \$3127 VPWR VGND \$2898 sg13cmos5l_inv_1
* cell instance sg13cmos5l_inv_1_12 r0 *1 0,0
Xsg13cmos5l_inv_1_12 \$3813 VPWR VGND \$3812 sg13cmos5l_inv_1
* cell instance sg13cmos5l_inv_1_13 r0 *1 0,0
Xsg13cmos5l_inv_1_13 \$10517 VPWR VGND \$10874 sg13cmos5l_inv_1
* cell instance sg13cmos5l_inv_1_14 r0 *1 0,0
Xsg13cmos5l_inv_1_14 \$1101 VPWR VGND \$2269 sg13cmos5l_inv_1
* cell instance sg13cmos5l_inv_1_15 r0 *1 0,0
Xsg13cmos5l_inv_1_15 \$5031 VPWR VGND \$5011 sg13cmos5l_inv_1
* cell instance sg13cmos5l_inv_1_16 r0 *1 0,0
Xsg13cmos5l_inv_1_16 \$1089 VPWR VGND \$1031 sg13cmos5l_inv_1
* cell instance sg13cmos5l_inv_1_17 r0 *1 0,0
Xsg13cmos5l_inv_1_17 \$3962 VPWR VGND \$1585 sg13cmos5l_inv_1
* cell instance sg13cmos5l_inv_1_18 r0 *1 0,0
Xsg13cmos5l_inv_1_18 \$1250 VPWR VGND \$3968 sg13cmos5l_inv_1
* cell instance sg13cmos5l_inv_1_19 r0 *1 0,0
Xsg13cmos5l_inv_1_19 \$11554 VPWR VGND \$14379 sg13cmos5l_inv_1
* cell instance sg13cmos5l_inv_1_20 r0 *1 0,0
Xsg13cmos5l_inv_1_20 \$686 VPWR VGND \$796 sg13cmos5l_inv_1
* cell instance sg13cmos5l_inv_1_21 r0 *1 0,0
Xsg13cmos5l_inv_1_21 \$10958 VPWR VGND \$3488 sg13cmos5l_inv_1
* cell instance sg13cmos5l_inv_1_22 r0 *1 0,0
Xsg13cmos5l_inv_1_22 \$1135 VPWR VGND \$945 sg13cmos5l_inv_1
* cell instance sg13cmos5l_inv_1_23 r0 *1 0,0
Xsg13cmos5l_inv_1_23 \$12001 VPWR VGND \$11929 sg13cmos5l_inv_1
* cell instance sg13cmos5l_inv_1_24 r0 *1 0,0
Xsg13cmos5l_inv_1_24 \$405 VPWR VGND \$320 sg13cmos5l_inv_1
* cell instance sg13cmos5l_inv_1_25 r0 *1 0,0
Xsg13cmos5l_inv_1_25 \$1796 VPWR VGND \$2160 sg13cmos5l_inv_1
* cell instance sg13cmos5l_inv_1_26 r0 *1 0,0
Xsg13cmos5l_inv_1_26 \$1799 VPWR VGND \$1887 sg13cmos5l_inv_1
* cell instance sg13cmos5l_inv_1_27 r0 *1 0,0
Xsg13cmos5l_inv_1_27 \$923 VPWR VGND \$1036 sg13cmos5l_inv_1
* cell instance sg13cmos5l_inv_1_28 r0 *1 0,0
Xsg13cmos5l_inv_1_28 \$687 VPWR VGND \$1917 sg13cmos5l_inv_1
* cell instance sg13cmos5l_inv_1_29 r0 *1 0,0
Xsg13cmos5l_inv_1_29 \$632 VPWR VGND \$690 sg13cmos5l_inv_1
* cell instance sg13cmos5l_inv_1_30 r0 *1 0,0
Xsg13cmos5l_inv_1_30 \$332 VPWR VGND \$333 sg13cmos5l_inv_1
* cell instance sg13cmos5l_inv_1_31 r0 *1 0,0
Xsg13cmos5l_inv_1_31 \$701 VPWR VGND \$934 sg13cmos5l_inv_1
* cell instance sg13cmos5l_inv_1_32 r0 *1 0,0
Xsg13cmos5l_inv_1_32 \$2038 VPWR VGND \$2176 sg13cmos5l_inv_1
* cell instance sg13cmos5l_inv_1_33 r0 *1 0,0
Xsg13cmos5l_inv_1_33 \$1151 VPWR VGND \$1045 sg13cmos5l_inv_1
* cell instance sg13cmos5l_inv_1_34 r0 *1 0,0
Xsg13cmos5l_inv_1_34 \$1155 VPWR VGND \$1245 sg13cmos5l_inv_1
* cell instance sg13cmos5l_inv_1_35 r0 *1 0,0
Xsg13cmos5l_inv_1_35 \$1368 VPWR VGND \$1485 sg13cmos5l_inv_1
* cell instance sg13cmos5l_inv_1_36 r0 *1 0,0
Xsg13cmos5l_inv_1_36 \$38 VPWR VGND \$101 sg13cmos5l_inv_1
* cell instance sg13cmos5l_inv_1_37 r0 *1 0,0
Xsg13cmos5l_inv_1_37 \$1815 VPWR VGND \$1816 sg13cmos5l_inv_1
* cell instance sg13cmos5l_inv_1_38 r0 *1 0,0
Xsg13cmos5l_inv_1_38 \$2301 VPWR VGND \$3148 sg13cmos5l_inv_1
* cell instance sg13cmos5l_inv_1_39 r0 *1 0,0
Xsg13cmos5l_inv_1_39 \$719 VPWR VGND \$720 sg13cmos5l_inv_1
* cell instance sg13cmos5l_inv_1_40 r0 *1 0,0
Xsg13cmos5l_inv_1_40 \$31 VPWR VGND \$1 sg13cmos5l_inv_1
* cell instance sg13cmos5l_inv_1_41 r0 *1 0,0
Xsg13cmos5l_inv_1_41 \$33 VPWR VGND \$34 sg13cmos5l_inv_1
* cell instance sg13cmos5l_inv_1_42 r0 *1 0,0
Xsg13cmos5l_inv_1_42 \$2769 VPWR VGND \$2200 sg13cmos5l_inv_1
* cell instance sg13cmos5l_inv_1_43 r0 *1 0,0
Xsg13cmos5l_inv_1_43 \$1822 VPWR VGND \$2182 sg13cmos5l_inv_1
* cell instance sg13cmos5l_inv_1_44 r0 *1 0,0
Xsg13cmos5l_inv_1_44 \$3353 VPWR VGND \$3522 sg13cmos5l_inv_1
* cell instance sg13cmos5l_inv_1_45 r0 *1 0,0
Xsg13cmos5l_inv_1_45 \$2096 VPWR VGND \$2485 sg13cmos5l_inv_1
* cell instance sg13cmos5l_inv_1_46 r0 *1 0,0
Xsg13cmos5l_inv_1_46 \$3400 VPWR VGND \$3563 sg13cmos5l_inv_1
* cell instance sg13cmos5l_inv_1_47 r0 *1 0,0
Xsg13cmos5l_inv_1_47 \$3234 VPWR VGND \$3741 sg13cmos5l_inv_1
* cell instance sg13cmos5l_inv_1_48 r0 *1 0,0
Xsg13cmos5l_inv_1_48 \$2883 VPWR VGND \$3250 sg13cmos5l_inv_1
* cell instance sg13cmos5l_inv_1_49 r0 *1 0,0
Xsg13cmos5l_inv_1_49 \$2546 VPWR VGND \$2547 sg13cmos5l_inv_1
* cell instance sg13cmos5l_inv_1_50 r0 *1 0,0
Xsg13cmos5l_inv_1_50 \$2880 VPWR VGND \$2548 sg13cmos5l_inv_1
* cell instance sg13cmos5l_inv_1_51 r0 *1 0,0
Xsg13cmos5l_inv_1_51 \$2392 VPWR VGND \$2393 sg13cmos5l_inv_1
* cell instance sg13cmos5l_inv_1_52 r0 *1 0,0
Xsg13cmos5l_inv_1_52 \$2740 VPWR VGND \$2735 sg13cmos5l_inv_1
* cell instance sg13cmos5l_inv_1_53 r0 *1 0,0
Xsg13cmos5l_inv_1_53 \$2888 VPWR VGND \$2885 sg13cmos5l_inv_1
* cell instance sg13cmos5l_inv_1_54 r0 *1 0,0
Xsg13cmos5l_inv_1_54 \$331 VPWR VGND \$2126 sg13cmos5l_inv_1
* cell instance sg13cmos5l_inv_1_55 r0 *1 0,0
Xsg13cmos5l_inv_1_55 \$146 VPWR VGND \$12 sg13cmos5l_inv_1
* cell instance sg13cmos5l_mux2_1_0 r0 *1 0,0
Xsg13cmos5l_mux2_1_0 \$5350 \$4450 \$5413 VPWR VGND \$5351 sg13cmos5l_mux2_1
* cell instance sg13cmos5l_mux2_1_1 r0 *1 0,0
Xsg13cmos5l_mux2_1_1 \$7408 \$2135 \$4972 VPWR VGND \$7338 sg13cmos5l_mux2_1
* cell instance sg13cmos5l_mux2_1_2 r0 *1 0,0
Xsg13cmos5l_mux2_1_2 \$9412 \$4991 \$5413 VPWR VGND \$8396 sg13cmos5l_mux2_1
* cell instance sg13cmos5l_mux2_1_3 r0 *1 0,0
Xsg13cmos5l_mux2_1_3 \$4970 \$4450 \$4972 VPWR VGND \$4961 sg13cmos5l_mux2_1
* cell instance sg13cmos5l_mux2_1_4 r0 *1 0,0
Xsg13cmos5l_mux2_1_4 \$5045 \$4450 \$5760 VPWR VGND \$5042 sg13cmos5l_mux2_1
* cell instance sg13cmos5l_mux2_1_5 r0 *1 0,0
Xsg13cmos5l_mux2_1_5 \$7154 \$2135 \$5413 VPWR VGND \$7171 sg13cmos5l_mux2_1
* cell instance sg13cmos5l_mux2_1_6 r0 *1 0,0
Xsg13cmos5l_mux2_1_6 \$10328 \$4991 \$4972 VPWR VGND \$9421 sg13cmos5l_mux2_1
* cell instance sg13cmos5l_mux2_1_7 r0 *1 0,0
Xsg13cmos5l_mux2_1_7 \$10512 \$4991 \$5760 VPWR VGND \$10331 sg13cmos5l_mux2_1
* cell instance sg13cmos5l_mux2_1_8 r0 *1 0,0
Xsg13cmos5l_mux2_1_8 \$6857 \$4995 \$4972 VPWR VGND \$6856 sg13cmos5l_mux2_1
* cell instance sg13cmos5l_mux2_1_9 r0 *1 0,0
Xsg13cmos5l_mux2_1_9 \$5598 \$5597 \$4972 VPWR VGND \$5596 sg13cmos5l_mux2_1
* cell instance sg13cmos5l_mux2_1_10 r0 *1 0,0
Xsg13cmos5l_mux2_1_10 \$6079 \$5597 \$5760 VPWR VGND \$6011 sg13cmos5l_mux2_1
* cell instance sg13cmos5l_mux2_1_11 r0 *1 0,0
Xsg13cmos5l_mux2_1_11 \$6405 \$4995 \$5413 VPWR VGND \$6383 sg13cmos5l_mux2_1
* cell instance sg13cmos5l_mux2_1_12 r0 *1 0,0
Xsg13cmos5l_mux2_1_12 \$7409 \$2135 \$5760 VPWR VGND \$7317 sg13cmos5l_mux2_1
* cell instance sg13cmos5l_mux2_1_13 r0 *1 0,0
Xsg13cmos5l_mux2_1_13 \$6080 \$5597 \$5758 VPWR VGND \$6016 sg13cmos5l_mux2_1
* cell instance sg13cmos5l_mux2_1_14 r0 *1 0,0
Xsg13cmos5l_mux2_1_14 \$6858 \$4995 \$5758 VPWR VGND \$6859 sg13cmos5l_mux2_1
* cell instance sg13cmos5l_mux2_1_15 r0 *1 0,0
Xsg13cmos5l_mux2_1_15 \$7599 \$2135 \$5758 VPWR VGND \$7783 sg13cmos5l_mux2_1
* cell instance sg13cmos5l_mux2_1_16 r0 *1 0,0
Xsg13cmos5l_mux2_1_16 \$10513 \$4991 \$5758 VPWR VGND \$9907 sg13cmos5l_mux2_1
* cell instance sg13cmos5l_mux2_1_17 r0 *1 0,0
Xsg13cmos5l_mux2_1_17 \$5236 \$4450 \$5758 VPWR VGND \$5091 sg13cmos5l_mux2_1
* cell instance sg13cmos5l_mux2_1_18 r0 *1 0,0
Xsg13cmos5l_mux2_1_18 \$5599 \$5597 \$5413 VPWR VGND \$5578 sg13cmos5l_mux2_1
* cell instance sg13cmos5l_mux2_1_19 r0 *1 0,0
Xsg13cmos5l_mux2_1_19 \$13922 \$3641 \$12461 VPWR VGND \$13834 sg13cmos5l_mux2_1
* cell instance sg13cmos5l_mux2_1_20 r0 *1 0,0
Xsg13cmos5l_mux2_1_20 \$14512 \$1234 \$12461 VPWR VGND \$14823 sg13cmos5l_mux2_1
* cell instance sg13cmos5l_mux2_1_21 r0 *1 0,0
Xsg13cmos5l_mux2_1_21 \$11546 \$2254 \$11398 VPWR VGND \$11384 sg13cmos5l_mux2_1
* cell instance sg13cmos5l_mux2_1_22 r0 *1 0,0
Xsg13cmos5l_mux2_1_22 \$11996 \$1234 \$11398 VPWR VGND \$11913 sg13cmos5l_mux2_1
* cell instance sg13cmos5l_mux2_1_23 r0 *1 0,0
Xsg13cmos5l_mux2_1_23 \$6646 \$4995 \$5760 VPWR VGND \$6648 sg13cmos5l_mux2_1
* cell instance sg13cmos5l_mux2_1_24 r0 *1 0,0
Xsg13cmos5l_mux2_1_24 \$1234 \$16939 \$7261 VPWR VGND \$16940 sg13cmos5l_mux2_1
* cell instance sg13cmos5l_mux2_1_25 r0 *1 0,0
Xsg13cmos5l_mux2_1_25 \$2254 \$16979 \$7261 VPWR VGND \$16978 sg13cmos5l_mux2_1
* cell instance sg13cmos5l_mux2_1_26 r0 *1 0,0
Xsg13cmos5l_mux2_1_26 \$1329 \$1456 \$872 VPWR VGND \$1453 sg13cmos5l_mux2_1
* cell instance sg13cmos5l_mux2_1_27 r0 *1 0,0
Xsg13cmos5l_mux2_1_27 \$776 \$774 \$872 VPWR VGND \$775 sg13cmos5l_mux2_1
* cell instance sg13cmos5l_mux2_1_28 r0 *1 0,0
Xsg13cmos5l_mux2_1_28 \$5037 \$2017 \$2246 VPWR VGND \$4988 sg13cmos5l_mux2_1
* cell instance sg13cmos5l_mux2_1_29 r0 *1 0,0
Xsg13cmos5l_mux2_1_29 \$9910 \$8408 \$4972 VPWR VGND \$10060 sg13cmos5l_mux2_1
* cell instance sg13cmos5l_mux2_1_30 r0 *1 0,0
Xsg13cmos5l_mux2_1_30 \$8547 \$8408 \$5413 VPWR VGND \$8406 sg13cmos5l_mux2_1
* cell instance sg13cmos5l_mux2_1_31 r0 *1 0,0
Xsg13cmos5l_mux2_1_31 \$7411 \$7179 \$5760 VPWR VGND \$7339 sg13cmos5l_mux2_1
* cell instance sg13cmos5l_mux2_1_32 r0 *1 0,0
Xsg13cmos5l_mux2_1_32 \$7205 \$7179 \$4972 VPWR VGND \$7161 sg13cmos5l_mux2_1
* cell instance sg13cmos5l_mux2_1_33 r0 *1 0,0
Xsg13cmos5l_mux2_1_33 \$9575 \$8408 \$5760 VPWR VGND \$9434 sg13cmos5l_mux2_1
* cell instance sg13cmos5l_mux2_1_34 r0 *1 0,0
Xsg13cmos5l_mux2_1_34 \$6860 \$5007 \$5413 VPWR VGND \$6861 sg13cmos5l_mux2_1
* cell instance sg13cmos5l_mux2_1_35 r0 *1 0,0
Xsg13cmos5l_mux2_1_35 \$7496 \$7179 \$5413 VPWR VGND \$7340 sg13cmos5l_mux2_1
* cell instance sg13cmos5l_mux2_1_36 r0 *1 0,0
Xsg13cmos5l_mux2_1_36 \$1335 \$1343 \$1223 VPWR VGND \$1344 sg13cmos5l_mux2_1
* cell instance sg13cmos5l_mux2_1_37 r0 *1 0,0
Xsg13cmos5l_mux2_1_37 \$6407 \$5007 \$5760 VPWR VGND \$6394 sg13cmos5l_mux2_1
* cell instance sg13cmos5l_mux2_1_38 r0 *1 0,0
Xsg13cmos5l_mux2_1_38 \$6084 \$5007 \$4972 VPWR VGND \$6031 sg13cmos5l_mux2_1
* cell instance sg13cmos5l_mux2_1_39 r0 *1 0,0
Xsg13cmos5l_mux2_1_39 \$9419 \$8408 \$5758 VPWR VGND \$9795 sg13cmos5l_mux2_1
* cell instance sg13cmos5l_mux2_1_40 r0 *1 0,0
Xsg13cmos5l_mux2_1_40 \$1115 \$1116 \$1223 VPWR VGND \$1093 sg13cmos5l_mux2_1
* cell instance sg13cmos5l_mux2_1_41 r0 *1 0,0
Xsg13cmos5l_mux2_1_41 \$1905 \$1788 \$1903 VPWR VGND \$1906 sg13cmos5l_mux2_1
* cell instance sg13cmos5l_mux2_1_42 r0 *1 0,0
Xsg13cmos5l_mux2_1_42 \$3623 \$16961 \$16985 VPWR VGND \$16988 sg13cmos5l_mux2_1
* cell instance sg13cmos5l_mux2_1_43 r0 *1 0,0
Xsg13cmos5l_mux2_1_43 \$1716 \$14514 \$14513 VPWR VGND \$14369 sg13cmos5l_mux2_1
* cell instance sg13cmos5l_mux2_1_44 r0 *1 0,0
Xsg13cmos5l_mux2_1_44 \$10518 \$4046 \$9576 VPWR VGND \$10356 sg13cmos5l_mux2_1
* cell instance sg13cmos5l_mux2_1_45 r0 *1 0,0
Xsg13cmos5l_mux2_1_45 \$5064 \$5047 \$2285 VPWR VGND \$5065 sg13cmos5l_mux2_1
* cell instance sg13cmos5l_mux2_1_46 r0 *1 0,0
Xsg13cmos5l_mux2_1_46 \$1159 \$16574 \$14513 VPWR VGND \$16269 sg13cmos5l_mux2_1
* cell instance sg13cmos5l_mux2_1_47 r0 *1 0,0
Xsg13cmos5l_mux2_1_47 \$7412 \$7179 \$5758 VPWR VGND \$7341 sg13cmos5l_mux2_1
* cell instance sg13cmos5l_mux2_1_48 r0 *1 0,0
Xsg13cmos5l_mux2_1_48 \$12465 \$4046 \$3971 VPWR VGND \$12306 sg13cmos5l_mux2_1
* cell instance sg13cmos5l_mux2_1_49 r0 *1 0,0
Xsg13cmos5l_mux2_1_49 \$10957 \$14834 \$14513 VPWR VGND \$14974
+ sg13cmos5l_mux2_1
* cell instance sg13cmos5l_mux2_1_50 r0 *1 0,0
Xsg13cmos5l_mux2_1_50 \$6862 \$5007 \$5758 VPWR VGND \$6869 sg13cmos5l_mux2_1
* cell instance sg13cmos5l_mux2_1_51 r0 *1 0,0
Xsg13cmos5l_mux2_1_51 \$3641 \$17028 \$16985 VPWR VGND \$17029 sg13cmos5l_mux2_1
* cell instance sg13cmos5l_mux2_1_52 r0 *1 0,0
Xsg13cmos5l_mux2_1_52 \$1909 \$545 \$1903 VPWR VGND \$2005 sg13cmos5l_mux2_1
* cell instance sg13cmos5l_mux2_1_53 r0 *1 0,0
Xsg13cmos5l_mux2_1_53 \$2273 \$2276 \$2246 VPWR VGND \$2030 sg13cmos5l_mux2_1
* cell instance sg13cmos5l_mux2_1_54 r0 *1 0,0
Xsg13cmos5l_mux2_1_54 \$13937 \$3427 \$3971 VPWR VGND \$13849 sg13cmos5l_mux2_1
* cell instance sg13cmos5l_mux2_1_55 r0 *1 0,0
Xsg13cmos5l_mux2_1_55 \$9577 \$3427 \$9576 VPWR VGND \$9439 sg13cmos5l_mux2_1
* cell instance sg13cmos5l_mux2_1_56 r0 *1 0,0
Xsg13cmos5l_mux2_1_56 \$3293 \$2221 \$1903 VPWR VGND \$3287 sg13cmos5l_mux2_1
* cell instance sg13cmos5l_mux2_1_57 r0 *1 0,0
Xsg13cmos5l_mux2_1_57 \$4046 \$15527 \$16985 VPWR VGND \$14836 sg13cmos5l_mux2_1
* cell instance sg13cmos5l_mux2_1_58 r0 *1 0,0
Xsg13cmos5l_mux2_1_58 \$12466 \$10957 \$3971 VPWR VGND \$12311 sg13cmos5l_mux2_1
* cell instance sg13cmos5l_mux2_1_59 r0 *1 0,0
Xsg13cmos5l_mux2_1_59 \$5015 \$3249 \$2246 VPWR VGND \$5018 sg13cmos5l_mux2_1
* cell instance sg13cmos5l_mux2_1_60 r0 *1 0,0
Xsg13cmos5l_mux2_1_60 \$3427 \$17008 \$7168 VPWR VGND \$17036 sg13cmos5l_mux2_1
* cell instance sg13cmos5l_mux2_1_61 r0 *1 0,0
Xsg13cmos5l_mux2_1_61 \$2018 \$480 \$1903 VPWR VGND \$2031 sg13cmos5l_mux2_1
* cell instance sg13cmos5l_mux2_1_62 r0 *1 0,0
Xsg13cmos5l_mux2_1_62 \$4584 \$4583 \$3312 VPWR VGND \$4577 sg13cmos5l_mux2_1
* cell instance sg13cmos5l_mux2_1_63 r0 *1 0,0
Xsg13cmos5l_mux2_1_63 \$918 \$925 \$1368 VPWR VGND \$1371 sg13cmos5l_mux2_1
* cell instance sg13cmos5l_mux2_1_64 r0 *1 0,0
Xsg13cmos5l_mux2_1_64 \$4131 \$1924 \$3312 VPWR VGND \$4118 sg13cmos5l_mux2_1
* cell instance sg13cmos5l_mux2_1_65 r0 *1 0,0
Xsg13cmos5l_mux2_1_65 \$3301 \$823 \$2043 VPWR VGND \$1373 sg13cmos5l_mux2_1
* cell instance sg13cmos5l_mux2_1_66 r0 *1 0,0
Xsg13cmos5l_mux2_1_66 \$4593 \$1931 \$3312 VPWR VGND \$4585 sg13cmos5l_mux2_1
* cell instance sg13cmos5l_mux2_1_67 r0 *1 0,0
Xsg13cmos5l_mux2_1_67 \$10957 \$17081 \$16985 VPWR VGND \$17082
+ sg13cmos5l_mux2_1
* cell instance sg13cmos5l_mux2_1_68 r0 *1 0,0
Xsg13cmos5l_mux2_1_68 \$3306 \$1818 \$2043 VPWR VGND \$3452 sg13cmos5l_mux2_1
* cell instance sg13cmos5l_mux2_1_69 r0 *1 0,0
Xsg13cmos5l_mux2_1_69 \$3982 \$2948 \$3312 VPWR VGND \$3647 sg13cmos5l_mux2_1
* cell instance sg13cmos5l_mux2_1_70 r0 *1 0,0
Xsg13cmos5l_mux2_1_70 \$2948 \$2748 \$2159 VPWR VGND \$3100 sg13cmos5l_mux2_1
* cell instance sg13cmos5l_mux2_1_71 r0 *1 0,0
Xsg13cmos5l_mux2_1_71 \$1931 \$1513 \$1928 VPWR VGND \$1041 sg13cmos5l_mux2_1
* cell instance sg13cmos5l_mux2_1_72 r0 *1 0,0
Xsg13cmos5l_mux2_1_72 \$4462 \$1938 \$3312 VPWR VGND \$4459 sg13cmos5l_mux2_1
* cell instance sg13cmos5l_mux2_1_73 r0 *1 0,0
Xsg13cmos5l_mux2_1_73 \$2047 \$509 \$1928 VPWR VGND \$1594 sg13cmos5l_mux2_1
* cell instance sg13cmos5l_mux2_1_74 r0 *1 0,0
Xsg13cmos5l_mux2_1_74 \$4583 \$568 \$1928 VPWR VGND \$935 sg13cmos5l_mux2_1
* cell instance sg13cmos5l_mux2_1_75 r0 *1 0,0
Xsg13cmos5l_mux2_1_75 \$1938 \$716 \$1928 VPWR VGND \$874 sg13cmos5l_mux2_1
* cell instance sg13cmos5l_mux2_1_76 r0 *1 0,0
Xsg13cmos5l_mux2_1_76 \$3315 \$2047 \$3312 VPWR VGND \$3316 sg13cmos5l_mux2_1
* cell instance sg13cmos5l_mux2_1_77 r0 *1 0,0
Xsg13cmos5l_mux2_1_77 \$4150 \$2053 \$1928 VPWR VGND \$646 sg13cmos5l_mux2_1
* cell instance sg13cmos5l_mux2_1_78 r0 *1 0,0
Xsg13cmos5l_mux2_1_78 \$4149 \$4150 \$3312 VPWR VGND \$4151 sg13cmos5l_mux2_1
* cell instance sg13cmos5l_mux2_1_79 r0 *1 0,0
Xsg13cmos5l_mux2_1_79 \$3652 \$3301 \$3312 VPWR VGND \$3653 sg13cmos5l_mux2_1
* cell instance sg13cmos5l_mux2_1_80 r0 *1 0,0
Xsg13cmos5l_mux2_1_80 \$1488 \$4165 \$2179 VPWR VGND \$3848 sg13cmos5l_mux2_1
* cell instance sg13cmos5l_mux2_1_81 r0 *1 0,0
Xsg13cmos5l_mux2_1_81 \$1412 \$1754 \$673 VPWR VGND \$1746 sg13cmos5l_mux2_1
* cell instance sg13cmos5l_mux2_1_82 r0 *1 0,0
Xsg13cmos5l_mux2_1_82 \$3036 \$1488 \$3034 VPWR VGND \$3037 sg13cmos5l_mux2_1
* cell instance sg13cmos5l_mux2_1_83 r0 *1 0,0
Xsg13cmos5l_mux2_1_83 \$4165 \$3888 \$3392 VPWR VGND \$4229 sg13cmos5l_mux2_1
* cell instance sg13cmos5l_mux2_1_84 r0 *1 0,0
Xsg13cmos5l_mux2_1_84 \$3036 \$3231 \$2376 VPWR VGND \$3179 sg13cmos5l_mux2_1
* cell instance sg13cmos5l_mux2_1_85 r0 *1 0,0
Xsg13cmos5l_mux2_1_85 \$3623 \$3553 \$2224 VPWR VGND \$3521 sg13cmos5l_mux2_1
* cell instance sg13cmos5l_mux2_1_86 r0 *1 0,0
Xsg13cmos5l_mux2_1_86 \$3641 \$3723 \$2224 VPWR VGND \$3709 sg13cmos5l_mux2_1
* cell instance sg13cmos5l_mux2_1_87 r0 *1 0,0
Xsg13cmos5l_mux2_1_87 \$3723 \$3553 \$3392 VPWR VGND \$3393 sg13cmos5l_mux2_1
* cell instance sg13cmos5l_mux2_1_88 r0 *1 0,0
Xsg13cmos5l_mux2_1_88 \$3569 \$3723 \$3392 VPWR VGND \$3730 sg13cmos5l_mux2_1
* cell instance sg13cmos5l_mux2_1_89 r0 *1 0,0
Xsg13cmos5l_mux2_1_89 \$4046 \$4047 \$2376 VPWR VGND \$4013 sg13cmos5l_mux2_1
* cell instance sg13cmos5l_mux2_1_90 r0 *1 0,0
Xsg13cmos5l_mux2_1_90 \$3888 \$4047 \$3392 VPWR VGND \$3896 sg13cmos5l_mux2_1
* cell instance sg13cmos5l_mux2_1_91 r0 *1 0,0
Xsg13cmos5l_mux2_1_91 \$3553 \$3231 \$3392 VPWR VGND \$3232 sg13cmos5l_mux2_1
* cell instance sg13cmos5l_mux2_1_92 r0 *1 0,0
Xsg13cmos5l_mux2_1_92 \$4392 \$3237 \$3562 VPWR VGND \$4199 sg13cmos5l_mux2_1
* cell instance sg13cmos5l_mux2_1_93 r0 *1 0,0
Xsg13cmos5l_mux2_1_93 \$3570 \$3569 \$3392 VPWR VGND \$3571 sg13cmos5l_mux2_1
* cell instance sg13cmos5l_mux2_1_94 r0 *1 0,0
Xsg13cmos5l_mux2_1_94 \$4515 \$4046 \$3034 VPWR VGND \$4516 sg13cmos5l_mux2_1
* cell instance sg13cmos5l_mux2_1_95 r0 *1 0,0
Xsg13cmos5l_mux2_1_95 \$3427 \$3570 \$3562 VPWR VGND \$3857 sg13cmos5l_mux2_1
* cell instance sg13cmos5l_mux2_1_96 r0 *1 0,0
Xsg13cmos5l_mux2_1_96 \$4047 \$3900 \$3392 VPWR VGND \$4061 sg13cmos5l_mux2_1
* cell instance sg13cmos5l_mux2_1_97 r0 *1 0,0
Xsg13cmos5l_mux2_1_97 \$3231 \$3237 \$3392 VPWR VGND \$3238 sg13cmos5l_mux2_1
* cell instance sg13cmos5l_mux2_1_98 r0 *1 0,0
Xsg13cmos5l_mux2_1_98 \$3900 \$3570 \$3903 VPWR VGND \$3905 sg13cmos5l_mux2_1
* cell instance sg13cmos5l_mux2_1_99 r0 *1 0,0
Xsg13cmos5l_mux2_1_99 \$4515 \$4066 \$3562 VPWR VGND \$4033 sg13cmos5l_mux2_1
* cell instance sg13cmos5l_mux2_1_100 r0 *1 0,0
Xsg13cmos5l_mux2_1_100 \$3237 \$4066 \$3903 VPWR VGND \$4069 sg13cmos5l_mux2_1
* cell instance sg13cmos5l_mux2_1_101 r0 *1 0,0
Xsg13cmos5l_mux2_1_101 \$3428 \$3427 \$3034 VPWR VGND \$3429 sg13cmos5l_mux2_1
* cell instance sg13cmos5l_mux2_1_102 r0 *1 0,0
Xsg13cmos5l_mux2_1_102 \$4403 \$4076 \$3562 VPWR VGND \$3549 sg13cmos5l_mux2_1
* cell instance sg13cmos5l_mux2_1_103 r0 *1 0,0
Xsg13cmos5l_mux2_1_103 \$4066 \$4076 \$3903 VPWR VGND \$4077 sg13cmos5l_mux2_1
* cell instance sg13cmos5l_mux2_1_104 r0 *1 0,0
Xsg13cmos5l_mux2_1_104 \$4544 \$3641 \$3152 VPWR VGND \$4543 sg13cmos5l_mux2_1
* cell instance sg13cmos5l_mux2_1_105 r0 *1 0,0
Xsg13cmos5l_mux2_1_105 \$3582 \$3960 \$3562 VPWR VGND \$3559 sg13cmos5l_mux2_1
* cell instance sg13cmos5l_mux2_1_106 r0 *1 0,0
Xsg13cmos5l_mux2_1_106 \$4414 \$3623 \$3152 VPWR VGND \$4548 sg13cmos5l_mux2_1
* cell instance sg13cmos5l_mux2_1_107 r0 *1 0,0
Xsg13cmos5l_mux2_1_107 \$3428 \$3768 \$3562 VPWR VGND \$3362 sg13cmos5l_mux2_1
* cell instance sg13cmos5l_mux2_1_108 r0 *1 0,0
Xsg13cmos5l_mux2_1_108 \$4544 \$4281 \$2105 VPWR VGND \$4226 sg13cmos5l_mux2_1
* cell instance sg13cmos5l_mux2_1_109 r0 *1 0,0
Xsg13cmos5l_mux2_1_109 \$3768 \$3960 \$3903 VPWR VGND \$3769 sg13cmos5l_mux2_1
* cell instance sg13cmos5l_mux2_1_110 r0 *1 0,0
Xsg13cmos5l_mux2_1_110 \$4076 \$3609 \$3903 VPWR VGND \$3923 sg13cmos5l_mux2_1
* cell instance sg13cmos5l_mux2_1_111 r0 *1 0,0
Xsg13cmos5l_mux2_1_111 \$1296 \$246 \$320 VPWR VGND \$1297 sg13cmos5l_mux2_1
* cell instance sg13cmos5l_mux2_1_112 r0 *1 0,0
Xsg13cmos5l_mux2_1_112 \$3960 \$4081 \$3903 VPWR VGND \$4082 sg13cmos5l_mux2_1
* cell instance sg13cmos5l_mux2_1_113 r0 *1 0,0
Xsg13cmos5l_mux2_1_113 \$4414 \$4278 \$2105 VPWR VGND \$3719 sg13cmos5l_mux2_1
* cell instance sg13cmos5l_mux2_1_114 r0 *1 0,0
Xsg13cmos5l_mux2_1_114 \$4281 \$4278 \$3903 VPWR VGND \$4282 sg13cmos5l_mux2_1
* cell instance sg13cmos5l_mux2_1_115 r0 *1 0,0
Xsg13cmos5l_mux2_1_115 \$142 \$1655 \$78 VPWR VGND \$1653 sg13cmos5l_mux2_1
* cell instance sg13cmos5l_mux2_1_116 r0 *1 0,0
Xsg13cmos5l_mux2_1_116 \$281 \$621 \$198 VPWR VGND \$1077 sg13cmos5l_mux2_1
* cell instance sg13cmos5l_mux4_1_0 r0 *1 0,0
Xsg13cmos5l_mux4_1_0 \$4965 \$5035 \$5049 \$5052 \$5047 \$5055 VPWR VGND \$3962
+ sg13cmos5l_mux4_1
* cell instance sg13cmos5l_mux4_1_1 r0 *1 0,0
Xsg13cmos5l_mux4_1_1 \$7282 \$7239 \$7203 \$7283 \$5018 \$4988 VPWR VGND \$7243
+ sg13cmos5l_mux4_1
* cell instance sg13cmos5l_mux4_1_2 r0 *1 0,0
Xsg13cmos5l_mux4_1_2 \$9786 \$8995 \$8994 \$8996 \$5018 \$5055 VPWR VGND \$8845
+ sg13cmos5l_mux4_1
* cell instance sg13cmos5l_mux4_1_3 r0 *1 0,0
Xsg13cmos5l_mux4_1_3 \$9786 \$8995 \$8994 \$8996 \$3132 \$3287 VPWR VGND \$4095
+ sg13cmos5l_mux4_1
* cell instance sg13cmos5l_mux4_1_4 r0 *1 0,0
Xsg13cmos5l_mux4_1_4 \$10345 \$8548 \$9133 \$8549 \$5047 \$5055 VPWR VGND
+ \$5002 sg13cmos5l_mux4_1
* cell instance sg13cmos5l_mux4_1_5 r0 *1 0,0
Xsg13cmos5l_mux4_1_5 \$10345 \$8548 \$9133 \$8549 \$3132 \$3287 VPWR VGND
+ \$3815 sg13cmos5l_mux4_1
* cell instance sg13cmos5l_mux4_1_6 r0 *1 0,0
Xsg13cmos5l_mux4_1_6 \$7253 \$7206 \$7256 \$7260 \$5018 \$5055 VPWR VGND \$1250
+ sg13cmos5l_mux4_1
* cell instance sg13cmos5l_nand2_1_0 r0 *1 0,0
Xsg13cmos5l_nand2_1_0 \$3275 \$3273 VPWR VGND \$3274 sg13cmos5l_nand2_1
* cell instance sg13cmos5l_nand2_1_1 r0 *1 0,0
Xsg13cmos5l_nand2_1_1 \$2592 \$2755 VPWR VGND \$2925 sg13cmos5l_nand2_1
* cell instance sg13cmos5l_nand2_1_2 r0 *1 0,0
Xsg13cmos5l_nand2_1_2 \$2261 \$2407 VPWR VGND \$2408 sg13cmos5l_nand2_1
* cell instance sg13cmos5l_nand2_1_3 r0 *1 0,0
Xsg13cmos5l_nand2_1_3 \$4097 \$2755 VPWR VGND \$4320 sg13cmos5l_nand2_1
* cell instance sg13cmos5l_nand2_1_4 r0 *1 0,0
Xsg13cmos5l_nand2_1_4 \$3112 \$2926 VPWR VGND \$2409 sg13cmos5l_nand2_1
* cell instance sg13cmos5l_nand2_1_5 r0 *1 0,0
Xsg13cmos5l_nand2_1_5 \$5049 \$5023 VPWR VGND \$4975 sg13cmos5l_nand2_1
* cell instance sg13cmos5l_nand2_1_6 r0 *1 0,0
Xsg13cmos5l_nand2_1_6 \$872 \$890 VPWR VGND \$891 sg13cmos5l_nand2_1
* cell instance sg13cmos5l_nand2_1_7 r0 *1 0,0
Xsg13cmos5l_nand2_1_7 \$1250 \$3967 VPWR VGND \$4678 sg13cmos5l_nand2_1
* cell instance sg13cmos5l_nand2_1_8 r0 *1 0,0
Xsg13cmos5l_nand2_1_8 \$3470 \$2419 VPWR VGND \$3472 sg13cmos5l_nand2_1
* cell instance sg13cmos5l_nand2_1_9 r0 *1 0,0
Xsg13cmos5l_nand2_1_9 \$3962 \$4322 VPWR VGND \$4323 sg13cmos5l_nand2_1
* cell instance sg13cmos5l_nand2_1_10 r0 *1 0,0
Xsg13cmos5l_nand2_1_10 \$651 \$891 VPWR VGND \$648 sg13cmos5l_nand2_1
* cell instance sg13cmos5l_nand2_1_11 r0 *1 0,0
Xsg13cmos5l_nand2_1_11 \$1234 \$3117 VPWR VGND \$2758 sg13cmos5l_nand2_1
* cell instance sg13cmos5l_nand2_1_12 r0 *1 0,0
Xsg13cmos5l_nand2_1_12 \$645 \$1012 VPWR VGND \$1017 sg13cmos5l_nand2_1
* cell instance sg13cmos5l_nand2_1_13 r0 *1 0,0
Xsg13cmos5l_nand2_1_13 \$1326 \$1216 VPWR VGND \$1328 sg13cmos5l_nand2_1
* cell instance sg13cmos5l_nand2_1_14 r0 *1 0,0
Xsg13cmos5l_nand2_1_14 \$5023 \$5024 VPWR VGND \$4981 sg13cmos5l_nand2_1
* cell instance sg13cmos5l_nand2_1_15 r0 *1 0,0
Xsg13cmos5l_nand2_1_15 \$6406 \$6389 VPWR VGND \$6337 sg13cmos5l_nand2_1
* cell instance sg13cmos5l_nand2_1_16 r0 *1 0,0
Xsg13cmos5l_nand2_1_16 \$1216 \$1329 VPWR VGND \$1330 sg13cmos5l_nand2_1
* cell instance sg13cmos5l_nand2_1_17 r0 *1 0,0
Xsg13cmos5l_nand2_1_17 \$15961 \$14513 VPWR VGND \$16497 sg13cmos5l_nand2_1
* cell instance sg13cmos5l_nand2_1_18 r0 *1 0,0
Xsg13cmos5l_nand2_1_18 \$1089 \$2018 VPWR VGND \$2019 sg13cmos5l_nand2_1
* cell instance sg13cmos5l_nand2_1_19 r0 *1 0,0
Xsg13cmos5l_nand2_1_19 \$1691 \$2268 VPWR VGND \$2148 sg13cmos5l_nand2_1
* cell instance sg13cmos5l_nand2_1_20 r0 *1 0,0
Xsg13cmos5l_nand2_1_20 \$3823 \$5037 VPWR VGND \$4992 sg13cmos5l_nand2_1
* cell instance sg13cmos5l_nand2_1_21 r0 *1 0,0
Xsg13cmos5l_nand2_1_21 \$15962 \$14513 VPWR VGND \$15524 sg13cmos5l_nand2_1
* cell instance sg13cmos5l_nand2_1_22 r0 *1 0,0
Xsg13cmos5l_nand2_1_22 \$2029 \$1783 VPWR VGND \$2028 sg13cmos5l_nand2_1
* cell instance sg13cmos5l_nand2_1_23 r0 *1 0,0
Xsg13cmos5l_nand2_1_23 \$6083 \$6058 VPWR VGND \$3473 sg13cmos5l_nand2_1
* cell instance sg13cmos5l_nand2_1_24 r0 *1 0,0
Xsg13cmos5l_nand2_1_24 \$2422 \$2423 VPWR VGND \$2268 sg13cmos5l_nand2_1
* cell instance sg13cmos5l_nand2_1_25 r0 *1 0,0
Xsg13cmos5l_nand2_1_25 \$3808 \$3812 VPWR VGND \$2764 sg13cmos5l_nand2_1
* cell instance sg13cmos5l_nand2_1_26 r0 *1 0,0
Xsg13cmos5l_nand2_1_26 \$781 \$756 VPWR VGND \$780 sg13cmos5l_nand2_1
* cell instance sg13cmos5l_nand2_1_27 r0 *1 0,0
Xsg13cmos5l_nand2_1_27 \$2031 \$1906 VPWR VGND \$2004 sg13cmos5l_nand2_1
* cell instance sg13cmos5l_nand2_1_28 r0 *1 0,0
Xsg13cmos5l_nand2_1_28 \$6628 \$6391 VPWR VGND \$6083 sg13cmos5l_nand2_1
* cell instance sg13cmos5l_nand2_1_29 r0 *1 0,0
Xsg13cmos5l_nand2_1_29 \$2754 \$2400 VPWR VGND \$3476 sg13cmos5l_nand2_1
* cell instance sg13cmos5l_nand2_1_30 r0 *1 0,0
Xsg13cmos5l_nand2_1_30 \$16499 \$14513 VPWR VGND \$16498 sg13cmos5l_nand2_1
* cell instance sg13cmos5l_nand2_1_31 r0 *1 0,0
Xsg13cmos5l_nand2_1_31 \$2029 \$2030 VPWR VGND \$2020 sg13cmos5l_nand2_1
* cell instance sg13cmos5l_nand2_1_32 r0 *1 0,0
Xsg13cmos5l_nand2_1_32 \$2400 \$4106 VPWR VGND \$4443 sg13cmos5l_nand2_1
* cell instance sg13cmos5l_nand2_1_33 r0 *1 0,0
Xsg13cmos5l_nand2_1_33 \$16953 \$16985 VPWR VGND \$16952 sg13cmos5l_nand2_1
* cell instance sg13cmos5l_nand2_1_34 r0 *1 0,0
Xsg13cmos5l_nand2_1_34 \$1488 \$3815 VPWR VGND \$3808 sg13cmos5l_nand2_1
* cell instance sg13cmos5l_nand2_1_35 r0 *1 0,0
Xsg13cmos5l_nand2_1_35 \$2005 \$2030 VPWR VGND \$1786 sg13cmos5l_nand2_1
* cell instance sg13cmos5l_nand2_1_36 r0 *1 0,0
Xsg13cmos5l_nand2_1_36 \$2005 \$1783 VPWR VGND \$2270 sg13cmos5l_nand2_1
* cell instance sg13cmos5l_nand2_1_37 r0 *1 0,0
Xsg13cmos5l_nand2_1_37 \$4105 \$2400 VPWR VGND \$4331 sg13cmos5l_nand2_1
* cell instance sg13cmos5l_nand2_1_38 r0 *1 0,0
Xsg13cmos5l_nand2_1_38 \$2031 \$2001 VPWR VGND \$2027 sg13cmos5l_nand2_1
* cell instance sg13cmos5l_nand2_1_39 r0 *1 0,0
Xsg13cmos5l_nand2_1_39 \$1700 \$5898 VPWR VGND \$7261 sg13cmos5l_nand2_1
* cell instance sg13cmos5l_nand2_1_40 r0 *1 0,0
Xsg13cmos5l_nand2_1_40 \$3823 \$1909 VPWR VGND \$4996 sg13cmos5l_nand2_1
* cell instance sg13cmos5l_nand2_1_41 r0 *1 0,0
Xsg13cmos5l_nand2_1_41 \$7164 \$7207 VPWR VGND \$6972 sg13cmos5l_nand2_1
* cell instance sg13cmos5l_nand2_1_42 r0 *1 0,0
Xsg13cmos5l_nand2_1_42 \$1326 \$781 VPWR VGND \$671 sg13cmos5l_nand2_1
* cell instance sg13cmos5l_nand2_1_43 r0 *1 0,0
Xsg13cmos5l_nand2_1_43 \$2142 \$3818 VPWR VGND \$3819 sg13cmos5l_nand2_1
* cell instance sg13cmos5l_nand2_1_44 r0 *1 0,0
Xsg13cmos5l_nand2_1_44 \$1034 \$1461 VPWR VGND \$1530 sg13cmos5l_nand2_1
* cell instance sg13cmos5l_nand2_1_45 r0 *1 0,0
Xsg13cmos5l_nand2_1_45 \$1700 \$2433 VPWR VGND \$7168 sg13cmos5l_nand2_1
* cell instance sg13cmos5l_nand2_1_46 r0 *1 0,0
Xsg13cmos5l_nand2_1_46 \$4981 \$2608 VPWR VGND \$2609 sg13cmos5l_nand2_1
* cell instance sg13cmos5l_nand2_1_47 r0 *1 0,0
Xsg13cmos5l_nand2_1_47 \$16998 \$6644 VPWR VGND \$8998 sg13cmos5l_nand2_1
* cell instance sg13cmos5l_nand2_1_48 r0 *1 0,0
Xsg13cmos5l_nand2_1_48 \$2610 \$2608 VPWR VGND \$2041 sg13cmos5l_nand2_1
* cell instance sg13cmos5l_nand2_1_49 r0 *1 0,0
Xsg13cmos5l_nand2_1_49 \$6212 \$6592 VPWR VGND \$5891 sg13cmos5l_nand2_1
* cell instance sg13cmos5l_nand2_1_50 r0 *1 0,0
Xsg13cmos5l_nand2_1_50 \$2610 \$1700 VPWR VGND \$2769 sg13cmos5l_nand2_1
* cell instance sg13cmos5l_nand2_1_51 r0 *1 0,0
Xsg13cmos5l_nand2_1_51 \$1699 \$2277 VPWR VGND \$1915 sg13cmos5l_nand2_1
* cell instance sg13cmos5l_nand2_1_52 r0 *1 0,0
Xsg13cmos5l_nand2_1_52 \$3823 \$3306 VPWR VGND \$4451 sg13cmos5l_nand2_1
* cell instance sg13cmos5l_nand2_1_53 r0 *1 0,0
Xsg13cmos5l_nand2_1_53 \$10957 \$11398 VPWR VGND \$10884 sg13cmos5l_nand2_1
* cell instance sg13cmos5l_nand2_1_54 r0 *1 0,0
Xsg13cmos5l_nand2_1_54 \$932 \$5015 VPWR VGND \$5014 sg13cmos5l_nand2_1
* cell instance sg13cmos5l_nand2_1_55 r0 *1 0,0
Xsg13cmos5l_nand2_1_55 \$15856 \$7168 VPWR VGND \$15963 sg13cmos5l_nand2_1
* cell instance sg13cmos5l_nand2_1_56 r0 *1 0,0
Xsg13cmos5l_nand2_1_56 \$1701 \$1567 VPWR VGND \$802 sg13cmos5l_nand2_1
* cell instance sg13cmos5l_nand2_1_57 r0 *1 0,0
Xsg13cmos5l_nand2_1_57 \$3823 \$3293 VPWR VGND \$3821 sg13cmos5l_nand2_1
* cell instance sg13cmos5l_nand2_1_58 r0 *1 0,0
Xsg13cmos5l_nand2_1_58 \$1327 \$1458 VPWR VGND \$2612 sg13cmos5l_nand2_1
* cell instance sg13cmos5l_nand2_1_59 r0 *1 0,0
Xsg13cmos5l_nand2_1_59 \$16861 \$7168 VPWR VGND \$17001 sg13cmos5l_nand2_1
* cell instance sg13cmos5l_nand2_1_60 r0 *1 0,0
Xsg13cmos5l_nand2_1_60 \$1135 \$796 VPWR VGND \$1134 sg13cmos5l_nand2_1
* cell instance sg13cmos5l_nand2_1_61 r0 *1 0,0
Xsg13cmos5l_nand2_1_61 \$4453 \$3297 VPWR VGND \$3824 sg13cmos5l_nand2_1
* cell instance sg13cmos5l_nand2_1_62 r0 *1 0,0
Xsg13cmos5l_nand2_1_62 \$2282 \$2281 VPWR VGND \$2038 sg13cmos5l_nand2_1
* cell instance sg13cmos5l_nand2_1_63 r0 *1 0,0
Xsg13cmos5l_nand2_1_63 \$1136 \$1161 VPWR VGND \$1797 sg13cmos5l_nand2_1
* cell instance sg13cmos5l_nand2_1_64 r0 *1 0,0
Xsg13cmos5l_nand2_1_64 \$1034 \$1476 VPWR VGND \$1477 sg13cmos5l_nand2_1
* cell instance sg13cmos5l_nand2_1_65 r0 *1 0,0
Xsg13cmos5l_nand2_1_65 \$878 \$930 VPWR VGND \$931 sg13cmos5l_nand2_1
* cell instance sg13cmos5l_nand2_1_66 r0 *1 0,0
Xsg13cmos5l_nand2_1_66 \$3983 \$4141 VPWR VGND \$4134 sg13cmos5l_nand2_1
* cell instance sg13cmos5l_nand2_1_67 r0 *1 0,0
Xsg13cmos5l_nand2_1_67 \$3837 \$2782 VPWR VGND \$3498 sg13cmos5l_nand2_1
* cell instance sg13cmos5l_nand2_1_68 r0 *1 0,0
Xsg13cmos5l_nand2_1_68 \$3001 \$3840 VPWR VGND \$3983 sg13cmos5l_nand2_1
* cell instance sg13cmos5l_nand2_1_69 r0 *1 0,0
Xsg13cmos5l_nand2_1_69 \$2174 \$2431 VPWR VGND \$2441 sg13cmos5l_nand2_1
* cell instance sg13cmos5l_nand2_1_70 r0 *1 0,0
Xsg13cmos5l_nand2_1_70 \$2568 \$2775 VPWR VGND \$2779 sg13cmos5l_nand2_1
* cell instance sg13cmos5l_nand2_1_71 r0 *1 0,0
Xsg13cmos5l_nand2_1_71 \$2177 \$2176 VPWR VGND \$2162 sg13cmos5l_nand2_1
* cell instance sg13cmos5l_nand2_1_72 r0 *1 0,0
Xsg13cmos5l_nand2_1_72 \$1368 \$1483 VPWR VGND \$1484 sg13cmos5l_nand2_1
* cell instance sg13cmos5l_nand2_1_73 r0 *1 0,0
Xsg13cmos5l_nand2_1_73 \$2909 \$3840 VPWR VGND \$3985 sg13cmos5l_nand2_1
* cell instance sg13cmos5l_nand2_1_74 r0 *1 0,0
Xsg13cmos5l_nand2_1_74 \$33 \$32 VPWR VGND \$155 sg13cmos5l_nand2_1
* cell instance sg13cmos5l_nand2_1_75 r0 *1 0,0
Xsg13cmos5l_nand2_1_75 \$1159 \$1940 VPWR VGND \$1941 sg13cmos5l_nand2_1
* cell instance sg13cmos5l_nand2_1_76 r0 *1 0,0
Xsg13cmos5l_nand2_1_76 \$2197 \$2635 VPWR VGND \$2634 sg13cmos5l_nand2_1
* cell instance sg13cmos5l_nand2_1_77 r0 *1 0,0
Xsg13cmos5l_nand2_1_77 \$45 \$193 VPWR VGND \$297 sg13cmos5l_nand2_1
* cell instance sg13cmos5l_nand2_1_78 r0 *1 0,0
Xsg13cmos5l_nand2_1_78 \$947 \$1150 VPWR VGND \$1162 sg13cmos5l_nand2_1
* cell instance sg13cmos5l_nand2_1_79 r0 *1 0,0
Xsg13cmos5l_nand2_1_79 \$569 \$719 VPWR VGND \$159 sg13cmos5l_nand2_1
* cell instance sg13cmos5l_nand2_1_80 r0 *1 0,0
Xsg13cmos5l_nand2_1_80 \$569 \$345 VPWR VGND \$418 sg13cmos5l_nand2_1
* cell instance sg13cmos5l_nand2_1_81 r0 *1 0,0
Xsg13cmos5l_nand2_1_81 \$31 \$103 VPWR VGND \$412 sg13cmos5l_nand2_1
* cell instance sg13cmos5l_nand2_1_82 r0 *1 0,0
Xsg13cmos5l_nand2_1_82 \$3171 \$3840 VPWR VGND \$3311 sg13cmos5l_nand2_1
* cell instance sg13cmos5l_nand2_1_83 r0 *1 0,0
Xsg13cmos5l_nand2_1_83 \$346 \$345 VPWR VGND \$378 sg13cmos5l_nand2_1
* cell instance sg13cmos5l_nand2_1_84 r0 *1 0,0
Xsg13cmos5l_nand2_1_84 \$212 \$256 VPWR VGND \$258 sg13cmos5l_nand2_1
* cell instance sg13cmos5l_nand2_1_85 r0 *1 0,0
Xsg13cmos5l_nand2_1_85 \$2470 \$2460 VPWR VGND \$2643 sg13cmos5l_nand2_1
* cell instance sg13cmos5l_nand2_1_86 r0 *1 0,0
Xsg13cmos5l_nand2_1_86 \$2197 \$2459 VPWR VGND \$2461 sg13cmos5l_nand2_1
* cell instance sg13cmos5l_nand2_1_87 r0 *1 0,0
Xsg13cmos5l_nand2_1_87 \$38 \$353 VPWR VGND \$209 sg13cmos5l_nand2_1
* cell instance sg13cmos5l_nand2_1_88 r0 *1 0,0
Xsg13cmos5l_nand2_1_88 \$3508 \$2977 VPWR VGND \$3156 sg13cmos5l_nand2_1
* cell instance sg13cmos5l_nand2_1_89 r0 *1 0,0
Xsg13cmos5l_nand2_1_89 \$4353 \$2977 VPWR VGND \$4167 sg13cmos5l_nand2_1
* cell instance sg13cmos5l_nand2_1_90 r0 *1 0,0
Xsg13cmos5l_nand2_1_90 \$2979 \$2977 VPWR VGND \$2978 sg13cmos5l_nand2_1
* cell instance sg13cmos5l_nand2_1_91 r0 *1 0,0
Xsg13cmos5l_nand2_1_91 \$1822 \$2461 VPWR VGND \$2462 sg13cmos5l_nand2_1
* cell instance sg13cmos5l_nand2_1_92 r0 *1 0,0
Xsg13cmos5l_nand2_1_92 \$2308 \$2462 VPWR VGND \$2463 sg13cmos5l_nand2_1
* cell instance sg13cmos5l_nand2_1_93 r0 *1 0,0
Xsg13cmos5l_nand2_1_93 \$3163 \$2977 VPWR VGND \$3162 sg13cmos5l_nand2_1
* cell instance sg13cmos5l_nand2_1_94 r0 *1 0,0
Xsg13cmos5l_nand2_1_94 \$259 \$726 VPWR VGND \$1055 sg13cmos5l_nand2_1
* cell instance sg13cmos5l_nand2_1_95 r0 *1 0,0
Xsg13cmos5l_nand2_1_95 \$1983 \$45 VPWR VGND \$1982 sg13cmos5l_nand2_1
* cell instance sg13cmos5l_nand2_1_96 r0 *1 0,0
Xsg13cmos5l_nand2_1_96 \$1983 \$332 VPWR VGND \$1984 sg13cmos5l_nand2_1
* cell instance sg13cmos5l_nand2_1_97 r0 *1 0,0
Xsg13cmos5l_nand2_1_97 \$1983 \$31 VPWR VGND \$2129 sg13cmos5l_nand2_1
* cell instance sg13cmos5l_nand2_1_98 r0 *1 0,0
Xsg13cmos5l_nand2_1_98 \$4183 \$2977 VPWR VGND \$4181 sg13cmos5l_nand2_1
* cell instance sg13cmos5l_nand2_1_99 r0 *1 0,0
Xsg13cmos5l_nand2_1_99 \$1983 \$405 VPWR VGND \$2087 sg13cmos5l_nand2_1
* cell instance sg13cmos5l_nand2_1_100 r0 *1 0,0
Xsg13cmos5l_nand2_1_100 \$4185 \$2977 VPWR VGND \$4184 sg13cmos5l_nand2_1
* cell instance sg13cmos5l_nand2_1_101 r0 *1 0,0
Xsg13cmos5l_nand2_1_101 \$120 \$1983 VPWR VGND \$2207 sg13cmos5l_nand2_1
* cell instance sg13cmos5l_nand2_1_102 r0 *1 0,0
Xsg13cmos5l_nand2_1_102 \$43 \$45 VPWR VGND \$64 sg13cmos5l_nand2_1
* cell instance sg13cmos5l_nand2_1_103 r0 *1 0,0
Xsg13cmos5l_nand2_1_103 \$1983 \$115 VPWR VGND \$2088 sg13cmos5l_nand2_1
* cell instance sg13cmos5l_nand2_1_104 r0 *1 0,0
Xsg13cmos5l_nand2_1_104 \$1983 \$719 VPWR VGND \$2089 sg13cmos5l_nand2_1
* cell instance sg13cmos5l_nand2_1_105 r0 *1 0,0
Xsg13cmos5l_nand2_1_105 \$346 \$719 VPWR VGND \$961 sg13cmos5l_nand2_1
* cell instance sg13cmos5l_nand2_1_106 r0 *1 0,0
Xsg13cmos5l_nand2_1_106 \$1983 \$346 VPWR VGND \$2209 sg13cmos5l_nand2_1
* cell instance sg13cmos5l_nand2_1_107 r0 *1 0,0
Xsg13cmos5l_nand2_1_107 \$36 \$121 VPWR VGND \$266 sg13cmos5l_nand2_1
* cell instance sg13cmos5l_nand2_1_108 r0 *1 0,0
Xsg13cmos5l_nand2_1_108 \$3008 \$3007 VPWR VGND \$3005 sg13cmos5l_nand2_1
* cell instance sg13cmos5l_nand2_1_109 r0 *1 0,0
Xsg13cmos5l_nand2_1_109 \$164 \$55 VPWR VGND \$731 sg13cmos5l_nand2_1
* cell instance sg13cmos5l_nand2_1_110 r0 *1 0,0
Xsg13cmos5l_nand2_1_110 \$55 \$116 VPWR VGND \$218 sg13cmos5l_nand2_1
* cell instance sg13cmos5l_nand2_1_111 r0 *1 0,0
Xsg13cmos5l_nand2_1_111 \$2389 \$2474 VPWR VGND \$2476 sg13cmos5l_nand2_1
* cell instance sg13cmos5l_nand2_1_112 r0 *1 0,0
Xsg13cmos5l_nand2_1_112 \$65 \$55 VPWR VGND \$1057 sg13cmos5l_nand2_1
* cell instance sg13cmos5l_nand2_1_113 r0 *1 0,0
Xsg13cmos5l_nand2_1_113 \$3692 \$3007 VPWR VGND \$3691 sg13cmos5l_nand2_1
* cell instance sg13cmos5l_nand2_1_114 r0 *1 0,0
Xsg13cmos5l_nand2_1_114 \$825 \$332 VPWR VGND \$730 sg13cmos5l_nand2_1
* cell instance sg13cmos5l_nand2_1_115 r0 *1 0,0
Xsg13cmos5l_nand2_1_115 \$2102 \$2202 VPWR VGND \$2350 sg13cmos5l_nand2_1
* cell instance sg13cmos5l_nand2_1_116 r0 *1 0,0
Xsg13cmos5l_nand2_1_116 \$3015 \$3007 VPWR VGND \$2833 sg13cmos5l_nand2_1
* cell instance sg13cmos5l_nand2_1_117 r0 *1 0,0
Xsg13cmos5l_nand2_1_117 \$1060 \$599 VPWR VGND \$1853 sg13cmos5l_nand2_1
* cell instance sg13cmos5l_nand2_1_118 r0 *1 0,0
Xsg13cmos5l_nand2_1_118 \$2834 \$2474 VPWR VGND \$2832 sg13cmos5l_nand2_1
* cell instance sg13cmos5l_nand2_1_119 r0 *1 0,0
Xsg13cmos5l_nand2_1_119 \$221 \$268 VPWR VGND \$269 sg13cmos5l_nand2_1
* cell instance sg13cmos5l_nand2_1_120 r0 *1 0,0
Xsg13cmos5l_nand2_1_120 \$260 \$453 VPWR VGND \$1060 sg13cmos5l_nand2_1
* cell instance sg13cmos5l_nand2_1_121 r0 *1 0,0
Xsg13cmos5l_nand2_1_121 \$2226 \$2224 VPWR VGND \$2225 sg13cmos5l_nand2_1
* cell instance sg13cmos5l_nand2_1_122 r0 *1 0,0
Xsg13cmos5l_nand2_1_122 \$2364 \$2224 VPWR VGND \$2677 sg13cmos5l_nand2_1
* cell instance sg13cmos5l_nand2_1_123 r0 *1 0,0
Xsg13cmos5l_nand2_1_123 \$2229 \$2224 VPWR VGND \$2228 sg13cmos5l_nand2_1
* cell instance sg13cmos5l_nand2_1_124 r0 *1 0,0
Xsg13cmos5l_nand2_1_124 \$54 \$55 VPWR VGND \$1182 sg13cmos5l_nand2_1
* cell instance sg13cmos5l_nand2_1_125 r0 *1 0,0
Xsg13cmos5l_nand2_1_125 \$4024 \$3007 VPWR VGND \$4023 sg13cmos5l_nand2_1
* cell instance sg13cmos5l_nand2_1_126 r0 *1 0,0
Xsg13cmos5l_nand2_1_126 \$3711 \$3007 VPWR VGND \$3710 sg13cmos5l_nand2_1
* cell instance sg13cmos5l_nand2_1_127 r0 *1 0,0
Xsg13cmos5l_nand2_1_127 \$275 \$1414 VPWR VGND \$1404 sg13cmos5l_nand2_1
* cell instance sg13cmos5l_nand2_1_128 r0 *1 0,0
Xsg13cmos5l_nand2_1_128 \$3536 \$3007 VPWR VGND \$3535 sg13cmos5l_nand2_1
* cell instance sg13cmos5l_nand2_1_129 r0 *1 0,0
Xsg13cmos5l_nand2_1_129 \$3382 \$3007 VPWR VGND \$3381 sg13cmos5l_nand2_1
* cell instance sg13cmos5l_nand2_1_130 r0 *1 0,0
Xsg13cmos5l_nand2_1_130 \$739 \$305 VPWR VGND \$971 sg13cmos5l_nand2_1
* cell instance sg13cmos5l_nand2_1_131 r0 *1 0,0
Xsg13cmos5l_nand2_1_131 \$148 \$164 VPWR VGND \$1401 sg13cmos5l_nand2_1
* cell instance sg13cmos5l_nand2_1_132 r0 *1 0,0
Xsg13cmos5l_nand2_1_132 \$2376 \$3888 VPWR VGND \$3889 sg13cmos5l_nand2_1
* cell instance sg13cmos5l_nand2_1_133 r0 *1 0,0
Xsg13cmos5l_nand2_1_133 \$2378 \$2376 VPWR VGND \$2377 sg13cmos5l_nand2_1
* cell instance sg13cmos5l_nand2_1_134 r0 *1 0,0
Xsg13cmos5l_nand2_1_134 \$164 \$433 VPWR VGND \$1522 sg13cmos5l_nand2_1
* cell instance sg13cmos5l_nand2_1_135 r0 *1 0,0
Xsg13cmos5l_nand2_1_135 \$154 \$100 VPWR VGND \$1628 sg13cmos5l_nand2_1
* cell instance sg13cmos5l_nand2_1_136 r0 *1 0,0
Xsg13cmos5l_nand2_1_136 \$2864 \$2376 VPWR VGND \$2498 sg13cmos5l_nand2_1
* cell instance sg13cmos5l_nand2_1_137 r0 *1 0,0
Xsg13cmos5l_nand2_1_137 \$2866 \$2376 VPWR VGND \$2865 sg13cmos5l_nand2_1
* cell instance sg13cmos5l_nand2_1_138 r0 *1 0,0
Xsg13cmos5l_nand2_1_138 \$164 \$739 VPWR VGND \$390 sg13cmos5l_nand2_1
* cell instance sg13cmos5l_nand2_1_139 r0 *1 0,0
Xsg13cmos5l_nand2_1_139 \$2866 \$2864 VPWR VGND \$2702 sg13cmos5l_nand2_1
* cell instance sg13cmos5l_nand2_1_140 r0 *1 0,0
Xsg13cmos5l_nand2_1_140 \$230 \$1519 VPWR VGND \$307 sg13cmos5l_nand2_1
* cell instance sg13cmos5l_nand2_1_141 r0 *1 0,0
Xsg13cmos5l_nand2_1_141 \$76 \$279 VPWR VGND \$230 sg13cmos5l_nand2_1
* cell instance sg13cmos5l_nand2_1_142 r0 *1 0,0
Xsg13cmos5l_nand2_1_142 \$2376 \$3569 VPWR VGND \$4041 sg13cmos5l_nand2_1
* cell instance sg13cmos5l_nand2_1_143 r0 *1 0,0
Xsg13cmos5l_nand2_1_143 \$737 \$1073 VPWR VGND \$521 sg13cmos5l_nand2_1
* cell instance sg13cmos5l_nand2_1_144 r0 *1 0,0
Xsg13cmos5l_nand2_1_144 \$2378 \$2387 VPWR VGND \$2388 sg13cmos5l_nand2_1
* cell instance sg13cmos5l_nand2_1_145 r0 *1 0,0
Xsg13cmos5l_nand2_1_145 \$3562 \$3900 VPWR VGND \$3901 sg13cmos5l_nand2_1
* cell instance sg13cmos5l_nand2_1_146 r0 *1 0,0
Xsg13cmos5l_nand2_1_146 \$201 \$1418 VPWR VGND \$1524 sg13cmos5l_nand2_1
* cell instance sg13cmos5l_nand2_1_147 r0 *1 0,0
Xsg13cmos5l_nand2_1_147 \$1066 \$85 VPWR VGND \$1065 sg13cmos5l_nand2_1
* cell instance sg13cmos5l_nand2_1_148 r0 *1 0,0
Xsg13cmos5l_nand2_1_148 \$1066 \$726 VPWR VGND \$1765 sg13cmos5l_nand2_1
* cell instance sg13cmos5l_nand2_1_149 r0 *1 0,0
Xsg13cmos5l_nand2_1_149 \$24 \$393 VPWR VGND \$18 sg13cmos5l_nand2_1
* cell instance sg13cmos5l_nand2_1_150 r0 *1 0,0
Xsg13cmos5l_nand2_1_150 \$1639 \$179 VPWR VGND \$75 sg13cmos5l_nand2_1
* cell instance sg13cmos5l_nand2_1_151 r0 *1 0,0
Xsg13cmos5l_nand2_1_151 \$2548 \$3070 VPWR VGND \$3071 sg13cmos5l_nand2_1
* cell instance sg13cmos5l_nand2_1_152 r0 *1 0,0
Xsg13cmos5l_nand2_1_152 \$1655 \$305 VPWR VGND \$1067 sg13cmos5l_nand2_1
* cell instance sg13cmos5l_nand2_1_153 r0 *1 0,0
Xsg13cmos5l_nand2_1_153 \$614 \$179 VPWR VGND \$617 sg13cmos5l_nand2_1
* cell instance sg13cmos5l_nand2_1_154 r0 *1 0,0
Xsg13cmos5l_nand2_1_154 \$319 \$154 VPWR VGND \$315 sg13cmos5l_nand2_1
* cell instance sg13cmos5l_nand2_1_155 r0 *1 0,0
Xsg13cmos5l_nand2_1_155 \$136 \$368 VPWR VGND \$135 sg13cmos5l_nand2_1
* cell instance sg13cmos5l_nand2_1_156 r0 *1 0,0
Xsg13cmos5l_nand2_1_156 \$2719 \$2544 VPWR VGND \$2881 sg13cmos5l_nand2_1
* cell instance sg13cmos5l_nand2_1_157 r0 *1 0,0
Xsg13cmos5l_nand2_1_157 \$319 \$238 VPWR VGND \$318 sg13cmos5l_nand2_1
* cell instance sg13cmos5l_nand2_1_158 r0 *1 0,0
Xsg13cmos5l_nand2_1_158 \$986 \$739 VPWR VGND \$852 sg13cmos5l_nand2_1
* cell instance sg13cmos5l_nand2_1_159 r0 *1 0,0
Xsg13cmos5l_nand2_1_159 \$292 \$983 VPWR VGND \$620 sg13cmos5l_nand2_1
* cell instance sg13cmos5l_nand2_1_160 r0 *1 0,0
Xsg13cmos5l_nand2_1_160 \$449 \$1993 VPWR VGND \$1650 sg13cmos5l_nand2_1
* cell instance sg13cmos5l_nand2_1_161 r0 *1 0,0
Xsg13cmos5l_nand2_1_161 \$39 \$621 VPWR VGND \$442 sg13cmos5l_nand2_1
* cell instance sg13cmos5l_nand2_1_162 r0 *1 0,0
Xsg13cmos5l_nand2_1_162 \$179 \$366 VPWR VGND \$991 sg13cmos5l_nand2_1
* cell instance sg13cmos5l_nand2_1_163 r0 *1 0,0
Xsg13cmos5l_nand2_1_163 \$1653 \$621 VPWR VGND \$386 sg13cmos5l_nand2_1
* cell instance sg13cmos5l_nand2_1_164 r0 *1 0,0
Xsg13cmos5l_nand2_1_164 \$482 \$82 VPWR VGND \$397 sg13cmos5l_nand2_1
* cell instance sg13cmos5l_nand2_1_165 r0 *1 0,0
Xsg13cmos5l_nand2_1_165 \$1769 \$2119 VPWR VGND \$2242 sg13cmos5l_nand2_1
* cell instance sg13cmos5l_nand2_1_166 r0 *1 0,0
Xsg13cmos5l_nand2_1_166 \$195 \$624 VPWR VGND \$27 sg13cmos5l_nand2_1
* cell instance sg13cmos5l_nand2_1_167 r0 *1 0,0
Xsg13cmos5l_nand2_1_167 \$949 \$183 VPWR VGND \$447 sg13cmos5l_nand2_1
* cell instance sg13cmos5l_nand2_1_168 r0 *1 0,0
Xsg13cmos5l_nand2_1_168 \$78 \$30 VPWR VGND \$1858 sg13cmos5l_nand2_1
* cell instance sg13cmos5l_nand2_1_169 r0 *1 0,0
Xsg13cmos5l_nand2_1_169 \$79 \$30 VPWR VGND \$83 sg13cmos5l_nand2_1
* cell instance sg13cmos5l_nand2_1_170 r0 *1 0,0
Xsg13cmos5l_nand2_1_170 \$83 \$280 VPWR VGND \$1658 sg13cmos5l_nand2_1
* cell instance sg13cmos5l_nand2_1_171 r0 *1 0,0
Xsg13cmos5l_nand2_1_171 \$126 \$860 VPWR VGND \$1301 sg13cmos5l_nand2_1
* cell instance sg13cmos5l_nand2_1_172 r0 *1 0,0
Xsg13cmos5l_nand2_1_172 \$136 \$145 VPWR VGND \$194 sg13cmos5l_nand2_1
* cell instance sg13cmos5l_nand2_1_173 r0 *1 0,0
Xsg13cmos5l_nand2_1_173 \$368 \$195 VPWR VGND \$393 sg13cmos5l_nand2_1
* cell instance sg13cmos5l_nand2_1_174 r0 *1 0,0
Xsg13cmos5l_nand2_1_174 \$1655 \$179 VPWR VGND \$974 sg13cmos5l_nand2_1
* cell instance sg13cmos5l_nand2_1_175 r0 *1 0,0
Xsg13cmos5l_nand2_1_175 \$355 \$1878 VPWR VGND \$1435 sg13cmos5l_nand2_1
* cell instance sg13cmos5l_nand2_1_176 r0 *1 0,0
Xsg13cmos5l_nand2_1_176 \$79 \$368 VPWR VGND \$355 sg13cmos5l_nand2_1
* cell instance sg13cmos5l_nand2_1_177 r0 *1 0,0
Xsg13cmos5l_nand2_1_177 \$136 \$19 VPWR VGND \$85 sg13cmos5l_nand2_1
* cell instance sg13cmos5l_nand2_1_178 r0 *1 0,0
Xsg13cmos5l_nand2_1_178 \$136 \$79 VPWR VGND \$358 sg13cmos5l_nand2_1
* cell instance sg13cmos5l_nand2_1_179 r0 *1 0,0
Xsg13cmos5l_nand2_1_179 \$986 \$30 VPWR VGND \$533 sg13cmos5l_nand2_1
* cell instance sg13cmos5l_nand2_1_180 r0 *1 0,0
Xsg13cmos5l_nand2_1_180 \$146 \$624 VPWR VGND \$604 sg13cmos5l_nand2_1
* cell instance sg13cmos5l_nand2_1_181 r0 *1 0,0
Xsg13cmos5l_nand2_1_181 \$358 \$366 VPWR VGND \$402 sg13cmos5l_nand2_1
* cell instance sg13cmos5l_nand2b_1_0 r0 *1 0,0
Xsg13cmos5l_nand2b_1_0 \$2757 \$2758 VPWR VGND \$2405 sg13cmos5l_nand2b_1
* cell instance sg13cmos5l_nand2b_1_1 r0 *1 0,0
Xsg13cmos5l_nand2b_1_1 \$4965 \$2610 VPWR VGND \$4978 sg13cmos5l_nand2b_1
* cell instance sg13cmos5l_nand2b_1_2 r0 *1 0,0
Xsg13cmos5l_nand2b_1_2 \$2758 \$2755 VPWR VGND \$2603 sg13cmos5l_nand2b_1
* cell instance sg13cmos5l_nand2b_1_3 r0 *1 0,0
Xsg13cmos5l_nand2b_1_3 \$1221 \$1212 VPWR VGND \$1222 sg13cmos5l_nand2b_1
* cell instance sg13cmos5l_nand2b_1_4 r0 *1 0,0
Xsg13cmos5l_nand2b_1_4 \$1111 \$1331 VPWR VGND \$1337 sg13cmos5l_nand2b_1
* cell instance sg13cmos5l_nand2b_1_5 r0 *1 0,0
Xsg13cmos5l_nand2b_1_5 \$2027 \$2028 VPWR VGND \$2025 sg13cmos5l_nand2b_1
* cell instance sg13cmos5l_nand2b_1_6 r0 *1 0,0
Xsg13cmos5l_nand2b_1_6 \$6208 \$6081 VPWR VGND \$6058 sg13cmos5l_nand2b_1
* cell instance sg13cmos5l_nand2b_1_7 r0 *1 0,0
Xsg13cmos5l_nand2b_1_7 \$3808 \$2755 VPWR VGND \$3936 sg13cmos5l_nand2b_1
* cell instance sg13cmos5l_nand2b_1_8 r0 *1 0,0
Xsg13cmos5l_nand2b_1_8 \$1488 \$3815 VPWR VGND \$4683 sg13cmos5l_nand2b_1
* cell instance sg13cmos5l_nand2b_1_9 r0 *1 0,0
Xsg13cmos5l_nand2b_1_9 \$2031 \$1906 VPWR VGND \$2422 sg13cmos5l_nand2b_1
* cell instance sg13cmos5l_nand2b_1_10 r0 *1 0,0
Xsg13cmos5l_nand2b_1_10 \$2768 \$2277 VPWR VGND \$2937 sg13cmos5l_nand2b_1
* cell instance sg13cmos5l_nand2b_1_11 r0 *1 0,0
Xsg13cmos5l_nand2b_1_11 \$797 \$1131 VPWR VGND \$1132 sg13cmos5l_nand2b_1
* cell instance sg13cmos5l_nand2b_1_12 r0 *1 0,0
Xsg13cmos5l_nand2b_1_12 \$920 \$805 VPWR VGND \$1145 sg13cmos5l_nand2b_1
* cell instance sg13cmos5l_nand2b_1_13 r0 *1 0,0
Xsg13cmos5l_nand2b_1_13 \$805 \$1007 VPWR VGND \$878 sg13cmos5l_nand2b_1
* cell instance sg13cmos5l_nand2b_1_14 r0 *1 0,0
Xsg13cmos5l_nand2b_1_14 \$920 \$1479 VPWR VGND \$1590 sg13cmos5l_nand2b_1
* cell instance sg13cmos5l_nand2b_1_15 r0 *1 0,0
Xsg13cmos5l_nand2b_1_15 \$920 \$1245 VPWR VGND \$1378 sg13cmos5l_nand2b_1
* cell instance sg13cmos5l_nand2b_1_16 r0 *1 0,0
Xsg13cmos5l_nand2b_1_16 \$920 \$940 VPWR VGND \$879 sg13cmos5l_nand2b_1
* cell instance sg13cmos5l_nand2b_1_17 r0 *1 0,0
Xsg13cmos5l_nand2b_1_17 \$920 \$1600 VPWR VGND \$1711 sg13cmos5l_nand2b_1
* cell instance sg13cmos5l_nand2b_1_18 r0 *1 0,0
Xsg13cmos5l_nand2b_1_18 \$2055 \$2443 VPWR VGND \$1943 sg13cmos5l_nand2b_1
* cell instance sg13cmos5l_nand2b_1_19 r0 *1 0,0
Xsg13cmos5l_nand2b_1_19 \$17112 \$7225 VPWR VGND \$4351 sg13cmos5l_nand2b_1
* cell instance sg13cmos5l_nand2b_1_20 r0 *1 0,0
Xsg13cmos5l_nand2b_1_20 \$17126 \$6644 VPWR VGND \$4352 sg13cmos5l_nand2b_1
* cell instance sg13cmos5l_nand2b_1_21 r0 *1 0,0
Xsg13cmos5l_nand2b_1_21 \$2202 \$2915 VPWR VGND \$1972 sg13cmos5l_nand2b_1
* cell instance sg13cmos5l_nand2b_1_22 r0 *1 0,0
Xsg13cmos5l_nand2b_1_22 \$1812 \$1972 VPWR VGND \$1832 sg13cmos5l_nand2b_1
* cell instance sg13cmos5l_nand2b_1_23 r0 *1 0,0
Xsg13cmos5l_nand2b_1_23 \$1053 \$193 VPWR VGND \$1174 sg13cmos5l_nand2b_1
* cell instance sg13cmos5l_nand2b_1_24 r0 *1 0,0
Xsg13cmos5l_nand2b_1_24 \$4359 \$3153 VPWR VGND \$4376 sg13cmos5l_nand2b_1
* cell instance sg13cmos5l_nand2b_1_25 r0 *1 0,0
Xsg13cmos5l_nand2b_1_25 \$1410 \$1060 VPWR VGND \$1287 sg13cmos5l_nand2b_1
* cell instance sg13cmos5l_nand2b_1_26 r0 *1 0,0
Xsg13cmos5l_nand2b_1_26 \$271 \$272 VPWR VGND \$295 sg13cmos5l_nand2b_1
* cell instance sg13cmos5l_nand2b_1_27 r0 *1 0,0
Xsg13cmos5l_nand2b_1_27 \$2705 \$2869 VPWR VGND \$2867 sg13cmos5l_nand2b_1
* cell instance sg13cmos5l_nand2b_1_28 r0 *1 0,0
Xsg13cmos5l_nand2b_1_28 \$2389 \$2388 VPWR VGND \$2581 sg13cmos5l_nand2b_1
* cell instance sg13cmos5l_nand2b_1_29 r0 *1 0,0
Xsg13cmos5l_nand2b_1_29 \$1653 \$1875 VPWR VGND \$1769 sg13cmos5l_nand2b_1
* cell instance sg13cmos5l_nand3_1_0 r0 *1 0,0
Xsg13cmos5l_nand3_1_0 \$4103 \$4566 \$4567 VPWR VGND \$4568 sg13cmos5l_nand3_1
* cell instance sg13cmos5l_nand3_1_1 r0 *1 0,0
Xsg13cmos5l_nand3_1_1 \$2405 \$2400 \$2594 VPWR VGND \$2595 sg13cmos5l_nand3_1
* cell instance sg13cmos5l_nand3_1_2 r0 *1 0,0
Xsg13cmos5l_nand3_1_2 \$4976 \$5025 \$4975 VPWR VGND \$4980 sg13cmos5l_nand3_1
* cell instance sg13cmos5l_nand3_1_3 r0 *1 0,0
Xsg13cmos5l_nand3_1_3 \$5052 \$3132 \$3287 VPWR VGND \$5025 sg13cmos5l_nand3_1
* cell instance sg13cmos5l_nand3_1_4 r0 *1 0,0
Xsg13cmos5l_nand3_1_4 \$4567 \$2419 \$4569 VPWR VGND \$4439 sg13cmos5l_nand3_1
* cell instance sg13cmos5l_nand3_1_5 r0 *1 0,0
Xsg13cmos5l_nand3_1_5 \$2597 \$2764 \$2763 VPWR VGND \$2146 sg13cmos5l_nand3_1
* cell instance sg13cmos5l_nand3_1_6 r0 *1 0,0
Xsg13cmos5l_nand3_1_6 \$3285 \$3125 \$3627 VPWR VGND \$2267 sg13cmos5l_nand3_1
* cell instance sg13cmos5l_nand3_1_7 r0 *1 0,0
Xsg13cmos5l_nand3_1_7 \$2142 \$4331 \$4116 VPWR VGND \$4332 sg13cmos5l_nand3_1
* cell instance sg13cmos5l_nand3_1_8 r0 *1 0,0
Xsg13cmos5l_nand3_1_8 \$1691 \$1915 \$2609 VPWR VGND \$2611 sg13cmos5l_nand3_1
* cell instance sg13cmos5l_nand3_1_9 r0 *1 0,0
Xsg13cmos5l_nand3_1_9 \$1034 \$921 \$917 VPWR VGND \$1033 sg13cmos5l_nand3_1
* cell instance sg13cmos5l_nand3_1_10 r0 *1 0,0
Xsg13cmos5l_nand3_1_10 \$1033 \$1132 \$1232 VPWR VGND \$1133 sg13cmos5l_nand3_1
* cell instance sg13cmos5l_nand3_1_11 r0 *1 0,0
Xsg13cmos5l_nand3_1_11 \$1161 \$1133 \$1134 VPWR VGND \$922 sg13cmos5l_nand3_1
* cell instance sg13cmos5l_nand3_1_12 r0 *1 0,0
Xsg13cmos5l_nand3_1_12 \$3824 \$3825 \$3496 VPWR VGND \$3640 sg13cmos5l_nand3_1
* cell instance sg13cmos5l_nand3_1_13 r0 *1 0,0
Xsg13cmos5l_nand3_1_13 \$1034 \$1037 \$924 VPWR VGND \$929 sg13cmos5l_nand3_1
* cell instance sg13cmos5l_nand3_1_14 r0 *1 0,0
Xsg13cmos5l_nand3_1_14 \$2779 \$3140 \$3975 VPWR VGND \$3977 sg13cmos5l_nand3_1
* cell instance sg13cmos5l_nand3_1_15 r0 *1 0,0
Xsg13cmos5l_nand3_1_15 \$3141 \$4138 \$4458 VPWR VGND \$4343 sg13cmos5l_nand3_1
* cell instance sg13cmos5l_nand3_1_16 r0 *1 0,0
Xsg13cmos5l_nand3_1_16 \$2174 \$2435 \$1458 VPWR VGND \$2045 sg13cmos5l_nand3_1
* cell instance sg13cmos5l_nand3_1_17 r0 *1 0,0
Xsg13cmos5l_nand3_1_17 \$2174 \$2435 \$1593 VPWR VGND \$2618 sg13cmos5l_nand3_1
* cell instance sg13cmos5l_nand3_1_18 r0 *1 0,0
Xsg13cmos5l_nand3_1_18 \$3498 \$3307 \$2960 VPWR VGND \$3497 sg13cmos5l_nand3_1
* cell instance sg13cmos5l_nand3_1_19 r0 *1 0,0
Xsg13cmos5l_nand3_1_19 \$704 \$701 \$809 VPWR VGND \$689 sg13cmos5l_nand3_1
* cell instance sg13cmos5l_nand3_1_20 r0 *1 0,0
Xsg13cmos5l_nand3_1_20 \$4346 \$3459 \$3311 VPWR VGND \$2955 sg13cmos5l_nand3_1
* cell instance sg13cmos5l_nand3_1_21 r0 *1 0,0
Xsg13cmos5l_nand3_1_21 \$1368 \$1483 \$1596 VPWR VGND \$1152 sg13cmos5l_nand3_1
* cell instance sg13cmos5l_nand3_1_22 r0 *1 0,0
Xsg13cmos5l_nand3_1_22 \$3984 \$4143 \$3985 VPWR VGND \$3986 sg13cmos5l_nand3_1
* cell instance sg13cmos5l_nand3_1_23 r0 *1 0,0
Xsg13cmos5l_nand3_1_23 \$3987 \$3329 \$4333 VPWR VGND \$4162 sg13cmos5l_nand3_1
* cell instance sg13cmos5l_nand3_1_24 r0 *1 0,0
Xsg13cmos5l_nand3_1_24 \$345 \$421 \$881 VPWR VGND \$1622 sg13cmos5l_nand3_1
* cell instance sg13cmos5l_nand3_1_25 r0 *1 0,0
Xsg13cmos5l_nand3_1_25 \$64 \$21 \$265 VPWR VGND \$299 sg13cmos5l_nand3_1
* cell instance sg13cmos5l_nand3_1_26 r0 *1 0,0
Xsg13cmos5l_nand3_1_26 \$36 \$110 \$115 VPWR VGND \$153 sg13cmos5l_nand3_1
* cell instance sg13cmos5l_nand3_1_27 r0 *1 0,0
Xsg13cmos5l_nand3_1_27 \$302 \$55 \$116 VPWR VGND \$301 sg13cmos5l_nand3_1
* cell instance sg13cmos5l_nand3_1_28 r0 *1 0,0
Xsg13cmos5l_nand3_1_28 \$118 \$65 \$83 VPWR VGND \$1748 sg13cmos5l_nand3_1
* cell instance sg13cmos5l_nand3_1_29 r0 *1 0,0
Xsg13cmos5l_nand3_1_29 \$843 \$302 \$353 VPWR VGND \$1402 sg13cmos5l_nand3_1
* cell instance sg13cmos5l_nand3_1_30 r0 *1 0,0
Xsg13cmos5l_nand3_1_30 \$221 \$114 \$116 VPWR VGND \$220 sg13cmos5l_nand3_1
* cell instance sg13cmos5l_nand3_1_31 r0 *1 0,0
Xsg13cmos5l_nand3_1_31 \$302 \$1057 \$1060 VPWR VGND \$1061 sg13cmos5l_nand3_1
* cell instance sg13cmos5l_nand3_1_32 r0 *1 0,0
Xsg13cmos5l_nand3_1_32 \$2102 \$2397 \$2202 VPWR VGND \$2101 sg13cmos5l_nand3_1
* cell instance sg13cmos5l_nand3_1_33 r0 *1 0,0
Xsg13cmos5l_nand3_1_33 \$301 \$727 \$269 VPWR VGND \$732 sg13cmos5l_nand3_1
* cell instance sg13cmos5l_nand3_1_34 r0 *1 0,0
Xsg13cmos5l_nand3_1_34 \$221 \$388 \$453 VPWR VGND \$524 sg13cmos5l_nand3_1
* cell instance sg13cmos5l_nand3_1_35 r0 *1 0,0
Xsg13cmos5l_nand3_1_35 \$121 \$65 \$39 VPWR VGND \$733 sg13cmos5l_nand3_1
* cell instance sg13cmos5l_nand3_1_36 r0 *1 0,0
Xsg13cmos5l_nand3_1_36 \$601 \$732 \$170 VPWR VGND \$600 sg13cmos5l_nand3_1
* cell instance sg13cmos5l_nand3_1_37 r0 *1 0,0
Xsg13cmos5l_nand3_1_37 \$1401 \$733 \$1182 VPWR VGND \$1183 sg13cmos5l_nand3_1
* cell instance sg13cmos5l_nand3_1_38 r0 *1 0,0
Xsg13cmos5l_nand3_1_38 \$275 \$218 \$387 VPWR VGND \$1635 sg13cmos5l_nand3_1
* cell instance sg13cmos5l_nand3_1_39 r0 *1 0,0
Xsg13cmos5l_nand3_1_39 \$1756 \$734 \$972 VPWR VGND \$963 sg13cmos5l_nand3_1
* cell instance sg13cmos5l_nand3_1_40 r0 *1 0,0
Xsg13cmos5l_nand3_1_40 \$2229 \$2226 \$2235 VPWR VGND \$2231 sg13cmos5l_nand3_1
* cell instance sg13cmos5l_nand3_1_41 r0 *1 0,0
Xsg13cmos5l_nand3_1_41 \$154 \$411 \$1211 VPWR VGND \$1289 sg13cmos5l_nand3_1
* cell instance sg13cmos5l_nand3_1_42 r0 *1 0,0
Xsg13cmos5l_nand3_1_42 \$110 \$115 \$117 VPWR VGND \$1063 sg13cmos5l_nand3_1
* cell instance sg13cmos5l_nand3_1_43 r0 *1 0,0
Xsg13cmos5l_nand3_1_43 \$388 \$393 \$1184 VPWR VGND \$1180 sg13cmos5l_nand3_1
* cell instance sg13cmos5l_nand3_1_44 r0 *1 0,0
Xsg13cmos5l_nand3_1_44 \$465 \$429 \$386 VPWR VGND \$426 sg13cmos5l_nand3_1
* cell instance sg13cmos5l_nand3_1_45 r0 *1 0,0
Xsg13cmos5l_nand3_1_45 \$742 \$743 \$848 VPWR VGND \$980 sg13cmos5l_nand3_1
* cell instance sg13cmos5l_nand3_1_46 r0 *1 0,0
Xsg13cmos5l_nand3_1_46 \$76 \$412 \$75 VPWR VGND \$437 sg13cmos5l_nand3_1
* cell instance sg13cmos5l_nand3_1_47 r0 *1 0,0
Xsg13cmos5l_nand3_1_47 \$2719 \$2544 \$2705 VPWR VGND \$3070 sg13cmos5l_nand3_1
* cell instance sg13cmos5l_nand3_1_48 r0 *1 0,0
Xsg13cmos5l_nand3_1_48 \$2739 \$2738 \$2731 VPWR VGND \$2737 sg13cmos5l_nand3_1
* cell instance sg13cmos5l_nand3_1_49 r0 *1 0,0
Xsg13cmos5l_nand3_1_49 \$30 \$146 \$39 VPWR VGND \$25 sg13cmos5l_nand3_1
* cell instance sg13cmos5l_nand3_1_50 r0 *1 0,0
Xsg13cmos5l_nand3_1_50 \$281 \$193 \$280 VPWR VGND \$192 sg13cmos5l_nand3_1
* cell instance sg13cmos5l_nand3_1_51 r0 *1 0,0
Xsg13cmos5l_nand3_1_51 \$195 \$433 \$83 VPWR VGND \$451 sg13cmos5l_nand3_1
* cell instance sg13cmos5l_nand3_1_52 r0 *1 0,0
Xsg13cmos5l_nand3_1_52 \$78 \$145 \$368 VPWR VGND \$280 sg13cmos5l_nand3_1
* cell instance sg13cmos5l_nand3_1_53 r0 *1 0,0
Xsg13cmos5l_nand3_1_53 \$78 \$79 \$30 VPWR VGND \$205 sg13cmos5l_nand3_1
* cell instance sg13cmos5l_nand3_1_54 r0 *1 0,0
Xsg13cmos5l_nand3_1_54 \$533 \$355 \$366 VPWR VGND \$532 sg13cmos5l_nand3_1
* cell instance sg13cmos5l_nand3_1_55 r0 *1 0,0
Xsg13cmos5l_nand3_1_55 \$287 \$289 \$203 VPWR VGND \$290 sg13cmos5l_nand3_1
* cell instance sg13cmos5l_nand3b_1_0 r0 *1 0,0
Xsg13cmos5l_nand3b_1_0 \$337 \$262 \$332 VPWR VGND \$375 sg13cmos5l_nand3b_1
* cell instance sg13cmos5l_nand3b_1_1 r0 *1 0,0
Xsg13cmos5l_nand3b_1_1 \$1721 \$1972 \$1971 VPWR VGND \$1733 sg13cmos5l_nand3b_1
* cell instance sg13cmos5l_nand3b_1_2 r0 *1 0,0
Xsg13cmos5l_nand3b_1_2 \$827 \$441 \$617 VPWR VGND \$619 sg13cmos5l_nand3b_1
* cell instance sg13cmos5l_nand4_1_0 r0 *1 0,0
Xsg13cmos5l_nand4_1_0 \$2757 \$2591 \$3795 \$3110 VPWR VGND \$3111
+ sg13cmos5l_nand4_1
* cell instance sg13cmos5l_nand4_1_1 r0 *1 0,0
Xsg13cmos5l_nand4_1_1 \$4320 \$4319 \$4315 \$4317 VPWR VGND \$4318
+ sg13cmos5l_nand4_1
* cell instance sg13cmos5l_nand4_1_2 r0 *1 0,0
Xsg13cmos5l_nand4_1_2 \$3797 \$3784 \$3801 \$3800 VPWR VGND \$3618
+ sg13cmos5l_nand4_1
* cell instance sg13cmos5l_nand4_1_3 r0 *1 0,0
Xsg13cmos5l_nand4_1_3 \$3118 \$2603 \$2760 \$2761 VPWR VGND \$2416
+ sg13cmos5l_nand4_1
* cell instance sg13cmos5l_nand4_1_4 r0 *1 0,0
Xsg13cmos5l_nand4_1_4 \$2758 \$3808 \$3807 \$2755 VPWR VGND \$3785
+ sg13cmos5l_nand4_1
* cell instance sg13cmos5l_nand4_1_5 r0 *1 0,0
Xsg13cmos5l_nand4_1_5 \$2764 \$4291 \$4313 \$4109 VPWR VGND \$3124
+ sg13cmos5l_nand4_1
* cell instance sg13cmos5l_nand4_1_6 r0 *1 0,0
Xsg13cmos5l_nand4_1_6 \$2422 \$2423 \$2898 \$2606 VPWR VGND \$2768
+ sg13cmos5l_nand4_1
* cell instance sg13cmos5l_nand4_1_7 r0 *1 0,0
Xsg13cmos5l_nand4_1_7 \$2031 \$2001 \$2005 \$1783 VPWR VGND \$2152
+ sg13cmos5l_nand4_1
* cell instance sg13cmos5l_nand4_1_8 r0 *1 0,0
Xsg13cmos5l_nand4_1_8 \$2031 \$2001 \$2029 \$2030 VPWR VGND \$1699
+ sg13cmos5l_nand4_1
* cell instance sg13cmos5l_nand4_1_9 r0 *1 0,0
Xsg13cmos5l_nand4_1_9 \$1117 \$1594 \$2771 \$2770 VPWR VGND \$2427
+ sg13cmos5l_nand4_1
* cell instance sg13cmos5l_nand4_1_10 r0 *1 0,0
Xsg13cmos5l_nand4_1_10 \$1790 \$1373 \$1460 \$2431 VPWR VGND \$3451
+ sg13cmos5l_nand4_1
* cell instance sg13cmos5l_nand4_1_11 r0 *1 0,0
Xsg13cmos5l_nand4_1_11 \$823 \$2043 \$1460 \$2431 VPWR VGND \$3140
+ sg13cmos5l_nand4_1
* cell instance sg13cmos5l_nand4_1_12 r0 *1 0,0
Xsg13cmos5l_nand4_1_12 \$2776 \$2435 \$1458 \$2436 VPWR VGND \$1679
+ sg13cmos5l_nand4_1
* cell instance sg13cmos5l_nand4_1_13 r0 *1 0,0
Xsg13cmos5l_nand4_1_13 \$1327 \$2435 \$1593 \$2436 VPWR VGND \$2943
+ sg13cmos5l_nand4_1
* cell instance sg13cmos5l_nand4_1_14 r0 *1 0,0
Xsg13cmos5l_nand4_1_14 \$2928 \$4162 \$4352 \$4351 VPWR VGND \$4319
+ sg13cmos5l_nand4_1
* cell instance sg13cmos5l_nand4_1_15 r0 *1 0,0
Xsg13cmos5l_nand4_1_15 \$2003 \$1967 \$2308 \$2193 VPWR VGND \$2459
+ sg13cmos5l_nand4_1
* cell instance sg13cmos5l_nand4_1_16 r0 *1 0,0
Xsg13cmos5l_nand4_1_16 \$2003 \$2194 \$2197 \$2193 VPWR VGND \$2198
+ sg13cmos5l_nand4_1
* cell instance sg13cmos5l_nand4_1_17 r0 *1 0,0
Xsg13cmos5l_nand4_1_17 \$46 \$51 \$50 \$48 VPWR VGND \$49 sg13cmos5l_nand4_1
* cell instance sg13cmos5l_nand4_1_18 r0 *1 0,0
Xsg13cmos5l_nand4_1_18 \$157 \$169 \$83 \$52 VPWR VGND \$48 sg13cmos5l_nand4_1
* cell instance sg13cmos5l_nand4_1_19 r0 *1 0,0
Xsg13cmos5l_nand4_1_19 \$117 \$388 \$358 \$266 VPWR VGND \$387
+ sg13cmos5l_nand4_1
* cell instance sg13cmos5l_nand4_1_20 r0 *1 0,0
Xsg13cmos5l_nand4_1_20 \$221 \$387 \$1401 \$733 VPWR VGND \$972
+ sg13cmos5l_nand4_1
* cell instance sg13cmos5l_nand4_1_21 r0 *1 0,0
Xsg13cmos5l_nand4_1_21 \$843 \$825 \$260 \$1184 VPWR VGND \$1211
+ sg13cmos5l_nand4_1
* cell instance sg13cmos5l_nand4_1_22 r0 *1 0,0
Xsg13cmos5l_nand4_1_22 \$2229 \$2834 \$2226 \$2364 VPWR VGND \$2375
+ sg13cmos5l_nand4_1
* cell instance sg13cmos5l_nand4_1_23 r0 *1 0,0
Xsg13cmos5l_nand4_1_23 \$465 \$393 \$25 \$27 VPWR VGND \$743 sg13cmos5l_nand4_1
* cell instance sg13cmos5l_nand4_1_24 r0 *1 0,0
Xsg13cmos5l_nand4_1_24 \$320 \$851 \$1423 \$1422 VPWR VGND \$1424
+ sg13cmos5l_nand4_1
* cell instance sg13cmos5l_nand4_1_25 r0 *1 0,0
Xsg13cmos5l_nand4_1_25 \$2548 \$2888 \$2719 \$2736 VPWR VGND \$2887
+ sg13cmos5l_nand4_1
* cell instance sg13cmos5l_nand4_1_26 r0 *1 0,0
Xsg13cmos5l_nand4_1_26 \$845 \$983 \$1067 \$25 VPWR VGND \$1200
+ sg13cmos5l_nand4_1
* cell instance sg13cmos5l_nand4_1_27 r0 *1 0,0
Xsg13cmos5l_nand4_1_27 \$97 \$17 \$149 \$2 VPWR VGND \$82 sg13cmos5l_nand4_1
* cell instance sg13cmos5l_nand4_1_28 r0 *1 0,0
Xsg13cmos5l_nand4_1_28 \$89 \$1664 \$83 \$974 VPWR VGND \$2119
+ sg13cmos5l_nand4_1
* cell instance sg13cmos5l_nand4_1_29 r0 *1 0,0
Xsg13cmos5l_nand4_1_29 \$183 \$252 \$192 \$191 VPWR VGND \$70 sg13cmos5l_nand4_1
* cell instance sg13cmos5l_nand4_1_30 r0 *1 0,0
Xsg13cmos5l_nand4_1_30 \$195 \$194 \$193 \$83 VPWR VGND \$191 sg13cmos5l_nand4_1
* cell instance sg13cmos5l_nor2_1_0 r0 *1 0,0
Xsg13cmos5l_nor2_1_0 \$1716 \$4095 VPWR VGND \$4096 sg13cmos5l_nor2_1
* cell instance sg13cmos5l_nor2_1_1 r0 *1 0,0
Xsg13cmos5l_nor2_1_1 \$2254 \$2257 VPWR VGND \$2591 sg13cmos5l_nor2_1
* cell instance sg13cmos5l_nor2_1_2 r0 *1 0,0
Xsg13cmos5l_nor2_1_2 \$1159 \$3612 VPWR VGND \$3795 sg13cmos5l_nor2_1
* cell instance sg13cmos5l_nor2_1_3 r0 *1 0,0
Xsg13cmos5l_nor2_1_3 \$4097 \$4096 VPWR VGND \$4103 sg13cmos5l_nor2_1
* cell instance sg13cmos5l_nor2_1_4 r0 *1 0,0
Xsg13cmos5l_nor2_1_4 \$3795 \$2923 VPWR VGND \$3796 sg13cmos5l_nor2_1
* cell instance sg13cmos5l_nor2_1_5 r0 *1 0,0
Xsg13cmos5l_nor2_1_5 \$3275 \$3273 VPWR VGND \$3276 sg13cmos5l_nor2_1
* cell instance sg13cmos5l_nor2_1_6 r0 *1 0,0
Xsg13cmos5l_nor2_1_6 \$2591 \$2592 VPWR VGND \$2593 sg13cmos5l_nor2_1
* cell instance sg13cmos5l_nor2_1_7 r0 *1 0,0
Xsg13cmos5l_nor2_1_7 \$4564 \$4674 VPWR VGND \$4675 sg13cmos5l_nor2_1
* cell instance sg13cmos5l_nor2_1_8 r0 *1 0,0
Xsg13cmos5l_nor2_1_8 \$3795 \$3799 VPWR VGND \$2753 sg13cmos5l_nor2_1
* cell instance sg13cmos5l_nor2_1_9 r0 *1 0,0
Xsg13cmos5l_nor2_1_9 \$4564 \$2263 VPWR VGND \$4431 sg13cmos5l_nor2_1
* cell instance sg13cmos5l_nor2_1_10 r0 *1 0,0
Xsg13cmos5l_nor2_1_10 \$1250 \$3967 VPWR VGND \$4676 sg13cmos5l_nor2_1
* cell instance sg13cmos5l_nor2_1_11 r0 *1 0,0
Xsg13cmos5l_nor2_1_11 \$645 \$646 VPWR VGND \$643 sg13cmos5l_nor2_1
* cell instance sg13cmos5l_nor2_1_12 r0 *1 0,0
Xsg13cmos5l_nor2_1_12 \$4679 \$4680 VPWR VGND \$4322 sg13cmos5l_nor2_1
* cell instance sg13cmos5l_nor2_1_13 r0 *1 0,0
Xsg13cmos5l_nor2_1_13 \$11545 \$11398 VPWR VGND \$11380 sg13cmos5l_nor2_1
* cell instance sg13cmos5l_nor2_1_14 r0 *1 0,0
Xsg13cmos5l_nor2_1_14 \$1089 \$2141 VPWR VGND \$2253 sg13cmos5l_nor2_1
* cell instance sg13cmos5l_nor2_1_15 r0 *1 0,0
Xsg13cmos5l_nor2_1_15 \$1234 \$3117 VPWR VGND \$2757 sg13cmos5l_nor2_1
* cell instance sg13cmos5l_nor2_1_16 r0 *1 0,0
Xsg13cmos5l_nor2_1_16 \$646 \$2142 VPWR VGND \$2141 sg13cmos5l_nor2_1
* cell instance sg13cmos5l_nor2_1_17 r0 *1 0,0
Xsg13cmos5l_nor2_1_17 \$1216 \$872 VPWR VGND \$1217 sg13cmos5l_nor2_1
* cell instance sg13cmos5l_nor2_1_18 r0 *1 0,0
Xsg13cmos5l_nor2_1_18 \$3473 \$3273 VPWR VGND \$3280 sg13cmos5l_nor2_1
* cell instance sg13cmos5l_nor2_1_19 r0 *1 0,0
Xsg13cmos5l_nor2_1_19 \$4965 \$4981 VPWR VGND \$4679 sg13cmos5l_nor2_1
* cell instance sg13cmos5l_nor2_1_20 r0 *1 0,0
Xsg13cmos5l_nor2_1_20 \$12462 \$12461 VPWR VGND \$12138 sg13cmos5l_nor2_1
* cell instance sg13cmos5l_nor2_1_21 r0 *1 0,0
Xsg13cmos5l_nor2_1_21 \$4336 \$3480 VPWR VGND \$15562 sg13cmos5l_nor2_1
* cell instance sg13cmos5l_nor2_1_22 r0 *1 0,0
Xsg13cmos5l_nor2_1_22 \$3110 \$3280 VPWR VGND \$2754 sg13cmos5l_nor2_1
* cell instance sg13cmos5l_nor2_1_23 r0 *1 0,0
Xsg13cmos5l_nor2_1_23 \$4144 \$5004 VPWR VGND \$16935 sg13cmos5l_nor2_1
* cell instance sg13cmos5l_nor2_1_24 r0 *1 0,0
Xsg13cmos5l_nor2_1_24 \$4432 \$4435 VPWR VGND \$4105 sg13cmos5l_nor2_1
* cell instance sg13cmos5l_nor2_1_25 r0 *1 0,0
Xsg13cmos5l_nor2_1_25 \$5023 \$5024 VPWR VGND \$5898 sg13cmos5l_nor2_1
* cell instance sg13cmos5l_nor2_1_26 r0 *1 0,0
Xsg13cmos5l_nor2_1_26 \$4290 \$11910 VPWR VGND \$14358 sg13cmos5l_nor2_1
* cell instance sg13cmos5l_nor2_1_27 r0 *1 0,0
Xsg13cmos5l_nor2_1_27 \$1216 \$1329 VPWR VGND \$1331 sg13cmos5l_nor2_1
* cell instance sg13cmos5l_nor2_1_28 r0 *1 0,0
Xsg13cmos5l_nor2_1_28 \$899 \$1331 VPWR VGND \$1332 sg13cmos5l_nor2_1
* cell instance sg13cmos5l_nor2_1_29 r0 *1 0,0
Xsg13cmos5l_nor2_1_29 \$1895 \$1783 VPWR VGND \$1784 sg13cmos5l_nor2_1
* cell instance sg13cmos5l_nor2_1_30 r0 *1 0,0
Xsg13cmos5l_nor2_1_30 \$645 \$935 VPWR VGND \$903 sg13cmos5l_nor2_1
* cell instance sg13cmos5l_nor2_1_31 r0 *1 0,0
Xsg13cmos5l_nor2_1_31 \$5047 \$4985 VPWR VGND \$6389 sg13cmos5l_nor2_1
* cell instance sg13cmos5l_nor2_1_32 r0 *1 0,0
Xsg13cmos5l_nor2_1_32 \$5047 \$5055 VPWR VGND \$6081 sg13cmos5l_nor2_1
* cell instance sg13cmos5l_nor2_1_33 r0 *1 0,0
Xsg13cmos5l_nor2_1_33 \$2028 \$2422 VPWR VGND \$2419 sg13cmos5l_nor2_1
* cell instance sg13cmos5l_nor2_1_34 r0 *1 0,0
Xsg13cmos5l_nor2_1_34 \$1782 \$2029 VPWR VGND \$1785 sg13cmos5l_nor2_1
* cell instance sg13cmos5l_nor2_1_35 r0 *1 0,0
Xsg13cmos5l_nor2_1_35 \$3285 \$2767 VPWR VGND \$3286 sg13cmos5l_nor2_1
* cell instance sg13cmos5l_nor2_1_36 r0 *1 0,0
Xsg13cmos5l_nor2_1_36 \$1906 \$2423 VPWR VGND \$2411 sg13cmos5l_nor2_1
* cell instance sg13cmos5l_nor2_1_37 r0 *1 0,0
Xsg13cmos5l_nor2_1_37 \$11998 \$11398 VPWR VGND \$11917 sg13cmos5l_nor2_1
* cell instance sg13cmos5l_nor2_1_38 r0 *1 0,0
Xsg13cmos5l_nor2_1_38 \$645 \$1530 VPWR VGND \$1688 sg13cmos5l_nor2_1
* cell instance sg13cmos5l_nor2_1_39 r0 *1 0,0
Xsg13cmos5l_nor2_1_39 \$13503 \$12461 VPWR VGND \$13336 sg13cmos5l_nor2_1
* cell instance sg13cmos5l_nor2_1_40 r0 *1 0,0
Xsg13cmos5l_nor2_1_40 \$2770 \$2606 VPWR VGND \$2930 sg13cmos5l_nor2_1
* cell instance sg13cmos5l_nor2_1_41 r0 *1 0,0
Xsg13cmos5l_nor2_1_41 \$3287 \$2606 VPWR VGND \$3116 sg13cmos5l_nor2_1
* cell instance sg13cmos5l_nor2_1_42 r0 *1 0,0
Xsg13cmos5l_nor2_1_42 \$12464 \$12461 VPWR VGND \$12302 sg13cmos5l_nor2_1
* cell instance sg13cmos5l_nor2_1_43 r0 *1 0,0
Xsg13cmos5l_nor2_1_43 \$3827 \$3648 VPWR VGND \$14364 sg13cmos5l_nor2_1
* cell instance sg13cmos5l_nor2_1_44 r0 *1 0,0
Xsg13cmos5l_nor2_1_44 \$5058 \$2285 VPWR VGND \$5026 sg13cmos5l_nor2_1
* cell instance sg13cmos5l_nor2_1_45 r0 *1 0,0
Xsg13cmos5l_nor2_1_45 \$4426 \$3976 VPWR VGND \$12303 sg13cmos5l_nor2_1
* cell instance sg13cmos5l_nor2_1_46 r0 *1 0,0
Xsg13cmos5l_nor2_1_46 \$1786 \$2004 VPWR VGND \$1692 sg13cmos5l_nor2_1
* cell instance sg13cmos5l_nor2_1_47 r0 *1 0,0
Xsg13cmos5l_nor2_1_47 \$2027 \$1786 VPWR VGND \$1565 sg13cmos5l_nor2_1
* cell instance sg13cmos5l_nor2_1_48 r0 *1 0,0
Xsg13cmos5l_nor2_1_48 \$1488 \$3815 VPWR VGND \$3813 sg13cmos5l_nor2_1
* cell instance sg13cmos5l_nor2_1_49 r0 *1 0,0
Xsg13cmos5l_nor2_1_49 \$5237 \$5238 VPWR VGND \$5103 sg13cmos5l_nor2_1
* cell instance sg13cmos5l_nor2_1_50 r0 *1 0,0
Xsg13cmos5l_nor2_1_50 \$2928 \$2768 VPWR VGND \$3113 sg13cmos5l_nor2_1
* cell instance sg13cmos5l_nor2_1_51 r0 *1 0,0
Xsg13cmos5l_nor2_1_51 \$2270 \$2422 VPWR VGND \$2899 sg13cmos5l_nor2_1
* cell instance sg13cmos5l_nor2_1_52 r0 *1 0,0
Xsg13cmos5l_nor2_1_52 \$10956 \$9576 VPWR VGND \$10878 sg13cmos5l_nor2_1
* cell instance sg13cmos5l_nor2_1_53 r0 *1 0,0
Xsg13cmos5l_nor2_1_53 \$4293 \$4335 VPWR VGND \$13340 sg13cmos5l_nor2_1
* cell instance sg13cmos5l_nor2_1_54 r0 *1 0,0
Xsg13cmos5l_nor2_1_54 \$1786 \$2422 VPWR VGND \$2400 sg13cmos5l_nor2_1
* cell instance sg13cmos5l_nor2_1_55 r0 *1 0,0
Xsg13cmos5l_nor2_1_55 \$1906 \$2270 VPWR VGND \$2900 sg13cmos5l_nor2_1
* cell instance sg13cmos5l_nor2_1_56 r0 *1 0,0
Xsg13cmos5l_nor2_1_56 \$2027 \$2270 VPWR VGND \$2928 sg13cmos5l_nor2_1
* cell instance sg13cmos5l_nor2_1_57 r0 *1 0,0
Xsg13cmos5l_nor2_1_57 \$3132 \$3287 VPWR VGND \$7410 sg13cmos5l_nor2_1
* cell instance sg13cmos5l_nor2_1_58 r0 *1 0,0
Xsg13cmos5l_nor2_1_58 \$2027 \$2020 VPWR VGND \$2608 sg13cmos5l_nor2_1
* cell instance sg13cmos5l_nor2_1_59 r0 *1 0,0
Xsg13cmos5l_nor2_1_59 \$899 \$1112 VPWR VGND \$925 sg13cmos5l_nor2_1
* cell instance sg13cmos5l_nor2_1_60 r0 *1 0,0
Xsg13cmos5l_nor2_1_60 \$2152 \$4693 VPWR VGND \$4575 sg13cmos5l_nor2_1
* cell instance sg13cmos5l_nor2_1_61 r0 *1 0,0
Xsg13cmos5l_nor2_1_61 \$3132 \$2770 VPWR VGND \$7183 sg13cmos5l_nor2_1
* cell instance sg13cmos5l_nor2_1_62 r0 *1 0,0
Xsg13cmos5l_nor2_1_62 \$4453 \$9578 VPWR VGND \$14975 sg13cmos5l_nor2_1
* cell instance sg13cmos5l_nor2_1_63 r0 *1 0,0
Xsg13cmos5l_nor2_1_63 \$2771 \$3287 VPWR VGND \$2433 sg13cmos5l_nor2_1
* cell instance sg13cmos5l_nor2_1_64 r0 *1 0,0
Xsg13cmos5l_nor2_1_64 \$2769 \$1679 VPWR VGND \$3633 sg13cmos5l_nor2_1
* cell instance sg13cmos5l_nor2_1_65 r0 *1 0,0
Xsg13cmos5l_nor2_1_65 \$1699 \$2427 VPWR VGND \$2426 sg13cmos5l_nor2_1
* cell instance sg13cmos5l_nor2_1_66 r0 *1 0,0
Xsg13cmos5l_nor2_1_66 \$1702 \$1794 VPWR VGND \$1569 sg13cmos5l_nor2_1
* cell instance sg13cmos5l_nor2_1_67 r0 *1 0,0
Xsg13cmos5l_nor2_1_67 \$1790 \$1464 VPWR VGND \$1916 sg13cmos5l_nor2_1
* cell instance sg13cmos5l_nor2_1_68 r0 *1 0,0
Xsg13cmos5l_nor2_1_68 \$12001 \$10959 VPWR VGND \$12072 sg13cmos5l_nor2_1
* cell instance sg13cmos5l_nor2_1_69 r0 *1 0,0
Xsg13cmos5l_nor2_1_69 \$799 \$1797 VPWR VGND \$1796 sg13cmos5l_nor2_1
* cell instance sg13cmos5l_nor2_1_70 r0 *1 0,0
Xsg13cmos5l_nor2_1_70 \$1034 \$1472 VPWR VGND \$1131 sg13cmos5l_nor2_1
* cell instance sg13cmos5l_nor2_1_71 r0 *1 0,0
Xsg13cmos5l_nor2_1_71 \$2277 \$2433 VPWR VGND \$2615 sg13cmos5l_nor2_1
* cell instance sg13cmos5l_nor2_1_72 r0 *1 0,0
Xsg13cmos5l_nor2_1_72 \$1034 \$1797 VPWR VGND \$1702 sg13cmos5l_nor2_1
* cell instance sg13cmos5l_nor2_1_73 r0 *1 0,0
Xsg13cmos5l_nor2_1_73 \$1924 \$2043 VPWR VGND \$1926 sg13cmos5l_nor2_1
* cell instance sg13cmos5l_nor2_1_74 r0 *1 0,0
Xsg13cmos5l_nor2_1_74 \$2776 \$2618 VPWR VGND \$2945 sg13cmos5l_nor2_1
* cell instance sg13cmos5l_nor2_1_75 r0 *1 0,0
Xsg13cmos5l_nor2_1_75 \$1373 \$1594 VPWR VGND \$2436 sg13cmos5l_nor2_1
* cell instance sg13cmos5l_nor2_1_76 r0 *1 0,0
Xsg13cmos5l_nor2_1_76 \$1327 \$2618 VPWR VGND \$3840 sg13cmos5l_nor2_1
* cell instance sg13cmos5l_nor2_1_77 r0 *1 0,0
Xsg13cmos5l_nor2_1_77 \$1373 \$1460 VPWR VGND \$2174 sg13cmos5l_nor2_1
* cell instance sg13cmos5l_nor2_1_78 r0 *1 0,0
Xsg13cmos5l_nor2_1_78 \$1940 \$2041 VPWR VGND \$2175 sg13cmos5l_nor2_1
* cell instance sg13cmos5l_nor2_1_79 r0 *1 0,0
Xsg13cmos5l_nor2_1_79 \$2452 \$2443 VPWR VGND \$2619 sg13cmos5l_nor2_1
* cell instance sg13cmos5l_nor2_1_80 r0 *1 0,0
Xsg13cmos5l_nor2_1_80 \$1045 \$1152 VPWR VGND \$809 sg13cmos5l_nor2_1
* cell instance sg13cmos5l_nor2_1_81 r0 *1 0,0
Xsg13cmos5l_nor2_1_81 \$2205 \$2443 VPWR VGND \$2290 sg13cmos5l_nor2_1
* cell instance sg13cmos5l_nor2_1_82 r0 *1 0,0
Xsg13cmos5l_nor2_1_82 \$405 \$373 VPWR VGND \$408 sg13cmos5l_nor2_1
* cell instance sg13cmos5l_nor2_1_83 r0 *1 0,0
Xsg13cmos5l_nor2_1_83 \$31 \$38 VPWR VGND \$32 sg13cmos5l_nor2_1
* cell instance sg13cmos5l_nor2_1_84 r0 *1 0,0
Xsg13cmos5l_nor2_1_84 \$2196 \$2193 VPWR VGND \$2055 sg13cmos5l_nor2_1
* cell instance sg13cmos5l_nor2_1_85 r0 *1 0,0
Xsg13cmos5l_nor2_1_85 \$2182 \$2191 VPWR VGND \$1945 sg13cmos5l_nor2_1
* cell instance sg13cmos5l_nor2_1_86 r0 *1 0,0
Xsg13cmos5l_nor2_1_86 \$157 \$159 VPWR VGND \$158 sg13cmos5l_nor2_1
* cell instance sg13cmos5l_nor2_1_87 r0 *1 0,0
Xsg13cmos5l_nor2_1_87 \$2639 \$1822 VPWR VGND \$2641 sg13cmos5l_nor2_1
* cell instance sg13cmos5l_nor2_1_88 r0 *1 0,0
Xsg13cmos5l_nor2_1_88 \$2194 \$1945 VPWR VGND \$2195 sg13cmos5l_nor2_1
* cell instance sg13cmos5l_nor2_1_89 r0 *1 0,0
Xsg13cmos5l_nor2_1_89 \$103 \$39 VPWR VGND \$107 sg13cmos5l_nor2_1
* cell instance sg13cmos5l_nor2_1_90 r0 *1 0,0
Xsg13cmos5l_nor2_1_90 \$673 \$349 VPWR VGND \$376 sg13cmos5l_nor2_1
* cell instance sg13cmos5l_nor2_1_91 r0 *1 0,0
Xsg13cmos5l_nor2_1_91 \$2196 \$2459 VPWR VGND \$2460 sg13cmos5l_nor2_1
* cell instance sg13cmos5l_nor2_1_92 r0 *1 0,0
Xsg13cmos5l_nor2_1_92 \$36 \$31 VPWR VGND \$353 sg13cmos5l_nor2_1
* cell instance sg13cmos5l_nor2_1_93 r0 *1 0,0
Xsg13cmos5l_nor2_1_93 \$297 \$209 VPWR VGND \$416 sg13cmos5l_nor2_1
* cell instance sg13cmos5l_nor2_1_94 r0 *1 0,0
Xsg13cmos5l_nor2_1_94 \$2769 \$2943 VPWR VGND \$3152 sg13cmos5l_nor2_1
* cell instance sg13cmos5l_nor2_1_95 r0 *1 0,0
Xsg13cmos5l_nor2_1_95 \$2308 \$2198 VPWR VGND \$2309 sg13cmos5l_nor2_1
* cell instance sg13cmos5l_nor2_1_96 r0 *1 0,0
Xsg13cmos5l_nor2_1_96 \$569 \$345 VPWR VGND \$169 sg13cmos5l_nor2_1
* cell instance sg13cmos5l_nor2_1_97 r0 *1 0,0
Xsg13cmos5l_nor2_1_97 \$31 \$103 VPWR VGND \$163 sg13cmos5l_nor2_1
* cell instance sg13cmos5l_nor2_1_98 r0 *1 0,0
Xsg13cmos5l_nor2_1_98 \$2068 \$1822 VPWR VGND \$2069 sg13cmos5l_nor2_1
* cell instance sg13cmos5l_nor2_1_99 r0 *1 0,0
Xsg13cmos5l_nor2_1_99 \$2068 \$2196 VPWR VGND \$2070 sg13cmos5l_nor2_1
* cell instance sg13cmos5l_nor2_1_100 r0 *1 0,0
Xsg13cmos5l_nor2_1_100 \$335 \$354 VPWR VGND \$417 sg13cmos5l_nor2_1
* cell instance sg13cmos5l_nor2_1_101 r0 *1 0,0
Xsg13cmos5l_nor2_1_101 \$33 \$38 VPWR VGND \$114 sg13cmos5l_nor2_1
* cell instance sg13cmos5l_nor2_1_102 r0 *1 0,0
Xsg13cmos5l_nor2_1_102 \$43 \$38 VPWR VGND \$4 sg13cmos5l_nor2_1
* cell instance sg13cmos5l_nor2_1_103 r0 *1 0,0
Xsg13cmos5l_nor2_1_103 \$157 \$569 VPWR VGND \$881 sg13cmos5l_nor2_1
* cell instance sg13cmos5l_nor2_1_104 r0 *1 0,0
Xsg13cmos5l_nor2_1_104 \$43 \$157 VPWR VGND \$164 sg13cmos5l_nor2_1
* cell instance sg13cmos5l_nor2_1_105 r0 *1 0,0
Xsg13cmos5l_nor2_1_105 \$33 \$43 VPWR VGND \$421 sg13cmos5l_nor2_1
* cell instance sg13cmos5l_nor2_1_106 r0 *1 0,0
Xsg13cmos5l_nor2_1_106 \$266 \$231 VPWR VGND \$300 sg13cmos5l_nor2_1
* cell instance sg13cmos5l_nor2_1_107 r0 *1 0,0
Xsg13cmos5l_nor2_1_107 \$110 \$117 VPWR VGND \$116 sg13cmos5l_nor2_1
* cell instance sg13cmos5l_nor2_1_108 r0 *1 0,0
Xsg13cmos5l_nor2_1_108 \$118 \$115 VPWR VGND \$119 sg13cmos5l_nor2_1
* cell instance sg13cmos5l_nor2_1_109 r0 *1 0,0
Xsg13cmos5l_nor2_1_109 \$117 \$275 VPWR VGND \$887 sg13cmos5l_nor2_1
* cell instance sg13cmos5l_nor2_1_110 r0 *1 0,0
Xsg13cmos5l_nor2_1_110 \$120 \$121 VPWR VGND \$148 sg13cmos5l_nor2_1
* cell instance sg13cmos5l_nor2_1_111 r0 *1 0,0
Xsg13cmos5l_nor2_1_111 \$518 \$303 VPWR VGND \$1989 sg13cmos5l_nor2_1
* cell instance sg13cmos5l_nor2_1_112 r0 *1 0,0
Xsg13cmos5l_nor2_1_112 \$2102 \$2202 VPWR VGND \$2222 sg13cmos5l_nor2_1
* cell instance sg13cmos5l_nor2_1_113 r0 *1 0,0
Xsg13cmos5l_nor2_1_113 \$106 \$65 VPWR VGND \$61 sg13cmos5l_nor2_1
* cell instance sg13cmos5l_nor2_1_114 r0 *1 0,0
Xsg13cmos5l_nor2_1_114 \$118 \$121 VPWR VGND \$173 sg13cmos5l_nor2_1
* cell instance sg13cmos5l_nor2_1_115 r0 *1 0,0
Xsg13cmos5l_nor2_1_115 \$275 \$521 VPWR VGND \$1519 sg13cmos5l_nor2_1
* cell instance sg13cmos5l_nor2_1_116 r0 *1 0,0
Xsg13cmos5l_nor2_1_116 \$422 \$1857 VPWR VGND \$2106 sg13cmos5l_nor2_1
* cell instance sg13cmos5l_nor2_1_117 r0 *1 0,0
Xsg13cmos5l_nor2_1_117 \$21 \$7 VPWR VGND \$22 sg13cmos5l_nor2_1
* cell instance sg13cmos5l_nor2_1_118 r0 *1 0,0
Xsg13cmos5l_nor2_1_118 \$302 \$67 VPWR VGND \$360 sg13cmos5l_nor2_1
* cell instance sg13cmos5l_nor2_1_119 r0 *1 0,0
Xsg13cmos5l_nor2_1_119 \$275 \$178 VPWR VGND \$226 sg13cmos5l_nor2_1
* cell instance sg13cmos5l_nor2_1_120 r0 *1 0,0
Xsg13cmos5l_nor2_1_120 \$24 \$739 VPWR VGND \$883 sg13cmos5l_nor2_1
* cell instance sg13cmos5l_nor2_1_121 r0 *1 0,0
Xsg13cmos5l_nor2_1_121 \$77 \$421 VPWR VGND \$278 sg13cmos5l_nor2_1
* cell instance sg13cmos5l_nor2_1_122 r0 *1 0,0
Xsg13cmos5l_nor2_1_122 \$2375 \$2702 VPWR VGND \$2703 sg13cmos5l_nor2_1
* cell instance sg13cmos5l_nor2_1_123 r0 *1 0,0
Xsg13cmos5l_nor2_1_123 \$76 \$52 VPWR VGND \$123 sg13cmos5l_nor2_1
* cell instance sg13cmos5l_nor2_1_124 r0 *1 0,0
Xsg13cmos5l_nor2_1_124 \$949 \$1073 VPWR VGND \$740 sg13cmos5l_nor2_1
* cell instance sg13cmos5l_nor2_1_125 r0 *1 0,0
Xsg13cmos5l_nor2_1_125 \$2702 \$2867 VPWR VGND \$3042 sg13cmos5l_nor2_1
* cell instance sg13cmos5l_nor2_1_126 r0 *1 0,0
Xsg13cmos5l_nor2_1_126 \$3047 \$3042 VPWR VGND \$3048 sg13cmos5l_nor2_1
* cell instance sg13cmos5l_nor2_1_127 r0 *1 0,0
Xsg13cmos5l_nor2_1_127 \$2384 \$2386 VPWR VGND \$2385 sg13cmos5l_nor2_1
* cell instance sg13cmos5l_nor2_1_128 r0 *1 0,0
Xsg13cmos5l_nor2_1_128 \$2378 \$2387 VPWR VGND \$2384 sg13cmos5l_nor2_1
* cell instance sg13cmos5l_nor2_1_129 r0 *1 0,0
Xsg13cmos5l_nor2_1_129 \$77 \$179 VPWR VGND \$1523 sg13cmos5l_nor2_1
* cell instance sg13cmos5l_nor2_1_130 r0 *1 0,0
Xsg13cmos5l_nor2_1_130 \$4392 \$3034 VPWR VGND \$4386 sg13cmos5l_nor2_1
* cell instance sg13cmos5l_nor2_1_131 r0 *1 0,0
Xsg13cmos5l_nor2_1_131 \$2389 \$2388 VPWR VGND \$2386 sg13cmos5l_nor2_1
* cell instance sg13cmos5l_nor2_1_132 r0 *1 0,0
Xsg13cmos5l_nor2_1_132 \$292 \$1414 VPWR VGND \$979 sg13cmos5l_nor2_1
* cell instance sg13cmos5l_nor2_1_133 r0 *1 0,0
Xsg13cmos5l_nor2_1_133 \$279 \$983 VPWR VGND \$849 sg13cmos5l_nor2_1
* cell instance sg13cmos5l_nor2_1_134 r0 *1 0,0
Xsg13cmos5l_nor2_1_134 \$55 \$64 VPWR VGND \$74 sg13cmos5l_nor2_1
* cell instance sg13cmos5l_nor2_1_135 r0 *1 0,0
Xsg13cmos5l_nor2_1_135 \$2880 \$2881 VPWR VGND \$2869 sg13cmos5l_nor2_1
* cell instance sg13cmos5l_nor2_1_136 r0 *1 0,0
Xsg13cmos5l_nor2_1_136 \$1270 \$435 VPWR VGND \$1184 sg13cmos5l_nor2_1
* cell instance sg13cmos5l_nor2_1_137 r0 *1 0,0
Xsg13cmos5l_nor2_1_137 \$319 \$1073 VPWR VGND \$1993 sg13cmos5l_nor2_1
* cell instance sg13cmos5l_nor2_1_138 r0 *1 0,0
Xsg13cmos5l_nor2_1_138 \$292 \$615 VPWR VGND \$850 sg13cmos5l_nor2_1
* cell instance sg13cmos5l_nor2_1_139 r0 *1 0,0
Xsg13cmos5l_nor2_1_139 \$4403 \$3034 VPWR VGND \$4401 sg13cmos5l_nor2_1
* cell instance sg13cmos5l_nor2_1_140 r0 *1 0,0
Xsg13cmos5l_nor2_1_140 \$949 \$183 VPWR VGND \$1756 sg13cmos5l_nor2_1
* cell instance sg13cmos5l_nor2_1_141 r0 *1 0,0
Xsg13cmos5l_nor2_1_141 \$319 \$183 VPWR VGND \$742 sg13cmos5l_nor2_1
* cell instance sg13cmos5l_nor2_1_142 r0 *1 0,0
Xsg13cmos5l_nor2_1_142 \$315 \$2121 VPWR VGND \$2240 sg13cmos5l_nor2_1
* cell instance sg13cmos5l_nor2_1_143 r0 *1 0,0
Xsg13cmos5l_nor2_1_143 \$3582 \$3034 VPWR VGND \$3583 sg13cmos5l_nor2_1
* cell instance sg13cmos5l_nor2_1_144 r0 *1 0,0
Xsg13cmos5l_nor2_1_144 \$134 \$244 VPWR VGND \$245 sg13cmos5l_nor2_1
* cell instance sg13cmos5l_nor2_1_145 r0 *1 0,0
Xsg13cmos5l_nor2_1_145 \$1650 \$1872 VPWR VGND \$2241 sg13cmos5l_nor2_1
* cell instance sg13cmos5l_nor2_1_146 r0 *1 0,0
Xsg13cmos5l_nor2_1_146 \$2393 \$2550 VPWR VGND \$2544 sg13cmos5l_nor2_1
* cell instance sg13cmos5l_nor2_1_147 r0 *1 0,0
Xsg13cmos5l_nor2_1_147 \$985 \$1201 VPWR VGND \$832 sg13cmos5l_nor2_1
* cell instance sg13cmos5l_nor2_1_148 r0 *1 0,0
Xsg13cmos5l_nor2_1_148 \$845 \$832 VPWR VGND \$1428 sg13cmos5l_nor2_1
* cell instance sg13cmos5l_nor2_1_149 r0 *1 0,0
Xsg13cmos5l_nor2_1_149 \$1201 \$449 VPWR VGND \$1875 sg13cmos5l_nor2_1
* cell instance sg13cmos5l_nor2_1_150 r0 *1 0,0
Xsg13cmos5l_nor2_1_150 \$856 \$624 VPWR VGND \$1657 sg13cmos5l_nor2_1
* cell instance sg13cmos5l_nor2_1_151 r0 *1 0,0
Xsg13cmos5l_nor2_1_151 \$194 \$393 VPWR VGND \$268 sg13cmos5l_nor2_1
* cell instance sg13cmos5l_nor2_1_152 r0 *1 0,0
Xsg13cmos5l_nor2_1_152 \$393 \$198 VPWR VGND \$745 sg13cmos5l_nor2_1
* cell instance sg13cmos5l_nor2_1_153 r0 *1 0,0
Xsg13cmos5l_nor2_1_153 \$482 \$400 VPWR VGND \$445 sg13cmos5l_nor2_1
* cell instance sg13cmos5l_nor2_1_154 r0 *1 0,0
Xsg13cmos5l_nor2_1_154 \$32 \$85 VPWR VGND \$84 sg13cmos5l_nor2_1
* cell instance sg13cmos5l_nor2_1_155 r0 *1 0,0
Xsg13cmos5l_nor2_1_155 \$140 \$865 VPWR VGND \$453 sg13cmos5l_nor2_1
* cell instance sg13cmos5l_nor2_1_156 r0 *1 0,0
Xsg13cmos5l_nor2_1_156 \$79 \$1655 VPWR VGND \$1528 sg13cmos5l_nor2_1
* cell instance sg13cmos5l_nor2_1_157 r0 *1 0,0
Xsg13cmos5l_nor2_1_157 \$1439 \$1307 VPWR VGND \$2124 sg13cmos5l_nor2_1
* cell instance sg13cmos5l_nor2_1_158 r0 *1 0,0
Xsg13cmos5l_nor2_1_158 \$19 \$173 VPWR VGND \$182 sg13cmos5l_nor2_1
* cell instance sg13cmos5l_nor2_1_159 r0 *1 0,0
Xsg13cmos5l_nor2_1_159 \$985 \$986 VPWR VGND \$624 sg13cmos5l_nor2_1
* cell instance sg13cmos5l_nor2_1_160 r0 *1 0,0
Xsg13cmos5l_nor2_1_160 \$1879 \$865 VPWR VGND \$1437 sg13cmos5l_nor2_1
* cell instance sg13cmos5l_nor2_1_161 r0 *1 0,0
Xsg13cmos5l_nor2_1_161 \$173 \$64 VPWR VGND \$199 sg13cmos5l_nor2_1
* cell instance sg13cmos5l_nor2_1_162 r0 *1 0,0
Xsg13cmos5l_nor2_1_162 \$433 \$64 VPWR VGND \$1410 sg13cmos5l_nor2_1
* cell instance sg13cmos5l_nor2_1_163 r0 *1 0,0
Xsg13cmos5l_nor2_1_163 \$89 \$856 VPWR VGND \$281 sg13cmos5l_nor2_1
* cell instance sg13cmos5l_nor2_1_164 r0 *1 0,0
Xsg13cmos5l_nor2_1_164 \$331 \$949 VPWR VGND \$1313 sg13cmos5l_nor2_1
* cell instance sg13cmos5l_nor2_1_165 r0 *1 0,0
Xsg13cmos5l_nor2_1_165 \$1664 \$949 VPWR VGND \$996 sg13cmos5l_nor2_1
* cell instance sg13cmos5l_nor2b_1_0 r0 *1 0,0
Xsg13cmos5l_nor2b_1_0 \$2257 \$2254 VPWR VGND \$2256 sg13cmos5l_nor2b_1
* cell instance sg13cmos5l_nor2b_1_1 r0 *1 0,0
Xsg13cmos5l_nor2b_1_1 \$3612 \$1159 VPWR VGND \$3613 sg13cmos5l_nor2b_1
* cell instance sg13cmos5l_nor2b_1_2 r0 *1 0,0
Xsg13cmos5l_nor2b_1_2 \$4095 \$1716 VPWR VGND \$4674 sg13cmos5l_nor2b_1
* cell instance sg13cmos5l_nor2b_1_3 r0 *1 0,0
Xsg13cmos5l_nor2b_1_3 \$2246 \$5037 VPWR VGND \$4983 sg13cmos5l_nor2b_1
* cell instance sg13cmos5l_nor2b_1_4 r0 *1 0,0
Xsg13cmos5l_nor2b_1_4 \$3811 \$3807 VPWR VGND \$4106 sg13cmos5l_nor2b_1
* cell instance sg13cmos5l_nor2b_1_5 r0 *1 0,0
Xsg13cmos5l_nor2b_1_5 \$3124 \$2422 VPWR VGND \$3125 sg13cmos5l_nor2b_1
* cell instance sg13cmos5l_nor2b_1_6 r0 *1 0,0
Xsg13cmos5l_nor2b_1_6 \$5055 \$5047 VPWR VGND \$6082 sg13cmos5l_nor2b_1
* cell instance sg13cmos5l_nor2b_1_7 r0 *1 0,0
Xsg13cmos5l_nor2b_1_7 \$6389 \$3260 VPWR VGND \$5605 sg13cmos5l_nor2b_1
* cell instance sg13cmos5l_nor2b_1_8 r0 *1 0,0
Xsg13cmos5l_nor2b_1_8 \$4691 \$5098 VPWR VGND \$4972 sg13cmos5l_nor2b_1
* cell instance sg13cmos5l_nor2b_1_9 r0 *1 0,0
Xsg13cmos5l_nor2b_1_9 \$6082 \$3260 VPWR VGND \$5871 sg13cmos5l_nor2b_1
* cell instance sg13cmos5l_nor2b_1_10 r0 *1 0,0
Xsg13cmos5l_nor2b_1_10 \$5238 \$5237 VPWR VGND \$5357 sg13cmos5l_nor2b_1
* cell instance sg13cmos5l_nor2b_1_11 r0 *1 0,0
Xsg13cmos5l_nor2b_1_11 \$5237 \$5238 VPWR VGND \$5418 sg13cmos5l_nor2b_1
* cell instance sg13cmos5l_nor2b_1_12 r0 *1 0,0
Xsg13cmos5l_nor2b_1_12 \$6057 \$3260 VPWR VGND \$5606 sg13cmos5l_nor2b_1
* cell instance sg13cmos5l_nor2b_1_13 r0 *1 0,0
Xsg13cmos5l_nor2b_1_13 \$2769 \$3297 VPWR VGND \$3971 sg13cmos5l_nor2b_1
* cell instance sg13cmos5l_nor2b_1_14 r0 *1 0,0
Xsg13cmos5l_nor2b_1_14 \$2277 \$2433 VPWR VGND \$2282 sg13cmos5l_nor2b_1
* cell instance sg13cmos5l_nor2b_1_15 r0 *1 0,0
Xsg13cmos5l_nor2b_1_15 \$1926 \$1813 VPWR VGND \$1593 sg13cmos5l_nor2b_1
* cell instance sg13cmos5l_nor2b_1_16 r0 *1 0,0
Xsg13cmos5l_nor2b_1_16 \$1928 \$2948 VPWR VGND \$2777 sg13cmos5l_nor2b_1
* cell instance sg13cmos5l_nor2b_1_17 r0 *1 0,0
Xsg13cmos5l_nor2b_1_17 \$1231 \$1928 VPWR VGND \$1934 sg13cmos5l_nor2b_1
* cell instance sg13cmos5l_nor2b_1_18 r0 *1 0,0
Xsg13cmos5l_nor2b_1_18 \$594 \$50 VPWR VGND \$591 sg13cmos5l_nor2b_1
* cell instance sg13cmos5l_nor2b_1_19 r0 *1 0,0
Xsg13cmos5l_nor2b_1_19 \$2233 \$2231 VPWR VGND \$2232 sg13cmos5l_nor2b_1
* cell instance sg13cmos5l_nor2b_1_20 r0 *1 0,0
Xsg13cmos5l_nor2b_1_20 \$1761 \$1519 VPWR VGND \$1758 sg13cmos5l_nor2b_1
* cell instance sg13cmos5l_nor2b_1_21 r0 *1 0,0
Xsg13cmos5l_nor2b_1_21 \$131 \$153 VPWR VGND \$228 sg13cmos5l_nor2b_1
* cell instance sg13cmos5l_nor2b_1_22 r0 *1 0,0
Xsg13cmos5l_nor2b_1_22 \$1628 \$1763 VPWR VGND \$1764 sg13cmos5l_nor2b_1
* cell instance sg13cmos5l_nor2b_1_23 r0 *1 0,0
Xsg13cmos5l_nor2b_1_23 \$1195 \$1192 VPWR VGND \$1293 sg13cmos5l_nor2b_1
* cell instance sg13cmos5l_nor2b_1_24 r0 *1 0,0
Xsg13cmos5l_nor2b_1_24 \$1417 \$1421 VPWR VGND \$1526 sg13cmos5l_nor2b_1
* cell instance sg13cmos5l_nor3_1_0 r0 *1 0,0
Xsg13cmos5l_nor3_1_0 \$2593 \$2753 \$2754 VPWR VGND \$2594 sg13cmos5l_nor3_1
* cell instance sg13cmos5l_nor3_1_1 r0 *1 0,0
Xsg13cmos5l_nor3_1_1 \$3470 \$2263 \$3471 VPWR VGND \$2407 sg13cmos5l_nor3_1
* cell instance sg13cmos5l_nor3_1_2 r0 *1 0,0
Xsg13cmos5l_nor3_1_2 \$1585 \$4679 \$4680 VPWR VGND \$4432 sg13cmos5l_nor3_1
* cell instance sg13cmos5l_nor3_1_3 r0 *1 0,0
Xsg13cmos5l_nor3_1_3 \$1008 \$651 \$896 VPWR VGND \$897 sg13cmos5l_nor3_1
* cell instance sg13cmos5l_nor3_1_4 r0 *1 0,0
Xsg13cmos5l_nor3_1_4 \$2415 \$2266 \$2267 VPWR VGND \$2265 sg13cmos5l_nor3_1
* cell instance sg13cmos5l_nor3_1_5 r0 *1 0,0
Xsg13cmos5l_nor3_1_5 \$4103 \$4105 \$4106 VPWR VGND \$2763 sg13cmos5l_nor3_1
* cell instance sg13cmos5l_nor3_1_6 r0 *1 0,0
Xsg13cmos5l_nor3_1_6 \$1895 \$2020 \$2004 VPWR VGND \$2021 sg13cmos5l_nor3_1
* cell instance sg13cmos5l_nor3_1_7 r0 *1 0,0
Xsg13cmos5l_nor3_1_7 \$2004 \$1784 \$1785 VPWR VGND \$803 sg13cmos5l_nor3_1
* cell instance sg13cmos5l_nor3_1_8 r0 *1 0,0
Xsg13cmos5l_nor3_1_8 \$4691 \$5605 \$5342 VPWR VGND \$5413 sg13cmos5l_nor3_1
* cell instance sg13cmos5l_nor3_1_9 r0 *1 0,0
Xsg13cmos5l_nor3_1_9 \$4691 \$5871 \$5343 VPWR VGND \$5760 sg13cmos5l_nor3_1
* cell instance sg13cmos5l_nor3_1_10 r0 *1 0,0
Xsg13cmos5l_nor3_1_10 \$2031 \$1906 \$2020 VPWR VGND \$2607 sg13cmos5l_nor3_1
* cell instance sg13cmos5l_nor3_1_11 r0 *1 0,0
Xsg13cmos5l_nor3_1_11 \$4575 \$4111 \$4446 VPWR VGND \$4572 sg13cmos5l_nor3_1
* cell instance sg13cmos5l_nor3_1_12 r0 *1 0,0
Xsg13cmos5l_nor3_1_12 \$4691 \$5606 \$5344 VPWR VGND \$5758 sg13cmos5l_nor3_1
* cell instance sg13cmos5l_nor3_1_13 r0 *1 0,0
Xsg13cmos5l_nor3_1_13 \$1530 \$918 \$1563 VPWR VGND \$1223 sg13cmos5l_nor3_1
* cell instance sg13cmos5l_nor3_1_14 r0 *1 0,0
Xsg13cmos5l_nor3_1_14 \$1326 \$1699 \$1530 VPWR VGND \$1700 sg13cmos5l_nor3_1
* cell instance sg13cmos5l_nor3_1_15 r0 *1 0,0
Xsg13cmos5l_nor3_1_15 \$1373 \$1594 \$2614 VPWR VGND \$3297 sg13cmos5l_nor3_1
* cell instance sg13cmos5l_nor3_1_16 r0 *1 0,0
Xsg13cmos5l_nor3_1_16 \$1327 \$2279 \$1593 VPWR VGND \$2431 sg13cmos5l_nor3_1
* cell instance sg13cmos5l_nor3_1_17 r0 *1 0,0
Xsg13cmos5l_nor3_1_17 \$2773 \$2615 \$2611 VPWR VGND \$2567 sg13cmos5l_nor3_1
* cell instance sg13cmos5l_nor3_1_18 r0 *1 0,0
Xsg13cmos5l_nor3_1_18 \$1034 \$1472 \$1479 VPWR VGND \$1583 sg13cmos5l_nor3_1
* cell instance sg13cmos5l_nor3_1_19 r0 *1 0,0
Xsg13cmos5l_nor3_1_19 \$2196 \$2307 \$2637 VPWR VGND \$2636 sg13cmos5l_nor3_1
* cell instance sg13cmos5l_nor3_1_20 r0 *1 0,0
Xsg13cmos5l_nor3_1_20 \$721 \$413 \$722 VPWR VGND \$641 sg13cmos5l_nor3_1
* cell instance sg13cmos5l_nor3_1_21 r0 *1 0,0
Xsg13cmos5l_nor3_1_21 \$54 \$259 \$955 VPWR VGND \$827 sg13cmos5l_nor3_1
* cell instance sg13cmos5l_nor3_1_22 r0 *1 0,0
Xsg13cmos5l_nor3_1_22 \$45 \$260 \$259 VPWR VGND \$211 sg13cmos5l_nor3_1
* cell instance sg13cmos5l_nor3_1_23 r0 *1 0,0
Xsg13cmos5l_nor3_1_23 \$120 \$110 \$103 VPWR VGND \$955 sg13cmos5l_nor3_1
* cell instance sg13cmos5l_nor3_1_24 r0 *1 0,0
Xsg13cmos5l_nor3_1_24 \$33 \$43 \$115 VPWR VGND \$259 sg13cmos5l_nor3_1
* cell instance sg13cmos5l_nor3_1_25 r0 *1 0,0
Xsg13cmos5l_nor3_1_25 \$43 \$38 \$45 VPWR VGND \$44 sg13cmos5l_nor3_1
* cell instance sg13cmos5l_nor3_1_26 r0 *1 0,0
Xsg13cmos5l_nor3_1_26 \$31 \$114 \$297 VPWR VGND \$298 sg13cmos5l_nor3_1
* cell instance sg13cmos5l_nor3_1_27 r0 *1 0,0
Xsg13cmos5l_nor3_1_27 \$420 \$1273 \$20 VPWR VGND \$1272 sg13cmos5l_nor3_1
* cell instance sg13cmos5l_nor3_1_28 r0 *1 0,0
Xsg13cmos5l_nor3_1_28 \$356 \$298 \$354 VPWR VGND \$357 sg13cmos5l_nor3_1
* cell instance sg13cmos5l_nor3_1_29 r0 *1 0,0
Xsg13cmos5l_nor3_1_29 \$405 \$596 \$515 VPWR VGND \$583 sg13cmos5l_nor3_1
* cell instance sg13cmos5l_nor3_1_30 r0 *1 0,0
Xsg13cmos5l_nor3_1_30 \$517 \$728 \$729 VPWR VGND \$718 sg13cmos5l_nor3_1
* cell instance sg13cmos5l_nor3_1_31 r0 *1 0,0
Xsg13cmos5l_nor3_1_31 \$221 \$730 \$731 VPWR VGND \$729 sg13cmos5l_nor3_1
* cell instance sg13cmos5l_nor3_1_32 r0 *1 0,0
Xsg13cmos5l_nor3_1_32 \$673 \$1629 \$1210 VPWR VGND \$1631 sg13cmos5l_nor3_1
* cell instance sg13cmos5l_nor3_1_33 r0 *1 0,0
Xsg13cmos5l_nor3_1_33 \$453 \$28 \$621 VPWR VGND \$265 sg13cmos5l_nor3_1
* cell instance sg13cmos5l_nor3_1_34 r0 *1 0,0
Xsg13cmos5l_nor3_1_34 \$221 \$67 \$282 VPWR VGND \$389 sg13cmos5l_nor3_1
* cell instance sg13cmos5l_nor3_1_35 r0 *1 0,0
Xsg13cmos5l_nor3_1_35 \$120 \$121 \$65 VPWR VGND \$67 sg13cmos5l_nor3_1
* cell instance sg13cmos5l_nor3_1_36 r0 *1 0,0
Xsg13cmos5l_nor3_1_36 \$177 \$77 \$179 VPWR VGND \$178 sg13cmos5l_nor3_1
* cell instance sg13cmos5l_nor3_1_37 r0 *1 0,0
Xsg13cmos5l_nor3_1_37 \$465 \$393 \$37 VPWR VGND \$526 sg13cmos5l_nor3_1
* cell instance sg13cmos5l_nor3_1_38 r0 *1 0,0
Xsg13cmos5l_nor3_1_38 \$123 \$611 \$612 VPWR VGND \$608 sg13cmos5l_nor3_1
* cell instance sg13cmos5l_nor3_1_39 r0 *1 0,0
Xsg13cmos5l_nor3_1_39 \$422 \$2114 \$416 VPWR VGND \$2115 sg13cmos5l_nor3_1
* cell instance sg13cmos5l_nor3_1_40 r0 *1 0,0
Xsg13cmos5l_nor3_1_40 \$77 \$114 \$279 VPWR VGND \$237 sg13cmos5l_nor3_1
* cell instance sg13cmos5l_nor3_1_41 r0 *1 0,0
Xsg13cmos5l_nor3_1_41 \$435 \$976 \$1401 VPWR VGND \$2114 sg13cmos5l_nor3_1
* cell instance sg13cmos5l_nor3_1_42 r0 *1 0,0
Xsg13cmos5l_nor3_1_42 \$76 \$955 \$1419 VPWR VGND \$1417 sg13cmos5l_nor3_1
* cell instance sg13cmos5l_nor3_1_43 r0 *1 0,0
Xsg13cmos5l_nor3_1_43 \$2880 \$2881 \$2705 VPWR VGND \$2708 sg13cmos5l_nor3_1
* cell instance sg13cmos5l_nor3_1_44 r0 *1 0,0
Xsg13cmos5l_nor3_1_44 \$1866 \$2240 \$2241 VPWR VGND \$409 sg13cmos5l_nor3_1
* cell instance sg13cmos5l_nor3_1_45 r0 *1 0,0
Xsg13cmos5l_nor3_1_45 \$2735 \$2393 \$2350 VPWR VGND \$2736 sg13cmos5l_nor3_1
* cell instance sg13cmos5l_nor3_1_46 r0 *1 0,0
Xsg13cmos5l_nor3_1_46 \$245 \$325 \$326 VPWR VGND \$324 sg13cmos5l_nor3_1
* cell instance sg13cmos5l_nor3_1_47 r0 *1 0,0
Xsg13cmos5l_nor3_1_47 \$4 \$21 \$7 VPWR VGND \$15 sg13cmos5l_nor3_1
* cell instance sg13cmos5l_nor3_1_48 r0 *1 0,0
Xsg13cmos5l_nor3_1_48 \$195 \$739 \$624 VPWR VGND \$251 sg13cmos5l_nor3_1
* cell instance sg13cmos5l_nor3_1_49 r0 *1 0,0
Xsg13cmos5l_nor3_1_49 \$140 \$142 \$1655 VPWR VGND \$1439 sg13cmos5l_nor3_1
* cell instance sg13cmos5l_nor3_1_50 r0 *1 0,0
Xsg13cmos5l_nor3_1_50 \$140 \$986 \$1879 VPWR VGND \$1419 sg13cmos5l_nor3_1
* cell instance sg13cmos5l_nor3_1_51 r0 *1 0,0
Xsg13cmos5l_nor3_1_51 \$78 \$145 \$368 VPWR VGND \$7 sg13cmos5l_nor3_1
* cell instance sg13cmos5l_nor3_1_52 r0 *1 0,0
Xsg13cmos5l_nor3_1_52 \$146 \$163 \$198 VPWR VGND \$197 sg13cmos5l_nor3_1
* cell instance sg13cmos5l_nor3_1_53 r0 *1 0,0
Xsg13cmos5l_nor3_1_53 \$976 \$1882 \$1663 VPWR VGND \$1881 sg13cmos5l_nor3_1
* cell instance sg13cmos5l_nor3_1_54 r0 *1 0,0
Xsg13cmos5l_nor3_1_54 \$331 \$856 \$1410 VPWR VGND \$1882 sg13cmos5l_nor3_1
* cell instance sg13cmos5l_nor3_1_55 r0 *1 0,0
Xsg13cmos5l_nor3_1_55 \$865 \$1439 \$1307 VPWR VGND \$134 sg13cmos5l_nor3_1
* cell instance sg13cmos5l_nor3_1_56 r0 *1 0,0
Xsg13cmos5l_nor3_1_56 \$949 \$238 \$889 VPWR VGND \$869 sg13cmos5l_nor3_1
* cell instance sg13cmos5l_nor3_1_57 r0 *1 0,0
Xsg13cmos5l_nor3_1_57 \$19 \$173 \$1419 VPWR VGND \$284 sg13cmos5l_nor3_1
* cell instance sg13cmos5l_nor3_1_58 r0 *1 0,0
Xsg13cmos5l_nor3_1_58 \$281 \$159 \$1439 VPWR VGND \$1308 sg13cmos5l_nor3_1
* cell instance sg13cmos5l_nor4_1_0 r0 *1 0,0
Xsg13cmos5l_nor4_1_0 \$2592 \$3280 \$3964 \$3785 VPWR VGND \$3474
+ sg13cmos5l_nor4_1
* cell instance sg13cmos5l_nor4_1_1 r0 *1 0,0
Xsg13cmos5l_nor4_1_1 \$2148 \$2265 \$2420 \$3474 VPWR VGND \$2147
+ sg13cmos5l_nor4_1
* cell instance sg13cmos5l_nor4_1_2 r0 *1 0,0
Xsg13cmos5l_nor4_1_2 \$3123 \$3124 \$2923 \$3111 VPWR VGND \$2420
+ sg13cmos5l_nor4_1
* cell instance sg13cmos5l_nor4_1_3 r0 *1 0,0
Xsg13cmos5l_nor4_1_3 \$1111 \$1001 \$1222 \$1021 VPWR VGND \$1112
+ sg13cmos5l_nor4_1
* cell instance sg13cmos5l_nor4_1_4 r0 *1 0,0
Xsg13cmos5l_nor4_1_4 \$3286 \$3601 \$3289 \$3291 VPWR VGND \$3478
+ sg13cmos5l_nor4_1
* cell instance sg13cmos5l_nor4_1_5 r0 *1 0,0
Xsg13cmos5l_nor4_1_5 \$3490 \$2931 \$3819 \$3816 VPWR VGND \$3820
+ sg13cmos5l_nor4_1
* cell instance sg13cmos5l_nor4_1_6 r0 *1 0,0
Xsg13cmos5l_nor4_1_6 \$4340 \$4332 \$4436 \$4442 VPWR VGND \$4448
+ sg13cmos5l_nor4_1
* cell instance sg13cmos5l_nor4_1_7 r0 *1 0,0
Xsg13cmos5l_nor4_1_7 \$2279 \$1699 \$2427 \$2612 VPWR VGND \$2428
+ sg13cmos5l_nor4_1
* cell instance sg13cmos5l_nor4_1_8 r0 *1 0,0
Xsg13cmos5l_nor4_1_8 \$1373 \$1460 \$2279 \$1458 VPWR VGND \$2901
+ sg13cmos5l_nor4_1
* cell instance sg13cmos5l_nor4_1_9 r0 *1 0,0
Xsg13cmos5l_nor4_1_9 \$1041 \$646 \$874 \$935 VPWR VGND \$2435 sg13cmos5l_nor4_1
* cell instance sg13cmos5l_nor4_1_10 r0 *1 0,0
Xsg13cmos5l_nor4_1_10 \$33 \$45 \$355 \$28 VPWR VGND \$354 sg13cmos5l_nor4_1
* cell instance sg13cmos5l_nor4_1_11 r0 *1 0,0
Xsg13cmos5l_nor4_1_11 \$33 \$103 \$159 \$64 VPWR VGND \$216 sg13cmos5l_nor4_1
* cell instance sg13cmos5l_nor4_1_12 r0 *1 0,0
Xsg13cmos5l_nor4_1_12 \$356 \$6 \$58 \$166 VPWR VGND \$60 sg13cmos5l_nor4_1
* cell instance sg13cmos5l_nor4_1_13 r0 *1 0,0
Xsg13cmos5l_nor4_1_13 \$737 \$154 \$303 \$389 VPWR VGND \$1991 sg13cmos5l_nor4_1
* cell instance sg13cmos5l_nor4_1_14 r0 *1 0,0
Xsg13cmos5l_nor4_1_14 \$1064 \$843 \$292 \$739 VPWR VGND \$846 sg13cmos5l_nor4_1
* cell instance sg13cmos5l_nor4_1_15 r0 *1 0,0
Xsg13cmos5l_nor4_1_15 \$608 \$522 \$432 \$609 VPWR VGND \$610 sg13cmos5l_nor4_1
* cell instance sg13cmos5l_nor4_1_16 r0 *1 0,0
Xsg13cmos5l_nor4_1_16 \$1189 \$1865 \$1866 \$1764 VPWR VGND \$1864
+ sg13cmos5l_nor4_1
* cell instance sg13cmos5l_nor4_1_17 r0 *1 0,0
Xsg13cmos5l_nor4_1_17 \$673 \$235 \$311 \$308 VPWR VGND \$312 sg13cmos5l_nor4_1
* cell instance sg13cmos5l_nor4_1_18 r0 *1 0,0
Xsg13cmos5l_nor4_1_18 \$2880 \$2885 \$2350 \$2737 VPWR VGND \$2886
+ sg13cmos5l_nor4_1
* cell instance sg13cmos5l_nor4_1_19 r0 *1 0,0
Xsg13cmos5l_nor4_1_19 \$986 \$89 \$1664 \$1858 VPWR VGND \$2120
+ sg13cmos5l_nor4_1
* cell instance sg13cmos5l_nor4_1_20 r0 *1 0,0
Xsg13cmos5l_nor4_1_20 \$865 \$331 \$856 \$148 VPWR VGND \$1878 sg13cmos5l_nor4_1
* cell instance sg13cmos5l_nor4_1_21 r0 *1 0,0
Xsg13cmos5l_nor4_1_21 \$322 \$869 \$999 \$1000 VPWR VGND \$629 sg13cmos5l_nor4_1
* cell instance sg13cmos5l_o21ai_1_0 r0 *1 0,0
Xsg13cmos5l_o21ai_1_0 \$2591 \$2923 \$2925 VPWR VGND \$2924 sg13cmos5l_o21ai_1
* cell instance sg13cmos5l_o21ai_1_1 r0 *1 0,0
Xsg13cmos5l_o21ai_1_1 \$4096 \$2923 \$4099 VPWR VGND \$4098 sg13cmos5l_o21ai_1
* cell instance sg13cmos5l_o21ai_1_2 r0 *1 0,0
Xsg13cmos5l_o21ai_1_2 \$2406 \$2408 \$2595 VPWR VGND \$2597 sg13cmos5l_o21ai_1
* cell instance sg13cmos5l_o21ai_1_3 r0 *1 0,0
Xsg13cmos5l_o21ai_1_3 \$2261 \$2263 \$2264 VPWR VGND \$2136 sg13cmos5l_o21ai_1
* cell instance sg13cmos5l_o21ai_1_4 r0 *1 0,0
Xsg13cmos5l_o21ai_1_4 \$7203 \$5024 \$5023 VPWR VGND \$7157 sg13cmos5l_o21ai_1
* cell instance sg13cmos5l_o21ai_1_5 r0 *1 0,0
Xsg13cmos5l_o21ai_1_5 \$643 \$756 \$644 VPWR VGND \$757 sg13cmos5l_o21ai_1
* cell instance sg13cmos5l_o21ai_1_6 r0 *1 0,0
Xsg13cmos5l_o21ai_1_6 \$5035 \$5023 \$5024 VPWR VGND \$4976 sg13cmos5l_o21ai_1
* cell instance sg13cmos5l_o21ai_1_7 r0 *1 0,0
Xsg13cmos5l_o21ai_1_7 \$5584 \$5024 \$5023 VPWR VGND \$5867 sg13cmos5l_o21ai_1
* cell instance sg13cmos5l_o21ai_1_8 r0 *1 0,0
Xsg13cmos5l_o21ai_1_8 \$4679 \$4680 \$3962 VPWR VGND \$4566 sg13cmos5l_o21ai_1
* cell instance sg13cmos5l_o21ai_1_9 r0 *1 0,0
Xsg13cmos5l_o21ai_1_9 \$6406 \$5024 \$5023 VPWR VGND \$6387 sg13cmos5l_o21ai_1
* cell instance sg13cmos5l_o21ai_1_10 r0 *1 0,0
Xsg13cmos5l_o21ai_1_10 \$1012 \$896 \$645 VPWR VGND \$890 sg13cmos5l_o21ai_1
* cell instance sg13cmos5l_o21ai_1_11 r0 *1 0,0
Xsg13cmos5l_o21ai_1_11 \$896 \$1017 \$1018 VPWR VGND \$1015 sg13cmos5l_o21ai_1
* cell instance sg13cmos5l_o21ai_1_12 r0 *1 0,0
Xsg13cmos5l_o21ai_1_12 \$1326 \$1327 \$1328 VPWR VGND \$1219 sg13cmos5l_o21ai_1
* cell instance sg13cmos5l_o21ai_1_13 r0 *1 0,0
Xsg13cmos5l_o21ai_1_13 \$3473 \$7261 \$16497 VPWR VGND \$16260
+ sg13cmos5l_o21ai_1
* cell instance sg13cmos5l_o21ai_1_14 r0 *1 0,0
Xsg13cmos5l_o21ai_1_14 \$4435 \$3808 \$4323 VPWR VGND \$4104 sg13cmos5l_o21ai_1
* cell instance sg13cmos5l_o21ai_1_15 r0 *1 0,0
Xsg13cmos5l_o21ai_1_15 \$4432 \$4435 \$4683 VPWR VGND \$4567 sg13cmos5l_o21ai_1
* cell instance sg13cmos5l_o21ai_1_16 r0 *1 0,0
Xsg13cmos5l_o21ai_1_16 \$2143 \$2144 \$2019 VPWR VGND \$5597 sg13cmos5l_o21ai_1
* cell instance sg13cmos5l_o21ai_1_17 r0 *1 0,0
Xsg13cmos5l_o21ai_1_17 \$899 \$897 \$872 VPWR VGND \$756 sg13cmos5l_o21ai_1
* cell instance sg13cmos5l_o21ai_1_18 r0 *1 0,0
Xsg13cmos5l_o21ai_1_18 \$3811 \$4101 \$3807 VPWR VGND \$3625 sg13cmos5l_o21ai_1
* cell instance sg13cmos5l_o21ai_1_19 r0 *1 0,0
Xsg13cmos5l_o21ai_1_19 \$1212 \$1221 \$1335 VPWR VGND \$1334 sg13cmos5l_o21ai_1
* cell instance sg13cmos5l_o21ai_1_20 r0 *1 0,0
Xsg13cmos5l_o21ai_1_20 \$1594 \$2142 \$4328 VPWR VGND \$4327 sg13cmos5l_o21ai_1
* cell instance sg13cmos5l_o21ai_1_21 r0 *1 0,0
Xsg13cmos5l_o21ai_1_21 \$3968 \$14513 \$15524 VPWR VGND \$15261
+ sg13cmos5l_o21ai_1
* cell instance sg13cmos5l_o21ai_1_22 r0 *1 0,0
Xsg13cmos5l_o21ai_1_22 \$3627 \$2767 \$3620 VPWR VGND \$3629 sg13cmos5l_o21ai_1
* cell instance sg13cmos5l_o21ai_1_23 r0 *1 0,0
Xsg13cmos5l_o21ai_1_23 \$4313 \$2767 \$4429 VPWR VGND \$4328 sg13cmos5l_o21ai_1
* cell instance sg13cmos5l_o21ai_1_24 r0 *1 0,0
Xsg13cmos5l_o21ai_1_24 \$3823 \$4327 \$4992 VPWR VGND \$4991 sg13cmos5l_o21ai_1
* cell instance sg13cmos5l_o21ai_1_25 r0 *1 0,0
Xsg13cmos5l_o21ai_1_25 \$935 \$2937 \$3629 VPWR VGND \$3631 sg13cmos5l_o21ai_1
* cell instance sg13cmos5l_o21ai_1_26 r0 *1 0,0
Xsg13cmos5l_o21ai_1_26 \$4109 \$2767 \$4439 VPWR VGND \$4442 sg13cmos5l_o21ai_1
* cell instance sg13cmos5l_o21ai_1_27 r0 *1 0,0
Xsg13cmos5l_o21ai_1_27 \$4291 \$2767 \$4572 VPWR VGND \$4571 sg13cmos5l_o21ai_1
* cell instance sg13cmos5l_o21ai_1_28 r0 *1 0,0
Xsg13cmos5l_o21ai_1_28 \$3823 \$3631 \$4996 VPWR VGND \$4995 sg13cmos5l_o21ai_1
* cell instance sg13cmos5l_o21ai_1_29 r0 *1 0,0
Xsg13cmos5l_o21ai_1_29 \$7253 \$4981 \$6972 VPWR VGND \$3967 sg13cmos5l_o21ai_1
* cell instance sg13cmos5l_o21ai_1_30 r0 *1 0,0
Xsg13cmos5l_o21ai_1_30 \$1585 \$14513 \$16498 VPWR VGND \$16850
+ sg13cmos5l_o21ai_1
* cell instance sg13cmos5l_o21ai_1_31 r0 *1 0,0
Xsg13cmos5l_o21ai_1_31 \$1585 \$16985 \$16952 VPWR VGND \$17045
+ sg13cmos5l_o21ai_1
* cell instance sg13cmos5l_o21ai_1_32 r0 *1 0,0
Xsg13cmos5l_o21ai_1_32 \$756 \$670 \$783 VPWR VGND \$782 sg13cmos5l_o21ai_1
* cell instance sg13cmos5l_o21ai_1_33 r0 *1 0,0
Xsg13cmos5l_o21ai_1_33 \$1326 \$1460 \$1338 VPWR VGND \$1343 sg13cmos5l_o21ai_1
* cell instance sg13cmos5l_o21ai_1_34 r0 *1 0,0
Xsg13cmos5l_o21ai_1_34 \$874 \$2142 \$2149 VPWR VGND \$2144 sg13cmos5l_o21ai_1
* cell instance sg13cmos5l_o21ai_1_35 r0 *1 0,0
Xsg13cmos5l_o21ai_1_35 \$3110 \$3122 \$3128 VPWR VGND \$3289 sg13cmos5l_o21ai_1
* cell instance sg13cmos5l_o21ai_1_36 r0 *1 0,0
Xsg13cmos5l_o21ai_1_36 \$7206 \$5023 \$2770 VPWR VGND \$7164 sg13cmos5l_o21ai_1
* cell instance sg13cmos5l_o21ai_1_37 r0 *1 0,0
Xsg13cmos5l_o21ai_1_37 \$1041 \$2142 \$2149 VPWR VGND \$2150 sg13cmos5l_o21ai_1
* cell instance sg13cmos5l_o21ai_1_38 r0 *1 0,0
Xsg13cmos5l_o21ai_1_38 \$3273 \$3458 \$3476 VPWR VGND \$3291 sg13cmos5l_o21ai_1
* cell instance sg13cmos5l_o21ai_1_39 r0 *1 0,0
Xsg13cmos5l_o21ai_1_39 \$3811 \$2923 \$4112 VPWR VGND \$4111 sg13cmos5l_o21ai_1
* cell instance sg13cmos5l_o21ai_1_40 r0 *1 0,0
Xsg13cmos5l_o21ai_1_40 \$3967 \$4445 \$4443 VPWR VGND \$4446 sg13cmos5l_o21ai_1
* cell instance sg13cmos5l_o21ai_1_41 r0 *1 0,0
Xsg13cmos5l_o21ai_1_41 \$3813 \$2923 \$3936 VPWR VGND \$3816 sg13cmos5l_o21ai_1
* cell instance sg13cmos5l_o21ai_1_42 r0 *1 0,0
Xsg13cmos5l_o21ai_1_42 \$669 \$874 \$671 VPWR VGND \$670 sg13cmos5l_o21ai_1
* cell instance sg13cmos5l_o21ai_1_43 r0 *1 0,0
Xsg13cmos5l_o21ai_1_43 \$2900 \$2768 \$2149 VPWR VGND \$2935 sg13cmos5l_o21ai_1
* cell instance sg13cmos5l_o21ai_1_44 r0 *1 0,0
Xsg13cmos5l_o21ai_1_44 \$3488 \$11398 \$10884 VPWR VGND \$11375
+ sg13cmos5l_o21ai_1
* cell instance sg13cmos5l_o21ai_1_45 r0 *1 0,0
Xsg13cmos5l_o21ai_1_45 \$2273 \$1903 \$2154 VPWR VGND \$1783 sg13cmos5l_o21ai_1
* cell instance sg13cmos5l_o21ai_1_46 r0 *1 0,0
Xsg13cmos5l_o21ai_1_46 \$6208 \$4981 \$5891 VPWR VGND \$3273 sg13cmos5l_o21ai_1
* cell instance sg13cmos5l_o21ai_1_47 r0 *1 0,0
Xsg13cmos5l_o21ai_1_47 \$1905 \$1903 \$1793 VPWR VGND \$2001 sg13cmos5l_o21ai_1
* cell instance sg13cmos5l_o21ai_1_48 r0 *1 0,0
Xsg13cmos5l_o21ai_1_48 \$3100 \$2142 \$2149 VPWR VGND \$3482 sg13cmos5l_o21ai_1
* cell instance sg13cmos5l_o21ai_1_49 r0 *1 0,0
Xsg13cmos5l_o21ai_1_49 \$1909 \$1903 \$1791 VPWR VGND \$2029 sg13cmos5l_o21ai_1
* cell instance sg13cmos5l_o21ai_1_50 r0 *1 0,0
Xsg13cmos5l_o21ai_1_50 \$1373 \$2937 \$2149 VPWR VGND \$3484 sg13cmos5l_o21ai_1
* cell instance sg13cmos5l_o21ai_1_51 r0 *1 0,0
Xsg13cmos5l_o21ai_1_51 \$4688 \$3484 \$5014 VPWR VGND \$7179 sg13cmos5l_o21ai_1
* cell instance sg13cmos5l_o21ai_1_52 r0 *1 0,0
Xsg13cmos5l_o21ai_1_52 \$6390 \$2771 \$5024 VPWR VGND \$6212 sg13cmos5l_o21ai_1
* cell instance sg13cmos5l_o21ai_1_53 r0 *1 0,0
Xsg13cmos5l_o21ai_1_53 \$3293 \$1903 \$3295 VPWR VGND \$3294 sg13cmos5l_o21ai_1
* cell instance sg13cmos5l_o21ai_1_54 r0 *1 0,0
Xsg13cmos5l_o21ai_1_54 \$3820 \$3482 \$3821 VPWR VGND \$8408 sg13cmos5l_o21ai_1
* cell instance sg13cmos5l_o21ai_1_55 r0 *1 0,0
Xsg13cmos5l_o21ai_1_55 \$1593 \$2142 \$2149 VPWR VGND \$2939 sg13cmos5l_o21ai_1
* cell instance sg13cmos5l_o21ai_1_56 r0 *1 0,0
Xsg13cmos5l_o21ai_1_56 \$4448 \$2939 \$4451 VPWR VGND \$4450 sg13cmos5l_o21ai_1
* cell instance sg13cmos5l_o21ai_1_57 r0 *1 0,0
Xsg13cmos5l_o21ai_1_57 \$3968 \$16985 \$15963 VPWR VGND \$15763
+ sg13cmos5l_o21ai_1
* cell instance sg13cmos5l_o21ai_1_58 r0 *1 0,0
Xsg13cmos5l_o21ai_1_58 \$3473 \$16985 \$17001 VPWR VGND \$16962
+ sg13cmos5l_o21ai_1
* cell instance sg13cmos5l_o21ai_1_59 r0 *1 0,0
Xsg13cmos5l_o21ai_1_59 \$920 \$797 \$798 VPWR VGND \$921 sg13cmos5l_o21ai_1
* cell instance sg13cmos5l_o21ai_1_60 r0 *1 0,0
Xsg13cmos5l_o21ai_1_60 \$3488 \$1679 \$3451 VPWR VGND \$3489 sg13cmos5l_o21ai_1
* cell instance sg13cmos5l_o21ai_1_61 r0 *1 0,0
Xsg13cmos5l_o21ai_1_61 \$3497 \$3489 \$3132 VPWR VGND \$3491 sg13cmos5l_o21ai_1
* cell instance sg13cmos5l_o21ai_1_62 r0 *1 0,0
Xsg13cmos5l_o21ai_1_62 \$1136 \$632 \$1161 VPWR VGND \$1138 sg13cmos5l_o21ai_1
* cell instance sg13cmos5l_o21ai_1_63 r0 *1 0,0
Xsg13cmos5l_o21ai_1_63 \$2160 \$2038 \$2036 VPWR VGND \$2039 sg13cmos5l_o21ai_1
* cell instance sg13cmos5l_o21ai_1_64 r0 *1 0,0
Xsg13cmos5l_o21ai_1_64 \$1702 \$2039 \$2162 VPWR VGND \$2161 sg13cmos5l_o21ai_1
* cell instance sg13cmos5l_o21ai_1_65 r0 *1 0,0
Xsg13cmos5l_o21ai_1_65 \$920 \$923 \$926 VPWR VGND \$1037 sg13cmos5l_o21ai_1
* cell instance sg13cmos5l_o21ai_1_66 r0 *1 0,0
Xsg13cmos5l_o21ai_1_66 \$3301 \$2043 \$3139 VPWR VGND \$1117 sg13cmos5l_o21ai_1
* cell instance sg13cmos5l_o21ai_1_67 r0 *1 0,0
Xsg13cmos5l_o21ai_1_67 \$2952 \$3642 \$3826 VPWR VGND \$3804 sg13cmos5l_o21ai_1
* cell instance sg13cmos5l_o21ai_1_68 r0 *1 0,0
Xsg13cmos5l_o21ai_1_68 \$1236 \$1371 \$1034 VPWR VGND \$1239 sg13cmos5l_o21ai_1
* cell instance sg13cmos5l_o21ai_1_69 r0 *1 0,0
Xsg13cmos5l_o21ai_1_69 \$4134 \$3977 \$3132 VPWR VGND \$4135 sg13cmos5l_o21ai_1
* cell instance sg13cmos5l_o21ai_1_70 r0 *1 0,0
Xsg13cmos5l_o21ai_1_70 \$1588 \$1477 \$1584 VPWR VGND \$1589 sg13cmos5l_o21ai_1
* cell instance sg13cmos5l_o21ai_1_71 r0 *1 0,0
Xsg13cmos5l_o21ai_1_71 \$1924 \$2043 \$1813 VPWR VGND \$1458 sg13cmos5l_o21ai_1
* cell instance sg13cmos5l_o21ai_1_72 r0 *1 0,0
Xsg13cmos5l_o21ai_1_72 \$2041 \$2045 \$2038 VPWR VGND \$1800 sg13cmos5l_o21ai_1
* cell instance sg13cmos5l_o21ai_1_73 r0 *1 0,0
Xsg13cmos5l_o21ai_1_73 \$2047 \$1928 \$2002 VPWR VGND \$1460 sg13cmos5l_o21ai_1
* cell instance sg13cmos5l_o21ai_1_74 r0 *1 0,0
Xsg13cmos5l_o21ai_1_74 \$3306 \$2043 \$3143 VPWR VGND \$2951 sg13cmos5l_o21ai_1
* cell instance sg13cmos5l_o21ai_1_75 r0 *1 0,0
Xsg13cmos5l_o21ai_1_75 \$2952 \$2954 \$2902 VPWR VGND \$2564 sg13cmos5l_o21ai_1
* cell instance sg13cmos5l_o21ai_1_76 r0 *1 0,0
Xsg13cmos5l_o21ai_1_76 \$337 \$338 \$332 VPWR VGND \$339 sg13cmos5l_o21ai_1
* cell instance sg13cmos5l_o21ai_1_77 r0 *1 0,0
Xsg13cmos5l_o21ai_1_77 \$3962 \$2782 \$2634 VPWR VGND \$2622 sg13cmos5l_o21ai_1
* cell instance sg13cmos5l_o21ai_1_78 r0 *1 0,0
Xsg13cmos5l_o21ai_1_78 \$206 \$295 \$332 VPWR VGND \$296 sg13cmos5l_o21ai_1
* cell instance sg13cmos5l_o21ai_1_79 r0 *1 0,0
Xsg13cmos5l_o21ai_1_79 \$2952 \$2958 \$2904 VPWR VGND \$2565 sg13cmos5l_o21ai_1
* cell instance sg13cmos5l_o21ai_1_80 r0 *1 0,0
Xsg13cmos5l_o21ai_1_80 \$1136 \$1596 \$1161 VPWR VGND \$1603 sg13cmos5l_o21ai_1
* cell instance sg13cmos5l_o21ai_1_81 r0 *1 0,0
Xsg13cmos5l_o21ai_1_81 \$945 \$704 \$947 VPWR VGND \$946 sg13cmos5l_o21ai_1
* cell instance sg13cmos5l_o21ai_1_82 r0 *1 0,0
Xsg13cmos5l_o21ai_1_82 \$1136 \$1483 \$1161 VPWR VGND \$1606 sg13cmos5l_o21ai_1
* cell instance sg13cmos5l_o21ai_1_83 r0 *1 0,0
Xsg13cmos5l_o21ai_1_83 \$1136 \$1368 \$1161 VPWR VGND \$1253 sg13cmos5l_o21ai_1
* cell instance sg13cmos5l_o21ai_1_84 r0 *1 0,0
Xsg13cmos5l_o21ai_1_84 \$1136 \$1151 \$1161 VPWR VGND \$1256 sg13cmos5l_o21ai_1
* cell instance sg13cmos5l_o21ai_1_85 r0 *1 0,0
Xsg13cmos5l_o21ai_1_85 \$33 \$31 \$103 VPWR VGND \$52 sg13cmos5l_o21ai_1
* cell instance sg13cmos5l_o21ai_1_86 r0 *1 0,0
Xsg13cmos5l_o21ai_1_86 \$52 \$297 \$411 VPWR VGND \$337 sg13cmos5l_o21ai_1
* cell instance sg13cmos5l_o21ai_1_87 r0 *1 0,0
Xsg13cmos5l_o21ai_1_87 \$2205 \$2307 \$2055 VPWR VGND \$2293 sg13cmos5l_o21ai_1
* cell instance sg13cmos5l_o21ai_1_88 r0 *1 0,0
Xsg13cmos5l_o21ai_1_88 \$418 \$255 \$344 VPWR VGND \$338 sg13cmos5l_o21ai_1
* cell instance sg13cmos5l_o21ai_1_89 r0 *1 0,0
Xsg13cmos5l_o21ai_1_89 \$3275 \$2197 \$2198 VPWR VGND \$1823 sg13cmos5l_o21ai_1
* cell instance sg13cmos5l_o21ai_1_90 r0 *1 0,0
Xsg13cmos5l_o21ai_1_90 \$160 \$211 \$169 VPWR VGND \$212 sg13cmos5l_o21ai_1
* cell instance sg13cmos5l_o21ai_1_91 r0 *1 0,0
Xsg13cmos5l_o21ai_1_91 \$1234 \$2197 \$2643 VPWR VGND \$2645 sg13cmos5l_o21ai_1
* cell instance sg13cmos5l_o21ai_1_92 r0 *1 0,0
Xsg13cmos5l_o21ai_1_92 \$259 \$955 \$157 VPWR VGND \$953 sg13cmos5l_o21ai_1
* cell instance sg13cmos5l_o21ai_1_93 r0 *1 0,0
Xsg13cmos5l_o21ai_1_93 \$511 \$258 \$482 VPWR VGND \$306 sg13cmos5l_o21ai_1
* cell instance sg13cmos5l_o21ai_1_94 r0 *1 0,0
Xsg13cmos5l_o21ai_1_94 \$3153 \$3154 \$3156 VPWR VGND \$3155 sg13cmos5l_o21ai_1
* cell instance sg13cmos5l_o21ai_1_95 r0 *1 0,0
Xsg13cmos5l_o21ai_1_95 \$3153 \$3994 \$4167 VPWR VGND \$4166 sg13cmos5l_o21ai_1
* cell instance sg13cmos5l_o21ai_1_96 r0 *1 0,0
Xsg13cmos5l_o21ai_1_96 \$43 \$38 \$45 VPWR VGND \$41 sg13cmos5l_o21ai_1
* cell instance sg13cmos5l_o21ai_1_97 r0 *1 0,0
Xsg13cmos5l_o21ai_1_97 \$2196 \$2769 \$2887 VPWR VGND \$2651 sg13cmos5l_o21ai_1
* cell instance sg13cmos5l_o21ai_1_98 r0 *1 0,0
Xsg13cmos5l_o21ai_1_98 \$2182 \$2310 \$2314 VPWR VGND \$2313 sg13cmos5l_o21ai_1
* cell instance sg13cmos5l_o21ai_1_99 r0 *1 0,0
Xsg13cmos5l_o21ai_1_99 \$215 \$513 \$417 VPWR VGND \$514 sg13cmos5l_o21ai_1
* cell instance sg13cmos5l_o21ai_1_100 r0 *1 0,0
Xsg13cmos5l_o21ai_1_100 \$36 \$260 \$726 VPWR VGND \$642 sg13cmos5l_o21ai_1
* cell instance sg13cmos5l_o21ai_1_101 r0 *1 0,0
Xsg13cmos5l_o21ai_1_101 \$3153 \$3160 \$2978 VPWR VGND \$3161 sg13cmos5l_o21ai_1
* cell instance sg13cmos5l_o21ai_1_102 r0 *1 0,0
Xsg13cmos5l_o21ai_1_102 \$3153 \$3345 \$3162 VPWR VGND \$3346 sg13cmos5l_o21ai_1
* cell instance sg13cmos5l_o21ai_1_103 r0 *1 0,0
Xsg13cmos5l_o21ai_1_103 \$412 \$297 \$332 VPWR VGND \$420 sg13cmos5l_o21ai_1
* cell instance sg13cmos5l_o21ai_1_104 r0 *1 0,0
Xsg13cmos5l_o21ai_1_104 \$44 \$40 \$47 VPWR VGND \$46 sg13cmos5l_o21ai_1
* cell instance sg13cmos5l_o21ai_1_105 r0 *1 0,0
Xsg13cmos5l_o21ai_1_105 \$825 \$958 \$1174 VPWR VGND \$959 sg13cmos5l_o21ai_1
* cell instance sg13cmos5l_o21ai_1_106 r0 *1 0,0
Xsg13cmos5l_o21ai_1_106 \$356 \$959 \$405 VPWR VGND \$1054 sg13cmos5l_o21ai_1
* cell instance sg13cmos5l_o21ai_1_107 r0 *1 0,0
Xsg13cmos5l_o21ai_1_107 \$1272 \$1054 \$1275 VPWR VGND \$1501 sg13cmos5l_o21ai_1
* cell instance sg13cmos5l_o21ai_1_108 r0 *1 0,0
Xsg13cmos5l_o21ai_1_108 \$3153 \$4000 \$4181 VPWR VGND \$4180 sg13cmos5l_o21ai_1
* cell instance sg13cmos5l_o21ai_1_109 r0 *1 0,0
Xsg13cmos5l_o21ai_1_109 \$2452 \$2287 \$2129 VPWR VGND \$2659 sg13cmos5l_o21ai_1
* cell instance sg13cmos5l_o21ai_1_110 r0 *1 0,0
Xsg13cmos5l_o21ai_1_110 \$2205 \$2287 \$1982 VPWR VGND \$2206 sg13cmos5l_o21ai_1
* cell instance sg13cmos5l_o21ai_1_111 r0 *1 0,0
Xsg13cmos5l_o21ai_1_111 \$2308 \$2287 \$1984 VPWR VGND \$2330 sg13cmos5l_o21ai_1
* cell instance sg13cmos5l_o21ai_1_112 r0 *1 0,0
Xsg13cmos5l_o21ai_1_112 \$1175 \$1276 \$405 VPWR VGND \$1280 sg13cmos5l_o21ai_1
* cell instance sg13cmos5l_o21ai_1_113 r0 *1 0,0
Xsg13cmos5l_o21ai_1_113 \$2639 \$2287 \$2088 VPWR VGND \$2666 sg13cmos5l_o21ai_1
* cell instance sg13cmos5l_o21ai_1_114 r0 *1 0,0
Xsg13cmos5l_o21ai_1_114 \$2470 \$2287 \$2087 VPWR VGND \$2471 sg13cmos5l_o21ai_1
* cell instance sg13cmos5l_o21ai_1_115 r0 *1 0,0
Xsg13cmos5l_o21ai_1_115 \$3153 \$3517 \$4184 VPWR VGND \$4186 sg13cmos5l_o21ai_1
* cell instance sg13cmos5l_o21ai_1_116 r0 *1 0,0
Xsg13cmos5l_o21ai_1_116 \$45 \$955 \$21 VPWR VGND \$595 sg13cmos5l_o21ai_1
* cell instance sg13cmos5l_o21ai_1_117 r0 *1 0,0
Xsg13cmos5l_o21ai_1_117 \$2068 \$2287 \$2207 VPWR VGND \$2668 sg13cmos5l_o21ai_1
* cell instance sg13cmos5l_o21ai_1_118 r0 *1 0,0
Xsg13cmos5l_o21ai_1_118 \$2194 \$2287 \$2089 VPWR VGND \$2472 sg13cmos5l_o21ai_1
* cell instance sg13cmos5l_o21ai_1_119 r0 *1 0,0
Xsg13cmos5l_o21ai_1_119 \$120 \$121 \$110 VPWR VGND \$1624 sg13cmos5l_o21ai_1
* cell instance sg13cmos5l_o21ai_1_120 r0 *1 0,0
Xsg13cmos5l_o21ai_1_120 \$482 \$1986 \$1515 VPWR VGND \$1987 sg13cmos5l_o21ai_1
* cell instance sg13cmos5l_o21ai_1_121 r0 *1 0,0
Xsg13cmos5l_o21ai_1_121 \$1815 \$2287 \$2209 VPWR VGND \$2332 sg13cmos5l_o21ai_1
* cell instance sg13cmos5l_o21ai_1_122 r0 *1 0,0
Xsg13cmos5l_o21ai_1_122 \$231 \$386 \$214 VPWR VGND \$1058 sg13cmos5l_o21ai_1
* cell instance sg13cmos5l_o21ai_1_123 r0 *1 0,0
Xsg13cmos5l_o21ai_1_123 \$2474 \$2471 \$2480 VPWR VGND \$2670 sg13cmos5l_o21ai_1
* cell instance sg13cmos5l_o21ai_1_124 r0 *1 0,0
Xsg13cmos5l_o21ai_1_124 \$2474 \$2330 \$2475 VPWR VGND \$2573 sg13cmos5l_o21ai_1
* cell instance sg13cmos5l_o21ai_1_125 r0 *1 0,0
Xsg13cmos5l_o21ai_1_125 \$3003 \$3004 \$3005 VPWR VGND \$2817 sg13cmos5l_o21ai_1
* cell instance sg13cmos5l_o21ai_1_126 r0 *1 0,0
Xsg13cmos5l_o21ai_1_126 \$157 \$358 \$386 VPWR VGND \$384 sg13cmos5l_o21ai_1
* cell instance sg13cmos5l_o21ai_1_127 r0 *1 0,0
Xsg13cmos5l_o21ai_1_127 \$1178 \$1285 \$673 VPWR VGND \$1275 sg13cmos5l_o21ai_1
* cell instance sg13cmos5l_o21ai_1_128 r0 *1 0,0
Xsg13cmos5l_o21ai_1_128 \$2664 \$3010 \$2651 VPWR VGND \$3011 sg13cmos5l_o21ai_1
* cell instance sg13cmos5l_o21ai_1_129 r0 *1 0,0
Xsg13cmos5l_o21ai_1_129 \$3153 \$3369 \$3691 VPWR VGND \$3526 sg13cmos5l_o21ai_1
* cell instance sg13cmos5l_o21ai_1_130 r0 *1 0,0
Xsg13cmos5l_o21ai_1_130 \$2102 \$2668 \$2484 VPWR VGND \$2673 sg13cmos5l_o21ai_1
* cell instance sg13cmos5l_o21ai_1_131 r0 *1 0,0
Xsg13cmos5l_o21ai_1_131 \$2102 \$2659 \$2829 VPWR VGND \$2828 sg13cmos5l_o21ai_1
* cell instance sg13cmos5l_o21ai_1_132 r0 *1 0,0
Xsg13cmos5l_o21ai_1_132 \$2474 \$2666 \$2831 VPWR VGND \$2830 sg13cmos5l_o21ai_1
* cell instance sg13cmos5l_o21ai_1_133 r0 *1 0,0
Xsg13cmos5l_o21ai_1_133 \$2102 \$2472 \$2676 VPWR VGND \$2675 sg13cmos5l_o21ai_1
* cell instance sg13cmos5l_o21ai_1_134 r0 *1 0,0
Xsg13cmos5l_o21ai_1_134 \$2102 \$2206 \$2488 VPWR VGND \$2487 sg13cmos5l_o21ai_1
* cell instance sg13cmos5l_o21ai_1_135 r0 *1 0,0
Xsg13cmos5l_o21ai_1_135 \$2102 \$2332 \$2490 VPWR VGND \$2489 sg13cmos5l_o21ai_1
* cell instance sg13cmos5l_o21ai_1_136 r0 *1 0,0
Xsg13cmos5l_o21ai_1_136 \$3003 \$2835 \$2833 VPWR VGND \$2836 sg13cmos5l_o21ai_1
* cell instance sg13cmos5l_o21ai_1_137 r0 *1 0,0
Xsg13cmos5l_o21ai_1_137 \$302 \$1401 \$301 VPWR VGND \$1633 sg13cmos5l_o21ai_1
* cell instance sg13cmos5l_o21ai_1_138 r0 *1 0,0
Xsg13cmos5l_o21ai_1_138 \$3003 \$4212 \$4023 VPWR VGND \$4214 sg13cmos5l_o21ai_1
* cell instance sg13cmos5l_o21ai_1_139 r0 *1 0,0
Xsg13cmos5l_o21ai_1_139 \$3003 \$3532 \$3535 VPWR VGND \$3534 sg13cmos5l_o21ai_1
* cell instance sg13cmos5l_o21ai_1_140 r0 *1 0,0
Xsg13cmos5l_o21ai_1_140 \$3003 \$3876 \$3710 VPWR VGND \$3877 sg13cmos5l_o21ai_1
* cell instance sg13cmos5l_o21ai_1_141 r0 *1 0,0
Xsg13cmos5l_o21ai_1_141 \$3003 \$3379 \$3381 VPWR VGND \$3203 sg13cmos5l_o21ai_1
* cell instance sg13cmos5l_o21ai_1_142 r0 *1 0,0
Xsg13cmos5l_o21ai_1_142 \$268 \$282 \$100 VPWR VGND \$272 sg13cmos5l_o21ai_1
* cell instance sg13cmos5l_o21ai_1_143 r0 *1 0,0
Xsg13cmos5l_o21ai_1_143 \$117 \$739 \$355 VPWR VGND \$254 sg13cmos5l_o21ai_1
* cell instance sg13cmos5l_o21ai_1_144 r0 *1 0,0
Xsg13cmos5l_o21ai_1_144 \$388 \$85 \$465 VPWR VGND \$734 sg13cmos5l_o21ai_1
* cell instance sg13cmos5l_o21ai_1_145 r0 *1 0,0
Xsg13cmos5l_o21ai_1_145 \$2376 \$1585 \$4036 VPWR VGND \$3858 sg13cmos5l_o21ai_1
* cell instance sg13cmos5l_o21ai_1_146 r0 *1 0,0
Xsg13cmos5l_o21ai_1_146 \$231 \$974 \$154 VPWR VGND \$356 sg13cmos5l_o21ai_1
* cell instance sg13cmos5l_o21ai_1_147 r0 *1 0,0
Xsg13cmos5l_o21ai_1_147 \$123 \$178 \$100 VPWR VGND \$51 sg13cmos5l_o21ai_1
* cell instance sg13cmos5l_o21ai_1_148 r0 *1 0,0
Xsg13cmos5l_o21ai_1_148 \$177 \$179 \$77 VPWR VGND \$429 sg13cmos5l_o21ai_1
* cell instance sg13cmos5l_o21ai_1_149 r0 *1 0,0
Xsg13cmos5l_o21ai_1_149 \$70 \$71 \$49 VPWR VGND \$94 sg13cmos5l_o21ai_1
* cell instance sg13cmos5l_o21ai_1_150 r0 *1 0,0
Xsg13cmos5l_o21ai_1_150 \$2224 \$3473 \$3890 VPWR VGND \$3944 sg13cmos5l_o21ai_1
* cell instance sg13cmos5l_o21ai_1_151 r0 *1 0,0
Xsg13cmos5l_o21ai_1_151 \$1185 \$231 \$229 VPWR VGND \$1188 sg13cmos5l_o21ai_1
* cell instance sg13cmos5l_o21ai_1_152 r0 *1 0,0
Xsg13cmos5l_o21ai_1_152 \$526 \$846 \$740 VPWR VGND \$847 sg13cmos5l_o21ai_1
* cell instance sg13cmos5l_o21ai_1_153 r0 *1 0,0
Xsg13cmos5l_o21ai_1_153 \$1639 \$1184 \$1523 VPWR VGND \$1640 sg13cmos5l_o21ai_1
* cell instance sg13cmos5l_o21ai_1_154 r0 *1 0,0
Xsg13cmos5l_o21ai_1_154 \$1639 \$24 \$390 VPWR VGND \$11 sg13cmos5l_o21ai_1
* cell instance sg13cmos5l_o21ai_1_155 r0 *1 0,0
Xsg13cmos5l_o21ai_1_155 \$418 \$390 \$422 VPWR VGND \$432 sg13cmos5l_o21ai_1
* cell instance sg13cmos5l_o21ai_1_156 r0 *1 0,0
Xsg13cmos5l_o21ai_1_156 \$81 \$83 \$742 VPWR VGND \$612 sg13cmos5l_o21ai_1
* cell instance sg13cmos5l_o21ai_1_157 r0 *1 0,0
Xsg13cmos5l_o21ai_1_157 \$3562 \$3968 \$4243 VPWR VGND \$4197 sg13cmos5l_o21ai_1
* cell instance sg13cmos5l_o21ai_1_158 r0 *1 0,0
Xsg13cmos5l_o21ai_1_158 \$1641 \$1524 \$1073 VPWR VGND \$1645 sg13cmos5l_o21ai_1
* cell instance sg13cmos5l_o21ai_1_159 r0 *1 0,0
Xsg13cmos5l_o21ai_1_159 \$1414 \$1417 \$126 VPWR VGND \$1418 sg13cmos5l_o21ai_1
* cell instance sg13cmos5l_o21ai_1_160 r0 *1 0,0
Xsg13cmos5l_o21ai_1_160 \$24 \$114 \$131 VPWR VGND \$129 sg13cmos5l_o21ai_1
* cell instance sg13cmos5l_o21ai_1_161 r0 *1 0,0
Xsg13cmos5l_o21ai_1_161 \$279 \$983 \$1401 VPWR VGND \$1763 sg13cmos5l_o21ai_1
* cell instance sg13cmos5l_o21ai_1_162 r0 *1 0,0
Xsg13cmos5l_o21ai_1_162 \$849 \$827 \$292 VPWR VGND \$848 sg13cmos5l_o21ai_1
* cell instance sg13cmos5l_o21ai_1_163 r0 *1 0,0
Xsg13cmos5l_o21ai_1_163 \$74 \$134 \$100 VPWR VGND \$132 sg13cmos5l_o21ai_1
* cell instance sg13cmos5l_o21ai_1_164 r0 *1 0,0
Xsg13cmos5l_o21ai_1_164 \$976 \$1647 \$422 VPWR VGND \$1866 sg13cmos5l_o21ai_1
* cell instance sg13cmos5l_o21ai_1_165 r0 *1 0,0
Xsg13cmos5l_o21ai_1_165 \$136 \$30 \$77 VPWR VGND \$21 sg13cmos5l_o21ai_1
* cell instance sg13cmos5l_o21ai_1_166 r0 *1 0,0
Xsg13cmos5l_o21ai_1_166 \$1421 \$1293 \$1756 VPWR VGND \$1422 sg13cmos5l_o21ai_1
* cell instance sg13cmos5l_o21ai_1_167 r0 *1 0,0
Xsg13cmos5l_o21ai_1_167 \$857 \$850 \$742 VPWR VGND \$851 sg13cmos5l_o21ai_1
* cell instance sg13cmos5l_o21ai_1_168 r0 *1 0,0
Xsg13cmos5l_o21ai_1_168 \$78 \$79 \$76 VPWR VGND \$24 sg13cmos5l_o21ai_1
* cell instance sg13cmos5l_o21ai_1_169 r0 *1 0,0
Xsg13cmos5l_o21ai_1_169 \$21 \$7 \$24 VPWR VGND \$14 sg13cmos5l_o21ai_1
* cell instance sg13cmos5l_o21ai_1_170 r0 *1 0,0
Xsg13cmos5l_o21ai_1_170 \$736 \$620 \$619 VPWR VGND \$395 sg13cmos5l_o21ai_1
* cell instance sg13cmos5l_o21ai_1_171 r0 *1 0,0
Xsg13cmos5l_o21ai_1_171 \$136 \$41 \$189 VPWR VGND \$244 sg13cmos5l_o21ai_1
* cell instance sg13cmos5l_o21ai_1_172 r0 *1 0,0
Xsg13cmos5l_o21ai_1_172 \$319 \$395 \$186 VPWR VGND \$396 sg13cmos5l_o21ai_1
* cell instance sg13cmos5l_o21ai_1_173 r0 *1 0,0
Xsg13cmos5l_o21ai_1_173 \$145 \$30 \$146 VPWR VGND \$131 sg13cmos5l_o21ai_1
* cell instance sg13cmos5l_o21ai_1_174 r0 *1 0,0
Xsg13cmos5l_o21ai_1_174 \$4 \$983 \$623 VPWR VGND \$622 sg13cmos5l_o21ai_1
* cell instance sg13cmos5l_o21ai_1_175 r0 *1 0,0
Xsg13cmos5l_o21ai_1_175 \$368 \$37 \$366 VPWR VGND \$623 sg13cmos5l_o21ai_1
* cell instance sg13cmos5l_o21ai_1_176 r0 *1 0,0
Xsg13cmos5l_o21ai_1_176 \$1302 \$397 \$1424 VPWR VGND \$1427 sg13cmos5l_o21ai_1
* cell instance sg13cmos5l_o21ai_1_177 r0 *1 0,0
Xsg13cmos5l_o21ai_1_177 \$148 \$131 \$150 VPWR VGND \$149 sg13cmos5l_o21ai_1
* cell instance sg13cmos5l_o21ai_1_178 r0 *1 0,0
Xsg13cmos5l_o21ai_1_178 \$2127 \$2242 \$1993 VPWR VGND \$2116 sg13cmos5l_o21ai_1
* cell instance sg13cmos5l_o21ai_1_179 r0 *1 0,0
Xsg13cmos5l_o21ai_1_179 \$856 \$1653 \$1201 VPWR VGND \$1312 sg13cmos5l_o21ai_1
* cell instance sg13cmos5l_o21ai_1_180 r0 *1 0,0
Xsg13cmos5l_o21ai_1_180 \$251 \$18 \$126 VPWR VGND \$252 sg13cmos5l_o21ai_1
* cell instance sg13cmos5l_o21ai_1_181 r0 *1 0,0
Xsg13cmos5l_o21ai_1_181 \$322 \$1074 \$1300 VPWR VGND \$1296 sg13cmos5l_o21ai_1
* cell instance sg13cmos5l_o21ai_1_182 r0 *1 0,0
Xsg13cmos5l_o21ai_1_182 \$251 \$745 \$126 VPWR VGND \$589 sg13cmos5l_o21ai_1
* cell instance sg13cmos5l_o21ai_1_183 r0 *1 0,0
Xsg13cmos5l_o21ai_1_183 \$418 \$452 \$993 VPWR VGND \$990 sg13cmos5l_o21ai_1
* cell instance sg13cmos5l_o21ai_1_184 r0 *1 0,0
Xsg13cmos5l_o21ai_1_184 \$84 \$15 \$47 VPWR VGND \$97 sg13cmos5l_o21ai_1
* cell instance sg13cmos5l_o21ai_1_185 r0 *1 0,0
Xsg13cmos5l_o21ai_1_185 \$856 \$366 \$100 VPWR VGND \$993 sg13cmos5l_o21ai_1
* cell instance sg13cmos5l_o21ai_1_186 r0 *1 0,0
Xsg13cmos5l_o21ai_1_186 \$1879 \$179 \$865 VPWR VGND \$864 sg13cmos5l_o21ai_1
* cell instance sg13cmos5l_o21ai_1_187 r0 *1 0,0
Xsg13cmos5l_o21ai_1_187 \$134 \$199 \$100 VPWR VGND \$201 sg13cmos5l_o21ai_1
* cell instance sg13cmos5l_o21ai_1_188 r0 *1 0,0
Xsg13cmos5l_o21ai_1_188 \$1410 \$84 \$126 VPWR VGND \$287 sg13cmos5l_o21ai_1
* cell instance sg13cmos5l_o21ai_1_189 r0 *1 0,0
Xsg13cmos5l_o21ai_1_189 \$1439 \$1307 \$621 VPWR VGND \$1051 sg13cmos5l_o21ai_1
* cell instance sg13cmos5l_o21ai_1_190 r0 *1 0,0
Xsg13cmos5l_o21ai_1_190 \$199 \$197 \$193 VPWR VGND \$203 sg13cmos5l_o21ai_1
* cell instance sg13cmos5l_o21ai_1_191 r0 *1 0,0
Xsg13cmos5l_o21ai_1_191 \$268 \$284 \$189 VPWR VGND \$289 sg13cmos5l_o21ai_1
* cell instance sg13cmos5l_o21ai_1_192 r0 *1 0,0
Xsg13cmos5l_o21ai_1_192 \$8 \$392 \$322 VPWR VGND \$461 sg13cmos5l_o21ai_1
* cell instance sg13cmos5l_o21ai_1_193 r0 *1 0,0
Xsg13cmos5l_o21ai_1_193 \$1308 \$749 \$1073 VPWR VGND \$2107 sg13cmos5l_o21ai_1
* cell instance sg13cmos5l_o21ai_1_194 r0 *1 0,0
Xsg13cmos5l_o21ai_1_194 \$629 \$306 \$463 VPWR VGND \$534 sg13cmos5l_o21ai_1
* cell instance sg13cmos5l_o21ai_1_195 r0 *1 0,0
Xsg13cmos5l_o21ai_1_195 \$461 \$290 \$456 VPWR VGND \$463 sg13cmos5l_o21ai_1
* cell instance sg13cmos5l_or2_1_0 r0 *1 0,0
Xsg13cmos5l_or2_1_0 \$2591 \$2592 VPWR VGND \$2403 sg13cmos5l_or2_1
* cell instance sg13cmos5l_or2_1_1 r0 *1 0,0
Xsg13cmos5l_or2_1_1 \$2757 \$2923 VPWR VGND \$2760 sg13cmos5l_or2_1
* cell instance sg13cmos5l_or2_1_2 r0 *1 0,0
Xsg13cmos5l_or2_1_2 \$645 \$1041 VPWR VGND \$1018 sg13cmos5l_or2_1
* cell instance sg13cmos5l_or2_1_3 r0 *1 0,0
Xsg13cmos5l_or2_1_3 \$5047 \$5055 VPWR VGND \$5097 sg13cmos5l_or2_1
* cell instance sg13cmos5l_or2_1_4 r0 *1 0,0
Xsg13cmos5l_or2_1_4 \$2020 \$2422 VPWR VGND \$3122 sg13cmos5l_or2_1
* cell instance sg13cmos5l_or2_1_5 r0 *1 0,0
Xsg13cmos5l_or2_1_5 \$2028 \$2422 VPWR VGND \$2263 sg13cmos5l_or2_1
* cell instance sg13cmos5l_or2_1_6 r0 *1 0,0
Xsg13cmos5l_or2_1_6 \$3968 \$3967 VPWR VGND \$3807 sg13cmos5l_or2_1
* cell instance sg13cmos5l_or2_1_7 r0 *1 0,0
Xsg13cmos5l_or2_1_7 \$776 \$907 VPWR VGND \$896 sg13cmos5l_or2_1
* cell instance sg13cmos5l_or2_1_8 r0 *1 0,0
Xsg13cmos5l_or2_1_8 \$2027 \$2028 VPWR VGND \$2606 sg13cmos5l_or2_1
* cell instance sg13cmos5l_or2_1_9 r0 *1 0,0
Xsg13cmos5l_or2_1_9 \$1906 \$2423 VPWR VGND \$2767 sg13cmos5l_or2_1
* cell instance sg13cmos5l_or2_1_10 r0 *1 0,0
Xsg13cmos5l_or2_1_10 \$1115 \$1337 VPWR VGND \$907 sg13cmos5l_or2_1
* cell instance sg13cmos5l_or2_1_11 r0 *1 0,0
Xsg13cmos5l_or2_1_11 \$2031 \$1786 VPWR VGND \$2423 sg13cmos5l_or2_1
* cell instance sg13cmos5l_or2_1_12 r0 *1 0,0
Xsg13cmos5l_or2_1_12 \$2279 \$2612 VPWR VGND \$2614 sg13cmos5l_or2_1
* cell instance sg13cmos5l_or2_1_13 r0 *1 0,0
Xsg13cmos5l_or2_1_13 \$690 \$689 VPWR VGND \$680 sg13cmos5l_or2_1
* cell instance sg13cmos5l_or2_1_14 r0 *1 0,0
Xsg13cmos5l_or2_1_14 \$1368 \$920 VPWR VGND \$1238 sg13cmos5l_or2_1
* cell instance sg13cmos5l_or2_1_15 r0 *1 0,0
Xsg13cmos5l_or2_1_15 \$2397 \$2202 VPWR VGND \$1971 sg13cmos5l_or2_1
* cell instance sg13cmos5l_or2_1_16 r0 *1 0,0
Xsg13cmos5l_or2_1_16 \$67 \$61 VPWR VGND \$29 sg13cmos5l_or2_1
* cell instance sg13cmos5l_or2_1_17 r0 *1 0,0
Xsg13cmos5l_or2_1_17 \$231 \$1063 VPWR VGND \$411 sg13cmos5l_or2_1
* cell instance sg13cmos5l_or2_1_18 r0 *1 0,0
Xsg13cmos5l_or2_1_18 \$67 \$22 VPWR VGND \$69 sg13cmos5l_or2_1
* cell instance sg13cmos5l_or2_1_19 r0 *1 0,0
Xsg13cmos5l_or2_1_19 \$2885 \$3903 VPWR VGND \$2890 sg13cmos5l_or2_1
* cell instance sg13cmos5l_or2_1_20 r0 *1 0,0
Xsg13cmos5l_or2_1_20 \$2735 \$2890 VPWR VGND \$2550 sg13cmos5l_or2_1
* cell instance sg13cmos5l_or3_1_0 r0 *1 0,0
Xsg13cmos5l_or3_1_0 \$3799 \$4097 \$4432 VPWR VGND \$3964 sg13cmos5l_or3_1
* cell instance sg13cmos5l_or3_1_1 r0 *1 0,0
Xsg13cmos5l_or3_1_1 \$4432 \$4435 \$4683 VPWR VGND \$4569 sg13cmos5l_or3_1
* cell instance sg13cmos5l_or3_1_2 r0 *1 0,0
Xsg13cmos5l_or3_1_2 \$545 \$1790 \$1464 VPWR VGND \$1791 sg13cmos5l_or3_1
* cell instance sg13cmos5l_or3_1_3 r0 *1 0,0
Xsg13cmos5l_or3_1_3 \$1788 \$1790 \$1464 VPWR VGND \$1793 sg13cmos5l_or3_1
* cell instance sg13cmos5l_or3_1_4 r0 *1 0,0
Xsg13cmos5l_or3_1_4 \$2276 \$1790 \$1531 VPWR VGND \$2154 sg13cmos5l_or3_1
* cell instance sg13cmos5l_or3_1_5 r0 *1 0,0
Xsg13cmos5l_or3_1_5 \$2221 \$1790 \$1531 VPWR VGND \$3295 sg13cmos5l_or3_1
* cell instance sg13cmos5l_or3_1_6 r0 *1 0,0
Xsg13cmos5l_or3_1_6 \$823 \$1790 \$1464 VPWR VGND \$3139 sg13cmos5l_or3_1
* cell instance sg13cmos5l_or3_1_7 r0 *1 0,0
Xsg13cmos5l_or3_1_7 \$497 \$1812 \$1464 VPWR VGND \$1813 sg13cmos5l_or3_1
* cell instance sg13cmos5l_or3_1_8 r0 *1 0,0
Xsg13cmos5l_or3_1_8 \$1818 \$1812 \$1464 VPWR VGND \$3143 sg13cmos5l_or3_1
* cell instance sg13cmos5l_or3_1_9 r0 *1 0,0
Xsg13cmos5l_or3_1_9 \$509 \$1790 \$1464 VPWR VGND \$2002 sg13cmos5l_or3_1
* cell instance sg13cmos5l_or3_1_10 r0 *1 0,0
Xsg13cmos5l_or3_1_10 \$55 \$44 \$28 VPWR VGND \$57 sg13cmos5l_or3_1
* cell instance sg13cmos5l_or3_1_11 r0 *1 0,0
Xsg13cmos5l_or3_1_11 \$737 \$736 \$734 VPWR VGND \$601 sg13cmos5l_or3_1
* cell instance sg13cmos5l_or3_1_12 r0 *1 0,0
Xsg13cmos5l_or3_1_12 \$228 \$159 \$29 VPWR VGND \$229 sg13cmos5l_or3_1
* cell instance sg13cmos5l_or3_1_13 r0 *1 0,0
Xsg13cmos5l_or3_1_13 \$8 \$18 \$15 VPWR VGND \$17 sg13cmos5l_or3_1
* cell instance sg13cmos5l_or3_1_14 r0 *1 0,0
Xsg13cmos5l_or3_1_14 \$154 \$1429 \$1656 VPWR VGND \$1300 sg13cmos5l_or3_1
* cell instance sg13cmos5l_or3_1_15 r0 *1 0,0
Xsg13cmos5l_or3_1_15 \$89 \$421 \$1419 VPWR VGND \$1314 sg13cmos5l_or3_1
* cell instance sg13cmos5l_or3_1_16 r0 *1 0,0
Xsg13cmos5l_or3_1_16 \$89 \$1439 \$1419 VPWR VGND \$1856 sg13cmos5l_or3_1
* cell instance sg13cmos5l_or4_1_0 r0 *1 0,0
Xsg13cmos5l_or4_1_0 \$1020 \$667 \$1008 \$771 VPWR VGND \$1021 sg13cmos5l_or4_1
* cell instance sg13cmos5l_or4_1_1 r0 *1 0,0
Xsg13cmos5l_or4_1_1 \$1041 \$646 \$874 \$935 VPWR VGND \$2279 sg13cmos5l_or4_1
* cell instance sg13cmos5l_or4_1_2 r0 *1 0,0
Xsg13cmos5l_or4_1_2 \$120 \$260 \$41 \$28 VPWR VGND \$214 sg13cmos5l_or4_1
* cell instance sg13cmos5l_or4_1_3 r0 *1 0,0
Xsg13cmos5l_or4_1_3 \$1857 \$602 \$1881 \$1758 VPWR VGND \$1754 sg13cmos5l_or4_1
* cell instance sg13cmos5l_tiehi_0 r0 *1 0,0
Xsg13cmos5l_tiehi_0 \$4727 VPWR VGND sg13cmos5l_tiehi
* cell instance sg13cmos5l_tiehi_1 r0 *1 0,0
Xsg13cmos5l_tiehi_1 \$4739 VPWR VGND sg13cmos5l_tiehi
* cell instance sg13cmos5l_tiehi_2 r0 *1 0,0
Xsg13cmos5l_tiehi_2 \$4754 VPWR VGND sg13cmos5l_tiehi
* cell instance sg13cmos5l_tiehi_3 r0 *1 0,0
Xsg13cmos5l_tiehi_3 \$4766 VPWR VGND sg13cmos5l_tiehi
* cell instance sg13cmos5l_tiehi_4 r0 *1 0,0
Xsg13cmos5l_tiehi_4 \$4778 VPWR VGND sg13cmos5l_tiehi
* cell instance sg13cmos5l_tiehi_5 r0 *1 0,0
Xsg13cmos5l_tiehi_5 \$4790 VPWR VGND sg13cmos5l_tiehi
* cell instance sg13cmos5l_tiehi_6 r0 *1 0,0
Xsg13cmos5l_tiehi_6 \$4800 VPWR VGND sg13cmos5l_tiehi
* cell instance sg13cmos5l_tiehi_7 r0 *1 0,0
Xsg13cmos5l_tiehi_7 \$4815 VPWR VGND sg13cmos5l_tiehi
* cell instance sg13cmos5l_tiehi_8 r0 *1 0,0
Xsg13cmos5l_tiehi_8 \$2333 VPWR VGND sg13cmos5l_tiehi
* cell instance sg13cmos5l_tiehi_9 r0 *1 0,0
Xsg13cmos5l_tiehi_9 \$4848 VPWR VGND sg13cmos5l_tiehi
* cell instance sg13cmos5l_tiehi_10 r0 *1 0,0
Xsg13cmos5l_tiehi_10 \$4854 VPWR VGND sg13cmos5l_tiehi
* cell instance sg13cmos5l_tiehi_11 r0 *1 0,0
Xsg13cmos5l_tiehi_11 \$4866 VPWR VGND sg13cmos5l_tiehi
* cell instance sg13cmos5l_tiehi_12 r0 *1 0,0
Xsg13cmos5l_tiehi_12 \$4879 VPWR VGND sg13cmos5l_tiehi
* cell instance sg13cmos5l_tiehi_13 r0 *1 0,0
Xsg13cmos5l_tiehi_13 \$4894 VPWR VGND sg13cmos5l_tiehi
* cell instance sg13cmos5l_tiehi_14 r0 *1 0,0
Xsg13cmos5l_tiehi_14 \$4910 VPWR VGND sg13cmos5l_tiehi
* cell instance sg13cmos5l_tiehi_15 r0 *1 0,0
Xsg13cmos5l_tiehi_15 \$4926 VPWR VGND sg13cmos5l_tiehi
* cell instance sg13cmos5l_tiehi_16 r0 *1 0,0
Xsg13cmos5l_tiehi_16 \$4942 VPWR VGND sg13cmos5l_tiehi
* cell instance sg13cmos5l_tiehi_17 r0 *1 0,0
Xsg13cmos5l_tiehi_17 \$4665 VPWR VGND sg13cmos5l_tiehi
* cell instance sg13cmos5l_tielo_0 r0 *1 0,0
Xsg13cmos5l_tielo_0 \$5076 VPWR VGND sg13cmos5l_tielo
* cell instance sg13cmos5l_tielo_1 r0 *1 0,0
Xsg13cmos5l_tielo_1 \$4723 VPWR VGND sg13cmos5l_tielo
* cell instance sg13cmos5l_tielo_2 r0 *1 0,0
Xsg13cmos5l_tielo_2 \$4731 VPWR VGND sg13cmos5l_tielo
* cell instance sg13cmos5l_tielo_3 r0 *1 0,0
Xsg13cmos5l_tielo_3 \$4735 VPWR VGND sg13cmos5l_tielo
* cell instance sg13cmos5l_tielo_4 r0 *1 0,0
Xsg13cmos5l_tielo_4 \$4743 VPWR VGND sg13cmos5l_tielo
* cell instance sg13cmos5l_tielo_5 r0 *1 0,0
Xsg13cmos5l_tielo_5 \$4747 VPWR VGND sg13cmos5l_tielo
* cell instance sg13cmos5l_tielo_6 r0 *1 0,0
Xsg13cmos5l_tielo_6 \$4758 VPWR VGND sg13cmos5l_tielo
* cell instance sg13cmos5l_tielo_7 r0 *1 0,0
Xsg13cmos5l_tielo_7 \$4760 VPWR VGND sg13cmos5l_tielo
* cell instance sg13cmos5l_tielo_8 r0 *1 0,0
Xsg13cmos5l_tielo_8 \$4770 VPWR VGND sg13cmos5l_tielo
* cell instance sg13cmos5l_tielo_9 r0 *1 0,0
Xsg13cmos5l_tielo_9 \$4772 VPWR VGND sg13cmos5l_tielo
* cell instance sg13cmos5l_tielo_10 r0 *1 0,0
Xsg13cmos5l_tielo_10 \$4782 VPWR VGND sg13cmos5l_tielo
* cell instance sg13cmos5l_tielo_11 r0 *1 0,0
Xsg13cmos5l_tielo_11 \$4784 VPWR VGND sg13cmos5l_tielo
* cell instance sg13cmos5l_tielo_12 r0 *1 0,0
Xsg13cmos5l_tielo_12 \$4794 VPWR VGND sg13cmos5l_tielo
* cell instance sg13cmos5l_tielo_13 r0 *1 0,0
Xsg13cmos5l_tielo_13 \$4798 VPWR VGND sg13cmos5l_tielo
* cell instance sg13cmos5l_tielo_14 r0 *1 0,0
Xsg13cmos5l_tielo_14 \$4807 VPWR VGND sg13cmos5l_tielo
* cell instance sg13cmos5l_tielo_15 r0 *1 0,0
Xsg13cmos5l_tielo_15 \$4612 VPWR VGND sg13cmos5l_tielo
* cell instance sg13cmos5l_tielo_16 r0 *1 0,0
Xsg13cmos5l_tielo_16 \$4470 VPWR VGND sg13cmos5l_tielo
* cell instance sg13cmos5l_tielo_17 r0 *1 0,0
Xsg13cmos5l_tielo_17 \$4620 VPWR VGND sg13cmos5l_tielo
* cell instance sg13cmos5l_tielo_18 r0 *1 0,0
Xsg13cmos5l_tielo_18 \$4471 VPWR VGND sg13cmos5l_tielo
* cell instance sg13cmos5l_tielo_19 r0 *1 0,0
Xsg13cmos5l_tielo_19 \$5348 VPWR VGND sg13cmos5l_tielo
* cell instance sg13cmos5l_tielo_20 r0 *1 0,0
Xsg13cmos5l_tielo_20 \$4822 VPWR VGND sg13cmos5l_tielo
* cell instance sg13cmos5l_tielo_21 r0 *1 0,0
Xsg13cmos5l_tielo_21 \$4478 VPWR VGND sg13cmos5l_tielo
* cell instance sg13cmos5l_tielo_22 r0 *1 0,0
Xsg13cmos5l_tielo_22 \$4482 VPWR VGND sg13cmos5l_tielo
* cell instance sg13cmos5l_tielo_23 r0 *1 0,0
Xsg13cmos5l_tielo_23 \$4830 VPWR VGND sg13cmos5l_tielo
* cell instance sg13cmos5l_tielo_24 r0 *1 0,0
Xsg13cmos5l_tielo_24 \$4634 VPWR VGND sg13cmos5l_tielo
* cell instance sg13cmos5l_tielo_25 r0 *1 0,0
Xsg13cmos5l_tielo_25 \$4834 VPWR VGND sg13cmos5l_tielo
* cell instance sg13cmos5l_tielo_26 r0 *1 0,0
Xsg13cmos5l_tielo_26 \$4838 VPWR VGND sg13cmos5l_tielo
* cell instance sg13cmos5l_tielo_27 r0 *1 0,0
Xsg13cmos5l_tielo_27 \$4842 VPWR VGND sg13cmos5l_tielo
* cell instance sg13cmos5l_tielo_28 r0 *1 0,0
Xsg13cmos5l_tielo_28 \$4846 VPWR VGND sg13cmos5l_tielo
* cell instance sg13cmos5l_tielo_29 r0 *1 0,0
Xsg13cmos5l_tielo_29 \$4858 VPWR VGND sg13cmos5l_tielo
* cell instance sg13cmos5l_tielo_30 r0 *1 0,0
Xsg13cmos5l_tielo_30 \$4862 VPWR VGND sg13cmos5l_tielo
* cell instance sg13cmos5l_tielo_31 r0 *1 0,0
Xsg13cmos5l_tielo_31 \$4870 VPWR VGND sg13cmos5l_tielo
* cell instance sg13cmos5l_tielo_32 r0 *1 0,0
Xsg13cmos5l_tielo_32 \$4874 VPWR VGND sg13cmos5l_tielo
* cell instance sg13cmos5l_tielo_33 r0 *1 0,0
Xsg13cmos5l_tielo_33 \$4883 VPWR VGND sg13cmos5l_tielo
* cell instance sg13cmos5l_tielo_34 r0 *1 0,0
Xsg13cmos5l_tielo_34 \$4890 VPWR VGND sg13cmos5l_tielo
* cell instance sg13cmos5l_tielo_35 r0 *1 0,0
Xsg13cmos5l_tielo_35 \$4898 VPWR VGND sg13cmos5l_tielo
* cell instance sg13cmos5l_tielo_36 r0 *1 0,0
Xsg13cmos5l_tielo_36 \$4902 VPWR VGND sg13cmos5l_tielo
* cell instance sg13cmos5l_tielo_37 r0 *1 0,0
Xsg13cmos5l_tielo_37 \$4914 VPWR VGND sg13cmos5l_tielo
* cell instance sg13cmos5l_tielo_38 r0 *1 0,0
Xsg13cmos5l_tielo_38 \$4918 VPWR VGND sg13cmos5l_tielo
* cell instance sg13cmos5l_tielo_39 r0 *1 0,0
Xsg13cmos5l_tielo_39 \$4930 VPWR VGND sg13cmos5l_tielo
* cell instance sg13cmos5l_tielo_40 r0 *1 0,0
Xsg13cmos5l_tielo_40 \$4648 VPWR VGND sg13cmos5l_tielo
* cell instance sg13cmos5l_tielo_41 r0 *1 0,0
Xsg13cmos5l_tielo_41 \$4934 VPWR VGND sg13cmos5l_tielo
* cell instance sg13cmos5l_tielo_42 r0 *1 0,0
Xsg13cmos5l_tielo_42 \$4408 VPWR VGND sg13cmos5l_tielo
* cell instance sg13cmos5l_tielo_43 r0 *1 0,0
Xsg13cmos5l_tielo_43 \$4959 VPWR VGND sg13cmos5l_tielo
* cell instance sg13cmos5l_tielo_44 r0 *1 0,0
Xsg13cmos5l_tielo_44 \$5077 VPWR VGND sg13cmos5l_tielo
* cell instance sg13cmos5l_xnor2_1_0 r0 *1 0,0
Xsg13cmos5l_xnor2_1_0 \$2403 \$2258 VPWR VGND \$2261 sg13cmos5l_xnor2_1
* cell instance sg13cmos5l_xnor2_1_1 r0 *1 0,0
Xsg13cmos5l_xnor2_1_1 \$2405 \$2401 VPWR VGND \$2406 sg13cmos5l_xnor2_1
* cell instance sg13cmos5l_xnor2_1_2 r0 *1 0,0
Xsg13cmos5l_xnor2_1_2 \$2753 \$3615 VPWR VGND \$3471 sg13cmos5l_xnor2_1
* cell instance sg13cmos5l_xnor2_1_3 r0 *1 0,0
Xsg13cmos5l_xnor2_1_3 \$2403 \$2414 VPWR VGND \$2266 sg13cmos5l_xnor2_1
* cell instance sg13cmos5l_xnor2_1_4 r0 *1 0,0
Xsg13cmos5l_xnor2_1_4 \$2598 \$2599 VPWR VGND \$2415 sg13cmos5l_xnor2_1
* cell instance sg13cmos5l_xnor2_1_5 r0 *1 0,0
Xsg13cmos5l_xnor2_1_5 \$4103 \$4104 VPWR VGND \$4313 sg13cmos5l_xnor2_1
* cell instance sg13cmos5l_xnor2_1_6 r0 *1 0,0
Xsg13cmos5l_xnor2_1_6 \$2753 \$3625 VPWR VGND \$3627 sg13cmos5l_xnor2_1
* cell instance sg13cmos5l_xnor2_1_7 r0 *1 0,0
Xsg13cmos5l_xnor2_1_7 \$2754 \$3282 VPWR VGND \$3285 sg13cmos5l_xnor2_1
* cell instance sg13cmos5l_xnor2_1_8 r0 *1 0,0
Xsg13cmos5l_xnor2_1_8 \$796 \$680 VPWR VGND \$797 sg13cmos5l_xnor2_1
* cell instance sg13cmos5l_xnor2_1_9 r0 *1 0,0
Xsg13cmos5l_xnor2_1_9 \$690 \$689 VPWR VGND \$923 sg13cmos5l_xnor2_1
* cell instance sg13cmos5l_xnor2_1_10 r0 *1 0,0
Xsg13cmos5l_xnor2_1_10 \$1045 \$1152 VPWR VGND \$1155 sg13cmos5l_xnor2_1
* cell instance sg13cmos5l_xnor2_1_11 r0 *1 0,0
Xsg13cmos5l_xnor2_1_11 \$1596 \$1484 VPWR VGND \$1600 sg13cmos5l_xnor2_1
* cell instance sg13cmos5l_xnor2_1_12 r0 *1 0,0
Xsg13cmos5l_xnor2_1_12 \$1974 \$2452 VPWR VGND \$2635 sg13cmos5l_xnor2_1
* cell instance sg13cmos5l_xnor2_1_13 r0 *1 0,0
Xsg13cmos5l_xnor2_1_13 \$36 \$43 VPWR VGND \$37 sg13cmos5l_xnor2_1
* cell instance sg13cmos5l_xnor2_1_14 r0 *1 0,0
Xsg13cmos5l_xnor2_1_14 \$3848 \$3667 VPWR VGND \$3849 sg13cmos5l_xnor2_1
* cell instance sg13cmos5l_xnor2_1_15 r0 *1 0,0
Xsg13cmos5l_xnor2_1_15 \$3851 \$3849 VPWR VGND \$3154 sg13cmos5l_xnor2_1
* cell instance sg13cmos5l_xnor2_1_16 r0 *1 0,0
Xsg13cmos5l_xnor2_1_16 \$3154 \$3993 VPWR VGND \$3994 sg13cmos5l_xnor2_1
* cell instance sg13cmos5l_xnor2_1_17 r0 *1 0,0
Xsg13cmos5l_xnor2_1_17 \$3154 \$3159 VPWR VGND \$3160 sg13cmos5l_xnor2_1
* cell instance sg13cmos5l_xnor2_1_18 r0 *1 0,0
Xsg13cmos5l_xnor2_1_18 \$3944 \$3996 VPWR VGND \$3993 sg13cmos5l_xnor2_1
* cell instance sg13cmos5l_xnor2_1_19 r0 *1 0,0
Xsg13cmos5l_xnor2_1_19 \$4353 \$4179 VPWR VGND \$3996 sg13cmos5l_xnor2_1
* cell instance sg13cmos5l_xnor2_1_20 r0 *1 0,0
Xsg13cmos5l_xnor2_1_20 \$3857 \$3685 VPWR VGND \$3851 sg13cmos5l_xnor2_1
* cell instance sg13cmos5l_xnor2_1_21 r0 *1 0,0
Xsg13cmos5l_xnor2_1_21 \$3367 \$3513 VPWR VGND \$3685 sg13cmos5l_xnor2_1
* cell instance sg13cmos5l_xnor2_1_22 r0 *1 0,0
Xsg13cmos5l_xnor2_1_22 \$3521 \$3264 VPWR VGND \$3515 sg13cmos5l_xnor2_1
* cell instance sg13cmos5l_xnor2_1_23 r0 *1 0,0
Xsg13cmos5l_xnor2_1_23 \$3171 \$3173 VPWR VGND \$3264 sg13cmos5l_xnor2_1
* cell instance sg13cmos5l_xnor2_1_24 r0 *1 0,0
Xsg13cmos5l_xnor2_1_24 \$3517 \$3515 VPWR VGND \$3345 sg13cmos5l_xnor2_1
* cell instance sg13cmos5l_xnor2_1_25 r0 *1 0,0
Xsg13cmos5l_xnor2_1_25 \$3360 \$3515 VPWR VGND \$3159 sg13cmos5l_xnor2_1
* cell instance sg13cmos5l_xnor2_1_26 r0 *1 0,0
Xsg13cmos5l_xnor2_1_26 \$3858 \$3686 VPWR VGND \$3860 sg13cmos5l_xnor2_1
* cell instance sg13cmos5l_xnor2_1_27 r0 *1 0,0
Xsg13cmos5l_xnor2_1_27 \$3164 \$3362 VPWR VGND \$3360 sg13cmos5l_xnor2_1
* cell instance sg13cmos5l_xnor2_1_28 r0 *1 0,0
Xsg13cmos5l_xnor2_1_28 \$3993 \$3860 VPWR VGND \$2664 sg13cmos5l_xnor2_1
* cell instance sg13cmos5l_xnor2_1_29 r0 *1 0,0
Xsg13cmos5l_xnor2_1_29 \$3360 \$3366 VPWR VGND \$3367 sg13cmos5l_xnor2_1
* cell instance sg13cmos5l_xnor2_1_30 r0 *1 0,0
Xsg13cmos5l_xnor2_1_30 \$2961 \$3179 VPWR VGND \$3366 sg13cmos5l_xnor2_1
* cell instance sg13cmos5l_xnor2_1_31 r0 *1 0,0
Xsg13cmos5l_xnor2_1_31 \$4197 \$3863 VPWR VGND \$3523 sg13cmos5l_xnor2_1
* cell instance sg13cmos5l_xnor2_1_32 r0 *1 0,0
Xsg13cmos5l_xnor2_1_32 \$3367 \$3369 VPWR VGND \$3004 sg13cmos5l_xnor2_1
* cell instance sg13cmos5l_xnor2_1_33 r0 *1 0,0
Xsg13cmos5l_xnor2_1_33 \$3515 \$3523 VPWR VGND \$3369 sg13cmos5l_xnor2_1
* cell instance sg13cmos5l_xnor2_1_34 r0 *1 0,0
Xsg13cmos5l_xnor2_1_34 \$3690 \$3869 VPWR VGND \$3863 sg13cmos5l_xnor2_1
* cell instance sg13cmos5l_xnor2_1_35 r0 *1 0,0
Xsg13cmos5l_xnor2_1_35 \$3990 \$3372 VPWR VGND \$4007 sg13cmos5l_xnor2_1
* cell instance sg13cmos5l_xnor2_1_36 r0 *1 0,0
Xsg13cmos5l_xnor2_1_36 \$4139 \$4199 VPWR VGND \$4200 sg13cmos5l_xnor2_1
* cell instance sg13cmos5l_xnor2_1_37 r0 *1 0,0
Xsg13cmos5l_xnor2_1_37 \$3372 \$4200 VPWR VGND \$4179 sg13cmos5l_xnor2_1
* cell instance sg13cmos5l_xnor2_1_38 r0 *1 0,0
Xsg13cmos5l_xnor2_1_38 \$4013 \$4007 VPWR VGND \$3871 sg13cmos5l_xnor2_1
* cell instance sg13cmos5l_xnor2_1_39 r0 *1 0,0
Xsg13cmos5l_xnor2_1_39 \$3198 \$3871 VPWR VGND \$3517 sg13cmos5l_xnor2_1
* cell instance sg13cmos5l_xnor2_1_40 r0 *1 0,0
Xsg13cmos5l_xnor2_1_40 \$4179 \$3869 VPWR VGND \$4381 sg13cmos5l_xnor2_1
* cell instance sg13cmos5l_xnor2_1_41 r0 *1 0,0
Xsg13cmos5l_xnor2_1_41 \$3151 \$3559 VPWR VGND \$3372 sg13cmos5l_xnor2_1
* cell instance sg13cmos5l_xnor2_1_42 r0 *1 0,0
Xsg13cmos5l_xnor2_1_42 \$3517 \$4381 VPWR VGND \$4212 sg13cmos5l_xnor2_1
* cell instance sg13cmos5l_xnor2_1_43 r0 *1 0,0
Xsg13cmos5l_xnor2_1_43 \$3511 \$3704 VPWR VGND \$3706 sg13cmos5l_xnor2_1
* cell instance sg13cmos5l_xnor2_1_44 r0 *1 0,0
Xsg13cmos5l_xnor2_1_44 \$3015 \$3704 VPWR VGND \$3874 sg13cmos5l_xnor2_1
* cell instance sg13cmos5l_xnor2_1_45 r0 *1 0,0
Xsg13cmos5l_xnor2_1_45 \$3369 \$3706 VPWR VGND \$3532 sg13cmos5l_xnor2_1
* cell instance sg13cmos5l_xnor2_1_46 r0 *1 0,0
Xsg13cmos5l_xnor2_1_46 \$3709 \$3874 VPWR VGND \$3198 sg13cmos5l_xnor2_1
* cell instance sg13cmos5l_xnor2_1_47 r0 *1 0,0
Xsg13cmos5l_xnor2_1_47 \$3993 \$3704 VPWR VGND \$3876 sg13cmos5l_xnor2_1
* cell instance sg13cmos5l_xnor2_1_48 r0 *1 0,0
Xsg13cmos5l_xnor2_1_48 \$3173 \$3198 VPWR VGND \$3379 sg13cmos5l_xnor2_1
* cell instance sg13cmos5l_xnor2_1_49 r0 *1 0,0
Xsg13cmos5l_xnor2_1_49 \$2364 \$2231 VPWR VGND \$2839 sg13cmos5l_xnor2_1
* cell instance sg13cmos5l_xnor2_1_50 r0 *1 0,0
Xsg13cmos5l_xnor2_1_50 \$4025 \$4226 VPWR VGND \$3869 sg13cmos5l_xnor2_1
* cell instance sg13cmos5l_xnor2_1_51 r0 *1 0,0
Xsg13cmos5l_xnor2_1_51 \$3869 \$4031 VPWR VGND \$3704 sg13cmos5l_xnor2_1
* cell instance sg13cmos5l_xnor2_1_52 r0 *1 0,0
Xsg13cmos5l_xnor2_1_52 \$3870 \$4033 VPWR VGND \$4031 sg13cmos5l_xnor2_1
* cell instance sg13cmos5l_xnor2_1_53 r0 *1 0,0
Xsg13cmos5l_xnor2_1_53 \$3511 \$3550 VPWR VGND \$3173 sg13cmos5l_xnor2_1
* cell instance sg13cmos5l_xnor2_1_54 r0 *1 0,0
Xsg13cmos5l_xnor2_1_54 \$3385 \$3549 VPWR VGND \$3550 sg13cmos5l_xnor2_1
* cell instance sg13cmos5l_xnor2_1_55 r0 *1 0,0
Xsg13cmos5l_xnor2_1_55 \$3499 \$3719 VPWR VGND \$3511 sg13cmos5l_xnor2_1
* cell instance sg13cmos5l_xnor2_1_56 r0 *1 0,0
Xsg13cmos5l_xnor2_1_56 \$2888 \$2101 VPWR VGND \$3255 sg13cmos5l_xnor2_1
* cell instance sg13cmos5l_xnor2_1_57 r0 *1 0,0
Xsg13cmos5l_xnor2_1_57 \$2740 \$2890 VPWR VGND \$3088 sg13cmos5l_xnor2_1
* cell instance sg13cmos5l_xnor2_1_58 r0 *1 0,0
Xsg13cmos5l_xnor2_1_58 \$2392 \$2550 VPWR VGND \$2552 sg13cmos5l_xnor2_1
* cell instance sg13cmos5l_xnor2_1_59 r0 *1 0,0
Xsg13cmos5l_xnor2_1_59 \$78 \$368 VPWR VGND \$739 sg13cmos5l_xnor2_1
* cell instance sg13cmos5l_xnor2_1_60 r0 *1 0,0
Xsg13cmos5l_xnor2_1_60 \$136 \$79 VPWR VGND \$87 sg13cmos5l_xnor2_1
* cell instance sg13cmos5l_xnor2_1_61 r0 *1 0,0
Xsg13cmos5l_xnor2_1_61 \$136 \$1655 VPWR VGND \$433 sg13cmos5l_xnor2_1
* cell instance sg13cmos5l_xor2_1_0 r0 *1 0,0
Xsg13cmos5l_xor2_1_0 \$3277 \$2754 VPWR VGND \$3470 sg13cmos5l_xor2_1
* cell instance sg13cmos5l_xor2_1_1 r0 *1 0,0
Xsg13cmos5l_xor2_1_1 \$4106 \$4101 VPWR VGND \$4291 sg13cmos5l_xor2_1
* cell instance sg13cmos5l_xor2_1_2 r0 *1 0,0
Xsg13cmos5l_xor2_1_2 \$4105 \$3808 VPWR VGND \$4109 sg13cmos5l_xor2_1
* cell instance sg13cmos5l_xor2_1_3 r0 *1 0,0
Xsg13cmos5l_xor2_1_3 \$4675 \$4106 VPWR VGND \$4687 sg13cmos5l_xor2_1
* cell instance sg13cmos5l_xor2_1_4 r0 *1 0,0
Xsg13cmos5l_xor2_1_4 \$1368 \$1483 VPWR VGND \$1479 sg13cmos5l_xor2_1
* cell instance sg13cmos5l_xor2_1_5 r0 *1 0,0
Xsg13cmos5l_xor2_1_5 \$704 \$809 VPWR VGND \$940 sg13cmos5l_xor2_1
* cell instance sg13cmos5l_xor2_1_6 r0 *1 0,0
Xsg13cmos5l_xor2_1_6 \$3308 \$3173 VPWR VGND \$3667 sg13cmos5l_xor2_1
* cell instance sg13cmos5l_xor2_1_7 r0 *1 0,0
Xsg13cmos5l_xor2_1_7 \$3664 \$3511 VPWR VGND \$3513 sg13cmos5l_xor2_1
* cell instance sg13cmos5l_xor2_1_8 r0 *1 0,0
Xsg13cmos5l_xor2_1_8 \$3851 \$4179 VPWR VGND \$4000 sg13cmos5l_xor2_1
* cell instance sg13cmos5l_xor2_1_9 r0 *1 0,0
Xsg13cmos5l_xor2_1_9 \$3001 \$3360 VPWR VGND \$3686 sg13cmos5l_xor2_1
* cell instance sg13cmos5l_xor2_1_10 r0 *1 0,0
Xsg13cmos5l_xor2_1_10 \$3367 \$3372 VPWR VGND \$3010 sg13cmos5l_xor2_1
* cell instance sg13cmos5l_xor2_1_11 r0 *1 0,0
Xsg13cmos5l_xor2_1_11 \$2664 \$3198 VPWR VGND \$2835 sg13cmos5l_xor2_1
* cell instance sg13cmos5l_xor2_1_12 r0 *1 0,0
Xsg13cmos5l_xor2_1_12 \$2229 \$2235 VPWR VGND \$2238 sg13cmos5l_xor2_1
* cell instance sg13cmos5l_xor2_1_13 r0 *1 0,0
Xsg13cmos5l_xor2_1_13 \$2834 \$3042 VPWR VGND \$2919 sg13cmos5l_xor2_1
* cell instance sg13cmos5l_xor2_1_14 r0 *1 0,0
Xsg13cmos5l_xor2_1_14 \$2864 \$2708 VPWR VGND \$3060 sg13cmos5l_xor2_1
* cell instance sg13cmos5l_xor2_1_15 r0 *1 0,0
Xsg13cmos5l_xor2_1_15 \$2719 \$2544 VPWR VGND \$2722 sg13cmos5l_xor2_1
.ENDS tt_um_2amlogic_protocol_emulator

* cell sg13cmos5l_xor2_1
* pin A
* pin B
* pin VDD
* pin VSS
* pin X
.SUBCKT sg13cmos5l_xor2_1 A B VDD VSS X
.ENDS sg13cmos5l_xor2_1

* cell sg13cmos5l_xnor2_1
* pin A
* pin B
* pin VDD
* pin VSS
* pin Y
.SUBCKT sg13cmos5l_xnor2_1 A B VDD VSS Y
.ENDS sg13cmos5l_xnor2_1

* cell sg13cmos5l_tielo
* pin L_LO
* pin VDD
* pin VSS
.SUBCKT sg13cmos5l_tielo L_LO VDD VSS
.ENDS sg13cmos5l_tielo

* cell sg13cmos5l_tiehi
* pin L_HI
* pin VDD
* pin VSS
.SUBCKT sg13cmos5l_tiehi L_HI VDD VSS
.ENDS sg13cmos5l_tiehi

* cell sg13cmos5l_or4_1
* pin A
* pin B
* pin C
* pin D
* pin VDD
* pin VSS
* pin X
.SUBCKT sg13cmos5l_or4_1 A B C D VDD VSS X
.ENDS sg13cmos5l_or4_1

* cell sg13cmos5l_or3_1
* pin A
* pin B
* pin C
* pin VDD
* pin VSS
* pin X
.SUBCKT sg13cmos5l_or3_1 A B C VDD VSS X
.ENDS sg13cmos5l_or3_1

* cell sg13cmos5l_or2_1
* pin A
* pin B
* pin VDD
* pin VSS
* pin X
.SUBCKT sg13cmos5l_or2_1 A B VDD VSS X
.ENDS sg13cmos5l_or2_1

* cell sg13cmos5l_o21ai_1
* pin A1
* pin A2
* pin B1
* pin VDD
* pin VSS
* pin Y
.SUBCKT sg13cmos5l_o21ai_1 A1 A2 B1 VDD VSS Y
.ENDS sg13cmos5l_o21ai_1

* cell sg13cmos5l_nor4_1
* pin A
* pin B
* pin C
* pin D
* pin VDD
* pin VSS
* pin Y
.SUBCKT sg13cmos5l_nor4_1 A B C D VDD VSS Y
.ENDS sg13cmos5l_nor4_1

* cell sg13cmos5l_nor3_1
* pin A
* pin B
* pin C
* pin VDD
* pin VSS
* pin Y
.SUBCKT sg13cmos5l_nor3_1 A B C VDD VSS Y
.ENDS sg13cmos5l_nor3_1

* cell sg13cmos5l_nor2b_1
* pin A
* pin B_N
* pin VDD
* pin VSS
* pin Y
.SUBCKT sg13cmos5l_nor2b_1 A B_N VDD VSS Y
.ENDS sg13cmos5l_nor2b_1

* cell sg13cmos5l_nor2_1
* pin A
* pin B
* pin VDD
* pin VSS
* pin Y
.SUBCKT sg13cmos5l_nor2_1 A B VDD VSS Y
.ENDS sg13cmos5l_nor2_1

* cell sg13cmos5l_nand4_1
* pin A
* pin B
* pin C
* pin D
* pin VDD
* pin VSS
* pin Y
.SUBCKT sg13cmos5l_nand4_1 A B C D VDD VSS Y
.ENDS sg13cmos5l_nand4_1

* cell sg13cmos5l_nand3b_1
* pin A_N
* pin B
* pin C
* pin VDD
* pin VSS
* pin Y
.SUBCKT sg13cmos5l_nand3b_1 A_N B C VDD VSS Y
.ENDS sg13cmos5l_nand3b_1

* cell sg13cmos5l_nand3_1
* pin A
* pin B
* pin C
* pin VDD
* pin VSS
* pin Y
.SUBCKT sg13cmos5l_nand3_1 A B C VDD VSS Y
.ENDS sg13cmos5l_nand3_1

* cell sg13cmos5l_nand2b_1
* pin A_N
* pin B
* pin VDD
* pin VSS
* pin Y
.SUBCKT sg13cmos5l_nand2b_1 A_N B VDD VSS Y
.ENDS sg13cmos5l_nand2b_1

* cell sg13cmos5l_nand2_1
* pin A
* pin B
* pin VDD
* pin VSS
* pin Y
.SUBCKT sg13cmos5l_nand2_1 A B VDD VSS Y
.ENDS sg13cmos5l_nand2_1

* cell sg13cmos5l_mux4_1
* pin A0
* pin A1
* pin A2
* pin A3
* pin S0
* pin S1
* pin VDD
* pin VSS
* pin X
.SUBCKT sg13cmos5l_mux4_1 A0 A1 A2 A3 S0 S1 VDD VSS X
.ENDS sg13cmos5l_mux4_1

* cell sg13cmos5l_mux2_1
* pin A0
* pin A1
* pin S
* pin VDD
* pin VSS
* pin X
.SUBCKT sg13cmos5l_mux2_1 A0 A1 S VDD VSS X
.ENDS sg13cmos5l_mux2_1

* cell sg13cmos5l_inv_1
* pin A
* pin VDD
* pin VSS
* pin Y
.SUBCKT sg13cmos5l_inv_1 A VDD VSS Y
.ENDS sg13cmos5l_inv_1

* cell sg13cmos5l_fill_2
* pin VDD
* pin VSS
.SUBCKT sg13cmos5l_fill_2 VDD VSS
.ENDS sg13cmos5l_fill_2

* cell sg13cmos5l_fill_1
* pin VDD
* pin VSS
.SUBCKT sg13cmos5l_fill_1 VDD VSS
.ENDS sg13cmos5l_fill_1

* cell sg13cmos5l_dlygate4sd3_1
* pin A
* pin VDD
* pin VSS
* pin X
.SUBCKT sg13cmos5l_dlygate4sd3_1 A VDD VSS X
.ENDS sg13cmos5l_dlygate4sd3_1

* cell sg13cmos5l_dfrbpq_1
* pin CLK
* pin D
* pin Q
* pin RESET_B
* pin VDD
* pin VSS
.SUBCKT sg13cmos5l_dfrbpq_1 CLK D Q RESET_B VDD VSS
.ENDS sg13cmos5l_dfrbpq_1

* cell sg13cmos5l_decap_8
* pin VDD
* pin VSS
.SUBCKT sg13cmos5l_decap_8 VDD VSS
.ENDS sg13cmos5l_decap_8

* cell sg13cmos5l_decap_4
* pin VDD
* pin VSS
.SUBCKT sg13cmos5l_decap_4 VDD VSS
.ENDS sg13cmos5l_decap_4

* cell sg13cmos5l_buf_8
* pin A
* pin VDD
* pin VSS
* pin X
.SUBCKT sg13cmos5l_buf_8 A VDD VSS X
.ENDS sg13cmos5l_buf_8

* cell sg13cmos5l_buf_4
* pin A
* pin VDD
* pin VSS
* pin X
.SUBCKT sg13cmos5l_buf_4 A VDD VSS X
.ENDS sg13cmos5l_buf_4

* cell sg13cmos5l_buf_1
* pin A
* pin VDD
* pin VSS
* pin X
.SUBCKT sg13cmos5l_buf_1 A VDD VSS X
.ENDS sg13cmos5l_buf_1

* cell sg13cmos5l_antennanp
* pin A
* pin VDD
* pin VSS
.SUBCKT sg13cmos5l_antennanp A VDD VSS
.ENDS sg13cmos5l_antennanp

* cell sg13cmos5l_and4_1
* pin A
* pin B
* pin C
* pin D
* pin VDD
* pin VSS
* pin X
.SUBCKT sg13cmos5l_and4_1 A B C D VDD VSS X
.ENDS sg13cmos5l_and4_1

* cell sg13cmos5l_and3_1
* pin A
* pin B
* pin C
* pin VDD
* pin VSS
* pin X
.SUBCKT sg13cmos5l_and3_1 A B C VDD VSS X
.ENDS sg13cmos5l_and3_1

* cell sg13cmos5l_and2_1
* pin A
* pin B
* pin VDD
* pin VSS
* pin X
.SUBCKT sg13cmos5l_and2_1 A B VDD VSS X
.ENDS sg13cmos5l_and2_1

* cell sg13cmos5l_a22oi_1
* pin A1
* pin A2
* pin B1
* pin B2
* pin VDD
* pin VSS
* pin Y
.SUBCKT sg13cmos5l_a22oi_1 A1 A2 B1 B2 VDD VSS Y
.ENDS sg13cmos5l_a22oi_1

* cell sg13cmos5l_a221oi_1
* pin A1
* pin A2
* pin B1
* pin B2
* pin C1
* pin VDD
* pin VSS
* pin Y
.SUBCKT sg13cmos5l_a221oi_1 A1 A2 B1 B2 C1 VDD VSS Y
.ENDS sg13cmos5l_a221oi_1

* cell sg13cmos5l_a21oi_1
* pin A1
* pin A2
* pin B1
* pin VDD
* pin VSS
* pin Y
.SUBCKT sg13cmos5l_a21oi_1 A1 A2 B1 VDD VSS Y
.ENDS sg13cmos5l_a21oi_1

* cell sg13cmos5l_a21o_1
* pin A1
* pin A2
* pin B1
* pin VDD
* pin VSS
* pin X
.SUBCKT sg13cmos5l_a21o_1 A1 A2 B1 VDD VSS X
.ENDS sg13cmos5l_a21o_1

* cell RM_IHPSG13_1P_256x16_c2_bm_bist
* pin A_ADDR<0>
* pin A_ADDR<1>
* pin A_ADDR<2>
* pin A_ADDR<3>
* pin A_ADDR<4>
* pin A_ADDR<5>
* pin A_ADDR<6>
* pin A_ADDR<7>
* pin A_BIST_ADDR<0>
* pin A_BIST_ADDR<1>
* pin A_BIST_ADDR<2>
* pin A_BIST_ADDR<3>
* pin A_BIST_ADDR<4>
* pin A_BIST_ADDR<5>
* pin A_BIST_ADDR<6>
* pin A_BIST_ADDR<7>
* pin A_BIST_BM<0>
* pin A_BIST_BM<10>
* pin A_BIST_BM<11>
* pin A_BIST_BM<12>
* pin A_BIST_BM<13>
* pin A_BIST_BM<14>
* pin A_BIST_BM<15>
* pin A_BIST_BM<1>
* pin A_BIST_BM<2>
* pin A_BIST_BM<3>
* pin A_BIST_BM<4>
* pin A_BIST_BM<5>
* pin A_BIST_BM<6>
* pin A_BIST_BM<7>
* pin A_BIST_BM<8>
* pin A_BIST_BM<9>
* pin A_BIST_CLK
* pin A_BIST_DIN<0>
* pin A_BIST_DIN<10>
* pin A_BIST_DIN<11>
* pin A_BIST_DIN<12>
* pin A_BIST_DIN<13>
* pin A_BIST_DIN<14>
* pin A_BIST_DIN<15>
* pin A_BIST_DIN<1>
* pin A_BIST_DIN<2>
* pin A_BIST_DIN<3>
* pin A_BIST_DIN<4>
* pin A_BIST_DIN<5>
* pin A_BIST_DIN<6>
* pin A_BIST_DIN<7>
* pin A_BIST_DIN<8>
* pin A_BIST_DIN<9>
* pin A_BIST_EN
* pin A_BIST_MEN
* pin A_BIST_REN
* pin A_BIST_WEN
* pin A_BM<0>
* pin A_BM<10>
* pin A_BM<11>
* pin A_BM<12>
* pin A_BM<13>
* pin A_BM<14>
* pin A_BM<15>
* pin A_BM<1>
* pin A_BM<2>
* pin A_BM<3>
* pin A_BM<4>
* pin A_BM<5>
* pin A_BM<6>
* pin A_BM<7>
* pin A_BM<8>
* pin A_BM<9>
* pin A_CLK
* pin A_DIN<0>
* pin A_DIN<10>
* pin A_DIN<11>
* pin A_DIN<12>
* pin A_DIN<13>
* pin A_DIN<14>
* pin A_DIN<15>
* pin A_DIN<1>
* pin A_DIN<2>
* pin A_DIN<3>
* pin A_DIN<4>
* pin A_DIN<5>
* pin A_DIN<6>
* pin A_DIN<7>
* pin A_DIN<8>
* pin A_DIN<9>
* pin A_DLY
* pin A_DOUT<0>
* pin A_DOUT<10>
* pin A_DOUT<11>
* pin A_DOUT<12>
* pin A_DOUT<13>
* pin A_DOUT<14>
* pin A_DOUT<15>
* pin A_DOUT<1>
* pin A_DOUT<2>
* pin A_DOUT<3>
* pin A_DOUT<4>
* pin A_DOUT<5>
* pin A_DOUT<6>
* pin A_DOUT<7>
* pin A_DOUT<8>
* pin A_DOUT<9>
* pin A_MEN
* pin A_REN
* pin A_WEN
* pin VDD!
* pin VDDARRAY!
* pin VSS!
.SUBCKT RM_IHPSG13_1P_256x16_c2_bm_bist A_ADDR<0> A_ADDR<1> A_ADDR<2> A_ADDR<3>
+ A_ADDR<4> A_ADDR<5> A_ADDR<6> A_ADDR<7> A_BIST_ADDR<0> A_BIST_ADDR<1>
+ A_BIST_ADDR<2> A_BIST_ADDR<3> A_BIST_ADDR<4> A_BIST_ADDR<5> A_BIST_ADDR<6>
+ A_BIST_ADDR<7> A_BIST_BM<0> A_BIST_BM<10> A_BIST_BM<11> A_BIST_BM<12>
+ A_BIST_BM<13> A_BIST_BM<14> A_BIST_BM<15> A_BIST_BM<1> A_BIST_BM<2>
+ A_BIST_BM<3> A_BIST_BM<4> A_BIST_BM<5> A_BIST_BM<6> A_BIST_BM<7> A_BIST_BM<8>
+ A_BIST_BM<9> A_BIST_CLK A_BIST_DIN<0> A_BIST_DIN<10> A_BIST_DIN<11>
+ A_BIST_DIN<12> A_BIST_DIN<13> A_BIST_DIN<14> A_BIST_DIN<15> A_BIST_DIN<1>
+ A_BIST_DIN<2> A_BIST_DIN<3> A_BIST_DIN<4> A_BIST_DIN<5> A_BIST_DIN<6>
+ A_BIST_DIN<7> A_BIST_DIN<8> A_BIST_DIN<9> A_BIST_EN A_BIST_MEN A_BIST_REN
+ A_BIST_WEN A_BM<0> A_BM<10> A_BM<11> A_BM<12> A_BM<13> A_BM<14> A_BM<15>
+ A_BM<1> A_BM<2> A_BM<3> A_BM<4> A_BM<5> A_BM<6> A_BM<7> A_BM<8> A_BM<9> A_CLK
+ A_DIN<0> A_DIN<10> A_DIN<11> A_DIN<12> A_DIN<13> A_DIN<14> A_DIN<15> A_DIN<1>
+ A_DIN<2> A_DIN<3> A_DIN<4> A_DIN<5> A_DIN<6> A_DIN<7> A_DIN<8> A_DIN<9> A_DLY
+ A_DOUT<0> A_DOUT<10> A_DOUT<11> A_DOUT<12> A_DOUT<13> A_DOUT<14> A_DOUT<15>
+ A_DOUT<1> A_DOUT<2> A_DOUT<3> A_DOUT<4> A_DOUT<5> A_DOUT<6> A_DOUT<7>
+ A_DOUT<8> A_DOUT<9> A_MEN A_REN A_WEN VDD! VDDARRAY! VSS!
.ENDS RM_IHPSG13_1P_256x16_c2_bm_bist
